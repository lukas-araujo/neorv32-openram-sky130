.meas tran vdout0_0ck40 FIND v(dout0_0) AT=50.05n

.meas tran vdout0_1ck40 FIND v(dout0_1) AT=50.05n

.meas tran vdout0_2ck40 FIND v(dout0_2) AT=50.05n

.meas tran vdout0_3ck40 FIND v(dout0_3) AT=50.05n

.meas tran vdout0_4ck40 FIND v(dout0_4) AT=50.05n

.meas tran vdout0_5ck40 FIND v(dout0_5) AT=50.05n

.meas tran vdout0_6ck40 FIND v(dout0_6) AT=50.05n

.meas tran vdout0_7ck40 FIND v(dout0_7) AT=50.05n

.meas tran vdout0_8ck40 FIND v(dout0_8) AT=50.05n

.meas tran vdout0_9ck40 FIND v(dout0_9) AT=50.05n

.meas tran vdout0_10ck40 FIND v(dout0_10) AT=50.05n

.meas tran vdout0_11ck40 FIND v(dout0_11) AT=50.05n

.meas tran vdout0_12ck40 FIND v(dout0_12) AT=50.05n

.meas tran vdout0_13ck40 FIND v(dout0_13) AT=50.05n

.meas tran vdout0_14ck40 FIND v(dout0_14) AT=50.05n

.meas tran vdout0_15ck40 FIND v(dout0_15) AT=50.05n

.meas tran vdout0_16ck40 FIND v(dout0_16) AT=50.05n

.meas tran vdout0_17ck40 FIND v(dout0_17) AT=50.05n

.meas tran vdout0_18ck40 FIND v(dout0_18) AT=50.05n

.meas tran vdout0_19ck40 FIND v(dout0_19) AT=50.05n

.meas tran vdout0_20ck40 FIND v(dout0_20) AT=50.05n

.meas tran vdout0_21ck40 FIND v(dout0_21) AT=50.05n

.meas tran vdout0_22ck40 FIND v(dout0_22) AT=50.05n

.meas tran vdout0_23ck40 FIND v(dout0_23) AT=50.05n

.meas tran vdout0_24ck40 FIND v(dout0_24) AT=50.05n

.meas tran vdout0_25ck40 FIND v(dout0_25) AT=50.05n

.meas tran vdout0_26ck40 FIND v(dout0_26) AT=50.05n

.meas tran vdout0_27ck40 FIND v(dout0_27) AT=50.05n

.meas tran vdout0_28ck40 FIND v(dout0_28) AT=50.05n

.meas tran vdout0_29ck40 FIND v(dout0_29) AT=50.05n

.meas tran vdout0_30ck40 FIND v(dout0_30) AT=50.05n

.meas tran vdout0_31ck40 FIND v(dout0_31) AT=50.05n

.meas tran vdout0_32ck40 FIND v(dout0_32) AT=50.05n

.meas tran vdout0_0ck70 FIND v(dout0_0) AT=80.05n

.meas tran vdout0_1ck70 FIND v(dout0_1) AT=80.05n

.meas tran vdout0_2ck70 FIND v(dout0_2) AT=80.05n

.meas tran vdout0_3ck70 FIND v(dout0_3) AT=80.05n

.meas tran vdout0_4ck70 FIND v(dout0_4) AT=80.05n

.meas tran vdout0_5ck70 FIND v(dout0_5) AT=80.05n

.meas tran vdout0_6ck70 FIND v(dout0_6) AT=80.05n

.meas tran vdout0_7ck70 FIND v(dout0_7) AT=80.05n

.meas tran vdout0_8ck70 FIND v(dout0_8) AT=80.05n

.meas tran vdout0_9ck70 FIND v(dout0_9) AT=80.05n

.meas tran vdout0_10ck70 FIND v(dout0_10) AT=80.05n

.meas tran vdout0_11ck70 FIND v(dout0_11) AT=80.05n

.meas tran vdout0_12ck70 FIND v(dout0_12) AT=80.05n

.meas tran vdout0_13ck70 FIND v(dout0_13) AT=80.05n

.meas tran vdout0_14ck70 FIND v(dout0_14) AT=80.05n

.meas tran vdout0_15ck70 FIND v(dout0_15) AT=80.05n

.meas tran vdout0_16ck70 FIND v(dout0_16) AT=80.05n

.meas tran vdout0_17ck70 FIND v(dout0_17) AT=80.05n

.meas tran vdout0_18ck70 FIND v(dout0_18) AT=80.05n

.meas tran vdout0_19ck70 FIND v(dout0_19) AT=80.05n

.meas tran vdout0_20ck70 FIND v(dout0_20) AT=80.05n

.meas tran vdout0_21ck70 FIND v(dout0_21) AT=80.05n

.meas tran vdout0_22ck70 FIND v(dout0_22) AT=80.05n

.meas tran vdout0_23ck70 FIND v(dout0_23) AT=80.05n

.meas tran vdout0_24ck70 FIND v(dout0_24) AT=80.05n

.meas tran vdout0_25ck70 FIND v(dout0_25) AT=80.05n

.meas tran vdout0_26ck70 FIND v(dout0_26) AT=80.05n

.meas tran vdout0_27ck70 FIND v(dout0_27) AT=80.05n

.meas tran vdout0_28ck70 FIND v(dout0_28) AT=80.05n

.meas tran vdout0_29ck70 FIND v(dout0_29) AT=80.05n

.meas tran vdout0_30ck70 FIND v(dout0_30) AT=80.05n

.meas tran vdout0_31ck70 FIND v(dout0_31) AT=80.05n

.meas tran vdout0_32ck70 FIND v(dout0_32) AT=80.05n

.meas tran vdout0_0ck130 FIND v(dout0_0) AT=140.05n

.meas tran vdout0_1ck130 FIND v(dout0_1) AT=140.05n

.meas tran vdout0_2ck130 FIND v(dout0_2) AT=140.05n

.meas tran vdout0_3ck130 FIND v(dout0_3) AT=140.05n

.meas tran vdout0_4ck130 FIND v(dout0_4) AT=140.05n

.meas tran vdout0_5ck130 FIND v(dout0_5) AT=140.05n

.meas tran vdout0_6ck130 FIND v(dout0_6) AT=140.05n

.meas tran vdout0_7ck130 FIND v(dout0_7) AT=140.05n

.meas tran vdout0_8ck130 FIND v(dout0_8) AT=140.05n

.meas tran vdout0_9ck130 FIND v(dout0_9) AT=140.05n

.meas tran vdout0_10ck130 FIND v(dout0_10) AT=140.05n

.meas tran vdout0_11ck130 FIND v(dout0_11) AT=140.05n

.meas tran vdout0_12ck130 FIND v(dout0_12) AT=140.05n

.meas tran vdout0_13ck130 FIND v(dout0_13) AT=140.05n

.meas tran vdout0_14ck130 FIND v(dout0_14) AT=140.05n

.meas tran vdout0_15ck130 FIND v(dout0_15) AT=140.05n

.meas tran vdout0_16ck130 FIND v(dout0_16) AT=140.05n

.meas tran vdout0_17ck130 FIND v(dout0_17) AT=140.05n

.meas tran vdout0_18ck130 FIND v(dout0_18) AT=140.05n

.meas tran vdout0_19ck130 FIND v(dout0_19) AT=140.05n

.meas tran vdout0_20ck130 FIND v(dout0_20) AT=140.05n

.meas tran vdout0_21ck130 FIND v(dout0_21) AT=140.05n

.meas tran vdout0_22ck130 FIND v(dout0_22) AT=140.05n

.meas tran vdout0_23ck130 FIND v(dout0_23) AT=140.05n

.meas tran vdout0_24ck130 FIND v(dout0_24) AT=140.05n

.meas tran vdout0_25ck130 FIND v(dout0_25) AT=140.05n

.meas tran vdout0_26ck130 FIND v(dout0_26) AT=140.05n

.meas tran vdout0_27ck130 FIND v(dout0_27) AT=140.05n

.meas tran vdout0_28ck130 FIND v(dout0_28) AT=140.05n

.meas tran vdout0_29ck130 FIND v(dout0_29) AT=140.05n

.meas tran vdout0_30ck130 FIND v(dout0_30) AT=140.05n

.meas tran vdout0_31ck130 FIND v(dout0_31) AT=140.05n

.meas tran vdout0_32ck130 FIND v(dout0_32) AT=140.05n

.meas tran vdout0_0ck140 FIND v(dout0_0) AT=150.05n

.meas tran vdout0_1ck140 FIND v(dout0_1) AT=150.05n

.meas tran vdout0_2ck140 FIND v(dout0_2) AT=150.05n

.meas tran vdout0_3ck140 FIND v(dout0_3) AT=150.05n

.meas tran vdout0_4ck140 FIND v(dout0_4) AT=150.05n

.meas tran vdout0_5ck140 FIND v(dout0_5) AT=150.05n

.meas tran vdout0_6ck140 FIND v(dout0_6) AT=150.05n

.meas tran vdout0_7ck140 FIND v(dout0_7) AT=150.05n

.meas tran vdout0_8ck140 FIND v(dout0_8) AT=150.05n

.meas tran vdout0_9ck140 FIND v(dout0_9) AT=150.05n

.meas tran vdout0_10ck140 FIND v(dout0_10) AT=150.05n

.meas tran vdout0_11ck140 FIND v(dout0_11) AT=150.05n

.meas tran vdout0_12ck140 FIND v(dout0_12) AT=150.05n

.meas tran vdout0_13ck140 FIND v(dout0_13) AT=150.05n

.meas tran vdout0_14ck140 FIND v(dout0_14) AT=150.05n

.meas tran vdout0_15ck140 FIND v(dout0_15) AT=150.05n

.meas tran vdout0_16ck140 FIND v(dout0_16) AT=150.05n

.meas tran vdout0_17ck140 FIND v(dout0_17) AT=150.05n

.meas tran vdout0_18ck140 FIND v(dout0_18) AT=150.05n

.meas tran vdout0_19ck140 FIND v(dout0_19) AT=150.05n

.meas tran vdout0_20ck140 FIND v(dout0_20) AT=150.05n

.meas tran vdout0_21ck140 FIND v(dout0_21) AT=150.05n

.meas tran vdout0_22ck140 FIND v(dout0_22) AT=150.05n

.meas tran vdout0_23ck140 FIND v(dout0_23) AT=150.05n

.meas tran vdout0_24ck140 FIND v(dout0_24) AT=150.05n

.meas tran vdout0_25ck140 FIND v(dout0_25) AT=150.05n

.meas tran vdout0_26ck140 FIND v(dout0_26) AT=150.05n

.meas tran vdout0_27ck140 FIND v(dout0_27) AT=150.05n

.meas tran vdout0_28ck140 FIND v(dout0_28) AT=150.05n

.meas tran vdout0_29ck140 FIND v(dout0_29) AT=150.05n

.meas tran vdout0_30ck140 FIND v(dout0_30) AT=150.05n

.meas tran vdout0_31ck140 FIND v(dout0_31) AT=150.05n

.meas tran vdout0_32ck140 FIND v(dout0_32) AT=150.05n

.meas tran vdout0_0ck170 FIND v(dout0_0) AT=180.05n

.meas tran vdout0_1ck170 FIND v(dout0_1) AT=180.05n

.meas tran vdout0_2ck170 FIND v(dout0_2) AT=180.05n

.meas tran vdout0_3ck170 FIND v(dout0_3) AT=180.05n

.meas tran vdout0_4ck170 FIND v(dout0_4) AT=180.05n

.meas tran vdout0_5ck170 FIND v(dout0_5) AT=180.05n

.meas tran vdout0_6ck170 FIND v(dout0_6) AT=180.05n

.meas tran vdout0_7ck170 FIND v(dout0_7) AT=180.05n

.meas tran vdout0_8ck170 FIND v(dout0_8) AT=180.05n

.meas tran vdout0_9ck170 FIND v(dout0_9) AT=180.05n

.meas tran vdout0_10ck170 FIND v(dout0_10) AT=180.05n

.meas tran vdout0_11ck170 FIND v(dout0_11) AT=180.05n

.meas tran vdout0_12ck170 FIND v(dout0_12) AT=180.05n

.meas tran vdout0_13ck170 FIND v(dout0_13) AT=180.05n

.meas tran vdout0_14ck170 FIND v(dout0_14) AT=180.05n

.meas tran vdout0_15ck170 FIND v(dout0_15) AT=180.05n

.meas tran vdout0_16ck170 FIND v(dout0_16) AT=180.05n

.meas tran vdout0_17ck170 FIND v(dout0_17) AT=180.05n

.meas tran vdout0_18ck170 FIND v(dout0_18) AT=180.05n

.meas tran vdout0_19ck170 FIND v(dout0_19) AT=180.05n

.meas tran vdout0_20ck170 FIND v(dout0_20) AT=180.05n

.meas tran vdout0_21ck170 FIND v(dout0_21) AT=180.05n

.meas tran vdout0_22ck170 FIND v(dout0_22) AT=180.05n

.meas tran vdout0_23ck170 FIND v(dout0_23) AT=180.05n

.meas tran vdout0_24ck170 FIND v(dout0_24) AT=180.05n

.meas tran vdout0_25ck170 FIND v(dout0_25) AT=180.05n

.meas tran vdout0_26ck170 FIND v(dout0_26) AT=180.05n

.meas tran vdout0_27ck170 FIND v(dout0_27) AT=180.05n

.meas tran vdout0_28ck170 FIND v(dout0_28) AT=180.05n

.meas tran vdout0_29ck170 FIND v(dout0_29) AT=180.05n

.meas tran vdout0_30ck170 FIND v(dout0_30) AT=180.05n

.meas tran vdout0_31ck170 FIND v(dout0_31) AT=180.05n

.meas tran vdout0_32ck170 FIND v(dout0_32) AT=180.05n

.meas tran vdout0_0ck240 FIND v(dout0_0) AT=250.05n

.meas tran vdout0_1ck240 FIND v(dout0_1) AT=250.05n

.meas tran vdout0_2ck240 FIND v(dout0_2) AT=250.05n

.meas tran vdout0_3ck240 FIND v(dout0_3) AT=250.05n

.meas tran vdout0_4ck240 FIND v(dout0_4) AT=250.05n

.meas tran vdout0_5ck240 FIND v(dout0_5) AT=250.05n

.meas tran vdout0_6ck240 FIND v(dout0_6) AT=250.05n

.meas tran vdout0_7ck240 FIND v(dout0_7) AT=250.05n

.meas tran vdout0_8ck240 FIND v(dout0_8) AT=250.05n

.meas tran vdout0_9ck240 FIND v(dout0_9) AT=250.05n

.meas tran vdout0_10ck240 FIND v(dout0_10) AT=250.05n

.meas tran vdout0_11ck240 FIND v(dout0_11) AT=250.05n

.meas tran vdout0_12ck240 FIND v(dout0_12) AT=250.05n

.meas tran vdout0_13ck240 FIND v(dout0_13) AT=250.05n

.meas tran vdout0_14ck240 FIND v(dout0_14) AT=250.05n

.meas tran vdout0_15ck240 FIND v(dout0_15) AT=250.05n

.meas tran vdout0_16ck240 FIND v(dout0_16) AT=250.05n

.meas tran vdout0_17ck240 FIND v(dout0_17) AT=250.05n

.meas tran vdout0_18ck240 FIND v(dout0_18) AT=250.05n

.meas tran vdout0_19ck240 FIND v(dout0_19) AT=250.05n

.meas tran vdout0_20ck240 FIND v(dout0_20) AT=250.05n

.meas tran vdout0_21ck240 FIND v(dout0_21) AT=250.05n

.meas tran vdout0_22ck240 FIND v(dout0_22) AT=250.05n

.meas tran vdout0_23ck240 FIND v(dout0_23) AT=250.05n

.meas tran vdout0_24ck240 FIND v(dout0_24) AT=250.05n

.meas tran vdout0_25ck240 FIND v(dout0_25) AT=250.05n

.meas tran vdout0_26ck240 FIND v(dout0_26) AT=250.05n

.meas tran vdout0_27ck240 FIND v(dout0_27) AT=250.05n

.meas tran vdout0_28ck240 FIND v(dout0_28) AT=250.05n

.meas tran vdout0_29ck240 FIND v(dout0_29) AT=250.05n

.meas tran vdout0_30ck240 FIND v(dout0_30) AT=250.05n

.meas tran vdout0_31ck240 FIND v(dout0_31) AT=250.05n

.meas tran vdout0_32ck240 FIND v(dout0_32) AT=250.05n

.meas tran vdout0_0ck280 FIND v(dout0_0) AT=290.05n

.meas tran vdout0_1ck280 FIND v(dout0_1) AT=290.05n

.meas tran vdout0_2ck280 FIND v(dout0_2) AT=290.05n

.meas tran vdout0_3ck280 FIND v(dout0_3) AT=290.05n

.meas tran vdout0_4ck280 FIND v(dout0_4) AT=290.05n

.meas tran vdout0_5ck280 FIND v(dout0_5) AT=290.05n

.meas tran vdout0_6ck280 FIND v(dout0_6) AT=290.05n

.meas tran vdout0_7ck280 FIND v(dout0_7) AT=290.05n

.meas tran vdout0_8ck280 FIND v(dout0_8) AT=290.05n

.meas tran vdout0_9ck280 FIND v(dout0_9) AT=290.05n

.meas tran vdout0_10ck280 FIND v(dout0_10) AT=290.05n

.meas tran vdout0_11ck280 FIND v(dout0_11) AT=290.05n

.meas tran vdout0_12ck280 FIND v(dout0_12) AT=290.05n

.meas tran vdout0_13ck280 FIND v(dout0_13) AT=290.05n

.meas tran vdout0_14ck280 FIND v(dout0_14) AT=290.05n

.meas tran vdout0_15ck280 FIND v(dout0_15) AT=290.05n

.meas tran vdout0_16ck280 FIND v(dout0_16) AT=290.05n

.meas tran vdout0_17ck280 FIND v(dout0_17) AT=290.05n

.meas tran vdout0_18ck280 FIND v(dout0_18) AT=290.05n

.meas tran vdout0_19ck280 FIND v(dout0_19) AT=290.05n

.meas tran vdout0_20ck280 FIND v(dout0_20) AT=290.05n

.meas tran vdout0_21ck280 FIND v(dout0_21) AT=290.05n

.meas tran vdout0_22ck280 FIND v(dout0_22) AT=290.05n

.meas tran vdout0_23ck280 FIND v(dout0_23) AT=290.05n

.meas tran vdout0_24ck280 FIND v(dout0_24) AT=290.05n

.meas tran vdout0_25ck280 FIND v(dout0_25) AT=290.05n

.meas tran vdout0_26ck280 FIND v(dout0_26) AT=290.05n

.meas tran vdout0_27ck280 FIND v(dout0_27) AT=290.05n

.meas tran vdout0_28ck280 FIND v(dout0_28) AT=290.05n

.meas tran vdout0_29ck280 FIND v(dout0_29) AT=290.05n

.meas tran vdout0_30ck280 FIND v(dout0_30) AT=290.05n

.meas tran vdout0_31ck280 FIND v(dout0_31) AT=290.05n

.meas tran vdout0_32ck280 FIND v(dout0_32) AT=290.05n

.meas tran vdout0_0ck330 FIND v(dout0_0) AT=340.05n

.meas tran vdout0_1ck330 FIND v(dout0_1) AT=340.05n

.meas tran vdout0_2ck330 FIND v(dout0_2) AT=340.05n

.meas tran vdout0_3ck330 FIND v(dout0_3) AT=340.05n

.meas tran vdout0_4ck330 FIND v(dout0_4) AT=340.05n

.meas tran vdout0_5ck330 FIND v(dout0_5) AT=340.05n

.meas tran vdout0_6ck330 FIND v(dout0_6) AT=340.05n

.meas tran vdout0_7ck330 FIND v(dout0_7) AT=340.05n

.meas tran vdout0_8ck330 FIND v(dout0_8) AT=340.05n

.meas tran vdout0_9ck330 FIND v(dout0_9) AT=340.05n

.meas tran vdout0_10ck330 FIND v(dout0_10) AT=340.05n

.meas tran vdout0_11ck330 FIND v(dout0_11) AT=340.05n

.meas tran vdout0_12ck330 FIND v(dout0_12) AT=340.05n

.meas tran vdout0_13ck330 FIND v(dout0_13) AT=340.05n

.meas tran vdout0_14ck330 FIND v(dout0_14) AT=340.05n

.meas tran vdout0_15ck330 FIND v(dout0_15) AT=340.05n

.meas tran vdout0_16ck330 FIND v(dout0_16) AT=340.05n

.meas tran vdout0_17ck330 FIND v(dout0_17) AT=340.05n

.meas tran vdout0_18ck330 FIND v(dout0_18) AT=340.05n

.meas tran vdout0_19ck330 FIND v(dout0_19) AT=340.05n

.meas tran vdout0_20ck330 FIND v(dout0_20) AT=340.05n

.meas tran vdout0_21ck330 FIND v(dout0_21) AT=340.05n

.meas tran vdout0_22ck330 FIND v(dout0_22) AT=340.05n

.meas tran vdout0_23ck330 FIND v(dout0_23) AT=340.05n

.meas tran vdout0_24ck330 FIND v(dout0_24) AT=340.05n

.meas tran vdout0_25ck330 FIND v(dout0_25) AT=340.05n

.meas tran vdout0_26ck330 FIND v(dout0_26) AT=340.05n

.meas tran vdout0_27ck330 FIND v(dout0_27) AT=340.05n

.meas tran vdout0_28ck330 FIND v(dout0_28) AT=340.05n

.meas tran vdout0_29ck330 FIND v(dout0_29) AT=340.05n

.meas tran vdout0_30ck330 FIND v(dout0_30) AT=340.05n

.meas tran vdout0_31ck330 FIND v(dout0_31) AT=340.05n

.meas tran vdout0_32ck330 FIND v(dout0_32) AT=340.05n

.meas tran vdout0_0ck350 FIND v(dout0_0) AT=360.05n

.meas tran vdout0_1ck350 FIND v(dout0_1) AT=360.05n

.meas tran vdout0_2ck350 FIND v(dout0_2) AT=360.05n

.meas tran vdout0_3ck350 FIND v(dout0_3) AT=360.05n

.meas tran vdout0_4ck350 FIND v(dout0_4) AT=360.05n

.meas tran vdout0_5ck350 FIND v(dout0_5) AT=360.05n

.meas tran vdout0_6ck350 FIND v(dout0_6) AT=360.05n

.meas tran vdout0_7ck350 FIND v(dout0_7) AT=360.05n

.meas tran vdout0_8ck350 FIND v(dout0_8) AT=360.05n

.meas tran vdout0_9ck350 FIND v(dout0_9) AT=360.05n

.meas tran vdout0_10ck350 FIND v(dout0_10) AT=360.05n

.meas tran vdout0_11ck350 FIND v(dout0_11) AT=360.05n

.meas tran vdout0_12ck350 FIND v(dout0_12) AT=360.05n

.meas tran vdout0_13ck350 FIND v(dout0_13) AT=360.05n

.meas tran vdout0_14ck350 FIND v(dout0_14) AT=360.05n

.meas tran vdout0_15ck350 FIND v(dout0_15) AT=360.05n

.meas tran vdout0_16ck350 FIND v(dout0_16) AT=360.05n

.meas tran vdout0_17ck350 FIND v(dout0_17) AT=360.05n

.meas tran vdout0_18ck350 FIND v(dout0_18) AT=360.05n

.meas tran vdout0_19ck350 FIND v(dout0_19) AT=360.05n

.meas tran vdout0_20ck350 FIND v(dout0_20) AT=360.05n

.meas tran vdout0_21ck350 FIND v(dout0_21) AT=360.05n

.meas tran vdout0_22ck350 FIND v(dout0_22) AT=360.05n

.meas tran vdout0_23ck350 FIND v(dout0_23) AT=360.05n

.meas tran vdout0_24ck350 FIND v(dout0_24) AT=360.05n

.meas tran vdout0_25ck350 FIND v(dout0_25) AT=360.05n

.meas tran vdout0_26ck350 FIND v(dout0_26) AT=360.05n

.meas tran vdout0_27ck350 FIND v(dout0_27) AT=360.05n

.meas tran vdout0_28ck350 FIND v(dout0_28) AT=360.05n

.meas tran vdout0_29ck350 FIND v(dout0_29) AT=360.05n

.meas tran vdout0_30ck350 FIND v(dout0_30) AT=360.05n

.meas tran vdout0_31ck350 FIND v(dout0_31) AT=360.05n

.meas tran vdout0_32ck350 FIND v(dout0_32) AT=360.05n

.meas tran vdout0_0ck400 FIND v(dout0_0) AT=410.05n

.meas tran vdout0_1ck400 FIND v(dout0_1) AT=410.05n

.meas tran vdout0_2ck400 FIND v(dout0_2) AT=410.05n

.meas tran vdout0_3ck400 FIND v(dout0_3) AT=410.05n

.meas tran vdout0_4ck400 FIND v(dout0_4) AT=410.05n

.meas tran vdout0_5ck400 FIND v(dout0_5) AT=410.05n

.meas tran vdout0_6ck400 FIND v(dout0_6) AT=410.05n

.meas tran vdout0_7ck400 FIND v(dout0_7) AT=410.05n

.meas tran vdout0_8ck400 FIND v(dout0_8) AT=410.05n

.meas tran vdout0_9ck400 FIND v(dout0_9) AT=410.05n

.meas tran vdout0_10ck400 FIND v(dout0_10) AT=410.05n

.meas tran vdout0_11ck400 FIND v(dout0_11) AT=410.05n

.meas tran vdout0_12ck400 FIND v(dout0_12) AT=410.05n

.meas tran vdout0_13ck400 FIND v(dout0_13) AT=410.05n

.meas tran vdout0_14ck400 FIND v(dout0_14) AT=410.05n

.meas tran vdout0_15ck400 FIND v(dout0_15) AT=410.05n

.meas tran vdout0_16ck400 FIND v(dout0_16) AT=410.05n

.meas tran vdout0_17ck400 FIND v(dout0_17) AT=410.05n

.meas tran vdout0_18ck400 FIND v(dout0_18) AT=410.05n

.meas tran vdout0_19ck400 FIND v(dout0_19) AT=410.05n

.meas tran vdout0_20ck400 FIND v(dout0_20) AT=410.05n

.meas tran vdout0_21ck400 FIND v(dout0_21) AT=410.05n

.meas tran vdout0_22ck400 FIND v(dout0_22) AT=410.05n

.meas tran vdout0_23ck400 FIND v(dout0_23) AT=410.05n

.meas tran vdout0_24ck400 FIND v(dout0_24) AT=410.05n

.meas tran vdout0_25ck400 FIND v(dout0_25) AT=410.05n

.meas tran vdout0_26ck400 FIND v(dout0_26) AT=410.05n

.meas tran vdout0_27ck400 FIND v(dout0_27) AT=410.05n

.meas tran vdout0_28ck400 FIND v(dout0_28) AT=410.05n

.meas tran vdout0_29ck400 FIND v(dout0_29) AT=410.05n

.meas tran vdout0_30ck400 FIND v(dout0_30) AT=410.05n

.meas tran vdout0_31ck400 FIND v(dout0_31) AT=410.05n

.meas tran vdout0_32ck400 FIND v(dout0_32) AT=410.05n

.meas tran vdout0_0ck440 FIND v(dout0_0) AT=450.05n

.meas tran vdout0_1ck440 FIND v(dout0_1) AT=450.05n

.meas tran vdout0_2ck440 FIND v(dout0_2) AT=450.05n

.meas tran vdout0_3ck440 FIND v(dout0_3) AT=450.05n

.meas tran vdout0_4ck440 FIND v(dout0_4) AT=450.05n

.meas tran vdout0_5ck440 FIND v(dout0_5) AT=450.05n

.meas tran vdout0_6ck440 FIND v(dout0_6) AT=450.05n

.meas tran vdout0_7ck440 FIND v(dout0_7) AT=450.05n

.meas tran vdout0_8ck440 FIND v(dout0_8) AT=450.05n

.meas tran vdout0_9ck440 FIND v(dout0_9) AT=450.05n

.meas tran vdout0_10ck440 FIND v(dout0_10) AT=450.05n

.meas tran vdout0_11ck440 FIND v(dout0_11) AT=450.05n

.meas tran vdout0_12ck440 FIND v(dout0_12) AT=450.05n

.meas tran vdout0_13ck440 FIND v(dout0_13) AT=450.05n

.meas tran vdout0_14ck440 FIND v(dout0_14) AT=450.05n

.meas tran vdout0_15ck440 FIND v(dout0_15) AT=450.05n

.meas tran vdout0_16ck440 FIND v(dout0_16) AT=450.05n

.meas tran vdout0_17ck440 FIND v(dout0_17) AT=450.05n

.meas tran vdout0_18ck440 FIND v(dout0_18) AT=450.05n

.meas tran vdout0_19ck440 FIND v(dout0_19) AT=450.05n

.meas tran vdout0_20ck440 FIND v(dout0_20) AT=450.05n

.meas tran vdout0_21ck440 FIND v(dout0_21) AT=450.05n

.meas tran vdout0_22ck440 FIND v(dout0_22) AT=450.05n

.meas tran vdout0_23ck440 FIND v(dout0_23) AT=450.05n

.meas tran vdout0_24ck440 FIND v(dout0_24) AT=450.05n

.meas tran vdout0_25ck440 FIND v(dout0_25) AT=450.05n

.meas tran vdout0_26ck440 FIND v(dout0_26) AT=450.05n

.meas tran vdout0_27ck440 FIND v(dout0_27) AT=450.05n

.meas tran vdout0_28ck440 FIND v(dout0_28) AT=450.05n

.meas tran vdout0_29ck440 FIND v(dout0_29) AT=450.05n

.meas tran vdout0_30ck440 FIND v(dout0_30) AT=450.05n

.meas tran vdout0_31ck440 FIND v(dout0_31) AT=450.05n

.meas tran vdout0_32ck440 FIND v(dout0_32) AT=450.05n

.meas tran vdout0_0ck470 FIND v(dout0_0) AT=480.05n

.meas tran vdout0_1ck470 FIND v(dout0_1) AT=480.05n

.meas tran vdout0_2ck470 FIND v(dout0_2) AT=480.05n

.meas tran vdout0_3ck470 FIND v(dout0_3) AT=480.05n

.meas tran vdout0_4ck470 FIND v(dout0_4) AT=480.05n

.meas tran vdout0_5ck470 FIND v(dout0_5) AT=480.05n

.meas tran vdout0_6ck470 FIND v(dout0_6) AT=480.05n

.meas tran vdout0_7ck470 FIND v(dout0_7) AT=480.05n

.meas tran vdout0_8ck470 FIND v(dout0_8) AT=480.05n

.meas tran vdout0_9ck470 FIND v(dout0_9) AT=480.05n

.meas tran vdout0_10ck470 FIND v(dout0_10) AT=480.05n

.meas tran vdout0_11ck470 FIND v(dout0_11) AT=480.05n

.meas tran vdout0_12ck470 FIND v(dout0_12) AT=480.05n

.meas tran vdout0_13ck470 FIND v(dout0_13) AT=480.05n

.meas tran vdout0_14ck470 FIND v(dout0_14) AT=480.05n

.meas tran vdout0_15ck470 FIND v(dout0_15) AT=480.05n

.meas tran vdout0_16ck470 FIND v(dout0_16) AT=480.05n

.meas tran vdout0_17ck470 FIND v(dout0_17) AT=480.05n

.meas tran vdout0_18ck470 FIND v(dout0_18) AT=480.05n

.meas tran vdout0_19ck470 FIND v(dout0_19) AT=480.05n

.meas tran vdout0_20ck470 FIND v(dout0_20) AT=480.05n

.meas tran vdout0_21ck470 FIND v(dout0_21) AT=480.05n

.meas tran vdout0_22ck470 FIND v(dout0_22) AT=480.05n

.meas tran vdout0_23ck470 FIND v(dout0_23) AT=480.05n

.meas tran vdout0_24ck470 FIND v(dout0_24) AT=480.05n

.meas tran vdout0_25ck470 FIND v(dout0_25) AT=480.05n

.meas tran vdout0_26ck470 FIND v(dout0_26) AT=480.05n

.meas tran vdout0_27ck470 FIND v(dout0_27) AT=480.05n

.meas tran vdout0_28ck470 FIND v(dout0_28) AT=480.05n

.meas tran vdout0_29ck470 FIND v(dout0_29) AT=480.05n

.meas tran vdout0_30ck470 FIND v(dout0_30) AT=480.05n

.meas tran vdout0_31ck470 FIND v(dout0_31) AT=480.05n

.meas tran vdout0_32ck470 FIND v(dout0_32) AT=480.05n

.meas tran vdout0_0ck480 FIND v(dout0_0) AT=490.05n

.meas tran vdout0_1ck480 FIND v(dout0_1) AT=490.05n

.meas tran vdout0_2ck480 FIND v(dout0_2) AT=490.05n

.meas tran vdout0_3ck480 FIND v(dout0_3) AT=490.05n

.meas tran vdout0_4ck480 FIND v(dout0_4) AT=490.05n

.meas tran vdout0_5ck480 FIND v(dout0_5) AT=490.05n

.meas tran vdout0_6ck480 FIND v(dout0_6) AT=490.05n

.meas tran vdout0_7ck480 FIND v(dout0_7) AT=490.05n

.meas tran vdout0_8ck480 FIND v(dout0_8) AT=490.05n

.meas tran vdout0_9ck480 FIND v(dout0_9) AT=490.05n

.meas tran vdout0_10ck480 FIND v(dout0_10) AT=490.05n

.meas tran vdout0_11ck480 FIND v(dout0_11) AT=490.05n

.meas tran vdout0_12ck480 FIND v(dout0_12) AT=490.05n

.meas tran vdout0_13ck480 FIND v(dout0_13) AT=490.05n

.meas tran vdout0_14ck480 FIND v(dout0_14) AT=490.05n

.meas tran vdout0_15ck480 FIND v(dout0_15) AT=490.05n

.meas tran vdout0_16ck480 FIND v(dout0_16) AT=490.05n

.meas tran vdout0_17ck480 FIND v(dout0_17) AT=490.05n

.meas tran vdout0_18ck480 FIND v(dout0_18) AT=490.05n

.meas tran vdout0_19ck480 FIND v(dout0_19) AT=490.05n

.meas tran vdout0_20ck480 FIND v(dout0_20) AT=490.05n

.meas tran vdout0_21ck480 FIND v(dout0_21) AT=490.05n

.meas tran vdout0_22ck480 FIND v(dout0_22) AT=490.05n

.meas tran vdout0_23ck480 FIND v(dout0_23) AT=490.05n

.meas tran vdout0_24ck480 FIND v(dout0_24) AT=490.05n

.meas tran vdout0_25ck480 FIND v(dout0_25) AT=490.05n

.meas tran vdout0_26ck480 FIND v(dout0_26) AT=490.05n

.meas tran vdout0_27ck480 FIND v(dout0_27) AT=490.05n

.meas tran vdout0_28ck480 FIND v(dout0_28) AT=490.05n

.meas tran vdout0_29ck480 FIND v(dout0_29) AT=490.05n

.meas tran vdout0_30ck480 FIND v(dout0_30) AT=490.05n

.meas tran vdout0_31ck480 FIND v(dout0_31) AT=490.05n

.meas tran vdout0_32ck480 FIND v(dout0_32) AT=490.05n

.meas tran vdout0_0ck500 FIND v(dout0_0) AT=510.05n

.meas tran vdout0_1ck500 FIND v(dout0_1) AT=510.05n

.meas tran vdout0_2ck500 FIND v(dout0_2) AT=510.05n

.meas tran vdout0_3ck500 FIND v(dout0_3) AT=510.05n

.meas tran vdout0_4ck500 FIND v(dout0_4) AT=510.05n

.meas tran vdout0_5ck500 FIND v(dout0_5) AT=510.05n

.meas tran vdout0_6ck500 FIND v(dout0_6) AT=510.05n

.meas tran vdout0_7ck500 FIND v(dout0_7) AT=510.05n

.meas tran vdout0_8ck500 FIND v(dout0_8) AT=510.05n

.meas tran vdout0_9ck500 FIND v(dout0_9) AT=510.05n

.meas tran vdout0_10ck500 FIND v(dout0_10) AT=510.05n

.meas tran vdout0_11ck500 FIND v(dout0_11) AT=510.05n

.meas tran vdout0_12ck500 FIND v(dout0_12) AT=510.05n

.meas tran vdout0_13ck500 FIND v(dout0_13) AT=510.05n

.meas tran vdout0_14ck500 FIND v(dout0_14) AT=510.05n

.meas tran vdout0_15ck500 FIND v(dout0_15) AT=510.05n

.meas tran vdout0_16ck500 FIND v(dout0_16) AT=510.05n

.meas tran vdout0_17ck500 FIND v(dout0_17) AT=510.05n

.meas tran vdout0_18ck500 FIND v(dout0_18) AT=510.05n

.meas tran vdout0_19ck500 FIND v(dout0_19) AT=510.05n

.meas tran vdout0_20ck500 FIND v(dout0_20) AT=510.05n

.meas tran vdout0_21ck500 FIND v(dout0_21) AT=510.05n

.meas tran vdout0_22ck500 FIND v(dout0_22) AT=510.05n

.meas tran vdout0_23ck500 FIND v(dout0_23) AT=510.05n

.meas tran vdout0_24ck500 FIND v(dout0_24) AT=510.05n

.meas tran vdout0_25ck500 FIND v(dout0_25) AT=510.05n

.meas tran vdout0_26ck500 FIND v(dout0_26) AT=510.05n

.meas tran vdout0_27ck500 FIND v(dout0_27) AT=510.05n

.meas tran vdout0_28ck500 FIND v(dout0_28) AT=510.05n

.meas tran vdout0_29ck500 FIND v(dout0_29) AT=510.05n

.meas tran vdout0_30ck500 FIND v(dout0_30) AT=510.05n

.meas tran vdout0_31ck500 FIND v(dout0_31) AT=510.05n

.meas tran vdout0_32ck500 FIND v(dout0_32) AT=510.05n

.meas tran vdout0_0ck520 FIND v(dout0_0) AT=530.05n

.meas tran vdout0_1ck520 FIND v(dout0_1) AT=530.05n

.meas tran vdout0_2ck520 FIND v(dout0_2) AT=530.05n

.meas tran vdout0_3ck520 FIND v(dout0_3) AT=530.05n

.meas tran vdout0_4ck520 FIND v(dout0_4) AT=530.05n

.meas tran vdout0_5ck520 FIND v(dout0_5) AT=530.05n

.meas tran vdout0_6ck520 FIND v(dout0_6) AT=530.05n

.meas tran vdout0_7ck520 FIND v(dout0_7) AT=530.05n

.meas tran vdout0_8ck520 FIND v(dout0_8) AT=530.05n

.meas tran vdout0_9ck520 FIND v(dout0_9) AT=530.05n

.meas tran vdout0_10ck520 FIND v(dout0_10) AT=530.05n

.meas tran vdout0_11ck520 FIND v(dout0_11) AT=530.05n

.meas tran vdout0_12ck520 FIND v(dout0_12) AT=530.05n

.meas tran vdout0_13ck520 FIND v(dout0_13) AT=530.05n

.meas tran vdout0_14ck520 FIND v(dout0_14) AT=530.05n

.meas tran vdout0_15ck520 FIND v(dout0_15) AT=530.05n

.meas tran vdout0_16ck520 FIND v(dout0_16) AT=530.05n

.meas tran vdout0_17ck520 FIND v(dout0_17) AT=530.05n

.meas tran vdout0_18ck520 FIND v(dout0_18) AT=530.05n

.meas tran vdout0_19ck520 FIND v(dout0_19) AT=530.05n

.meas tran vdout0_20ck520 FIND v(dout0_20) AT=530.05n

.meas tran vdout0_21ck520 FIND v(dout0_21) AT=530.05n

.meas tran vdout0_22ck520 FIND v(dout0_22) AT=530.05n

.meas tran vdout0_23ck520 FIND v(dout0_23) AT=530.05n

.meas tran vdout0_24ck520 FIND v(dout0_24) AT=530.05n

.meas tran vdout0_25ck520 FIND v(dout0_25) AT=530.05n

.meas tran vdout0_26ck520 FIND v(dout0_26) AT=530.05n

.meas tran vdout0_27ck520 FIND v(dout0_27) AT=530.05n

.meas tran vdout0_28ck520 FIND v(dout0_28) AT=530.05n

.meas tran vdout0_29ck520 FIND v(dout0_29) AT=530.05n

.meas tran vdout0_30ck520 FIND v(dout0_30) AT=530.05n

.meas tran vdout0_31ck520 FIND v(dout0_31) AT=530.05n

.meas tran vdout0_32ck520 FIND v(dout0_32) AT=530.05n

.meas tran vdout0_0ck530 FIND v(dout0_0) AT=540.05n

.meas tran vdout0_1ck530 FIND v(dout0_1) AT=540.05n

.meas tran vdout0_2ck530 FIND v(dout0_2) AT=540.05n

.meas tran vdout0_3ck530 FIND v(dout0_3) AT=540.05n

.meas tran vdout0_4ck530 FIND v(dout0_4) AT=540.05n

.meas tran vdout0_5ck530 FIND v(dout0_5) AT=540.05n

.meas tran vdout0_6ck530 FIND v(dout0_6) AT=540.05n

.meas tran vdout0_7ck530 FIND v(dout0_7) AT=540.05n

.meas tran vdout0_8ck530 FIND v(dout0_8) AT=540.05n

.meas tran vdout0_9ck530 FIND v(dout0_9) AT=540.05n

.meas tran vdout0_10ck530 FIND v(dout0_10) AT=540.05n

.meas tran vdout0_11ck530 FIND v(dout0_11) AT=540.05n

.meas tran vdout0_12ck530 FIND v(dout0_12) AT=540.05n

.meas tran vdout0_13ck530 FIND v(dout0_13) AT=540.05n

.meas tran vdout0_14ck530 FIND v(dout0_14) AT=540.05n

.meas tran vdout0_15ck530 FIND v(dout0_15) AT=540.05n

.meas tran vdout0_16ck530 FIND v(dout0_16) AT=540.05n

.meas tran vdout0_17ck530 FIND v(dout0_17) AT=540.05n

.meas tran vdout0_18ck530 FIND v(dout0_18) AT=540.05n

.meas tran vdout0_19ck530 FIND v(dout0_19) AT=540.05n

.meas tran vdout0_20ck530 FIND v(dout0_20) AT=540.05n

.meas tran vdout0_21ck530 FIND v(dout0_21) AT=540.05n

.meas tran vdout0_22ck530 FIND v(dout0_22) AT=540.05n

.meas tran vdout0_23ck530 FIND v(dout0_23) AT=540.05n

.meas tran vdout0_24ck530 FIND v(dout0_24) AT=540.05n

.meas tran vdout0_25ck530 FIND v(dout0_25) AT=540.05n

.meas tran vdout0_26ck530 FIND v(dout0_26) AT=540.05n

.meas tran vdout0_27ck530 FIND v(dout0_27) AT=540.05n

.meas tran vdout0_28ck530 FIND v(dout0_28) AT=540.05n

.meas tran vdout0_29ck530 FIND v(dout0_29) AT=540.05n

.meas tran vdout0_30ck530 FIND v(dout0_30) AT=540.05n

.meas tran vdout0_31ck530 FIND v(dout0_31) AT=540.05n

.meas tran vdout0_32ck530 FIND v(dout0_32) AT=540.05n

.meas tran vdout0_0ck580 FIND v(dout0_0) AT=590.05n

.meas tran vdout0_1ck580 FIND v(dout0_1) AT=590.05n

.meas tran vdout0_2ck580 FIND v(dout0_2) AT=590.05n

.meas tran vdout0_3ck580 FIND v(dout0_3) AT=590.05n

.meas tran vdout0_4ck580 FIND v(dout0_4) AT=590.05n

.meas tran vdout0_5ck580 FIND v(dout0_5) AT=590.05n

.meas tran vdout0_6ck580 FIND v(dout0_6) AT=590.05n

.meas tran vdout0_7ck580 FIND v(dout0_7) AT=590.05n

.meas tran vdout0_8ck580 FIND v(dout0_8) AT=590.05n

.meas tran vdout0_9ck580 FIND v(dout0_9) AT=590.05n

.meas tran vdout0_10ck580 FIND v(dout0_10) AT=590.05n

.meas tran vdout0_11ck580 FIND v(dout0_11) AT=590.05n

.meas tran vdout0_12ck580 FIND v(dout0_12) AT=590.05n

.meas tran vdout0_13ck580 FIND v(dout0_13) AT=590.05n

.meas tran vdout0_14ck580 FIND v(dout0_14) AT=590.05n

.meas tran vdout0_15ck580 FIND v(dout0_15) AT=590.05n

.meas tran vdout0_16ck580 FIND v(dout0_16) AT=590.05n

.meas tran vdout0_17ck580 FIND v(dout0_17) AT=590.05n

.meas tran vdout0_18ck580 FIND v(dout0_18) AT=590.05n

.meas tran vdout0_19ck580 FIND v(dout0_19) AT=590.05n

.meas tran vdout0_20ck580 FIND v(dout0_20) AT=590.05n

.meas tran vdout0_21ck580 FIND v(dout0_21) AT=590.05n

.meas tran vdout0_22ck580 FIND v(dout0_22) AT=590.05n

.meas tran vdout0_23ck580 FIND v(dout0_23) AT=590.05n

.meas tran vdout0_24ck580 FIND v(dout0_24) AT=590.05n

.meas tran vdout0_25ck580 FIND v(dout0_25) AT=590.05n

.meas tran vdout0_26ck580 FIND v(dout0_26) AT=590.05n

.meas tran vdout0_27ck580 FIND v(dout0_27) AT=590.05n

.meas tran vdout0_28ck580 FIND v(dout0_28) AT=590.05n

.meas tran vdout0_29ck580 FIND v(dout0_29) AT=590.05n

.meas tran vdout0_30ck580 FIND v(dout0_30) AT=590.05n

.meas tran vdout0_31ck580 FIND v(dout0_31) AT=590.05n

.meas tran vdout0_32ck580 FIND v(dout0_32) AT=590.05n

.meas tran vdout0_0ck600 FIND v(dout0_0) AT=610.05n

.meas tran vdout0_1ck600 FIND v(dout0_1) AT=610.05n

.meas tran vdout0_2ck600 FIND v(dout0_2) AT=610.05n

.meas tran vdout0_3ck600 FIND v(dout0_3) AT=610.05n

.meas tran vdout0_4ck600 FIND v(dout0_4) AT=610.05n

.meas tran vdout0_5ck600 FIND v(dout0_5) AT=610.05n

.meas tran vdout0_6ck600 FIND v(dout0_6) AT=610.05n

.meas tran vdout0_7ck600 FIND v(dout0_7) AT=610.05n

.meas tran vdout0_8ck600 FIND v(dout0_8) AT=610.05n

.meas tran vdout0_9ck600 FIND v(dout0_9) AT=610.05n

.meas tran vdout0_10ck600 FIND v(dout0_10) AT=610.05n

.meas tran vdout0_11ck600 FIND v(dout0_11) AT=610.05n

.meas tran vdout0_12ck600 FIND v(dout0_12) AT=610.05n

.meas tran vdout0_13ck600 FIND v(dout0_13) AT=610.05n

.meas tran vdout0_14ck600 FIND v(dout0_14) AT=610.05n

.meas tran vdout0_15ck600 FIND v(dout0_15) AT=610.05n

.meas tran vdout0_16ck600 FIND v(dout0_16) AT=610.05n

.meas tran vdout0_17ck600 FIND v(dout0_17) AT=610.05n

.meas tran vdout0_18ck600 FIND v(dout0_18) AT=610.05n

.meas tran vdout0_19ck600 FIND v(dout0_19) AT=610.05n

.meas tran vdout0_20ck600 FIND v(dout0_20) AT=610.05n

.meas tran vdout0_21ck600 FIND v(dout0_21) AT=610.05n

.meas tran vdout0_22ck600 FIND v(dout0_22) AT=610.05n

.meas tran vdout0_23ck600 FIND v(dout0_23) AT=610.05n

.meas tran vdout0_24ck600 FIND v(dout0_24) AT=610.05n

.meas tran vdout0_25ck600 FIND v(dout0_25) AT=610.05n

.meas tran vdout0_26ck600 FIND v(dout0_26) AT=610.05n

.meas tran vdout0_27ck600 FIND v(dout0_27) AT=610.05n

.meas tran vdout0_28ck600 FIND v(dout0_28) AT=610.05n

.meas tran vdout0_29ck600 FIND v(dout0_29) AT=610.05n

.meas tran vdout0_30ck600 FIND v(dout0_30) AT=610.05n

.meas tran vdout0_31ck600 FIND v(dout0_31) AT=610.05n

.meas tran vdout0_32ck600 FIND v(dout0_32) AT=610.05n

.meas tran vdout0_0ck620 FIND v(dout0_0) AT=630.05n

.meas tran vdout0_1ck620 FIND v(dout0_1) AT=630.05n

.meas tran vdout0_2ck620 FIND v(dout0_2) AT=630.05n

.meas tran vdout0_3ck620 FIND v(dout0_3) AT=630.05n

.meas tran vdout0_4ck620 FIND v(dout0_4) AT=630.05n

.meas tran vdout0_5ck620 FIND v(dout0_5) AT=630.05n

.meas tran vdout0_6ck620 FIND v(dout0_6) AT=630.05n

.meas tran vdout0_7ck620 FIND v(dout0_7) AT=630.05n

.meas tran vdout0_8ck620 FIND v(dout0_8) AT=630.05n

.meas tran vdout0_9ck620 FIND v(dout0_9) AT=630.05n

.meas tran vdout0_10ck620 FIND v(dout0_10) AT=630.05n

.meas tran vdout0_11ck620 FIND v(dout0_11) AT=630.05n

.meas tran vdout0_12ck620 FIND v(dout0_12) AT=630.05n

.meas tran vdout0_13ck620 FIND v(dout0_13) AT=630.05n

.meas tran vdout0_14ck620 FIND v(dout0_14) AT=630.05n

.meas tran vdout0_15ck620 FIND v(dout0_15) AT=630.05n

.meas tran vdout0_16ck620 FIND v(dout0_16) AT=630.05n

.meas tran vdout0_17ck620 FIND v(dout0_17) AT=630.05n

.meas tran vdout0_18ck620 FIND v(dout0_18) AT=630.05n

.meas tran vdout0_19ck620 FIND v(dout0_19) AT=630.05n

.meas tran vdout0_20ck620 FIND v(dout0_20) AT=630.05n

.meas tran vdout0_21ck620 FIND v(dout0_21) AT=630.05n

.meas tran vdout0_22ck620 FIND v(dout0_22) AT=630.05n

.meas tran vdout0_23ck620 FIND v(dout0_23) AT=630.05n

.meas tran vdout0_24ck620 FIND v(dout0_24) AT=630.05n

.meas tran vdout0_25ck620 FIND v(dout0_25) AT=630.05n

.meas tran vdout0_26ck620 FIND v(dout0_26) AT=630.05n

.meas tran vdout0_27ck620 FIND v(dout0_27) AT=630.05n

.meas tran vdout0_28ck620 FIND v(dout0_28) AT=630.05n

.meas tran vdout0_29ck620 FIND v(dout0_29) AT=630.05n

.meas tran vdout0_30ck620 FIND v(dout0_30) AT=630.05n

.meas tran vdout0_31ck620 FIND v(dout0_31) AT=630.05n

.meas tran vdout0_32ck620 FIND v(dout0_32) AT=630.05n

.meas tran vdout0_0ck630 FIND v(dout0_0) AT=640.05n

.meas tran vdout0_1ck630 FIND v(dout0_1) AT=640.05n

.meas tran vdout0_2ck630 FIND v(dout0_2) AT=640.05n

.meas tran vdout0_3ck630 FIND v(dout0_3) AT=640.05n

.meas tran vdout0_4ck630 FIND v(dout0_4) AT=640.05n

.meas tran vdout0_5ck630 FIND v(dout0_5) AT=640.05n

.meas tran vdout0_6ck630 FIND v(dout0_6) AT=640.05n

.meas tran vdout0_7ck630 FIND v(dout0_7) AT=640.05n

.meas tran vdout0_8ck630 FIND v(dout0_8) AT=640.05n

.meas tran vdout0_9ck630 FIND v(dout0_9) AT=640.05n

.meas tran vdout0_10ck630 FIND v(dout0_10) AT=640.05n

.meas tran vdout0_11ck630 FIND v(dout0_11) AT=640.05n

.meas tran vdout0_12ck630 FIND v(dout0_12) AT=640.05n

.meas tran vdout0_13ck630 FIND v(dout0_13) AT=640.05n

.meas tran vdout0_14ck630 FIND v(dout0_14) AT=640.05n

.meas tran vdout0_15ck630 FIND v(dout0_15) AT=640.05n

.meas tran vdout0_16ck630 FIND v(dout0_16) AT=640.05n

.meas tran vdout0_17ck630 FIND v(dout0_17) AT=640.05n

.meas tran vdout0_18ck630 FIND v(dout0_18) AT=640.05n

.meas tran vdout0_19ck630 FIND v(dout0_19) AT=640.05n

.meas tran vdout0_20ck630 FIND v(dout0_20) AT=640.05n

.meas tran vdout0_21ck630 FIND v(dout0_21) AT=640.05n

.meas tran vdout0_22ck630 FIND v(dout0_22) AT=640.05n

.meas tran vdout0_23ck630 FIND v(dout0_23) AT=640.05n

.meas tran vdout0_24ck630 FIND v(dout0_24) AT=640.05n

.meas tran vdout0_25ck630 FIND v(dout0_25) AT=640.05n

.meas tran vdout0_26ck630 FIND v(dout0_26) AT=640.05n

.meas tran vdout0_27ck630 FIND v(dout0_27) AT=640.05n

.meas tran vdout0_28ck630 FIND v(dout0_28) AT=640.05n

.meas tran vdout0_29ck630 FIND v(dout0_29) AT=640.05n

.meas tran vdout0_30ck630 FIND v(dout0_30) AT=640.05n

.meas tran vdout0_31ck630 FIND v(dout0_31) AT=640.05n

.meas tran vdout0_32ck630 FIND v(dout0_32) AT=640.05n

.meas tran vdout0_0ck700 FIND v(dout0_0) AT=710.05n

.meas tran vdout0_1ck700 FIND v(dout0_1) AT=710.05n

.meas tran vdout0_2ck700 FIND v(dout0_2) AT=710.05n

.meas tran vdout0_3ck700 FIND v(dout0_3) AT=710.05n

.meas tran vdout0_4ck700 FIND v(dout0_4) AT=710.05n

.meas tran vdout0_5ck700 FIND v(dout0_5) AT=710.05n

.meas tran vdout0_6ck700 FIND v(dout0_6) AT=710.05n

.meas tran vdout0_7ck700 FIND v(dout0_7) AT=710.05n

.meas tran vdout0_8ck700 FIND v(dout0_8) AT=710.05n

.meas tran vdout0_9ck700 FIND v(dout0_9) AT=710.05n

.meas tran vdout0_10ck700 FIND v(dout0_10) AT=710.05n

.meas tran vdout0_11ck700 FIND v(dout0_11) AT=710.05n

.meas tran vdout0_12ck700 FIND v(dout0_12) AT=710.05n

.meas tran vdout0_13ck700 FIND v(dout0_13) AT=710.05n

.meas tran vdout0_14ck700 FIND v(dout0_14) AT=710.05n

.meas tran vdout0_15ck700 FIND v(dout0_15) AT=710.05n

.meas tran vdout0_16ck700 FIND v(dout0_16) AT=710.05n

.meas tran vdout0_17ck700 FIND v(dout0_17) AT=710.05n

.meas tran vdout0_18ck700 FIND v(dout0_18) AT=710.05n

.meas tran vdout0_19ck700 FIND v(dout0_19) AT=710.05n

.meas tran vdout0_20ck700 FIND v(dout0_20) AT=710.05n

.meas tran vdout0_21ck700 FIND v(dout0_21) AT=710.05n

.meas tran vdout0_22ck700 FIND v(dout0_22) AT=710.05n

.meas tran vdout0_23ck700 FIND v(dout0_23) AT=710.05n

.meas tran vdout0_24ck700 FIND v(dout0_24) AT=710.05n

.meas tran vdout0_25ck700 FIND v(dout0_25) AT=710.05n

.meas tran vdout0_26ck700 FIND v(dout0_26) AT=710.05n

.meas tran vdout0_27ck700 FIND v(dout0_27) AT=710.05n

.meas tran vdout0_28ck700 FIND v(dout0_28) AT=710.05n

.meas tran vdout0_29ck700 FIND v(dout0_29) AT=710.05n

.meas tran vdout0_30ck700 FIND v(dout0_30) AT=710.05n

.meas tran vdout0_31ck700 FIND v(dout0_31) AT=710.05n

.meas tran vdout0_32ck700 FIND v(dout0_32) AT=710.05n

.meas tran vdout0_0ck760 FIND v(dout0_0) AT=770.05n

.meas tran vdout0_1ck760 FIND v(dout0_1) AT=770.05n

.meas tran vdout0_2ck760 FIND v(dout0_2) AT=770.05n

.meas tran vdout0_3ck760 FIND v(dout0_3) AT=770.05n

.meas tran vdout0_4ck760 FIND v(dout0_4) AT=770.05n

.meas tran vdout0_5ck760 FIND v(dout0_5) AT=770.05n

.meas tran vdout0_6ck760 FIND v(dout0_6) AT=770.05n

.meas tran vdout0_7ck760 FIND v(dout0_7) AT=770.05n

.meas tran vdout0_8ck760 FIND v(dout0_8) AT=770.05n

.meas tran vdout0_9ck760 FIND v(dout0_9) AT=770.05n

.meas tran vdout0_10ck760 FIND v(dout0_10) AT=770.05n

.meas tran vdout0_11ck760 FIND v(dout0_11) AT=770.05n

.meas tran vdout0_12ck760 FIND v(dout0_12) AT=770.05n

.meas tran vdout0_13ck760 FIND v(dout0_13) AT=770.05n

.meas tran vdout0_14ck760 FIND v(dout0_14) AT=770.05n

.meas tran vdout0_15ck760 FIND v(dout0_15) AT=770.05n

.meas tran vdout0_16ck760 FIND v(dout0_16) AT=770.05n

.meas tran vdout0_17ck760 FIND v(dout0_17) AT=770.05n

.meas tran vdout0_18ck760 FIND v(dout0_18) AT=770.05n

.meas tran vdout0_19ck760 FIND v(dout0_19) AT=770.05n

.meas tran vdout0_20ck760 FIND v(dout0_20) AT=770.05n

.meas tran vdout0_21ck760 FIND v(dout0_21) AT=770.05n

.meas tran vdout0_22ck760 FIND v(dout0_22) AT=770.05n

.meas tran vdout0_23ck760 FIND v(dout0_23) AT=770.05n

.meas tran vdout0_24ck760 FIND v(dout0_24) AT=770.05n

.meas tran vdout0_25ck760 FIND v(dout0_25) AT=770.05n

.meas tran vdout0_26ck760 FIND v(dout0_26) AT=770.05n

.meas tran vdout0_27ck760 FIND v(dout0_27) AT=770.05n

.meas tran vdout0_28ck760 FIND v(dout0_28) AT=770.05n

.meas tran vdout0_29ck760 FIND v(dout0_29) AT=770.05n

.meas tran vdout0_30ck760 FIND v(dout0_30) AT=770.05n

.meas tran vdout0_31ck760 FIND v(dout0_31) AT=770.05n

.meas tran vdout0_32ck760 FIND v(dout0_32) AT=770.05n

.meas tran vdout0_0ck770 FIND v(dout0_0) AT=780.05n

.meas tran vdout0_1ck770 FIND v(dout0_1) AT=780.05n

.meas tran vdout0_2ck770 FIND v(dout0_2) AT=780.05n

.meas tran vdout0_3ck770 FIND v(dout0_3) AT=780.05n

.meas tran vdout0_4ck770 FIND v(dout0_4) AT=780.05n

.meas tran vdout0_5ck770 FIND v(dout0_5) AT=780.05n

.meas tran vdout0_6ck770 FIND v(dout0_6) AT=780.05n

.meas tran vdout0_7ck770 FIND v(dout0_7) AT=780.05n

.meas tran vdout0_8ck770 FIND v(dout0_8) AT=780.05n

.meas tran vdout0_9ck770 FIND v(dout0_9) AT=780.05n

.meas tran vdout0_10ck770 FIND v(dout0_10) AT=780.05n

.meas tran vdout0_11ck770 FIND v(dout0_11) AT=780.05n

.meas tran vdout0_12ck770 FIND v(dout0_12) AT=780.05n

.meas tran vdout0_13ck770 FIND v(dout0_13) AT=780.05n

.meas tran vdout0_14ck770 FIND v(dout0_14) AT=780.05n

.meas tran vdout0_15ck770 FIND v(dout0_15) AT=780.05n

.meas tran vdout0_16ck770 FIND v(dout0_16) AT=780.05n

.meas tran vdout0_17ck770 FIND v(dout0_17) AT=780.05n

.meas tran vdout0_18ck770 FIND v(dout0_18) AT=780.05n

.meas tran vdout0_19ck770 FIND v(dout0_19) AT=780.05n

.meas tran vdout0_20ck770 FIND v(dout0_20) AT=780.05n

.meas tran vdout0_21ck770 FIND v(dout0_21) AT=780.05n

.meas tran vdout0_22ck770 FIND v(dout0_22) AT=780.05n

.meas tran vdout0_23ck770 FIND v(dout0_23) AT=780.05n

.meas tran vdout0_24ck770 FIND v(dout0_24) AT=780.05n

.meas tran vdout0_25ck770 FIND v(dout0_25) AT=780.05n

.meas tran vdout0_26ck770 FIND v(dout0_26) AT=780.05n

.meas tran vdout0_27ck770 FIND v(dout0_27) AT=780.05n

.meas tran vdout0_28ck770 FIND v(dout0_28) AT=780.05n

.meas tran vdout0_29ck770 FIND v(dout0_29) AT=780.05n

.meas tran vdout0_30ck770 FIND v(dout0_30) AT=780.05n

.meas tran vdout0_31ck770 FIND v(dout0_31) AT=780.05n

.meas tran vdout0_32ck770 FIND v(dout0_32) AT=780.05n

.meas tran vdout0_0ck780 FIND v(dout0_0) AT=790.05n

.meas tran vdout0_1ck780 FIND v(dout0_1) AT=790.05n

.meas tran vdout0_2ck780 FIND v(dout0_2) AT=790.05n

.meas tran vdout0_3ck780 FIND v(dout0_3) AT=790.05n

.meas tran vdout0_4ck780 FIND v(dout0_4) AT=790.05n

.meas tran vdout0_5ck780 FIND v(dout0_5) AT=790.05n

.meas tran vdout0_6ck780 FIND v(dout0_6) AT=790.05n

.meas tran vdout0_7ck780 FIND v(dout0_7) AT=790.05n

.meas tran vdout0_8ck780 FIND v(dout0_8) AT=790.05n

.meas tran vdout0_9ck780 FIND v(dout0_9) AT=790.05n

.meas tran vdout0_10ck780 FIND v(dout0_10) AT=790.05n

.meas tran vdout0_11ck780 FIND v(dout0_11) AT=790.05n

.meas tran vdout0_12ck780 FIND v(dout0_12) AT=790.05n

.meas tran vdout0_13ck780 FIND v(dout0_13) AT=790.05n

.meas tran vdout0_14ck780 FIND v(dout0_14) AT=790.05n

.meas tran vdout0_15ck780 FIND v(dout0_15) AT=790.05n

.meas tran vdout0_16ck780 FIND v(dout0_16) AT=790.05n

.meas tran vdout0_17ck780 FIND v(dout0_17) AT=790.05n

.meas tran vdout0_18ck780 FIND v(dout0_18) AT=790.05n

.meas tran vdout0_19ck780 FIND v(dout0_19) AT=790.05n

.meas tran vdout0_20ck780 FIND v(dout0_20) AT=790.05n

.meas tran vdout0_21ck780 FIND v(dout0_21) AT=790.05n

.meas tran vdout0_22ck780 FIND v(dout0_22) AT=790.05n

.meas tran vdout0_23ck780 FIND v(dout0_23) AT=790.05n

.meas tran vdout0_24ck780 FIND v(dout0_24) AT=790.05n

.meas tran vdout0_25ck780 FIND v(dout0_25) AT=790.05n

.meas tran vdout0_26ck780 FIND v(dout0_26) AT=790.05n

.meas tran vdout0_27ck780 FIND v(dout0_27) AT=790.05n

.meas tran vdout0_28ck780 FIND v(dout0_28) AT=790.05n

.meas tran vdout0_29ck780 FIND v(dout0_29) AT=790.05n

.meas tran vdout0_30ck780 FIND v(dout0_30) AT=790.05n

.meas tran vdout0_31ck780 FIND v(dout0_31) AT=790.05n

.meas tran vdout0_32ck780 FIND v(dout0_32) AT=790.05n

.meas tran vdout0_0ck790 FIND v(dout0_0) AT=800.05n

.meas tran vdout0_1ck790 FIND v(dout0_1) AT=800.05n

.meas tran vdout0_2ck790 FIND v(dout0_2) AT=800.05n

.meas tran vdout0_3ck790 FIND v(dout0_3) AT=800.05n

.meas tran vdout0_4ck790 FIND v(dout0_4) AT=800.05n

.meas tran vdout0_5ck790 FIND v(dout0_5) AT=800.05n

.meas tran vdout0_6ck790 FIND v(dout0_6) AT=800.05n

.meas tran vdout0_7ck790 FIND v(dout0_7) AT=800.05n

.meas tran vdout0_8ck790 FIND v(dout0_8) AT=800.05n

.meas tran vdout0_9ck790 FIND v(dout0_9) AT=800.05n

.meas tran vdout0_10ck790 FIND v(dout0_10) AT=800.05n

.meas tran vdout0_11ck790 FIND v(dout0_11) AT=800.05n

.meas tran vdout0_12ck790 FIND v(dout0_12) AT=800.05n

.meas tran vdout0_13ck790 FIND v(dout0_13) AT=800.05n

.meas tran vdout0_14ck790 FIND v(dout0_14) AT=800.05n

.meas tran vdout0_15ck790 FIND v(dout0_15) AT=800.05n

.meas tran vdout0_16ck790 FIND v(dout0_16) AT=800.05n

.meas tran vdout0_17ck790 FIND v(dout0_17) AT=800.05n

.meas tran vdout0_18ck790 FIND v(dout0_18) AT=800.05n

.meas tran vdout0_19ck790 FIND v(dout0_19) AT=800.05n

.meas tran vdout0_20ck790 FIND v(dout0_20) AT=800.05n

.meas tran vdout0_21ck790 FIND v(dout0_21) AT=800.05n

.meas tran vdout0_22ck790 FIND v(dout0_22) AT=800.05n

.meas tran vdout0_23ck790 FIND v(dout0_23) AT=800.05n

.meas tran vdout0_24ck790 FIND v(dout0_24) AT=800.05n

.meas tran vdout0_25ck790 FIND v(dout0_25) AT=800.05n

.meas tran vdout0_26ck790 FIND v(dout0_26) AT=800.05n

.meas tran vdout0_27ck790 FIND v(dout0_27) AT=800.05n

.meas tran vdout0_28ck790 FIND v(dout0_28) AT=800.05n

.meas tran vdout0_29ck790 FIND v(dout0_29) AT=800.05n

.meas tran vdout0_30ck790 FIND v(dout0_30) AT=800.05n

.meas tran vdout0_31ck790 FIND v(dout0_31) AT=800.05n

.meas tran vdout0_32ck790 FIND v(dout0_32) AT=800.05n

.meas tran vdout0_0ck810 FIND v(dout0_0) AT=820.05n

.meas tran vdout0_1ck810 FIND v(dout0_1) AT=820.05n

.meas tran vdout0_2ck810 FIND v(dout0_2) AT=820.05n

.meas tran vdout0_3ck810 FIND v(dout0_3) AT=820.05n

.meas tran vdout0_4ck810 FIND v(dout0_4) AT=820.05n

.meas tran vdout0_5ck810 FIND v(dout0_5) AT=820.05n

.meas tran vdout0_6ck810 FIND v(dout0_6) AT=820.05n

.meas tran vdout0_7ck810 FIND v(dout0_7) AT=820.05n

.meas tran vdout0_8ck810 FIND v(dout0_8) AT=820.05n

.meas tran vdout0_9ck810 FIND v(dout0_9) AT=820.05n

.meas tran vdout0_10ck810 FIND v(dout0_10) AT=820.05n

.meas tran vdout0_11ck810 FIND v(dout0_11) AT=820.05n

.meas tran vdout0_12ck810 FIND v(dout0_12) AT=820.05n

.meas tran vdout0_13ck810 FIND v(dout0_13) AT=820.05n

.meas tran vdout0_14ck810 FIND v(dout0_14) AT=820.05n

.meas tran vdout0_15ck810 FIND v(dout0_15) AT=820.05n

.meas tran vdout0_16ck810 FIND v(dout0_16) AT=820.05n

.meas tran vdout0_17ck810 FIND v(dout0_17) AT=820.05n

.meas tran vdout0_18ck810 FIND v(dout0_18) AT=820.05n

.meas tran vdout0_19ck810 FIND v(dout0_19) AT=820.05n

.meas tran vdout0_20ck810 FIND v(dout0_20) AT=820.05n

.meas tran vdout0_21ck810 FIND v(dout0_21) AT=820.05n

.meas tran vdout0_22ck810 FIND v(dout0_22) AT=820.05n

.meas tran vdout0_23ck810 FIND v(dout0_23) AT=820.05n

.meas tran vdout0_24ck810 FIND v(dout0_24) AT=820.05n

.meas tran vdout0_25ck810 FIND v(dout0_25) AT=820.05n

.meas tran vdout0_26ck810 FIND v(dout0_26) AT=820.05n

.meas tran vdout0_27ck810 FIND v(dout0_27) AT=820.05n

.meas tran vdout0_28ck810 FIND v(dout0_28) AT=820.05n

.meas tran vdout0_29ck810 FIND v(dout0_29) AT=820.05n

.meas tran vdout0_30ck810 FIND v(dout0_30) AT=820.05n

.meas tran vdout0_31ck810 FIND v(dout0_31) AT=820.05n

.meas tran vdout0_32ck810 FIND v(dout0_32) AT=820.05n

.meas tran vdout0_0ck860 FIND v(dout0_0) AT=870.05n

.meas tran vdout0_1ck860 FIND v(dout0_1) AT=870.05n

.meas tran vdout0_2ck860 FIND v(dout0_2) AT=870.05n

.meas tran vdout0_3ck860 FIND v(dout0_3) AT=870.05n

.meas tran vdout0_4ck860 FIND v(dout0_4) AT=870.05n

.meas tran vdout0_5ck860 FIND v(dout0_5) AT=870.05n

.meas tran vdout0_6ck860 FIND v(dout0_6) AT=870.05n

.meas tran vdout0_7ck860 FIND v(dout0_7) AT=870.05n

.meas tran vdout0_8ck860 FIND v(dout0_8) AT=870.05n

.meas tran vdout0_9ck860 FIND v(dout0_9) AT=870.05n

.meas tran vdout0_10ck860 FIND v(dout0_10) AT=870.05n

.meas tran vdout0_11ck860 FIND v(dout0_11) AT=870.05n

.meas tran vdout0_12ck860 FIND v(dout0_12) AT=870.05n

.meas tran vdout0_13ck860 FIND v(dout0_13) AT=870.05n

.meas tran vdout0_14ck860 FIND v(dout0_14) AT=870.05n

.meas tran vdout0_15ck860 FIND v(dout0_15) AT=870.05n

.meas tran vdout0_16ck860 FIND v(dout0_16) AT=870.05n

.meas tran vdout0_17ck860 FIND v(dout0_17) AT=870.05n

.meas tran vdout0_18ck860 FIND v(dout0_18) AT=870.05n

.meas tran vdout0_19ck860 FIND v(dout0_19) AT=870.05n

.meas tran vdout0_20ck860 FIND v(dout0_20) AT=870.05n

.meas tran vdout0_21ck860 FIND v(dout0_21) AT=870.05n

.meas tran vdout0_22ck860 FIND v(dout0_22) AT=870.05n

.meas tran vdout0_23ck860 FIND v(dout0_23) AT=870.05n

.meas tran vdout0_24ck860 FIND v(dout0_24) AT=870.05n

.meas tran vdout0_25ck860 FIND v(dout0_25) AT=870.05n

.meas tran vdout0_26ck860 FIND v(dout0_26) AT=870.05n

.meas tran vdout0_27ck860 FIND v(dout0_27) AT=870.05n

.meas tran vdout0_28ck860 FIND v(dout0_28) AT=870.05n

.meas tran vdout0_29ck860 FIND v(dout0_29) AT=870.05n

.meas tran vdout0_30ck860 FIND v(dout0_30) AT=870.05n

.meas tran vdout0_31ck860 FIND v(dout0_31) AT=870.05n

.meas tran vdout0_32ck860 FIND v(dout0_32) AT=870.05n

.meas tran vdout0_0ck880 FIND v(dout0_0) AT=890.05n

.meas tran vdout0_1ck880 FIND v(dout0_1) AT=890.05n

.meas tran vdout0_2ck880 FIND v(dout0_2) AT=890.05n

.meas tran vdout0_3ck880 FIND v(dout0_3) AT=890.05n

.meas tran vdout0_4ck880 FIND v(dout0_4) AT=890.05n

.meas tran vdout0_5ck880 FIND v(dout0_5) AT=890.05n

.meas tran vdout0_6ck880 FIND v(dout0_6) AT=890.05n

.meas tran vdout0_7ck880 FIND v(dout0_7) AT=890.05n

.meas tran vdout0_8ck880 FIND v(dout0_8) AT=890.05n

.meas tran vdout0_9ck880 FIND v(dout0_9) AT=890.05n

.meas tran vdout0_10ck880 FIND v(dout0_10) AT=890.05n

.meas tran vdout0_11ck880 FIND v(dout0_11) AT=890.05n

.meas tran vdout0_12ck880 FIND v(dout0_12) AT=890.05n

.meas tran vdout0_13ck880 FIND v(dout0_13) AT=890.05n

.meas tran vdout0_14ck880 FIND v(dout0_14) AT=890.05n

.meas tran vdout0_15ck880 FIND v(dout0_15) AT=890.05n

.meas tran vdout0_16ck880 FIND v(dout0_16) AT=890.05n

.meas tran vdout0_17ck880 FIND v(dout0_17) AT=890.05n

.meas tran vdout0_18ck880 FIND v(dout0_18) AT=890.05n

.meas tran vdout0_19ck880 FIND v(dout0_19) AT=890.05n

.meas tran vdout0_20ck880 FIND v(dout0_20) AT=890.05n

.meas tran vdout0_21ck880 FIND v(dout0_21) AT=890.05n

.meas tran vdout0_22ck880 FIND v(dout0_22) AT=890.05n

.meas tran vdout0_23ck880 FIND v(dout0_23) AT=890.05n

.meas tran vdout0_24ck880 FIND v(dout0_24) AT=890.05n

.meas tran vdout0_25ck880 FIND v(dout0_25) AT=890.05n

.meas tran vdout0_26ck880 FIND v(dout0_26) AT=890.05n

.meas tran vdout0_27ck880 FIND v(dout0_27) AT=890.05n

.meas tran vdout0_28ck880 FIND v(dout0_28) AT=890.05n

.meas tran vdout0_29ck880 FIND v(dout0_29) AT=890.05n

.meas tran vdout0_30ck880 FIND v(dout0_30) AT=890.05n

.meas tran vdout0_31ck880 FIND v(dout0_31) AT=890.05n

.meas tran vdout0_32ck880 FIND v(dout0_32) AT=890.05n

.meas tran vdout0_0ck910 FIND v(dout0_0) AT=920.05n

.meas tran vdout0_1ck910 FIND v(dout0_1) AT=920.05n

.meas tran vdout0_2ck910 FIND v(dout0_2) AT=920.05n

.meas tran vdout0_3ck910 FIND v(dout0_3) AT=920.05n

.meas tran vdout0_4ck910 FIND v(dout0_4) AT=920.05n

.meas tran vdout0_5ck910 FIND v(dout0_5) AT=920.05n

.meas tran vdout0_6ck910 FIND v(dout0_6) AT=920.05n

.meas tran vdout0_7ck910 FIND v(dout0_7) AT=920.05n

.meas tran vdout0_8ck910 FIND v(dout0_8) AT=920.05n

.meas tran vdout0_9ck910 FIND v(dout0_9) AT=920.05n

.meas tran vdout0_10ck910 FIND v(dout0_10) AT=920.05n

.meas tran vdout0_11ck910 FIND v(dout0_11) AT=920.05n

.meas tran vdout0_12ck910 FIND v(dout0_12) AT=920.05n

.meas tran vdout0_13ck910 FIND v(dout0_13) AT=920.05n

.meas tran vdout0_14ck910 FIND v(dout0_14) AT=920.05n

.meas tran vdout0_15ck910 FIND v(dout0_15) AT=920.05n

.meas tran vdout0_16ck910 FIND v(dout0_16) AT=920.05n

.meas tran vdout0_17ck910 FIND v(dout0_17) AT=920.05n

.meas tran vdout0_18ck910 FIND v(dout0_18) AT=920.05n

.meas tran vdout0_19ck910 FIND v(dout0_19) AT=920.05n

.meas tran vdout0_20ck910 FIND v(dout0_20) AT=920.05n

.meas tran vdout0_21ck910 FIND v(dout0_21) AT=920.05n

.meas tran vdout0_22ck910 FIND v(dout0_22) AT=920.05n

.meas tran vdout0_23ck910 FIND v(dout0_23) AT=920.05n

.meas tran vdout0_24ck910 FIND v(dout0_24) AT=920.05n

.meas tran vdout0_25ck910 FIND v(dout0_25) AT=920.05n

.meas tran vdout0_26ck910 FIND v(dout0_26) AT=920.05n

.meas tran vdout0_27ck910 FIND v(dout0_27) AT=920.05n

.meas tran vdout0_28ck910 FIND v(dout0_28) AT=920.05n

.meas tran vdout0_29ck910 FIND v(dout0_29) AT=920.05n

.meas tran vdout0_30ck910 FIND v(dout0_30) AT=920.05n

.meas tran vdout0_31ck910 FIND v(dout0_31) AT=920.05n

.meas tran vdout0_32ck910 FIND v(dout0_32) AT=920.05n

.meas tran vdout0_0ck920 FIND v(dout0_0) AT=930.05n

.meas tran vdout0_1ck920 FIND v(dout0_1) AT=930.05n

.meas tran vdout0_2ck920 FIND v(dout0_2) AT=930.05n

.meas tran vdout0_3ck920 FIND v(dout0_3) AT=930.05n

.meas tran vdout0_4ck920 FIND v(dout0_4) AT=930.05n

.meas tran vdout0_5ck920 FIND v(dout0_5) AT=930.05n

.meas tran vdout0_6ck920 FIND v(dout0_6) AT=930.05n

.meas tran vdout0_7ck920 FIND v(dout0_7) AT=930.05n

.meas tran vdout0_8ck920 FIND v(dout0_8) AT=930.05n

.meas tran vdout0_9ck920 FIND v(dout0_9) AT=930.05n

.meas tran vdout0_10ck920 FIND v(dout0_10) AT=930.05n

.meas tran vdout0_11ck920 FIND v(dout0_11) AT=930.05n

.meas tran vdout0_12ck920 FIND v(dout0_12) AT=930.05n

.meas tran vdout0_13ck920 FIND v(dout0_13) AT=930.05n

.meas tran vdout0_14ck920 FIND v(dout0_14) AT=930.05n

.meas tran vdout0_15ck920 FIND v(dout0_15) AT=930.05n

.meas tran vdout0_16ck920 FIND v(dout0_16) AT=930.05n

.meas tran vdout0_17ck920 FIND v(dout0_17) AT=930.05n

.meas tran vdout0_18ck920 FIND v(dout0_18) AT=930.05n

.meas tran vdout0_19ck920 FIND v(dout0_19) AT=930.05n

.meas tran vdout0_20ck920 FIND v(dout0_20) AT=930.05n

.meas tran vdout0_21ck920 FIND v(dout0_21) AT=930.05n

.meas tran vdout0_22ck920 FIND v(dout0_22) AT=930.05n

.meas tran vdout0_23ck920 FIND v(dout0_23) AT=930.05n

.meas tran vdout0_24ck920 FIND v(dout0_24) AT=930.05n

.meas tran vdout0_25ck920 FIND v(dout0_25) AT=930.05n

.meas tran vdout0_26ck920 FIND v(dout0_26) AT=930.05n

.meas tran vdout0_27ck920 FIND v(dout0_27) AT=930.05n

.meas tran vdout0_28ck920 FIND v(dout0_28) AT=930.05n

.meas tran vdout0_29ck920 FIND v(dout0_29) AT=930.05n

.meas tran vdout0_30ck920 FIND v(dout0_30) AT=930.05n

.meas tran vdout0_31ck920 FIND v(dout0_31) AT=930.05n

.meas tran vdout0_32ck920 FIND v(dout0_32) AT=930.05n

.meas tran vdout0_0ck940 FIND v(dout0_0) AT=950.05n

.meas tran vdout0_1ck940 FIND v(dout0_1) AT=950.05n

.meas tran vdout0_2ck940 FIND v(dout0_2) AT=950.05n

.meas tran vdout0_3ck940 FIND v(dout0_3) AT=950.05n

.meas tran vdout0_4ck940 FIND v(dout0_4) AT=950.05n

.meas tran vdout0_5ck940 FIND v(dout0_5) AT=950.05n

.meas tran vdout0_6ck940 FIND v(dout0_6) AT=950.05n

.meas tran vdout0_7ck940 FIND v(dout0_7) AT=950.05n

.meas tran vdout0_8ck940 FIND v(dout0_8) AT=950.05n

.meas tran vdout0_9ck940 FIND v(dout0_9) AT=950.05n

.meas tran vdout0_10ck940 FIND v(dout0_10) AT=950.05n

.meas tran vdout0_11ck940 FIND v(dout0_11) AT=950.05n

.meas tran vdout0_12ck940 FIND v(dout0_12) AT=950.05n

.meas tran vdout0_13ck940 FIND v(dout0_13) AT=950.05n

.meas tran vdout0_14ck940 FIND v(dout0_14) AT=950.05n

.meas tran vdout0_15ck940 FIND v(dout0_15) AT=950.05n

.meas tran vdout0_16ck940 FIND v(dout0_16) AT=950.05n

.meas tran vdout0_17ck940 FIND v(dout0_17) AT=950.05n

.meas tran vdout0_18ck940 FIND v(dout0_18) AT=950.05n

.meas tran vdout0_19ck940 FIND v(dout0_19) AT=950.05n

.meas tran vdout0_20ck940 FIND v(dout0_20) AT=950.05n

.meas tran vdout0_21ck940 FIND v(dout0_21) AT=950.05n

.meas tran vdout0_22ck940 FIND v(dout0_22) AT=950.05n

.meas tran vdout0_23ck940 FIND v(dout0_23) AT=950.05n

.meas tran vdout0_24ck940 FIND v(dout0_24) AT=950.05n

.meas tran vdout0_25ck940 FIND v(dout0_25) AT=950.05n

.meas tran vdout0_26ck940 FIND v(dout0_26) AT=950.05n

.meas tran vdout0_27ck940 FIND v(dout0_27) AT=950.05n

.meas tran vdout0_28ck940 FIND v(dout0_28) AT=950.05n

.meas tran vdout0_29ck940 FIND v(dout0_29) AT=950.05n

.meas tran vdout0_30ck940 FIND v(dout0_30) AT=950.05n

.meas tran vdout0_31ck940 FIND v(dout0_31) AT=950.05n

.meas tran vdout0_32ck940 FIND v(dout0_32) AT=950.05n

.meas tran vdout0_0ck970 FIND v(dout0_0) AT=980.05n

.meas tran vdout0_1ck970 FIND v(dout0_1) AT=980.05n

.meas tran vdout0_2ck970 FIND v(dout0_2) AT=980.05n

.meas tran vdout0_3ck970 FIND v(dout0_3) AT=980.05n

.meas tran vdout0_4ck970 FIND v(dout0_4) AT=980.05n

.meas tran vdout0_5ck970 FIND v(dout0_5) AT=980.05n

.meas tran vdout0_6ck970 FIND v(dout0_6) AT=980.05n

.meas tran vdout0_7ck970 FIND v(dout0_7) AT=980.05n

.meas tran vdout0_8ck970 FIND v(dout0_8) AT=980.05n

.meas tran vdout0_9ck970 FIND v(dout0_9) AT=980.05n

.meas tran vdout0_10ck970 FIND v(dout0_10) AT=980.05n

.meas tran vdout0_11ck970 FIND v(dout0_11) AT=980.05n

.meas tran vdout0_12ck970 FIND v(dout0_12) AT=980.05n

.meas tran vdout0_13ck970 FIND v(dout0_13) AT=980.05n

.meas tran vdout0_14ck970 FIND v(dout0_14) AT=980.05n

.meas tran vdout0_15ck970 FIND v(dout0_15) AT=980.05n

.meas tran vdout0_16ck970 FIND v(dout0_16) AT=980.05n

.meas tran vdout0_17ck970 FIND v(dout0_17) AT=980.05n

.meas tran vdout0_18ck970 FIND v(dout0_18) AT=980.05n

.meas tran vdout0_19ck970 FIND v(dout0_19) AT=980.05n

.meas tran vdout0_20ck970 FIND v(dout0_20) AT=980.05n

.meas tran vdout0_21ck970 FIND v(dout0_21) AT=980.05n

.meas tran vdout0_22ck970 FIND v(dout0_22) AT=980.05n

.meas tran vdout0_23ck970 FIND v(dout0_23) AT=980.05n

.meas tran vdout0_24ck970 FIND v(dout0_24) AT=980.05n

.meas tran vdout0_25ck970 FIND v(dout0_25) AT=980.05n

.meas tran vdout0_26ck970 FIND v(dout0_26) AT=980.05n

.meas tran vdout0_27ck970 FIND v(dout0_27) AT=980.05n

.meas tran vdout0_28ck970 FIND v(dout0_28) AT=980.05n

.meas tran vdout0_29ck970 FIND v(dout0_29) AT=980.05n

.meas tran vdout0_30ck970 FIND v(dout0_30) AT=980.05n

.meas tran vdout0_31ck970 FIND v(dout0_31) AT=980.05n

.meas tran vdout0_32ck970 FIND v(dout0_32) AT=980.05n

.meas tran vdout0_0ck990 FIND v(dout0_0) AT=1000.05n

.meas tran vdout0_1ck990 FIND v(dout0_1) AT=1000.05n

.meas tran vdout0_2ck990 FIND v(dout0_2) AT=1000.05n

.meas tran vdout0_3ck990 FIND v(dout0_3) AT=1000.05n

.meas tran vdout0_4ck990 FIND v(dout0_4) AT=1000.05n

.meas tran vdout0_5ck990 FIND v(dout0_5) AT=1000.05n

.meas tran vdout0_6ck990 FIND v(dout0_6) AT=1000.05n

.meas tran vdout0_7ck990 FIND v(dout0_7) AT=1000.05n

.meas tran vdout0_8ck990 FIND v(dout0_8) AT=1000.05n

.meas tran vdout0_9ck990 FIND v(dout0_9) AT=1000.05n

.meas tran vdout0_10ck990 FIND v(dout0_10) AT=1000.05n

.meas tran vdout0_11ck990 FIND v(dout0_11) AT=1000.05n

.meas tran vdout0_12ck990 FIND v(dout0_12) AT=1000.05n

.meas tran vdout0_13ck990 FIND v(dout0_13) AT=1000.05n

.meas tran vdout0_14ck990 FIND v(dout0_14) AT=1000.05n

.meas tran vdout0_15ck990 FIND v(dout0_15) AT=1000.05n

.meas tran vdout0_16ck990 FIND v(dout0_16) AT=1000.05n

.meas tran vdout0_17ck990 FIND v(dout0_17) AT=1000.05n

.meas tran vdout0_18ck990 FIND v(dout0_18) AT=1000.05n

.meas tran vdout0_19ck990 FIND v(dout0_19) AT=1000.05n

.meas tran vdout0_20ck990 FIND v(dout0_20) AT=1000.05n

.meas tran vdout0_21ck990 FIND v(dout0_21) AT=1000.05n

.meas tran vdout0_22ck990 FIND v(dout0_22) AT=1000.05n

.meas tran vdout0_23ck990 FIND v(dout0_23) AT=1000.05n

.meas tran vdout0_24ck990 FIND v(dout0_24) AT=1000.05n

.meas tran vdout0_25ck990 FIND v(dout0_25) AT=1000.05n

.meas tran vdout0_26ck990 FIND v(dout0_26) AT=1000.05n

.meas tran vdout0_27ck990 FIND v(dout0_27) AT=1000.05n

.meas tran vdout0_28ck990 FIND v(dout0_28) AT=1000.05n

.meas tran vdout0_29ck990 FIND v(dout0_29) AT=1000.05n

.meas tran vdout0_30ck990 FIND v(dout0_30) AT=1000.05n

.meas tran vdout0_31ck990 FIND v(dout0_31) AT=1000.05n

.meas tran vdout0_32ck990 FIND v(dout0_32) AT=1000.05n

.meas tran vdout0_0ck1010 FIND v(dout0_0) AT=1020.05n

.meas tran vdout0_1ck1010 FIND v(dout0_1) AT=1020.05n

.meas tran vdout0_2ck1010 FIND v(dout0_2) AT=1020.05n

.meas tran vdout0_3ck1010 FIND v(dout0_3) AT=1020.05n

.meas tran vdout0_4ck1010 FIND v(dout0_4) AT=1020.05n

.meas tran vdout0_5ck1010 FIND v(dout0_5) AT=1020.05n

.meas tran vdout0_6ck1010 FIND v(dout0_6) AT=1020.05n

.meas tran vdout0_7ck1010 FIND v(dout0_7) AT=1020.05n

.meas tran vdout0_8ck1010 FIND v(dout0_8) AT=1020.05n

.meas tran vdout0_9ck1010 FIND v(dout0_9) AT=1020.05n

.meas tran vdout0_10ck1010 FIND v(dout0_10) AT=1020.05n

.meas tran vdout0_11ck1010 FIND v(dout0_11) AT=1020.05n

.meas tran vdout0_12ck1010 FIND v(dout0_12) AT=1020.05n

.meas tran vdout0_13ck1010 FIND v(dout0_13) AT=1020.05n

.meas tran vdout0_14ck1010 FIND v(dout0_14) AT=1020.05n

.meas tran vdout0_15ck1010 FIND v(dout0_15) AT=1020.05n

.meas tran vdout0_16ck1010 FIND v(dout0_16) AT=1020.05n

.meas tran vdout0_17ck1010 FIND v(dout0_17) AT=1020.05n

.meas tran vdout0_18ck1010 FIND v(dout0_18) AT=1020.05n

.meas tran vdout0_19ck1010 FIND v(dout0_19) AT=1020.05n

.meas tran vdout0_20ck1010 FIND v(dout0_20) AT=1020.05n

.meas tran vdout0_21ck1010 FIND v(dout0_21) AT=1020.05n

.meas tran vdout0_22ck1010 FIND v(dout0_22) AT=1020.05n

.meas tran vdout0_23ck1010 FIND v(dout0_23) AT=1020.05n

.meas tran vdout0_24ck1010 FIND v(dout0_24) AT=1020.05n

.meas tran vdout0_25ck1010 FIND v(dout0_25) AT=1020.05n

.meas tran vdout0_26ck1010 FIND v(dout0_26) AT=1020.05n

.meas tran vdout0_27ck1010 FIND v(dout0_27) AT=1020.05n

.meas tran vdout0_28ck1010 FIND v(dout0_28) AT=1020.05n

.meas tran vdout0_29ck1010 FIND v(dout0_29) AT=1020.05n

.meas tran vdout0_30ck1010 FIND v(dout0_30) AT=1020.05n

.meas tran vdout0_31ck1010 FIND v(dout0_31) AT=1020.05n

.meas tran vdout0_32ck1010 FIND v(dout0_32) AT=1020.05n

.meas tran vdout0_0ck1020 FIND v(dout0_0) AT=1030.05n

.meas tran vdout0_1ck1020 FIND v(dout0_1) AT=1030.05n

.meas tran vdout0_2ck1020 FIND v(dout0_2) AT=1030.05n

.meas tran vdout0_3ck1020 FIND v(dout0_3) AT=1030.05n

.meas tran vdout0_4ck1020 FIND v(dout0_4) AT=1030.05n

.meas tran vdout0_5ck1020 FIND v(dout0_5) AT=1030.05n

.meas tran vdout0_6ck1020 FIND v(dout0_6) AT=1030.05n

.meas tran vdout0_7ck1020 FIND v(dout0_7) AT=1030.05n

.meas tran vdout0_8ck1020 FIND v(dout0_8) AT=1030.05n

.meas tran vdout0_9ck1020 FIND v(dout0_9) AT=1030.05n

.meas tran vdout0_10ck1020 FIND v(dout0_10) AT=1030.05n

.meas tran vdout0_11ck1020 FIND v(dout0_11) AT=1030.05n

.meas tran vdout0_12ck1020 FIND v(dout0_12) AT=1030.05n

.meas tran vdout0_13ck1020 FIND v(dout0_13) AT=1030.05n

.meas tran vdout0_14ck1020 FIND v(dout0_14) AT=1030.05n

.meas tran vdout0_15ck1020 FIND v(dout0_15) AT=1030.05n

.meas tran vdout0_16ck1020 FIND v(dout0_16) AT=1030.05n

.meas tran vdout0_17ck1020 FIND v(dout0_17) AT=1030.05n

.meas tran vdout0_18ck1020 FIND v(dout0_18) AT=1030.05n

.meas tran vdout0_19ck1020 FIND v(dout0_19) AT=1030.05n

.meas tran vdout0_20ck1020 FIND v(dout0_20) AT=1030.05n

.meas tran vdout0_21ck1020 FIND v(dout0_21) AT=1030.05n

.meas tran vdout0_22ck1020 FIND v(dout0_22) AT=1030.05n

.meas tran vdout0_23ck1020 FIND v(dout0_23) AT=1030.05n

.meas tran vdout0_24ck1020 FIND v(dout0_24) AT=1030.05n

.meas tran vdout0_25ck1020 FIND v(dout0_25) AT=1030.05n

.meas tran vdout0_26ck1020 FIND v(dout0_26) AT=1030.05n

.meas tran vdout0_27ck1020 FIND v(dout0_27) AT=1030.05n

.meas tran vdout0_28ck1020 FIND v(dout0_28) AT=1030.05n

.meas tran vdout0_29ck1020 FIND v(dout0_29) AT=1030.05n

.meas tran vdout0_30ck1020 FIND v(dout0_30) AT=1030.05n

.meas tran vdout0_31ck1020 FIND v(dout0_31) AT=1030.05n

.meas tran vdout0_32ck1020 FIND v(dout0_32) AT=1030.05n

.meas tran vdout0_0ck1030 FIND v(dout0_0) AT=1040.05n

.meas tran vdout0_1ck1030 FIND v(dout0_1) AT=1040.05n

.meas tran vdout0_2ck1030 FIND v(dout0_2) AT=1040.05n

.meas tran vdout0_3ck1030 FIND v(dout0_3) AT=1040.05n

.meas tran vdout0_4ck1030 FIND v(dout0_4) AT=1040.05n

.meas tran vdout0_5ck1030 FIND v(dout0_5) AT=1040.05n

.meas tran vdout0_6ck1030 FIND v(dout0_6) AT=1040.05n

.meas tran vdout0_7ck1030 FIND v(dout0_7) AT=1040.05n

.meas tran vdout0_8ck1030 FIND v(dout0_8) AT=1040.05n

.meas tran vdout0_9ck1030 FIND v(dout0_9) AT=1040.05n

.meas tran vdout0_10ck1030 FIND v(dout0_10) AT=1040.05n

.meas tran vdout0_11ck1030 FIND v(dout0_11) AT=1040.05n

.meas tran vdout0_12ck1030 FIND v(dout0_12) AT=1040.05n

.meas tran vdout0_13ck1030 FIND v(dout0_13) AT=1040.05n

.meas tran vdout0_14ck1030 FIND v(dout0_14) AT=1040.05n

.meas tran vdout0_15ck1030 FIND v(dout0_15) AT=1040.05n

.meas tran vdout0_16ck1030 FIND v(dout0_16) AT=1040.05n

.meas tran vdout0_17ck1030 FIND v(dout0_17) AT=1040.05n

.meas tran vdout0_18ck1030 FIND v(dout0_18) AT=1040.05n

.meas tran vdout0_19ck1030 FIND v(dout0_19) AT=1040.05n

.meas tran vdout0_20ck1030 FIND v(dout0_20) AT=1040.05n

.meas tran vdout0_21ck1030 FIND v(dout0_21) AT=1040.05n

.meas tran vdout0_22ck1030 FIND v(dout0_22) AT=1040.05n

.meas tran vdout0_23ck1030 FIND v(dout0_23) AT=1040.05n

.meas tran vdout0_24ck1030 FIND v(dout0_24) AT=1040.05n

.meas tran vdout0_25ck1030 FIND v(dout0_25) AT=1040.05n

.meas tran vdout0_26ck1030 FIND v(dout0_26) AT=1040.05n

.meas tran vdout0_27ck1030 FIND v(dout0_27) AT=1040.05n

.meas tran vdout0_28ck1030 FIND v(dout0_28) AT=1040.05n

.meas tran vdout0_29ck1030 FIND v(dout0_29) AT=1040.05n

.meas tran vdout0_30ck1030 FIND v(dout0_30) AT=1040.05n

.meas tran vdout0_31ck1030 FIND v(dout0_31) AT=1040.05n

.meas tran vdout0_32ck1030 FIND v(dout0_32) AT=1040.05n

.meas tran vdout0_0ck1040 FIND v(dout0_0) AT=1050.05n

.meas tran vdout0_1ck1040 FIND v(dout0_1) AT=1050.05n

.meas tran vdout0_2ck1040 FIND v(dout0_2) AT=1050.05n

.meas tran vdout0_3ck1040 FIND v(dout0_3) AT=1050.05n

.meas tran vdout0_4ck1040 FIND v(dout0_4) AT=1050.05n

.meas tran vdout0_5ck1040 FIND v(dout0_5) AT=1050.05n

.meas tran vdout0_6ck1040 FIND v(dout0_6) AT=1050.05n

.meas tran vdout0_7ck1040 FIND v(dout0_7) AT=1050.05n

.meas tran vdout0_8ck1040 FIND v(dout0_8) AT=1050.05n

.meas tran vdout0_9ck1040 FIND v(dout0_9) AT=1050.05n

.meas tran vdout0_10ck1040 FIND v(dout0_10) AT=1050.05n

.meas tran vdout0_11ck1040 FIND v(dout0_11) AT=1050.05n

.meas tran vdout0_12ck1040 FIND v(dout0_12) AT=1050.05n

.meas tran vdout0_13ck1040 FIND v(dout0_13) AT=1050.05n

.meas tran vdout0_14ck1040 FIND v(dout0_14) AT=1050.05n

.meas tran vdout0_15ck1040 FIND v(dout0_15) AT=1050.05n

.meas tran vdout0_16ck1040 FIND v(dout0_16) AT=1050.05n

.meas tran vdout0_17ck1040 FIND v(dout0_17) AT=1050.05n

.meas tran vdout0_18ck1040 FIND v(dout0_18) AT=1050.05n

.meas tran vdout0_19ck1040 FIND v(dout0_19) AT=1050.05n

.meas tran vdout0_20ck1040 FIND v(dout0_20) AT=1050.05n

.meas tran vdout0_21ck1040 FIND v(dout0_21) AT=1050.05n

.meas tran vdout0_22ck1040 FIND v(dout0_22) AT=1050.05n

.meas tran vdout0_23ck1040 FIND v(dout0_23) AT=1050.05n

.meas tran vdout0_24ck1040 FIND v(dout0_24) AT=1050.05n

.meas tran vdout0_25ck1040 FIND v(dout0_25) AT=1050.05n

.meas tran vdout0_26ck1040 FIND v(dout0_26) AT=1050.05n

.meas tran vdout0_27ck1040 FIND v(dout0_27) AT=1050.05n

.meas tran vdout0_28ck1040 FIND v(dout0_28) AT=1050.05n

.meas tran vdout0_29ck1040 FIND v(dout0_29) AT=1050.05n

.meas tran vdout0_30ck1040 FIND v(dout0_30) AT=1050.05n

.meas tran vdout0_31ck1040 FIND v(dout0_31) AT=1050.05n

.meas tran vdout0_32ck1040 FIND v(dout0_32) AT=1050.05n

.meas tran vdout0_0ck1050 FIND v(dout0_0) AT=1060.05n

.meas tran vdout0_1ck1050 FIND v(dout0_1) AT=1060.05n

.meas tran vdout0_2ck1050 FIND v(dout0_2) AT=1060.05n

.meas tran vdout0_3ck1050 FIND v(dout0_3) AT=1060.05n

.meas tran vdout0_4ck1050 FIND v(dout0_4) AT=1060.05n

.meas tran vdout0_5ck1050 FIND v(dout0_5) AT=1060.05n

.meas tran vdout0_6ck1050 FIND v(dout0_6) AT=1060.05n

.meas tran vdout0_7ck1050 FIND v(dout0_7) AT=1060.05n

.meas tran vdout0_8ck1050 FIND v(dout0_8) AT=1060.05n

.meas tran vdout0_9ck1050 FIND v(dout0_9) AT=1060.05n

.meas tran vdout0_10ck1050 FIND v(dout0_10) AT=1060.05n

.meas tran vdout0_11ck1050 FIND v(dout0_11) AT=1060.05n

.meas tran vdout0_12ck1050 FIND v(dout0_12) AT=1060.05n

.meas tran vdout0_13ck1050 FIND v(dout0_13) AT=1060.05n

.meas tran vdout0_14ck1050 FIND v(dout0_14) AT=1060.05n

.meas tran vdout0_15ck1050 FIND v(dout0_15) AT=1060.05n

.meas tran vdout0_16ck1050 FIND v(dout0_16) AT=1060.05n

.meas tran vdout0_17ck1050 FIND v(dout0_17) AT=1060.05n

.meas tran vdout0_18ck1050 FIND v(dout0_18) AT=1060.05n

.meas tran vdout0_19ck1050 FIND v(dout0_19) AT=1060.05n

.meas tran vdout0_20ck1050 FIND v(dout0_20) AT=1060.05n

.meas tran vdout0_21ck1050 FIND v(dout0_21) AT=1060.05n

.meas tran vdout0_22ck1050 FIND v(dout0_22) AT=1060.05n

.meas tran vdout0_23ck1050 FIND v(dout0_23) AT=1060.05n

.meas tran vdout0_24ck1050 FIND v(dout0_24) AT=1060.05n

.meas tran vdout0_25ck1050 FIND v(dout0_25) AT=1060.05n

.meas tran vdout0_26ck1050 FIND v(dout0_26) AT=1060.05n

.meas tran vdout0_27ck1050 FIND v(dout0_27) AT=1060.05n

.meas tran vdout0_28ck1050 FIND v(dout0_28) AT=1060.05n

.meas tran vdout0_29ck1050 FIND v(dout0_29) AT=1060.05n

.meas tran vdout0_30ck1050 FIND v(dout0_30) AT=1060.05n

.meas tran vdout0_31ck1050 FIND v(dout0_31) AT=1060.05n

.meas tran vdout0_32ck1050 FIND v(dout0_32) AT=1060.05n

.meas tran vdout0_0ck1070 FIND v(dout0_0) AT=1080.05n

.meas tran vdout0_1ck1070 FIND v(dout0_1) AT=1080.05n

.meas tran vdout0_2ck1070 FIND v(dout0_2) AT=1080.05n

.meas tran vdout0_3ck1070 FIND v(dout0_3) AT=1080.05n

.meas tran vdout0_4ck1070 FIND v(dout0_4) AT=1080.05n

.meas tran vdout0_5ck1070 FIND v(dout0_5) AT=1080.05n

.meas tran vdout0_6ck1070 FIND v(dout0_6) AT=1080.05n

.meas tran vdout0_7ck1070 FIND v(dout0_7) AT=1080.05n

.meas tran vdout0_8ck1070 FIND v(dout0_8) AT=1080.05n

.meas tran vdout0_9ck1070 FIND v(dout0_9) AT=1080.05n

.meas tran vdout0_10ck1070 FIND v(dout0_10) AT=1080.05n

.meas tran vdout0_11ck1070 FIND v(dout0_11) AT=1080.05n

.meas tran vdout0_12ck1070 FIND v(dout0_12) AT=1080.05n

.meas tran vdout0_13ck1070 FIND v(dout0_13) AT=1080.05n

.meas tran vdout0_14ck1070 FIND v(dout0_14) AT=1080.05n

.meas tran vdout0_15ck1070 FIND v(dout0_15) AT=1080.05n

.meas tran vdout0_16ck1070 FIND v(dout0_16) AT=1080.05n

.meas tran vdout0_17ck1070 FIND v(dout0_17) AT=1080.05n

.meas tran vdout0_18ck1070 FIND v(dout0_18) AT=1080.05n

.meas tran vdout0_19ck1070 FIND v(dout0_19) AT=1080.05n

.meas tran vdout0_20ck1070 FIND v(dout0_20) AT=1080.05n

.meas tran vdout0_21ck1070 FIND v(dout0_21) AT=1080.05n

.meas tran vdout0_22ck1070 FIND v(dout0_22) AT=1080.05n

.meas tran vdout0_23ck1070 FIND v(dout0_23) AT=1080.05n

.meas tran vdout0_24ck1070 FIND v(dout0_24) AT=1080.05n

.meas tran vdout0_25ck1070 FIND v(dout0_25) AT=1080.05n

.meas tran vdout0_26ck1070 FIND v(dout0_26) AT=1080.05n

.meas tran vdout0_27ck1070 FIND v(dout0_27) AT=1080.05n

.meas tran vdout0_28ck1070 FIND v(dout0_28) AT=1080.05n

.meas tran vdout0_29ck1070 FIND v(dout0_29) AT=1080.05n

.meas tran vdout0_30ck1070 FIND v(dout0_30) AT=1080.05n

.meas tran vdout0_31ck1070 FIND v(dout0_31) AT=1080.05n

.meas tran vdout0_32ck1070 FIND v(dout0_32) AT=1080.05n

.meas tran vdout0_0ck1090 FIND v(dout0_0) AT=1100.05n

.meas tran vdout0_1ck1090 FIND v(dout0_1) AT=1100.05n

.meas tran vdout0_2ck1090 FIND v(dout0_2) AT=1100.05n

.meas tran vdout0_3ck1090 FIND v(dout0_3) AT=1100.05n

.meas tran vdout0_4ck1090 FIND v(dout0_4) AT=1100.05n

.meas tran vdout0_5ck1090 FIND v(dout0_5) AT=1100.05n

.meas tran vdout0_6ck1090 FIND v(dout0_6) AT=1100.05n

.meas tran vdout0_7ck1090 FIND v(dout0_7) AT=1100.05n

.meas tran vdout0_8ck1090 FIND v(dout0_8) AT=1100.05n

.meas tran vdout0_9ck1090 FIND v(dout0_9) AT=1100.05n

.meas tran vdout0_10ck1090 FIND v(dout0_10) AT=1100.05n

.meas tran vdout0_11ck1090 FIND v(dout0_11) AT=1100.05n

.meas tran vdout0_12ck1090 FIND v(dout0_12) AT=1100.05n

.meas tran vdout0_13ck1090 FIND v(dout0_13) AT=1100.05n

.meas tran vdout0_14ck1090 FIND v(dout0_14) AT=1100.05n

.meas tran vdout0_15ck1090 FIND v(dout0_15) AT=1100.05n

.meas tran vdout0_16ck1090 FIND v(dout0_16) AT=1100.05n

.meas tran vdout0_17ck1090 FIND v(dout0_17) AT=1100.05n

.meas tran vdout0_18ck1090 FIND v(dout0_18) AT=1100.05n

.meas tran vdout0_19ck1090 FIND v(dout0_19) AT=1100.05n

.meas tran vdout0_20ck1090 FIND v(dout0_20) AT=1100.05n

.meas tran vdout0_21ck1090 FIND v(dout0_21) AT=1100.05n

.meas tran vdout0_22ck1090 FIND v(dout0_22) AT=1100.05n

.meas tran vdout0_23ck1090 FIND v(dout0_23) AT=1100.05n

.meas tran vdout0_24ck1090 FIND v(dout0_24) AT=1100.05n

.meas tran vdout0_25ck1090 FIND v(dout0_25) AT=1100.05n

.meas tran vdout0_26ck1090 FIND v(dout0_26) AT=1100.05n

.meas tran vdout0_27ck1090 FIND v(dout0_27) AT=1100.05n

.meas tran vdout0_28ck1090 FIND v(dout0_28) AT=1100.05n

.meas tran vdout0_29ck1090 FIND v(dout0_29) AT=1100.05n

.meas tran vdout0_30ck1090 FIND v(dout0_30) AT=1100.05n

.meas tran vdout0_31ck1090 FIND v(dout0_31) AT=1100.05n

.meas tran vdout0_32ck1090 FIND v(dout0_32) AT=1100.05n

.meas tran vdout0_0ck1110 FIND v(dout0_0) AT=1120.05n

.meas tran vdout0_1ck1110 FIND v(dout0_1) AT=1120.05n

.meas tran vdout0_2ck1110 FIND v(dout0_2) AT=1120.05n

.meas tran vdout0_3ck1110 FIND v(dout0_3) AT=1120.05n

.meas tran vdout0_4ck1110 FIND v(dout0_4) AT=1120.05n

.meas tran vdout0_5ck1110 FIND v(dout0_5) AT=1120.05n

.meas tran vdout0_6ck1110 FIND v(dout0_6) AT=1120.05n

.meas tran vdout0_7ck1110 FIND v(dout0_7) AT=1120.05n

.meas tran vdout0_8ck1110 FIND v(dout0_8) AT=1120.05n

.meas tran vdout0_9ck1110 FIND v(dout0_9) AT=1120.05n

.meas tran vdout0_10ck1110 FIND v(dout0_10) AT=1120.05n

.meas tran vdout0_11ck1110 FIND v(dout0_11) AT=1120.05n

.meas tran vdout0_12ck1110 FIND v(dout0_12) AT=1120.05n

.meas tran vdout0_13ck1110 FIND v(dout0_13) AT=1120.05n

.meas tran vdout0_14ck1110 FIND v(dout0_14) AT=1120.05n

.meas tran vdout0_15ck1110 FIND v(dout0_15) AT=1120.05n

.meas tran vdout0_16ck1110 FIND v(dout0_16) AT=1120.05n

.meas tran vdout0_17ck1110 FIND v(dout0_17) AT=1120.05n

.meas tran vdout0_18ck1110 FIND v(dout0_18) AT=1120.05n

.meas tran vdout0_19ck1110 FIND v(dout0_19) AT=1120.05n

.meas tran vdout0_20ck1110 FIND v(dout0_20) AT=1120.05n

.meas tran vdout0_21ck1110 FIND v(dout0_21) AT=1120.05n

.meas tran vdout0_22ck1110 FIND v(dout0_22) AT=1120.05n

.meas tran vdout0_23ck1110 FIND v(dout0_23) AT=1120.05n

.meas tran vdout0_24ck1110 FIND v(dout0_24) AT=1120.05n

.meas tran vdout0_25ck1110 FIND v(dout0_25) AT=1120.05n

.meas tran vdout0_26ck1110 FIND v(dout0_26) AT=1120.05n

.meas tran vdout0_27ck1110 FIND v(dout0_27) AT=1120.05n

.meas tran vdout0_28ck1110 FIND v(dout0_28) AT=1120.05n

.meas tran vdout0_29ck1110 FIND v(dout0_29) AT=1120.05n

.meas tran vdout0_30ck1110 FIND v(dout0_30) AT=1120.05n

.meas tran vdout0_31ck1110 FIND v(dout0_31) AT=1120.05n

.meas tran vdout0_32ck1110 FIND v(dout0_32) AT=1120.05n

.meas tran vdout0_0ck1140 FIND v(dout0_0) AT=1150.05n

.meas tran vdout0_1ck1140 FIND v(dout0_1) AT=1150.05n

.meas tran vdout0_2ck1140 FIND v(dout0_2) AT=1150.05n

.meas tran vdout0_3ck1140 FIND v(dout0_3) AT=1150.05n

.meas tran vdout0_4ck1140 FIND v(dout0_4) AT=1150.05n

.meas tran vdout0_5ck1140 FIND v(dout0_5) AT=1150.05n

.meas tran vdout0_6ck1140 FIND v(dout0_6) AT=1150.05n

.meas tran vdout0_7ck1140 FIND v(dout0_7) AT=1150.05n

.meas tran vdout0_8ck1140 FIND v(dout0_8) AT=1150.05n

.meas tran vdout0_9ck1140 FIND v(dout0_9) AT=1150.05n

.meas tran vdout0_10ck1140 FIND v(dout0_10) AT=1150.05n

.meas tran vdout0_11ck1140 FIND v(dout0_11) AT=1150.05n

.meas tran vdout0_12ck1140 FIND v(dout0_12) AT=1150.05n

.meas tran vdout0_13ck1140 FIND v(dout0_13) AT=1150.05n

.meas tran vdout0_14ck1140 FIND v(dout0_14) AT=1150.05n

.meas tran vdout0_15ck1140 FIND v(dout0_15) AT=1150.05n

.meas tran vdout0_16ck1140 FIND v(dout0_16) AT=1150.05n

.meas tran vdout0_17ck1140 FIND v(dout0_17) AT=1150.05n

.meas tran vdout0_18ck1140 FIND v(dout0_18) AT=1150.05n

.meas tran vdout0_19ck1140 FIND v(dout0_19) AT=1150.05n

.meas tran vdout0_20ck1140 FIND v(dout0_20) AT=1150.05n

.meas tran vdout0_21ck1140 FIND v(dout0_21) AT=1150.05n

.meas tran vdout0_22ck1140 FIND v(dout0_22) AT=1150.05n

.meas tran vdout0_23ck1140 FIND v(dout0_23) AT=1150.05n

.meas tran vdout0_24ck1140 FIND v(dout0_24) AT=1150.05n

.meas tran vdout0_25ck1140 FIND v(dout0_25) AT=1150.05n

.meas tran vdout0_26ck1140 FIND v(dout0_26) AT=1150.05n

.meas tran vdout0_27ck1140 FIND v(dout0_27) AT=1150.05n

.meas tran vdout0_28ck1140 FIND v(dout0_28) AT=1150.05n

.meas tran vdout0_29ck1140 FIND v(dout0_29) AT=1150.05n

.meas tran vdout0_30ck1140 FIND v(dout0_30) AT=1150.05n

.meas tran vdout0_31ck1140 FIND v(dout0_31) AT=1150.05n

.meas tran vdout0_32ck1140 FIND v(dout0_32) AT=1150.05n

.meas tran vdout0_0ck1170 FIND v(dout0_0) AT=1180.05n

.meas tran vdout0_1ck1170 FIND v(dout0_1) AT=1180.05n

.meas tran vdout0_2ck1170 FIND v(dout0_2) AT=1180.05n

.meas tran vdout0_3ck1170 FIND v(dout0_3) AT=1180.05n

.meas tran vdout0_4ck1170 FIND v(dout0_4) AT=1180.05n

.meas tran vdout0_5ck1170 FIND v(dout0_5) AT=1180.05n

.meas tran vdout0_6ck1170 FIND v(dout0_6) AT=1180.05n

.meas tran vdout0_7ck1170 FIND v(dout0_7) AT=1180.05n

.meas tran vdout0_8ck1170 FIND v(dout0_8) AT=1180.05n

.meas tran vdout0_9ck1170 FIND v(dout0_9) AT=1180.05n

.meas tran vdout0_10ck1170 FIND v(dout0_10) AT=1180.05n

.meas tran vdout0_11ck1170 FIND v(dout0_11) AT=1180.05n

.meas tran vdout0_12ck1170 FIND v(dout0_12) AT=1180.05n

.meas tran vdout0_13ck1170 FIND v(dout0_13) AT=1180.05n

.meas tran vdout0_14ck1170 FIND v(dout0_14) AT=1180.05n

.meas tran vdout0_15ck1170 FIND v(dout0_15) AT=1180.05n

.meas tran vdout0_16ck1170 FIND v(dout0_16) AT=1180.05n

.meas tran vdout0_17ck1170 FIND v(dout0_17) AT=1180.05n

.meas tran vdout0_18ck1170 FIND v(dout0_18) AT=1180.05n

.meas tran vdout0_19ck1170 FIND v(dout0_19) AT=1180.05n

.meas tran vdout0_20ck1170 FIND v(dout0_20) AT=1180.05n

.meas tran vdout0_21ck1170 FIND v(dout0_21) AT=1180.05n

.meas tran vdout0_22ck1170 FIND v(dout0_22) AT=1180.05n

.meas tran vdout0_23ck1170 FIND v(dout0_23) AT=1180.05n

.meas tran vdout0_24ck1170 FIND v(dout0_24) AT=1180.05n

.meas tran vdout0_25ck1170 FIND v(dout0_25) AT=1180.05n

.meas tran vdout0_26ck1170 FIND v(dout0_26) AT=1180.05n

.meas tran vdout0_27ck1170 FIND v(dout0_27) AT=1180.05n

.meas tran vdout0_28ck1170 FIND v(dout0_28) AT=1180.05n

.meas tran vdout0_29ck1170 FIND v(dout0_29) AT=1180.05n

.meas tran vdout0_30ck1170 FIND v(dout0_30) AT=1180.05n

.meas tran vdout0_31ck1170 FIND v(dout0_31) AT=1180.05n

.meas tran vdout0_32ck1170 FIND v(dout0_32) AT=1180.05n

.meas tran vdout0_0ck1200 FIND v(dout0_0) AT=1210.05n

.meas tran vdout0_1ck1200 FIND v(dout0_1) AT=1210.05n

.meas tran vdout0_2ck1200 FIND v(dout0_2) AT=1210.05n

.meas tran vdout0_3ck1200 FIND v(dout0_3) AT=1210.05n

.meas tran vdout0_4ck1200 FIND v(dout0_4) AT=1210.05n

.meas tran vdout0_5ck1200 FIND v(dout0_5) AT=1210.05n

.meas tran vdout0_6ck1200 FIND v(dout0_6) AT=1210.05n

.meas tran vdout0_7ck1200 FIND v(dout0_7) AT=1210.05n

.meas tran vdout0_8ck1200 FIND v(dout0_8) AT=1210.05n

.meas tran vdout0_9ck1200 FIND v(dout0_9) AT=1210.05n

.meas tran vdout0_10ck1200 FIND v(dout0_10) AT=1210.05n

.meas tran vdout0_11ck1200 FIND v(dout0_11) AT=1210.05n

.meas tran vdout0_12ck1200 FIND v(dout0_12) AT=1210.05n

.meas tran vdout0_13ck1200 FIND v(dout0_13) AT=1210.05n

.meas tran vdout0_14ck1200 FIND v(dout0_14) AT=1210.05n

.meas tran vdout0_15ck1200 FIND v(dout0_15) AT=1210.05n

.meas tran vdout0_16ck1200 FIND v(dout0_16) AT=1210.05n

.meas tran vdout0_17ck1200 FIND v(dout0_17) AT=1210.05n

.meas tran vdout0_18ck1200 FIND v(dout0_18) AT=1210.05n

.meas tran vdout0_19ck1200 FIND v(dout0_19) AT=1210.05n

.meas tran vdout0_20ck1200 FIND v(dout0_20) AT=1210.05n

.meas tran vdout0_21ck1200 FIND v(dout0_21) AT=1210.05n

.meas tran vdout0_22ck1200 FIND v(dout0_22) AT=1210.05n

.meas tran vdout0_23ck1200 FIND v(dout0_23) AT=1210.05n

.meas tran vdout0_24ck1200 FIND v(dout0_24) AT=1210.05n

.meas tran vdout0_25ck1200 FIND v(dout0_25) AT=1210.05n

.meas tran vdout0_26ck1200 FIND v(dout0_26) AT=1210.05n

.meas tran vdout0_27ck1200 FIND v(dout0_27) AT=1210.05n

.meas tran vdout0_28ck1200 FIND v(dout0_28) AT=1210.05n

.meas tran vdout0_29ck1200 FIND v(dout0_29) AT=1210.05n

.meas tran vdout0_30ck1200 FIND v(dout0_30) AT=1210.05n

.meas tran vdout0_31ck1200 FIND v(dout0_31) AT=1210.05n

.meas tran vdout0_32ck1200 FIND v(dout0_32) AT=1210.05n

.meas tran vdout0_0ck1210 FIND v(dout0_0) AT=1220.05n

.meas tran vdout0_1ck1210 FIND v(dout0_1) AT=1220.05n

.meas tran vdout0_2ck1210 FIND v(dout0_2) AT=1220.05n

.meas tran vdout0_3ck1210 FIND v(dout0_3) AT=1220.05n

.meas tran vdout0_4ck1210 FIND v(dout0_4) AT=1220.05n

.meas tran vdout0_5ck1210 FIND v(dout0_5) AT=1220.05n

.meas tran vdout0_6ck1210 FIND v(dout0_6) AT=1220.05n

.meas tran vdout0_7ck1210 FIND v(dout0_7) AT=1220.05n

.meas tran vdout0_8ck1210 FIND v(dout0_8) AT=1220.05n

.meas tran vdout0_9ck1210 FIND v(dout0_9) AT=1220.05n

.meas tran vdout0_10ck1210 FIND v(dout0_10) AT=1220.05n

.meas tran vdout0_11ck1210 FIND v(dout0_11) AT=1220.05n

.meas tran vdout0_12ck1210 FIND v(dout0_12) AT=1220.05n

.meas tran vdout0_13ck1210 FIND v(dout0_13) AT=1220.05n

.meas tran vdout0_14ck1210 FIND v(dout0_14) AT=1220.05n

.meas tran vdout0_15ck1210 FIND v(dout0_15) AT=1220.05n

.meas tran vdout0_16ck1210 FIND v(dout0_16) AT=1220.05n

.meas tran vdout0_17ck1210 FIND v(dout0_17) AT=1220.05n

.meas tran vdout0_18ck1210 FIND v(dout0_18) AT=1220.05n

.meas tran vdout0_19ck1210 FIND v(dout0_19) AT=1220.05n

.meas tran vdout0_20ck1210 FIND v(dout0_20) AT=1220.05n

.meas tran vdout0_21ck1210 FIND v(dout0_21) AT=1220.05n

.meas tran vdout0_22ck1210 FIND v(dout0_22) AT=1220.05n

.meas tran vdout0_23ck1210 FIND v(dout0_23) AT=1220.05n

.meas tran vdout0_24ck1210 FIND v(dout0_24) AT=1220.05n

.meas tran vdout0_25ck1210 FIND v(dout0_25) AT=1220.05n

.meas tran vdout0_26ck1210 FIND v(dout0_26) AT=1220.05n

.meas tran vdout0_27ck1210 FIND v(dout0_27) AT=1220.05n

.meas tran vdout0_28ck1210 FIND v(dout0_28) AT=1220.05n

.meas tran vdout0_29ck1210 FIND v(dout0_29) AT=1220.05n

.meas tran vdout0_30ck1210 FIND v(dout0_30) AT=1220.05n

.meas tran vdout0_31ck1210 FIND v(dout0_31) AT=1220.05n

.meas tran vdout0_32ck1210 FIND v(dout0_32) AT=1220.05n

.meas tran vdout0_0ck1410 FIND v(dout0_0) AT=1420.05n

.meas tran vdout0_1ck1410 FIND v(dout0_1) AT=1420.05n

.meas tran vdout0_2ck1410 FIND v(dout0_2) AT=1420.05n

.meas tran vdout0_3ck1410 FIND v(dout0_3) AT=1420.05n

.meas tran vdout0_4ck1410 FIND v(dout0_4) AT=1420.05n

.meas tran vdout0_5ck1410 FIND v(dout0_5) AT=1420.05n

.meas tran vdout0_6ck1410 FIND v(dout0_6) AT=1420.05n

.meas tran vdout0_7ck1410 FIND v(dout0_7) AT=1420.05n

.meas tran vdout0_8ck1410 FIND v(dout0_8) AT=1420.05n

.meas tran vdout0_9ck1410 FIND v(dout0_9) AT=1420.05n

.meas tran vdout0_10ck1410 FIND v(dout0_10) AT=1420.05n

.meas tran vdout0_11ck1410 FIND v(dout0_11) AT=1420.05n

.meas tran vdout0_12ck1410 FIND v(dout0_12) AT=1420.05n

.meas tran vdout0_13ck1410 FIND v(dout0_13) AT=1420.05n

.meas tran vdout0_14ck1410 FIND v(dout0_14) AT=1420.05n

.meas tran vdout0_15ck1410 FIND v(dout0_15) AT=1420.05n

.meas tran vdout0_16ck1410 FIND v(dout0_16) AT=1420.05n

.meas tran vdout0_17ck1410 FIND v(dout0_17) AT=1420.05n

.meas tran vdout0_18ck1410 FIND v(dout0_18) AT=1420.05n

.meas tran vdout0_19ck1410 FIND v(dout0_19) AT=1420.05n

.meas tran vdout0_20ck1410 FIND v(dout0_20) AT=1420.05n

.meas tran vdout0_21ck1410 FIND v(dout0_21) AT=1420.05n

.meas tran vdout0_22ck1410 FIND v(dout0_22) AT=1420.05n

.meas tran vdout0_23ck1410 FIND v(dout0_23) AT=1420.05n

.meas tran vdout0_24ck1410 FIND v(dout0_24) AT=1420.05n

.meas tran vdout0_25ck1410 FIND v(dout0_25) AT=1420.05n

.meas tran vdout0_26ck1410 FIND v(dout0_26) AT=1420.05n

.meas tran vdout0_27ck1410 FIND v(dout0_27) AT=1420.05n

.meas tran vdout0_28ck1410 FIND v(dout0_28) AT=1420.05n

.meas tran vdout0_29ck1410 FIND v(dout0_29) AT=1420.05n

.meas tran vdout0_30ck1410 FIND v(dout0_30) AT=1420.05n

.meas tran vdout0_31ck1410 FIND v(dout0_31) AT=1420.05n

.meas tran vdout0_32ck1410 FIND v(dout0_32) AT=1420.05n

.meas tran vdout0_0ck1430 FIND v(dout0_0) AT=1440.05n

.meas tran vdout0_1ck1430 FIND v(dout0_1) AT=1440.05n

.meas tran vdout0_2ck1430 FIND v(dout0_2) AT=1440.05n

.meas tran vdout0_3ck1430 FIND v(dout0_3) AT=1440.05n

.meas tran vdout0_4ck1430 FIND v(dout0_4) AT=1440.05n

.meas tran vdout0_5ck1430 FIND v(dout0_5) AT=1440.05n

.meas tran vdout0_6ck1430 FIND v(dout0_6) AT=1440.05n

.meas tran vdout0_7ck1430 FIND v(dout0_7) AT=1440.05n

.meas tran vdout0_8ck1430 FIND v(dout0_8) AT=1440.05n

.meas tran vdout0_9ck1430 FIND v(dout0_9) AT=1440.05n

.meas tran vdout0_10ck1430 FIND v(dout0_10) AT=1440.05n

.meas tran vdout0_11ck1430 FIND v(dout0_11) AT=1440.05n

.meas tran vdout0_12ck1430 FIND v(dout0_12) AT=1440.05n

.meas tran vdout0_13ck1430 FIND v(dout0_13) AT=1440.05n

.meas tran vdout0_14ck1430 FIND v(dout0_14) AT=1440.05n

.meas tran vdout0_15ck1430 FIND v(dout0_15) AT=1440.05n

.meas tran vdout0_16ck1430 FIND v(dout0_16) AT=1440.05n

.meas tran vdout0_17ck1430 FIND v(dout0_17) AT=1440.05n

.meas tran vdout0_18ck1430 FIND v(dout0_18) AT=1440.05n

.meas tran vdout0_19ck1430 FIND v(dout0_19) AT=1440.05n

.meas tran vdout0_20ck1430 FIND v(dout0_20) AT=1440.05n

.meas tran vdout0_21ck1430 FIND v(dout0_21) AT=1440.05n

.meas tran vdout0_22ck1430 FIND v(dout0_22) AT=1440.05n

.meas tran vdout0_23ck1430 FIND v(dout0_23) AT=1440.05n

.meas tran vdout0_24ck1430 FIND v(dout0_24) AT=1440.05n

.meas tran vdout0_25ck1430 FIND v(dout0_25) AT=1440.05n

.meas tran vdout0_26ck1430 FIND v(dout0_26) AT=1440.05n

.meas tran vdout0_27ck1430 FIND v(dout0_27) AT=1440.05n

.meas tran vdout0_28ck1430 FIND v(dout0_28) AT=1440.05n

.meas tran vdout0_29ck1430 FIND v(dout0_29) AT=1440.05n

.meas tran vdout0_30ck1430 FIND v(dout0_30) AT=1440.05n

.meas tran vdout0_31ck1430 FIND v(dout0_31) AT=1440.05n

.meas tran vdout0_32ck1430 FIND v(dout0_32) AT=1440.05n

.meas tran vdout0_0ck1440 FIND v(dout0_0) AT=1450.05n

.meas tran vdout0_1ck1440 FIND v(dout0_1) AT=1450.05n

.meas tran vdout0_2ck1440 FIND v(dout0_2) AT=1450.05n

.meas tran vdout0_3ck1440 FIND v(dout0_3) AT=1450.05n

.meas tran vdout0_4ck1440 FIND v(dout0_4) AT=1450.05n

.meas tran vdout0_5ck1440 FIND v(dout0_5) AT=1450.05n

.meas tran vdout0_6ck1440 FIND v(dout0_6) AT=1450.05n

.meas tran vdout0_7ck1440 FIND v(dout0_7) AT=1450.05n

.meas tran vdout0_8ck1440 FIND v(dout0_8) AT=1450.05n

.meas tran vdout0_9ck1440 FIND v(dout0_9) AT=1450.05n

.meas tran vdout0_10ck1440 FIND v(dout0_10) AT=1450.05n

.meas tran vdout0_11ck1440 FIND v(dout0_11) AT=1450.05n

.meas tran vdout0_12ck1440 FIND v(dout0_12) AT=1450.05n

.meas tran vdout0_13ck1440 FIND v(dout0_13) AT=1450.05n

.meas tran vdout0_14ck1440 FIND v(dout0_14) AT=1450.05n

.meas tran vdout0_15ck1440 FIND v(dout0_15) AT=1450.05n

.meas tran vdout0_16ck1440 FIND v(dout0_16) AT=1450.05n

.meas tran vdout0_17ck1440 FIND v(dout0_17) AT=1450.05n

.meas tran vdout0_18ck1440 FIND v(dout0_18) AT=1450.05n

.meas tran vdout0_19ck1440 FIND v(dout0_19) AT=1450.05n

.meas tran vdout0_20ck1440 FIND v(dout0_20) AT=1450.05n

.meas tran vdout0_21ck1440 FIND v(dout0_21) AT=1450.05n

.meas tran vdout0_22ck1440 FIND v(dout0_22) AT=1450.05n

.meas tran vdout0_23ck1440 FIND v(dout0_23) AT=1450.05n

.meas tran vdout0_24ck1440 FIND v(dout0_24) AT=1450.05n

.meas tran vdout0_25ck1440 FIND v(dout0_25) AT=1450.05n

.meas tran vdout0_26ck1440 FIND v(dout0_26) AT=1450.05n

.meas tran vdout0_27ck1440 FIND v(dout0_27) AT=1450.05n

.meas tran vdout0_28ck1440 FIND v(dout0_28) AT=1450.05n

.meas tran vdout0_29ck1440 FIND v(dout0_29) AT=1450.05n

.meas tran vdout0_30ck1440 FIND v(dout0_30) AT=1450.05n

.meas tran vdout0_31ck1440 FIND v(dout0_31) AT=1450.05n

.meas tran vdout0_32ck1440 FIND v(dout0_32) AT=1450.05n

.meas tran vdout0_0ck1460 FIND v(dout0_0) AT=1470.05n

.meas tran vdout0_1ck1460 FIND v(dout0_1) AT=1470.05n

.meas tran vdout0_2ck1460 FIND v(dout0_2) AT=1470.05n

.meas tran vdout0_3ck1460 FIND v(dout0_3) AT=1470.05n

.meas tran vdout0_4ck1460 FIND v(dout0_4) AT=1470.05n

.meas tran vdout0_5ck1460 FIND v(dout0_5) AT=1470.05n

.meas tran vdout0_6ck1460 FIND v(dout0_6) AT=1470.05n

.meas tran vdout0_7ck1460 FIND v(dout0_7) AT=1470.05n

.meas tran vdout0_8ck1460 FIND v(dout0_8) AT=1470.05n

.meas tran vdout0_9ck1460 FIND v(dout0_9) AT=1470.05n

.meas tran vdout0_10ck1460 FIND v(dout0_10) AT=1470.05n

.meas tran vdout0_11ck1460 FIND v(dout0_11) AT=1470.05n

.meas tran vdout0_12ck1460 FIND v(dout0_12) AT=1470.05n

.meas tran vdout0_13ck1460 FIND v(dout0_13) AT=1470.05n

.meas tran vdout0_14ck1460 FIND v(dout0_14) AT=1470.05n

.meas tran vdout0_15ck1460 FIND v(dout0_15) AT=1470.05n

.meas tran vdout0_16ck1460 FIND v(dout0_16) AT=1470.05n

.meas tran vdout0_17ck1460 FIND v(dout0_17) AT=1470.05n

.meas tran vdout0_18ck1460 FIND v(dout0_18) AT=1470.05n

.meas tran vdout0_19ck1460 FIND v(dout0_19) AT=1470.05n

.meas tran vdout0_20ck1460 FIND v(dout0_20) AT=1470.05n

.meas tran vdout0_21ck1460 FIND v(dout0_21) AT=1470.05n

.meas tran vdout0_22ck1460 FIND v(dout0_22) AT=1470.05n

.meas tran vdout0_23ck1460 FIND v(dout0_23) AT=1470.05n

.meas tran vdout0_24ck1460 FIND v(dout0_24) AT=1470.05n

.meas tran vdout0_25ck1460 FIND v(dout0_25) AT=1470.05n

.meas tran vdout0_26ck1460 FIND v(dout0_26) AT=1470.05n

.meas tran vdout0_27ck1460 FIND v(dout0_27) AT=1470.05n

.meas tran vdout0_28ck1460 FIND v(dout0_28) AT=1470.05n

.meas tran vdout0_29ck1460 FIND v(dout0_29) AT=1470.05n

.meas tran vdout0_30ck1460 FIND v(dout0_30) AT=1470.05n

.meas tran vdout0_31ck1460 FIND v(dout0_31) AT=1470.05n

.meas tran vdout0_32ck1460 FIND v(dout0_32) AT=1470.05n

.meas tran vdout0_0ck1570 FIND v(dout0_0) AT=1580.05n

.meas tran vdout0_1ck1570 FIND v(dout0_1) AT=1580.05n

.meas tran vdout0_2ck1570 FIND v(dout0_2) AT=1580.05n

.meas tran vdout0_3ck1570 FIND v(dout0_3) AT=1580.05n

.meas tran vdout0_4ck1570 FIND v(dout0_4) AT=1580.05n

.meas tran vdout0_5ck1570 FIND v(dout0_5) AT=1580.05n

.meas tran vdout0_6ck1570 FIND v(dout0_6) AT=1580.05n

.meas tran vdout0_7ck1570 FIND v(dout0_7) AT=1580.05n

.meas tran vdout0_8ck1570 FIND v(dout0_8) AT=1580.05n

.meas tran vdout0_9ck1570 FIND v(dout0_9) AT=1580.05n

.meas tran vdout0_10ck1570 FIND v(dout0_10) AT=1580.05n

.meas tran vdout0_11ck1570 FIND v(dout0_11) AT=1580.05n

.meas tran vdout0_12ck1570 FIND v(dout0_12) AT=1580.05n

.meas tran vdout0_13ck1570 FIND v(dout0_13) AT=1580.05n

.meas tran vdout0_14ck1570 FIND v(dout0_14) AT=1580.05n

.meas tran vdout0_15ck1570 FIND v(dout0_15) AT=1580.05n

.meas tran vdout0_16ck1570 FIND v(dout0_16) AT=1580.05n

.meas tran vdout0_17ck1570 FIND v(dout0_17) AT=1580.05n

.meas tran vdout0_18ck1570 FIND v(dout0_18) AT=1580.05n

.meas tran vdout0_19ck1570 FIND v(dout0_19) AT=1580.05n

.meas tran vdout0_20ck1570 FIND v(dout0_20) AT=1580.05n

.meas tran vdout0_21ck1570 FIND v(dout0_21) AT=1580.05n

.meas tran vdout0_22ck1570 FIND v(dout0_22) AT=1580.05n

.meas tran vdout0_23ck1570 FIND v(dout0_23) AT=1580.05n

.meas tran vdout0_24ck1570 FIND v(dout0_24) AT=1580.05n

.meas tran vdout0_25ck1570 FIND v(dout0_25) AT=1580.05n

.meas tran vdout0_26ck1570 FIND v(dout0_26) AT=1580.05n

.meas tran vdout0_27ck1570 FIND v(dout0_27) AT=1580.05n

.meas tran vdout0_28ck1570 FIND v(dout0_28) AT=1580.05n

.meas tran vdout0_29ck1570 FIND v(dout0_29) AT=1580.05n

.meas tran vdout0_30ck1570 FIND v(dout0_30) AT=1580.05n

.meas tran vdout0_31ck1570 FIND v(dout0_31) AT=1580.05n

.meas tran vdout0_32ck1570 FIND v(dout0_32) AT=1580.05n

.meas tran vdout0_0ck1590 FIND v(dout0_0) AT=1600.05n

.meas tran vdout0_1ck1590 FIND v(dout0_1) AT=1600.05n

.meas tran vdout0_2ck1590 FIND v(dout0_2) AT=1600.05n

.meas tran vdout0_3ck1590 FIND v(dout0_3) AT=1600.05n

.meas tran vdout0_4ck1590 FIND v(dout0_4) AT=1600.05n

.meas tran vdout0_5ck1590 FIND v(dout0_5) AT=1600.05n

.meas tran vdout0_6ck1590 FIND v(dout0_6) AT=1600.05n

.meas tran vdout0_7ck1590 FIND v(dout0_7) AT=1600.05n

.meas tran vdout0_8ck1590 FIND v(dout0_8) AT=1600.05n

.meas tran vdout0_9ck1590 FIND v(dout0_9) AT=1600.05n

.meas tran vdout0_10ck1590 FIND v(dout0_10) AT=1600.05n

.meas tran vdout0_11ck1590 FIND v(dout0_11) AT=1600.05n

.meas tran vdout0_12ck1590 FIND v(dout0_12) AT=1600.05n

.meas tran vdout0_13ck1590 FIND v(dout0_13) AT=1600.05n

.meas tran vdout0_14ck1590 FIND v(dout0_14) AT=1600.05n

.meas tran vdout0_15ck1590 FIND v(dout0_15) AT=1600.05n

.meas tran vdout0_16ck1590 FIND v(dout0_16) AT=1600.05n

.meas tran vdout0_17ck1590 FIND v(dout0_17) AT=1600.05n

.meas tran vdout0_18ck1590 FIND v(dout0_18) AT=1600.05n

.meas tran vdout0_19ck1590 FIND v(dout0_19) AT=1600.05n

.meas tran vdout0_20ck1590 FIND v(dout0_20) AT=1600.05n

.meas tran vdout0_21ck1590 FIND v(dout0_21) AT=1600.05n

.meas tran vdout0_22ck1590 FIND v(dout0_22) AT=1600.05n

.meas tran vdout0_23ck1590 FIND v(dout0_23) AT=1600.05n

.meas tran vdout0_24ck1590 FIND v(dout0_24) AT=1600.05n

.meas tran vdout0_25ck1590 FIND v(dout0_25) AT=1600.05n

.meas tran vdout0_26ck1590 FIND v(dout0_26) AT=1600.05n

.meas tran vdout0_27ck1590 FIND v(dout0_27) AT=1600.05n

.meas tran vdout0_28ck1590 FIND v(dout0_28) AT=1600.05n

.meas tran vdout0_29ck1590 FIND v(dout0_29) AT=1600.05n

.meas tran vdout0_30ck1590 FIND v(dout0_30) AT=1600.05n

.meas tran vdout0_31ck1590 FIND v(dout0_31) AT=1600.05n

.meas tran vdout0_32ck1590 FIND v(dout0_32) AT=1600.05n

.meas tran vdout0_0ck1610 FIND v(dout0_0) AT=1620.05n

.meas tran vdout0_1ck1610 FIND v(dout0_1) AT=1620.05n

.meas tran vdout0_2ck1610 FIND v(dout0_2) AT=1620.05n

.meas tran vdout0_3ck1610 FIND v(dout0_3) AT=1620.05n

.meas tran vdout0_4ck1610 FIND v(dout0_4) AT=1620.05n

.meas tran vdout0_5ck1610 FIND v(dout0_5) AT=1620.05n

.meas tran vdout0_6ck1610 FIND v(dout0_6) AT=1620.05n

.meas tran vdout0_7ck1610 FIND v(dout0_7) AT=1620.05n

.meas tran vdout0_8ck1610 FIND v(dout0_8) AT=1620.05n

.meas tran vdout0_9ck1610 FIND v(dout0_9) AT=1620.05n

.meas tran vdout0_10ck1610 FIND v(dout0_10) AT=1620.05n

.meas tran vdout0_11ck1610 FIND v(dout0_11) AT=1620.05n

.meas tran vdout0_12ck1610 FIND v(dout0_12) AT=1620.05n

.meas tran vdout0_13ck1610 FIND v(dout0_13) AT=1620.05n

.meas tran vdout0_14ck1610 FIND v(dout0_14) AT=1620.05n

.meas tran vdout0_15ck1610 FIND v(dout0_15) AT=1620.05n

.meas tran vdout0_16ck1610 FIND v(dout0_16) AT=1620.05n

.meas tran vdout0_17ck1610 FIND v(dout0_17) AT=1620.05n

.meas tran vdout0_18ck1610 FIND v(dout0_18) AT=1620.05n

.meas tran vdout0_19ck1610 FIND v(dout0_19) AT=1620.05n

.meas tran vdout0_20ck1610 FIND v(dout0_20) AT=1620.05n

.meas tran vdout0_21ck1610 FIND v(dout0_21) AT=1620.05n

.meas tran vdout0_22ck1610 FIND v(dout0_22) AT=1620.05n

.meas tran vdout0_23ck1610 FIND v(dout0_23) AT=1620.05n

.meas tran vdout0_24ck1610 FIND v(dout0_24) AT=1620.05n

.meas tran vdout0_25ck1610 FIND v(dout0_25) AT=1620.05n

.meas tran vdout0_26ck1610 FIND v(dout0_26) AT=1620.05n

.meas tran vdout0_27ck1610 FIND v(dout0_27) AT=1620.05n

.meas tran vdout0_28ck1610 FIND v(dout0_28) AT=1620.05n

.meas tran vdout0_29ck1610 FIND v(dout0_29) AT=1620.05n

.meas tran vdout0_30ck1610 FIND v(dout0_30) AT=1620.05n

.meas tran vdout0_31ck1610 FIND v(dout0_31) AT=1620.05n

.meas tran vdout0_32ck1610 FIND v(dout0_32) AT=1620.05n

.meas tran vdout0_0ck1620 FIND v(dout0_0) AT=1630.05n

.meas tran vdout0_1ck1620 FIND v(dout0_1) AT=1630.05n

.meas tran vdout0_2ck1620 FIND v(dout0_2) AT=1630.05n

.meas tran vdout0_3ck1620 FIND v(dout0_3) AT=1630.05n

.meas tran vdout0_4ck1620 FIND v(dout0_4) AT=1630.05n

.meas tran vdout0_5ck1620 FIND v(dout0_5) AT=1630.05n

.meas tran vdout0_6ck1620 FIND v(dout0_6) AT=1630.05n

.meas tran vdout0_7ck1620 FIND v(dout0_7) AT=1630.05n

.meas tran vdout0_8ck1620 FIND v(dout0_8) AT=1630.05n

.meas tran vdout0_9ck1620 FIND v(dout0_9) AT=1630.05n

.meas tran vdout0_10ck1620 FIND v(dout0_10) AT=1630.05n

.meas tran vdout0_11ck1620 FIND v(dout0_11) AT=1630.05n

.meas tran vdout0_12ck1620 FIND v(dout0_12) AT=1630.05n

.meas tran vdout0_13ck1620 FIND v(dout0_13) AT=1630.05n

.meas tran vdout0_14ck1620 FIND v(dout0_14) AT=1630.05n

.meas tran vdout0_15ck1620 FIND v(dout0_15) AT=1630.05n

.meas tran vdout0_16ck1620 FIND v(dout0_16) AT=1630.05n

.meas tran vdout0_17ck1620 FIND v(dout0_17) AT=1630.05n

.meas tran vdout0_18ck1620 FIND v(dout0_18) AT=1630.05n

.meas tran vdout0_19ck1620 FIND v(dout0_19) AT=1630.05n

.meas tran vdout0_20ck1620 FIND v(dout0_20) AT=1630.05n

.meas tran vdout0_21ck1620 FIND v(dout0_21) AT=1630.05n

.meas tran vdout0_22ck1620 FIND v(dout0_22) AT=1630.05n

.meas tran vdout0_23ck1620 FIND v(dout0_23) AT=1630.05n

.meas tran vdout0_24ck1620 FIND v(dout0_24) AT=1630.05n

.meas tran vdout0_25ck1620 FIND v(dout0_25) AT=1630.05n

.meas tran vdout0_26ck1620 FIND v(dout0_26) AT=1630.05n

.meas tran vdout0_27ck1620 FIND v(dout0_27) AT=1630.05n

.meas tran vdout0_28ck1620 FIND v(dout0_28) AT=1630.05n

.meas tran vdout0_29ck1620 FIND v(dout0_29) AT=1630.05n

.meas tran vdout0_30ck1620 FIND v(dout0_30) AT=1630.05n

.meas tran vdout0_31ck1620 FIND v(dout0_31) AT=1630.05n

.meas tran vdout0_32ck1620 FIND v(dout0_32) AT=1630.05n

.meas tran vdout0_0ck1640 FIND v(dout0_0) AT=1650.05n

.meas tran vdout0_1ck1640 FIND v(dout0_1) AT=1650.05n

.meas tran vdout0_2ck1640 FIND v(dout0_2) AT=1650.05n

.meas tran vdout0_3ck1640 FIND v(dout0_3) AT=1650.05n

.meas tran vdout0_4ck1640 FIND v(dout0_4) AT=1650.05n

.meas tran vdout0_5ck1640 FIND v(dout0_5) AT=1650.05n

.meas tran vdout0_6ck1640 FIND v(dout0_6) AT=1650.05n

.meas tran vdout0_7ck1640 FIND v(dout0_7) AT=1650.05n

.meas tran vdout0_8ck1640 FIND v(dout0_8) AT=1650.05n

.meas tran vdout0_9ck1640 FIND v(dout0_9) AT=1650.05n

.meas tran vdout0_10ck1640 FIND v(dout0_10) AT=1650.05n

.meas tran vdout0_11ck1640 FIND v(dout0_11) AT=1650.05n

.meas tran vdout0_12ck1640 FIND v(dout0_12) AT=1650.05n

.meas tran vdout0_13ck1640 FIND v(dout0_13) AT=1650.05n

.meas tran vdout0_14ck1640 FIND v(dout0_14) AT=1650.05n

.meas tran vdout0_15ck1640 FIND v(dout0_15) AT=1650.05n

.meas tran vdout0_16ck1640 FIND v(dout0_16) AT=1650.05n

.meas tran vdout0_17ck1640 FIND v(dout0_17) AT=1650.05n

.meas tran vdout0_18ck1640 FIND v(dout0_18) AT=1650.05n

.meas tran vdout0_19ck1640 FIND v(dout0_19) AT=1650.05n

.meas tran vdout0_20ck1640 FIND v(dout0_20) AT=1650.05n

.meas tran vdout0_21ck1640 FIND v(dout0_21) AT=1650.05n

.meas tran vdout0_22ck1640 FIND v(dout0_22) AT=1650.05n

.meas tran vdout0_23ck1640 FIND v(dout0_23) AT=1650.05n

.meas tran vdout0_24ck1640 FIND v(dout0_24) AT=1650.05n

.meas tran vdout0_25ck1640 FIND v(dout0_25) AT=1650.05n

.meas tran vdout0_26ck1640 FIND v(dout0_26) AT=1650.05n

.meas tran vdout0_27ck1640 FIND v(dout0_27) AT=1650.05n

.meas tran vdout0_28ck1640 FIND v(dout0_28) AT=1650.05n

.meas tran vdout0_29ck1640 FIND v(dout0_29) AT=1650.05n

.meas tran vdout0_30ck1640 FIND v(dout0_30) AT=1650.05n

.meas tran vdout0_31ck1640 FIND v(dout0_31) AT=1650.05n

.meas tran vdout0_32ck1640 FIND v(dout0_32) AT=1650.05n

.meas tran vdout0_0ck1650 FIND v(dout0_0) AT=1660.05n

.meas tran vdout0_1ck1650 FIND v(dout0_1) AT=1660.05n

.meas tran vdout0_2ck1650 FIND v(dout0_2) AT=1660.05n

.meas tran vdout0_3ck1650 FIND v(dout0_3) AT=1660.05n

.meas tran vdout0_4ck1650 FIND v(dout0_4) AT=1660.05n

.meas tran vdout0_5ck1650 FIND v(dout0_5) AT=1660.05n

.meas tran vdout0_6ck1650 FIND v(dout0_6) AT=1660.05n

.meas tran vdout0_7ck1650 FIND v(dout0_7) AT=1660.05n

.meas tran vdout0_8ck1650 FIND v(dout0_8) AT=1660.05n

.meas tran vdout0_9ck1650 FIND v(dout0_9) AT=1660.05n

.meas tran vdout0_10ck1650 FIND v(dout0_10) AT=1660.05n

.meas tran vdout0_11ck1650 FIND v(dout0_11) AT=1660.05n

.meas tran vdout0_12ck1650 FIND v(dout0_12) AT=1660.05n

.meas tran vdout0_13ck1650 FIND v(dout0_13) AT=1660.05n

.meas tran vdout0_14ck1650 FIND v(dout0_14) AT=1660.05n

.meas tran vdout0_15ck1650 FIND v(dout0_15) AT=1660.05n

.meas tran vdout0_16ck1650 FIND v(dout0_16) AT=1660.05n

.meas tran vdout0_17ck1650 FIND v(dout0_17) AT=1660.05n

.meas tran vdout0_18ck1650 FIND v(dout0_18) AT=1660.05n

.meas tran vdout0_19ck1650 FIND v(dout0_19) AT=1660.05n

.meas tran vdout0_20ck1650 FIND v(dout0_20) AT=1660.05n

.meas tran vdout0_21ck1650 FIND v(dout0_21) AT=1660.05n

.meas tran vdout0_22ck1650 FIND v(dout0_22) AT=1660.05n

.meas tran vdout0_23ck1650 FIND v(dout0_23) AT=1660.05n

.meas tran vdout0_24ck1650 FIND v(dout0_24) AT=1660.05n

.meas tran vdout0_25ck1650 FIND v(dout0_25) AT=1660.05n

.meas tran vdout0_26ck1650 FIND v(dout0_26) AT=1660.05n

.meas tran vdout0_27ck1650 FIND v(dout0_27) AT=1660.05n

.meas tran vdout0_28ck1650 FIND v(dout0_28) AT=1660.05n

.meas tran vdout0_29ck1650 FIND v(dout0_29) AT=1660.05n

.meas tran vdout0_30ck1650 FIND v(dout0_30) AT=1660.05n

.meas tran vdout0_31ck1650 FIND v(dout0_31) AT=1660.05n

.meas tran vdout0_32ck1650 FIND v(dout0_32) AT=1660.05n

.meas tran vdout0_0ck1700 FIND v(dout0_0) AT=1710.05n

.meas tran vdout0_1ck1700 FIND v(dout0_1) AT=1710.05n

.meas tran vdout0_2ck1700 FIND v(dout0_2) AT=1710.05n

.meas tran vdout0_3ck1700 FIND v(dout0_3) AT=1710.05n

.meas tran vdout0_4ck1700 FIND v(dout0_4) AT=1710.05n

.meas tran vdout0_5ck1700 FIND v(dout0_5) AT=1710.05n

.meas tran vdout0_6ck1700 FIND v(dout0_6) AT=1710.05n

.meas tran vdout0_7ck1700 FIND v(dout0_7) AT=1710.05n

.meas tran vdout0_8ck1700 FIND v(dout0_8) AT=1710.05n

.meas tran vdout0_9ck1700 FIND v(dout0_9) AT=1710.05n

.meas tran vdout0_10ck1700 FIND v(dout0_10) AT=1710.05n

.meas tran vdout0_11ck1700 FIND v(dout0_11) AT=1710.05n

.meas tran vdout0_12ck1700 FIND v(dout0_12) AT=1710.05n

.meas tran vdout0_13ck1700 FIND v(dout0_13) AT=1710.05n

.meas tran vdout0_14ck1700 FIND v(dout0_14) AT=1710.05n

.meas tran vdout0_15ck1700 FIND v(dout0_15) AT=1710.05n

.meas tran vdout0_16ck1700 FIND v(dout0_16) AT=1710.05n

.meas tran vdout0_17ck1700 FIND v(dout0_17) AT=1710.05n

.meas tran vdout0_18ck1700 FIND v(dout0_18) AT=1710.05n

.meas tran vdout0_19ck1700 FIND v(dout0_19) AT=1710.05n

.meas tran vdout0_20ck1700 FIND v(dout0_20) AT=1710.05n

.meas tran vdout0_21ck1700 FIND v(dout0_21) AT=1710.05n

.meas tran vdout0_22ck1700 FIND v(dout0_22) AT=1710.05n

.meas tran vdout0_23ck1700 FIND v(dout0_23) AT=1710.05n

.meas tran vdout0_24ck1700 FIND v(dout0_24) AT=1710.05n

.meas tran vdout0_25ck1700 FIND v(dout0_25) AT=1710.05n

.meas tran vdout0_26ck1700 FIND v(dout0_26) AT=1710.05n

.meas tran vdout0_27ck1700 FIND v(dout0_27) AT=1710.05n

.meas tran vdout0_28ck1700 FIND v(dout0_28) AT=1710.05n

.meas tran vdout0_29ck1700 FIND v(dout0_29) AT=1710.05n

.meas tran vdout0_30ck1700 FIND v(dout0_30) AT=1710.05n

.meas tran vdout0_31ck1700 FIND v(dout0_31) AT=1710.05n

.meas tran vdout0_32ck1700 FIND v(dout0_32) AT=1710.05n

.meas tran vdout0_0ck1720 FIND v(dout0_0) AT=1730.05n

.meas tran vdout0_1ck1720 FIND v(dout0_1) AT=1730.05n

.meas tran vdout0_2ck1720 FIND v(dout0_2) AT=1730.05n

.meas tran vdout0_3ck1720 FIND v(dout0_3) AT=1730.05n

.meas tran vdout0_4ck1720 FIND v(dout0_4) AT=1730.05n

.meas tran vdout0_5ck1720 FIND v(dout0_5) AT=1730.05n

.meas tran vdout0_6ck1720 FIND v(dout0_6) AT=1730.05n

.meas tran vdout0_7ck1720 FIND v(dout0_7) AT=1730.05n

.meas tran vdout0_8ck1720 FIND v(dout0_8) AT=1730.05n

.meas tran vdout0_9ck1720 FIND v(dout0_9) AT=1730.05n

.meas tran vdout0_10ck1720 FIND v(dout0_10) AT=1730.05n

.meas tran vdout0_11ck1720 FIND v(dout0_11) AT=1730.05n

.meas tran vdout0_12ck1720 FIND v(dout0_12) AT=1730.05n

.meas tran vdout0_13ck1720 FIND v(dout0_13) AT=1730.05n

.meas tran vdout0_14ck1720 FIND v(dout0_14) AT=1730.05n

.meas tran vdout0_15ck1720 FIND v(dout0_15) AT=1730.05n

.meas tran vdout0_16ck1720 FIND v(dout0_16) AT=1730.05n

.meas tran vdout0_17ck1720 FIND v(dout0_17) AT=1730.05n

.meas tran vdout0_18ck1720 FIND v(dout0_18) AT=1730.05n

.meas tran vdout0_19ck1720 FIND v(dout0_19) AT=1730.05n

.meas tran vdout0_20ck1720 FIND v(dout0_20) AT=1730.05n

.meas tran vdout0_21ck1720 FIND v(dout0_21) AT=1730.05n

.meas tran vdout0_22ck1720 FIND v(dout0_22) AT=1730.05n

.meas tran vdout0_23ck1720 FIND v(dout0_23) AT=1730.05n

.meas tran vdout0_24ck1720 FIND v(dout0_24) AT=1730.05n

.meas tran vdout0_25ck1720 FIND v(dout0_25) AT=1730.05n

.meas tran vdout0_26ck1720 FIND v(dout0_26) AT=1730.05n

.meas tran vdout0_27ck1720 FIND v(dout0_27) AT=1730.05n

.meas tran vdout0_28ck1720 FIND v(dout0_28) AT=1730.05n

.meas tran vdout0_29ck1720 FIND v(dout0_29) AT=1730.05n

.meas tran vdout0_30ck1720 FIND v(dout0_30) AT=1730.05n

.meas tran vdout0_31ck1720 FIND v(dout0_31) AT=1730.05n

.meas tran vdout0_32ck1720 FIND v(dout0_32) AT=1730.05n

.meas tran vdout0_0ck1730 FIND v(dout0_0) AT=1740.05n

.meas tran vdout0_1ck1730 FIND v(dout0_1) AT=1740.05n

.meas tran vdout0_2ck1730 FIND v(dout0_2) AT=1740.05n

.meas tran vdout0_3ck1730 FIND v(dout0_3) AT=1740.05n

.meas tran vdout0_4ck1730 FIND v(dout0_4) AT=1740.05n

.meas tran vdout0_5ck1730 FIND v(dout0_5) AT=1740.05n

.meas tran vdout0_6ck1730 FIND v(dout0_6) AT=1740.05n

.meas tran vdout0_7ck1730 FIND v(dout0_7) AT=1740.05n

.meas tran vdout0_8ck1730 FIND v(dout0_8) AT=1740.05n

.meas tran vdout0_9ck1730 FIND v(dout0_9) AT=1740.05n

.meas tran vdout0_10ck1730 FIND v(dout0_10) AT=1740.05n

.meas tran vdout0_11ck1730 FIND v(dout0_11) AT=1740.05n

.meas tran vdout0_12ck1730 FIND v(dout0_12) AT=1740.05n

.meas tran vdout0_13ck1730 FIND v(dout0_13) AT=1740.05n

.meas tran vdout0_14ck1730 FIND v(dout0_14) AT=1740.05n

.meas tran vdout0_15ck1730 FIND v(dout0_15) AT=1740.05n

.meas tran vdout0_16ck1730 FIND v(dout0_16) AT=1740.05n

.meas tran vdout0_17ck1730 FIND v(dout0_17) AT=1740.05n

.meas tran vdout0_18ck1730 FIND v(dout0_18) AT=1740.05n

.meas tran vdout0_19ck1730 FIND v(dout0_19) AT=1740.05n

.meas tran vdout0_20ck1730 FIND v(dout0_20) AT=1740.05n

.meas tran vdout0_21ck1730 FIND v(dout0_21) AT=1740.05n

.meas tran vdout0_22ck1730 FIND v(dout0_22) AT=1740.05n

.meas tran vdout0_23ck1730 FIND v(dout0_23) AT=1740.05n

.meas tran vdout0_24ck1730 FIND v(dout0_24) AT=1740.05n

.meas tran vdout0_25ck1730 FIND v(dout0_25) AT=1740.05n

.meas tran vdout0_26ck1730 FIND v(dout0_26) AT=1740.05n

.meas tran vdout0_27ck1730 FIND v(dout0_27) AT=1740.05n

.meas tran vdout0_28ck1730 FIND v(dout0_28) AT=1740.05n

.meas tran vdout0_29ck1730 FIND v(dout0_29) AT=1740.05n

.meas tran vdout0_30ck1730 FIND v(dout0_30) AT=1740.05n

.meas tran vdout0_31ck1730 FIND v(dout0_31) AT=1740.05n

.meas tran vdout0_32ck1730 FIND v(dout0_32) AT=1740.05n

.meas tran vdout0_0ck1760 FIND v(dout0_0) AT=1770.05n

.meas tran vdout0_1ck1760 FIND v(dout0_1) AT=1770.05n

.meas tran vdout0_2ck1760 FIND v(dout0_2) AT=1770.05n

.meas tran vdout0_3ck1760 FIND v(dout0_3) AT=1770.05n

.meas tran vdout0_4ck1760 FIND v(dout0_4) AT=1770.05n

.meas tran vdout0_5ck1760 FIND v(dout0_5) AT=1770.05n

.meas tran vdout0_6ck1760 FIND v(dout0_6) AT=1770.05n

.meas tran vdout0_7ck1760 FIND v(dout0_7) AT=1770.05n

.meas tran vdout0_8ck1760 FIND v(dout0_8) AT=1770.05n

.meas tran vdout0_9ck1760 FIND v(dout0_9) AT=1770.05n

.meas tran vdout0_10ck1760 FIND v(dout0_10) AT=1770.05n

.meas tran vdout0_11ck1760 FIND v(dout0_11) AT=1770.05n

.meas tran vdout0_12ck1760 FIND v(dout0_12) AT=1770.05n

.meas tran vdout0_13ck1760 FIND v(dout0_13) AT=1770.05n

.meas tran vdout0_14ck1760 FIND v(dout0_14) AT=1770.05n

.meas tran vdout0_15ck1760 FIND v(dout0_15) AT=1770.05n

.meas tran vdout0_16ck1760 FIND v(dout0_16) AT=1770.05n

.meas tran vdout0_17ck1760 FIND v(dout0_17) AT=1770.05n

.meas tran vdout0_18ck1760 FIND v(dout0_18) AT=1770.05n

.meas tran vdout0_19ck1760 FIND v(dout0_19) AT=1770.05n

.meas tran vdout0_20ck1760 FIND v(dout0_20) AT=1770.05n

.meas tran vdout0_21ck1760 FIND v(dout0_21) AT=1770.05n

.meas tran vdout0_22ck1760 FIND v(dout0_22) AT=1770.05n

.meas tran vdout0_23ck1760 FIND v(dout0_23) AT=1770.05n

.meas tran vdout0_24ck1760 FIND v(dout0_24) AT=1770.05n

.meas tran vdout0_25ck1760 FIND v(dout0_25) AT=1770.05n

.meas tran vdout0_26ck1760 FIND v(dout0_26) AT=1770.05n

.meas tran vdout0_27ck1760 FIND v(dout0_27) AT=1770.05n

.meas tran vdout0_28ck1760 FIND v(dout0_28) AT=1770.05n

.meas tran vdout0_29ck1760 FIND v(dout0_29) AT=1770.05n

.meas tran vdout0_30ck1760 FIND v(dout0_30) AT=1770.05n

.meas tran vdout0_31ck1760 FIND v(dout0_31) AT=1770.05n

.meas tran vdout0_32ck1760 FIND v(dout0_32) AT=1770.05n

.meas tran vdout0_0ck1780 FIND v(dout0_0) AT=1790.05n

.meas tran vdout0_1ck1780 FIND v(dout0_1) AT=1790.05n

.meas tran vdout0_2ck1780 FIND v(dout0_2) AT=1790.05n

.meas tran vdout0_3ck1780 FIND v(dout0_3) AT=1790.05n

.meas tran vdout0_4ck1780 FIND v(dout0_4) AT=1790.05n

.meas tran vdout0_5ck1780 FIND v(dout0_5) AT=1790.05n

.meas tran vdout0_6ck1780 FIND v(dout0_6) AT=1790.05n

.meas tran vdout0_7ck1780 FIND v(dout0_7) AT=1790.05n

.meas tran vdout0_8ck1780 FIND v(dout0_8) AT=1790.05n

.meas tran vdout0_9ck1780 FIND v(dout0_9) AT=1790.05n

.meas tran vdout0_10ck1780 FIND v(dout0_10) AT=1790.05n

.meas tran vdout0_11ck1780 FIND v(dout0_11) AT=1790.05n

.meas tran vdout0_12ck1780 FIND v(dout0_12) AT=1790.05n

.meas tran vdout0_13ck1780 FIND v(dout0_13) AT=1790.05n

.meas tran vdout0_14ck1780 FIND v(dout0_14) AT=1790.05n

.meas tran vdout0_15ck1780 FIND v(dout0_15) AT=1790.05n

.meas tran vdout0_16ck1780 FIND v(dout0_16) AT=1790.05n

.meas tran vdout0_17ck1780 FIND v(dout0_17) AT=1790.05n

.meas tran vdout0_18ck1780 FIND v(dout0_18) AT=1790.05n

.meas tran vdout0_19ck1780 FIND v(dout0_19) AT=1790.05n

.meas tran vdout0_20ck1780 FIND v(dout0_20) AT=1790.05n

.meas tran vdout0_21ck1780 FIND v(dout0_21) AT=1790.05n

.meas tran vdout0_22ck1780 FIND v(dout0_22) AT=1790.05n

.meas tran vdout0_23ck1780 FIND v(dout0_23) AT=1790.05n

.meas tran vdout0_24ck1780 FIND v(dout0_24) AT=1790.05n

.meas tran vdout0_25ck1780 FIND v(dout0_25) AT=1790.05n

.meas tran vdout0_26ck1780 FIND v(dout0_26) AT=1790.05n

.meas tran vdout0_27ck1780 FIND v(dout0_27) AT=1790.05n

.meas tran vdout0_28ck1780 FIND v(dout0_28) AT=1790.05n

.meas tran vdout0_29ck1780 FIND v(dout0_29) AT=1790.05n

.meas tran vdout0_30ck1780 FIND v(dout0_30) AT=1790.05n

.meas tran vdout0_31ck1780 FIND v(dout0_31) AT=1790.05n

.meas tran vdout0_32ck1780 FIND v(dout0_32) AT=1790.05n

.meas tran vdout0_0ck1810 FIND v(dout0_0) AT=1820.05n

.meas tran vdout0_1ck1810 FIND v(dout0_1) AT=1820.05n

.meas tran vdout0_2ck1810 FIND v(dout0_2) AT=1820.05n

.meas tran vdout0_3ck1810 FIND v(dout0_3) AT=1820.05n

.meas tran vdout0_4ck1810 FIND v(dout0_4) AT=1820.05n

.meas tran vdout0_5ck1810 FIND v(dout0_5) AT=1820.05n

.meas tran vdout0_6ck1810 FIND v(dout0_6) AT=1820.05n

.meas tran vdout0_7ck1810 FIND v(dout0_7) AT=1820.05n

.meas tran vdout0_8ck1810 FIND v(dout0_8) AT=1820.05n

.meas tran vdout0_9ck1810 FIND v(dout0_9) AT=1820.05n

.meas tran vdout0_10ck1810 FIND v(dout0_10) AT=1820.05n

.meas tran vdout0_11ck1810 FIND v(dout0_11) AT=1820.05n

.meas tran vdout0_12ck1810 FIND v(dout0_12) AT=1820.05n

.meas tran vdout0_13ck1810 FIND v(dout0_13) AT=1820.05n

.meas tran vdout0_14ck1810 FIND v(dout0_14) AT=1820.05n

.meas tran vdout0_15ck1810 FIND v(dout0_15) AT=1820.05n

.meas tran vdout0_16ck1810 FIND v(dout0_16) AT=1820.05n

.meas tran vdout0_17ck1810 FIND v(dout0_17) AT=1820.05n

.meas tran vdout0_18ck1810 FIND v(dout0_18) AT=1820.05n

.meas tran vdout0_19ck1810 FIND v(dout0_19) AT=1820.05n

.meas tran vdout0_20ck1810 FIND v(dout0_20) AT=1820.05n

.meas tran vdout0_21ck1810 FIND v(dout0_21) AT=1820.05n

.meas tran vdout0_22ck1810 FIND v(dout0_22) AT=1820.05n

.meas tran vdout0_23ck1810 FIND v(dout0_23) AT=1820.05n

.meas tran vdout0_24ck1810 FIND v(dout0_24) AT=1820.05n

.meas tran vdout0_25ck1810 FIND v(dout0_25) AT=1820.05n

.meas tran vdout0_26ck1810 FIND v(dout0_26) AT=1820.05n

.meas tran vdout0_27ck1810 FIND v(dout0_27) AT=1820.05n

.meas tran vdout0_28ck1810 FIND v(dout0_28) AT=1820.05n

.meas tran vdout0_29ck1810 FIND v(dout0_29) AT=1820.05n

.meas tran vdout0_30ck1810 FIND v(dout0_30) AT=1820.05n

.meas tran vdout0_31ck1810 FIND v(dout0_31) AT=1820.05n

.meas tran vdout0_32ck1810 FIND v(dout0_32) AT=1820.05n

.meas tran vdout0_0ck1820 FIND v(dout0_0) AT=1830.05n

.meas tran vdout0_1ck1820 FIND v(dout0_1) AT=1830.05n

.meas tran vdout0_2ck1820 FIND v(dout0_2) AT=1830.05n

.meas tran vdout0_3ck1820 FIND v(dout0_3) AT=1830.05n

.meas tran vdout0_4ck1820 FIND v(dout0_4) AT=1830.05n

.meas tran vdout0_5ck1820 FIND v(dout0_5) AT=1830.05n

.meas tran vdout0_6ck1820 FIND v(dout0_6) AT=1830.05n

.meas tran vdout0_7ck1820 FIND v(dout0_7) AT=1830.05n

.meas tran vdout0_8ck1820 FIND v(dout0_8) AT=1830.05n

.meas tran vdout0_9ck1820 FIND v(dout0_9) AT=1830.05n

.meas tran vdout0_10ck1820 FIND v(dout0_10) AT=1830.05n

.meas tran vdout0_11ck1820 FIND v(dout0_11) AT=1830.05n

.meas tran vdout0_12ck1820 FIND v(dout0_12) AT=1830.05n

.meas tran vdout0_13ck1820 FIND v(dout0_13) AT=1830.05n

.meas tran vdout0_14ck1820 FIND v(dout0_14) AT=1830.05n

.meas tran vdout0_15ck1820 FIND v(dout0_15) AT=1830.05n

.meas tran vdout0_16ck1820 FIND v(dout0_16) AT=1830.05n

.meas tran vdout0_17ck1820 FIND v(dout0_17) AT=1830.05n

.meas tran vdout0_18ck1820 FIND v(dout0_18) AT=1830.05n

.meas tran vdout0_19ck1820 FIND v(dout0_19) AT=1830.05n

.meas tran vdout0_20ck1820 FIND v(dout0_20) AT=1830.05n

.meas tran vdout0_21ck1820 FIND v(dout0_21) AT=1830.05n

.meas tran vdout0_22ck1820 FIND v(dout0_22) AT=1830.05n

.meas tran vdout0_23ck1820 FIND v(dout0_23) AT=1830.05n

.meas tran vdout0_24ck1820 FIND v(dout0_24) AT=1830.05n

.meas tran vdout0_25ck1820 FIND v(dout0_25) AT=1830.05n

.meas tran vdout0_26ck1820 FIND v(dout0_26) AT=1830.05n

.meas tran vdout0_27ck1820 FIND v(dout0_27) AT=1830.05n

.meas tran vdout0_28ck1820 FIND v(dout0_28) AT=1830.05n

.meas tran vdout0_29ck1820 FIND v(dout0_29) AT=1830.05n

.meas tran vdout0_30ck1820 FIND v(dout0_30) AT=1830.05n

.meas tran vdout0_31ck1820 FIND v(dout0_31) AT=1830.05n

.meas tran vdout0_32ck1820 FIND v(dout0_32) AT=1830.05n

.meas tran vdout0_0ck1830 FIND v(dout0_0) AT=1840.05n

.meas tran vdout0_1ck1830 FIND v(dout0_1) AT=1840.05n

.meas tran vdout0_2ck1830 FIND v(dout0_2) AT=1840.05n

.meas tran vdout0_3ck1830 FIND v(dout0_3) AT=1840.05n

.meas tran vdout0_4ck1830 FIND v(dout0_4) AT=1840.05n

.meas tran vdout0_5ck1830 FIND v(dout0_5) AT=1840.05n

.meas tran vdout0_6ck1830 FIND v(dout0_6) AT=1840.05n

.meas tran vdout0_7ck1830 FIND v(dout0_7) AT=1840.05n

.meas tran vdout0_8ck1830 FIND v(dout0_8) AT=1840.05n

.meas tran vdout0_9ck1830 FIND v(dout0_9) AT=1840.05n

.meas tran vdout0_10ck1830 FIND v(dout0_10) AT=1840.05n

.meas tran vdout0_11ck1830 FIND v(dout0_11) AT=1840.05n

.meas tran vdout0_12ck1830 FIND v(dout0_12) AT=1840.05n

.meas tran vdout0_13ck1830 FIND v(dout0_13) AT=1840.05n

.meas tran vdout0_14ck1830 FIND v(dout0_14) AT=1840.05n

.meas tran vdout0_15ck1830 FIND v(dout0_15) AT=1840.05n

.meas tran vdout0_16ck1830 FIND v(dout0_16) AT=1840.05n

.meas tran vdout0_17ck1830 FIND v(dout0_17) AT=1840.05n

.meas tran vdout0_18ck1830 FIND v(dout0_18) AT=1840.05n

.meas tran vdout0_19ck1830 FIND v(dout0_19) AT=1840.05n

.meas tran vdout0_20ck1830 FIND v(dout0_20) AT=1840.05n

.meas tran vdout0_21ck1830 FIND v(dout0_21) AT=1840.05n

.meas tran vdout0_22ck1830 FIND v(dout0_22) AT=1840.05n

.meas tran vdout0_23ck1830 FIND v(dout0_23) AT=1840.05n

.meas tran vdout0_24ck1830 FIND v(dout0_24) AT=1840.05n

.meas tran vdout0_25ck1830 FIND v(dout0_25) AT=1840.05n

.meas tran vdout0_26ck1830 FIND v(dout0_26) AT=1840.05n

.meas tran vdout0_27ck1830 FIND v(dout0_27) AT=1840.05n

.meas tran vdout0_28ck1830 FIND v(dout0_28) AT=1840.05n

.meas tran vdout0_29ck1830 FIND v(dout0_29) AT=1840.05n

.meas tran vdout0_30ck1830 FIND v(dout0_30) AT=1840.05n

.meas tran vdout0_31ck1830 FIND v(dout0_31) AT=1840.05n

.meas tran vdout0_32ck1830 FIND v(dout0_32) AT=1840.05n

.meas tran vdout0_0ck1880 FIND v(dout0_0) AT=1890.05n

.meas tran vdout0_1ck1880 FIND v(dout0_1) AT=1890.05n

.meas tran vdout0_2ck1880 FIND v(dout0_2) AT=1890.05n

.meas tran vdout0_3ck1880 FIND v(dout0_3) AT=1890.05n

.meas tran vdout0_4ck1880 FIND v(dout0_4) AT=1890.05n

.meas tran vdout0_5ck1880 FIND v(dout0_5) AT=1890.05n

.meas tran vdout0_6ck1880 FIND v(dout0_6) AT=1890.05n

.meas tran vdout0_7ck1880 FIND v(dout0_7) AT=1890.05n

.meas tran vdout0_8ck1880 FIND v(dout0_8) AT=1890.05n

.meas tran vdout0_9ck1880 FIND v(dout0_9) AT=1890.05n

.meas tran vdout0_10ck1880 FIND v(dout0_10) AT=1890.05n

.meas tran vdout0_11ck1880 FIND v(dout0_11) AT=1890.05n

.meas tran vdout0_12ck1880 FIND v(dout0_12) AT=1890.05n

.meas tran vdout0_13ck1880 FIND v(dout0_13) AT=1890.05n

.meas tran vdout0_14ck1880 FIND v(dout0_14) AT=1890.05n

.meas tran vdout0_15ck1880 FIND v(dout0_15) AT=1890.05n

.meas tran vdout0_16ck1880 FIND v(dout0_16) AT=1890.05n

.meas tran vdout0_17ck1880 FIND v(dout0_17) AT=1890.05n

.meas tran vdout0_18ck1880 FIND v(dout0_18) AT=1890.05n

.meas tran vdout0_19ck1880 FIND v(dout0_19) AT=1890.05n

.meas tran vdout0_20ck1880 FIND v(dout0_20) AT=1890.05n

.meas tran vdout0_21ck1880 FIND v(dout0_21) AT=1890.05n

.meas tran vdout0_22ck1880 FIND v(dout0_22) AT=1890.05n

.meas tran vdout0_23ck1880 FIND v(dout0_23) AT=1890.05n

.meas tran vdout0_24ck1880 FIND v(dout0_24) AT=1890.05n

.meas tran vdout0_25ck1880 FIND v(dout0_25) AT=1890.05n

.meas tran vdout0_26ck1880 FIND v(dout0_26) AT=1890.05n

.meas tran vdout0_27ck1880 FIND v(dout0_27) AT=1890.05n

.meas tran vdout0_28ck1880 FIND v(dout0_28) AT=1890.05n

.meas tran vdout0_29ck1880 FIND v(dout0_29) AT=1890.05n

.meas tran vdout0_30ck1880 FIND v(dout0_30) AT=1890.05n

.meas tran vdout0_31ck1880 FIND v(dout0_31) AT=1890.05n

.meas tran vdout0_32ck1880 FIND v(dout0_32) AT=1890.05n

.meas tran vdout0_0ck1940 FIND v(dout0_0) AT=1950.05n

.meas tran vdout0_1ck1940 FIND v(dout0_1) AT=1950.05n

.meas tran vdout0_2ck1940 FIND v(dout0_2) AT=1950.05n

.meas tran vdout0_3ck1940 FIND v(dout0_3) AT=1950.05n

.meas tran vdout0_4ck1940 FIND v(dout0_4) AT=1950.05n

.meas tran vdout0_5ck1940 FIND v(dout0_5) AT=1950.05n

.meas tran vdout0_6ck1940 FIND v(dout0_6) AT=1950.05n

.meas tran vdout0_7ck1940 FIND v(dout0_7) AT=1950.05n

.meas tran vdout0_8ck1940 FIND v(dout0_8) AT=1950.05n

.meas tran vdout0_9ck1940 FIND v(dout0_9) AT=1950.05n

.meas tran vdout0_10ck1940 FIND v(dout0_10) AT=1950.05n

.meas tran vdout0_11ck1940 FIND v(dout0_11) AT=1950.05n

.meas tran vdout0_12ck1940 FIND v(dout0_12) AT=1950.05n

.meas tran vdout0_13ck1940 FIND v(dout0_13) AT=1950.05n

.meas tran vdout0_14ck1940 FIND v(dout0_14) AT=1950.05n

.meas tran vdout0_15ck1940 FIND v(dout0_15) AT=1950.05n

.meas tran vdout0_16ck1940 FIND v(dout0_16) AT=1950.05n

.meas tran vdout0_17ck1940 FIND v(dout0_17) AT=1950.05n

.meas tran vdout0_18ck1940 FIND v(dout0_18) AT=1950.05n

.meas tran vdout0_19ck1940 FIND v(dout0_19) AT=1950.05n

.meas tran vdout0_20ck1940 FIND v(dout0_20) AT=1950.05n

.meas tran vdout0_21ck1940 FIND v(dout0_21) AT=1950.05n

.meas tran vdout0_22ck1940 FIND v(dout0_22) AT=1950.05n

.meas tran vdout0_23ck1940 FIND v(dout0_23) AT=1950.05n

.meas tran vdout0_24ck1940 FIND v(dout0_24) AT=1950.05n

.meas tran vdout0_25ck1940 FIND v(dout0_25) AT=1950.05n

.meas tran vdout0_26ck1940 FIND v(dout0_26) AT=1950.05n

.meas tran vdout0_27ck1940 FIND v(dout0_27) AT=1950.05n

.meas tran vdout0_28ck1940 FIND v(dout0_28) AT=1950.05n

.meas tran vdout0_29ck1940 FIND v(dout0_29) AT=1950.05n

.meas tran vdout0_30ck1940 FIND v(dout0_30) AT=1950.05n

.meas tran vdout0_31ck1940 FIND v(dout0_31) AT=1950.05n

.meas tran vdout0_32ck1940 FIND v(dout0_32) AT=1950.05n

.meas tran vdout0_0ck1970 FIND v(dout0_0) AT=1980.05n

.meas tran vdout0_1ck1970 FIND v(dout0_1) AT=1980.05n

.meas tran vdout0_2ck1970 FIND v(dout0_2) AT=1980.05n

.meas tran vdout0_3ck1970 FIND v(dout0_3) AT=1980.05n

.meas tran vdout0_4ck1970 FIND v(dout0_4) AT=1980.05n

.meas tran vdout0_5ck1970 FIND v(dout0_5) AT=1980.05n

.meas tran vdout0_6ck1970 FIND v(dout0_6) AT=1980.05n

.meas tran vdout0_7ck1970 FIND v(dout0_7) AT=1980.05n

.meas tran vdout0_8ck1970 FIND v(dout0_8) AT=1980.05n

.meas tran vdout0_9ck1970 FIND v(dout0_9) AT=1980.05n

.meas tran vdout0_10ck1970 FIND v(dout0_10) AT=1980.05n

.meas tran vdout0_11ck1970 FIND v(dout0_11) AT=1980.05n

.meas tran vdout0_12ck1970 FIND v(dout0_12) AT=1980.05n

.meas tran vdout0_13ck1970 FIND v(dout0_13) AT=1980.05n

.meas tran vdout0_14ck1970 FIND v(dout0_14) AT=1980.05n

.meas tran vdout0_15ck1970 FIND v(dout0_15) AT=1980.05n

.meas tran vdout0_16ck1970 FIND v(dout0_16) AT=1980.05n

.meas tran vdout0_17ck1970 FIND v(dout0_17) AT=1980.05n

.meas tran vdout0_18ck1970 FIND v(dout0_18) AT=1980.05n

.meas tran vdout0_19ck1970 FIND v(dout0_19) AT=1980.05n

.meas tran vdout0_20ck1970 FIND v(dout0_20) AT=1980.05n

.meas tran vdout0_21ck1970 FIND v(dout0_21) AT=1980.05n

.meas tran vdout0_22ck1970 FIND v(dout0_22) AT=1980.05n

.meas tran vdout0_23ck1970 FIND v(dout0_23) AT=1980.05n

.meas tran vdout0_24ck1970 FIND v(dout0_24) AT=1980.05n

.meas tran vdout0_25ck1970 FIND v(dout0_25) AT=1980.05n

.meas tran vdout0_26ck1970 FIND v(dout0_26) AT=1980.05n

.meas tran vdout0_27ck1970 FIND v(dout0_27) AT=1980.05n

.meas tran vdout0_28ck1970 FIND v(dout0_28) AT=1980.05n

.meas tran vdout0_29ck1970 FIND v(dout0_29) AT=1980.05n

.meas tran vdout0_30ck1970 FIND v(dout0_30) AT=1980.05n

.meas tran vdout0_31ck1970 FIND v(dout0_31) AT=1980.05n

.meas tran vdout0_32ck1970 FIND v(dout0_32) AT=1980.05n

.meas tran vdout0_0ck2040 FIND v(dout0_0) AT=2050.05n

.meas tran vdout0_1ck2040 FIND v(dout0_1) AT=2050.05n

.meas tran vdout0_2ck2040 FIND v(dout0_2) AT=2050.05n

.meas tran vdout0_3ck2040 FIND v(dout0_3) AT=2050.05n

.meas tran vdout0_4ck2040 FIND v(dout0_4) AT=2050.05n

.meas tran vdout0_5ck2040 FIND v(dout0_5) AT=2050.05n

.meas tran vdout0_6ck2040 FIND v(dout0_6) AT=2050.05n

.meas tran vdout0_7ck2040 FIND v(dout0_7) AT=2050.05n

.meas tran vdout0_8ck2040 FIND v(dout0_8) AT=2050.05n

.meas tran vdout0_9ck2040 FIND v(dout0_9) AT=2050.05n

.meas tran vdout0_10ck2040 FIND v(dout0_10) AT=2050.05n

.meas tran vdout0_11ck2040 FIND v(dout0_11) AT=2050.05n

.meas tran vdout0_12ck2040 FIND v(dout0_12) AT=2050.05n

.meas tran vdout0_13ck2040 FIND v(dout0_13) AT=2050.05n

.meas tran vdout0_14ck2040 FIND v(dout0_14) AT=2050.05n

.meas tran vdout0_15ck2040 FIND v(dout0_15) AT=2050.05n

.meas tran vdout0_16ck2040 FIND v(dout0_16) AT=2050.05n

.meas tran vdout0_17ck2040 FIND v(dout0_17) AT=2050.05n

.meas tran vdout0_18ck2040 FIND v(dout0_18) AT=2050.05n

.meas tran vdout0_19ck2040 FIND v(dout0_19) AT=2050.05n

.meas tran vdout0_20ck2040 FIND v(dout0_20) AT=2050.05n

.meas tran vdout0_21ck2040 FIND v(dout0_21) AT=2050.05n

.meas tran vdout0_22ck2040 FIND v(dout0_22) AT=2050.05n

.meas tran vdout0_23ck2040 FIND v(dout0_23) AT=2050.05n

.meas tran vdout0_24ck2040 FIND v(dout0_24) AT=2050.05n

.meas tran vdout0_25ck2040 FIND v(dout0_25) AT=2050.05n

.meas tran vdout0_26ck2040 FIND v(dout0_26) AT=2050.05n

.meas tran vdout0_27ck2040 FIND v(dout0_27) AT=2050.05n

.meas tran vdout0_28ck2040 FIND v(dout0_28) AT=2050.05n

.meas tran vdout0_29ck2040 FIND v(dout0_29) AT=2050.05n

.meas tran vdout0_30ck2040 FIND v(dout0_30) AT=2050.05n

.meas tran vdout0_31ck2040 FIND v(dout0_31) AT=2050.05n

.meas tran vdout0_32ck2040 FIND v(dout0_32) AT=2050.05n
