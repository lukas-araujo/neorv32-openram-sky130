.meas tran vdout0_0ck40 FIND v(dout0_0) AT=50.05n

.meas tran vdout0_1ck40 FIND v(dout0_1) AT=50.05n

.meas tran vdout0_2ck40 FIND v(dout0_2) AT=50.05n

.meas tran vdout0_3ck40 FIND v(dout0_3) AT=50.05n

.meas tran vdout0_4ck40 FIND v(dout0_4) AT=50.05n

.meas tran vdout0_5ck40 FIND v(dout0_5) AT=50.05n

.meas tran vdout0_6ck40 FIND v(dout0_6) AT=50.05n

.meas tran vdout0_7ck40 FIND v(dout0_7) AT=50.05n

.meas tran vdout0_8ck40 FIND v(dout0_8) AT=50.05n

.meas tran vdout0_9ck40 FIND v(dout0_9) AT=50.05n

.meas tran vdout0_10ck40 FIND v(dout0_10) AT=50.05n

.meas tran vdout0_11ck40 FIND v(dout0_11) AT=50.05n

.meas tran vdout0_12ck40 FIND v(dout0_12) AT=50.05n

.meas tran vdout0_13ck40 FIND v(dout0_13) AT=50.05n

.meas tran vdout0_14ck40 FIND v(dout0_14) AT=50.05n

.meas tran vdout0_15ck40 FIND v(dout0_15) AT=50.05n

.meas tran vdout0_16ck40 FIND v(dout0_16) AT=50.05n

.meas tran vdout0_17ck40 FIND v(dout0_17) AT=50.05n

.meas tran vdout0_18ck40 FIND v(dout0_18) AT=50.05n

.meas tran vdout0_19ck40 FIND v(dout0_19) AT=50.05n

.meas tran vdout0_20ck40 FIND v(dout0_20) AT=50.05n

.meas tran vdout0_21ck40 FIND v(dout0_21) AT=50.05n

.meas tran vdout0_22ck40 FIND v(dout0_22) AT=50.05n

.meas tran vdout0_23ck40 FIND v(dout0_23) AT=50.05n

.meas tran vdout0_24ck40 FIND v(dout0_24) AT=50.05n

.meas tran vdout0_25ck40 FIND v(dout0_25) AT=50.05n

.meas tran vdout0_26ck40 FIND v(dout0_26) AT=50.05n

.meas tran vdout0_27ck40 FIND v(dout0_27) AT=50.05n

.meas tran vdout0_28ck40 FIND v(dout0_28) AT=50.05n

.meas tran vdout0_29ck40 FIND v(dout0_29) AT=50.05n

.meas tran vdout0_30ck40 FIND v(dout0_30) AT=50.05n

.meas tran vdout0_31ck40 FIND v(dout0_31) AT=50.05n

.meas tran vdout1_0ck40 FIND v(dout1_0) AT=50.05n

.meas tran vdout1_1ck40 FIND v(dout1_1) AT=50.05n

.meas tran vdout1_2ck40 FIND v(dout1_2) AT=50.05n

.meas tran vdout1_3ck40 FIND v(dout1_3) AT=50.05n

.meas tran vdout1_4ck40 FIND v(dout1_4) AT=50.05n

.meas tran vdout1_5ck40 FIND v(dout1_5) AT=50.05n

.meas tran vdout1_6ck40 FIND v(dout1_6) AT=50.05n

.meas tran vdout1_7ck40 FIND v(dout1_7) AT=50.05n

.meas tran vdout1_8ck40 FIND v(dout1_8) AT=50.05n

.meas tran vdout1_9ck40 FIND v(dout1_9) AT=50.05n

.meas tran vdout1_10ck40 FIND v(dout1_10) AT=50.05n

.meas tran vdout1_11ck40 FIND v(dout1_11) AT=50.05n

.meas tran vdout1_12ck40 FIND v(dout1_12) AT=50.05n

.meas tran vdout1_13ck40 FIND v(dout1_13) AT=50.05n

.meas tran vdout1_14ck40 FIND v(dout1_14) AT=50.05n

.meas tran vdout1_15ck40 FIND v(dout1_15) AT=50.05n

.meas tran vdout1_16ck40 FIND v(dout1_16) AT=50.05n

.meas tran vdout1_17ck40 FIND v(dout1_17) AT=50.05n

.meas tran vdout1_18ck40 FIND v(dout1_18) AT=50.05n

.meas tran vdout1_19ck40 FIND v(dout1_19) AT=50.05n

.meas tran vdout1_20ck40 FIND v(dout1_20) AT=50.05n

.meas tran vdout1_21ck40 FIND v(dout1_21) AT=50.05n

.meas tran vdout1_22ck40 FIND v(dout1_22) AT=50.05n

.meas tran vdout1_23ck40 FIND v(dout1_23) AT=50.05n

.meas tran vdout1_24ck40 FIND v(dout1_24) AT=50.05n

.meas tran vdout1_25ck40 FIND v(dout1_25) AT=50.05n

.meas tran vdout1_26ck40 FIND v(dout1_26) AT=50.05n

.meas tran vdout1_27ck40 FIND v(dout1_27) AT=50.05n

.meas tran vdout1_28ck40 FIND v(dout1_28) AT=50.05n

.meas tran vdout1_29ck40 FIND v(dout1_29) AT=50.05n

.meas tran vdout1_30ck40 FIND v(dout1_30) AT=50.05n

.meas tran vdout1_31ck40 FIND v(dout1_31) AT=50.05n

.meas tran vdout1_0ck50 FIND v(dout1_0) AT=60.05n

.meas tran vdout1_1ck50 FIND v(dout1_1) AT=60.05n

.meas tran vdout1_2ck50 FIND v(dout1_2) AT=60.05n

.meas tran vdout1_3ck50 FIND v(dout1_3) AT=60.05n

.meas tran vdout1_4ck50 FIND v(dout1_4) AT=60.05n

.meas tran vdout1_5ck50 FIND v(dout1_5) AT=60.05n

.meas tran vdout1_6ck50 FIND v(dout1_6) AT=60.05n

.meas tran vdout1_7ck50 FIND v(dout1_7) AT=60.05n

.meas tran vdout1_8ck50 FIND v(dout1_8) AT=60.05n

.meas tran vdout1_9ck50 FIND v(dout1_9) AT=60.05n

.meas tran vdout1_10ck50 FIND v(dout1_10) AT=60.05n

.meas tran vdout1_11ck50 FIND v(dout1_11) AT=60.05n

.meas tran vdout1_12ck50 FIND v(dout1_12) AT=60.05n

.meas tran vdout1_13ck50 FIND v(dout1_13) AT=60.05n

.meas tran vdout1_14ck50 FIND v(dout1_14) AT=60.05n

.meas tran vdout1_15ck50 FIND v(dout1_15) AT=60.05n

.meas tran vdout1_16ck50 FIND v(dout1_16) AT=60.05n

.meas tran vdout1_17ck50 FIND v(dout1_17) AT=60.05n

.meas tran vdout1_18ck50 FIND v(dout1_18) AT=60.05n

.meas tran vdout1_19ck50 FIND v(dout1_19) AT=60.05n

.meas tran vdout1_20ck50 FIND v(dout1_20) AT=60.05n

.meas tran vdout1_21ck50 FIND v(dout1_21) AT=60.05n

.meas tran vdout1_22ck50 FIND v(dout1_22) AT=60.05n

.meas tran vdout1_23ck50 FIND v(dout1_23) AT=60.05n

.meas tran vdout1_24ck50 FIND v(dout1_24) AT=60.05n

.meas tran vdout1_25ck50 FIND v(dout1_25) AT=60.05n

.meas tran vdout1_26ck50 FIND v(dout1_26) AT=60.05n

.meas tran vdout1_27ck50 FIND v(dout1_27) AT=60.05n

.meas tran vdout1_28ck50 FIND v(dout1_28) AT=60.05n

.meas tran vdout1_29ck50 FIND v(dout1_29) AT=60.05n

.meas tran vdout1_30ck50 FIND v(dout1_30) AT=60.05n

.meas tran vdout1_31ck50 FIND v(dout1_31) AT=60.05n

.meas tran vdout0_0ck60 FIND v(dout0_0) AT=70.05n

.meas tran vdout0_1ck60 FIND v(dout0_1) AT=70.05n

.meas tran vdout0_2ck60 FIND v(dout0_2) AT=70.05n

.meas tran vdout0_3ck60 FIND v(dout0_3) AT=70.05n

.meas tran vdout0_4ck60 FIND v(dout0_4) AT=70.05n

.meas tran vdout0_5ck60 FIND v(dout0_5) AT=70.05n

.meas tran vdout0_6ck60 FIND v(dout0_6) AT=70.05n

.meas tran vdout0_7ck60 FIND v(dout0_7) AT=70.05n

.meas tran vdout0_8ck60 FIND v(dout0_8) AT=70.05n

.meas tran vdout0_9ck60 FIND v(dout0_9) AT=70.05n

.meas tran vdout0_10ck60 FIND v(dout0_10) AT=70.05n

.meas tran vdout0_11ck60 FIND v(dout0_11) AT=70.05n

.meas tran vdout0_12ck60 FIND v(dout0_12) AT=70.05n

.meas tran vdout0_13ck60 FIND v(dout0_13) AT=70.05n

.meas tran vdout0_14ck60 FIND v(dout0_14) AT=70.05n

.meas tran vdout0_15ck60 FIND v(dout0_15) AT=70.05n

.meas tran vdout0_16ck60 FIND v(dout0_16) AT=70.05n

.meas tran vdout0_17ck60 FIND v(dout0_17) AT=70.05n

.meas tran vdout0_18ck60 FIND v(dout0_18) AT=70.05n

.meas tran vdout0_19ck60 FIND v(dout0_19) AT=70.05n

.meas tran vdout0_20ck60 FIND v(dout0_20) AT=70.05n

.meas tran vdout0_21ck60 FIND v(dout0_21) AT=70.05n

.meas tran vdout0_22ck60 FIND v(dout0_22) AT=70.05n

.meas tran vdout0_23ck60 FIND v(dout0_23) AT=70.05n

.meas tran vdout0_24ck60 FIND v(dout0_24) AT=70.05n

.meas tran vdout0_25ck60 FIND v(dout0_25) AT=70.05n

.meas tran vdout0_26ck60 FIND v(dout0_26) AT=70.05n

.meas tran vdout0_27ck60 FIND v(dout0_27) AT=70.05n

.meas tran vdout0_28ck60 FIND v(dout0_28) AT=70.05n

.meas tran vdout0_29ck60 FIND v(dout0_29) AT=70.05n

.meas tran vdout0_30ck60 FIND v(dout0_30) AT=70.05n

.meas tran vdout0_31ck60 FIND v(dout0_31) AT=70.05n

.meas tran vdout1_0ck60 FIND v(dout1_0) AT=70.05n

.meas tran vdout1_1ck60 FIND v(dout1_1) AT=70.05n

.meas tran vdout1_2ck60 FIND v(dout1_2) AT=70.05n

.meas tran vdout1_3ck60 FIND v(dout1_3) AT=70.05n

.meas tran vdout1_4ck60 FIND v(dout1_4) AT=70.05n

.meas tran vdout1_5ck60 FIND v(dout1_5) AT=70.05n

.meas tran vdout1_6ck60 FIND v(dout1_6) AT=70.05n

.meas tran vdout1_7ck60 FIND v(dout1_7) AT=70.05n

.meas tran vdout1_8ck60 FIND v(dout1_8) AT=70.05n

.meas tran vdout1_9ck60 FIND v(dout1_9) AT=70.05n

.meas tran vdout1_10ck60 FIND v(dout1_10) AT=70.05n

.meas tran vdout1_11ck60 FIND v(dout1_11) AT=70.05n

.meas tran vdout1_12ck60 FIND v(dout1_12) AT=70.05n

.meas tran vdout1_13ck60 FIND v(dout1_13) AT=70.05n

.meas tran vdout1_14ck60 FIND v(dout1_14) AT=70.05n

.meas tran vdout1_15ck60 FIND v(dout1_15) AT=70.05n

.meas tran vdout1_16ck60 FIND v(dout1_16) AT=70.05n

.meas tran vdout1_17ck60 FIND v(dout1_17) AT=70.05n

.meas tran vdout1_18ck60 FIND v(dout1_18) AT=70.05n

.meas tran vdout1_19ck60 FIND v(dout1_19) AT=70.05n

.meas tran vdout1_20ck60 FIND v(dout1_20) AT=70.05n

.meas tran vdout1_21ck60 FIND v(dout1_21) AT=70.05n

.meas tran vdout1_22ck60 FIND v(dout1_22) AT=70.05n

.meas tran vdout1_23ck60 FIND v(dout1_23) AT=70.05n

.meas tran vdout1_24ck60 FIND v(dout1_24) AT=70.05n

.meas tran vdout1_25ck60 FIND v(dout1_25) AT=70.05n

.meas tran vdout1_26ck60 FIND v(dout1_26) AT=70.05n

.meas tran vdout1_27ck60 FIND v(dout1_27) AT=70.05n

.meas tran vdout1_28ck60 FIND v(dout1_28) AT=70.05n

.meas tran vdout1_29ck60 FIND v(dout1_29) AT=70.05n

.meas tran vdout1_30ck60 FIND v(dout1_30) AT=70.05n

.meas tran vdout1_31ck60 FIND v(dout1_31) AT=70.05n

.meas tran vdout1_0ck70 FIND v(dout1_0) AT=80.05n

.meas tran vdout1_1ck70 FIND v(dout1_1) AT=80.05n

.meas tran vdout1_2ck70 FIND v(dout1_2) AT=80.05n

.meas tran vdout1_3ck70 FIND v(dout1_3) AT=80.05n

.meas tran vdout1_4ck70 FIND v(dout1_4) AT=80.05n

.meas tran vdout1_5ck70 FIND v(dout1_5) AT=80.05n

.meas tran vdout1_6ck70 FIND v(dout1_6) AT=80.05n

.meas tran vdout1_7ck70 FIND v(dout1_7) AT=80.05n

.meas tran vdout1_8ck70 FIND v(dout1_8) AT=80.05n

.meas tran vdout1_9ck70 FIND v(dout1_9) AT=80.05n

.meas tran vdout1_10ck70 FIND v(dout1_10) AT=80.05n

.meas tran vdout1_11ck70 FIND v(dout1_11) AT=80.05n

.meas tran vdout1_12ck70 FIND v(dout1_12) AT=80.05n

.meas tran vdout1_13ck70 FIND v(dout1_13) AT=80.05n

.meas tran vdout1_14ck70 FIND v(dout1_14) AT=80.05n

.meas tran vdout1_15ck70 FIND v(dout1_15) AT=80.05n

.meas tran vdout1_16ck70 FIND v(dout1_16) AT=80.05n

.meas tran vdout1_17ck70 FIND v(dout1_17) AT=80.05n

.meas tran vdout1_18ck70 FIND v(dout1_18) AT=80.05n

.meas tran vdout1_19ck70 FIND v(dout1_19) AT=80.05n

.meas tran vdout1_20ck70 FIND v(dout1_20) AT=80.05n

.meas tran vdout1_21ck70 FIND v(dout1_21) AT=80.05n

.meas tran vdout1_22ck70 FIND v(dout1_22) AT=80.05n

.meas tran vdout1_23ck70 FIND v(dout1_23) AT=80.05n

.meas tran vdout1_24ck70 FIND v(dout1_24) AT=80.05n

.meas tran vdout1_25ck70 FIND v(dout1_25) AT=80.05n

.meas tran vdout1_26ck70 FIND v(dout1_26) AT=80.05n

.meas tran vdout1_27ck70 FIND v(dout1_27) AT=80.05n

.meas tran vdout1_28ck70 FIND v(dout1_28) AT=80.05n

.meas tran vdout1_29ck70 FIND v(dout1_29) AT=80.05n

.meas tran vdout1_30ck70 FIND v(dout1_30) AT=80.05n

.meas tran vdout1_31ck70 FIND v(dout1_31) AT=80.05n

.meas tran vdout0_0ck110 FIND v(dout0_0) AT=120.05n

.meas tran vdout0_1ck110 FIND v(dout0_1) AT=120.05n

.meas tran vdout0_2ck110 FIND v(dout0_2) AT=120.05n

.meas tran vdout0_3ck110 FIND v(dout0_3) AT=120.05n

.meas tran vdout0_4ck110 FIND v(dout0_4) AT=120.05n

.meas tran vdout0_5ck110 FIND v(dout0_5) AT=120.05n

.meas tran vdout0_6ck110 FIND v(dout0_6) AT=120.05n

.meas tran vdout0_7ck110 FIND v(dout0_7) AT=120.05n

.meas tran vdout0_8ck110 FIND v(dout0_8) AT=120.05n

.meas tran vdout0_9ck110 FIND v(dout0_9) AT=120.05n

.meas tran vdout0_10ck110 FIND v(dout0_10) AT=120.05n

.meas tran vdout0_11ck110 FIND v(dout0_11) AT=120.05n

.meas tran vdout0_12ck110 FIND v(dout0_12) AT=120.05n

.meas tran vdout0_13ck110 FIND v(dout0_13) AT=120.05n

.meas tran vdout0_14ck110 FIND v(dout0_14) AT=120.05n

.meas tran vdout0_15ck110 FIND v(dout0_15) AT=120.05n

.meas tran vdout0_16ck110 FIND v(dout0_16) AT=120.05n

.meas tran vdout0_17ck110 FIND v(dout0_17) AT=120.05n

.meas tran vdout0_18ck110 FIND v(dout0_18) AT=120.05n

.meas tran vdout0_19ck110 FIND v(dout0_19) AT=120.05n

.meas tran vdout0_20ck110 FIND v(dout0_20) AT=120.05n

.meas tran vdout0_21ck110 FIND v(dout0_21) AT=120.05n

.meas tran vdout0_22ck110 FIND v(dout0_22) AT=120.05n

.meas tran vdout0_23ck110 FIND v(dout0_23) AT=120.05n

.meas tran vdout0_24ck110 FIND v(dout0_24) AT=120.05n

.meas tran vdout0_25ck110 FIND v(dout0_25) AT=120.05n

.meas tran vdout0_26ck110 FIND v(dout0_26) AT=120.05n

.meas tran vdout0_27ck110 FIND v(dout0_27) AT=120.05n

.meas tran vdout0_28ck110 FIND v(dout0_28) AT=120.05n

.meas tran vdout0_29ck110 FIND v(dout0_29) AT=120.05n

.meas tran vdout0_30ck110 FIND v(dout0_30) AT=120.05n

.meas tran vdout0_31ck110 FIND v(dout0_31) AT=120.05n

.meas tran vdout1_0ck110 FIND v(dout1_0) AT=120.05n

.meas tran vdout1_1ck110 FIND v(dout1_1) AT=120.05n

.meas tran vdout1_2ck110 FIND v(dout1_2) AT=120.05n

.meas tran vdout1_3ck110 FIND v(dout1_3) AT=120.05n

.meas tran vdout1_4ck110 FIND v(dout1_4) AT=120.05n

.meas tran vdout1_5ck110 FIND v(dout1_5) AT=120.05n

.meas tran vdout1_6ck110 FIND v(dout1_6) AT=120.05n

.meas tran vdout1_7ck110 FIND v(dout1_7) AT=120.05n

.meas tran vdout1_8ck110 FIND v(dout1_8) AT=120.05n

.meas tran vdout1_9ck110 FIND v(dout1_9) AT=120.05n

.meas tran vdout1_10ck110 FIND v(dout1_10) AT=120.05n

.meas tran vdout1_11ck110 FIND v(dout1_11) AT=120.05n

.meas tran vdout1_12ck110 FIND v(dout1_12) AT=120.05n

.meas tran vdout1_13ck110 FIND v(dout1_13) AT=120.05n

.meas tran vdout1_14ck110 FIND v(dout1_14) AT=120.05n

.meas tran vdout1_15ck110 FIND v(dout1_15) AT=120.05n

.meas tran vdout1_16ck110 FIND v(dout1_16) AT=120.05n

.meas tran vdout1_17ck110 FIND v(dout1_17) AT=120.05n

.meas tran vdout1_18ck110 FIND v(dout1_18) AT=120.05n

.meas tran vdout1_19ck110 FIND v(dout1_19) AT=120.05n

.meas tran vdout1_20ck110 FIND v(dout1_20) AT=120.05n

.meas tran vdout1_21ck110 FIND v(dout1_21) AT=120.05n

.meas tran vdout1_22ck110 FIND v(dout1_22) AT=120.05n

.meas tran vdout1_23ck110 FIND v(dout1_23) AT=120.05n

.meas tran vdout1_24ck110 FIND v(dout1_24) AT=120.05n

.meas tran vdout1_25ck110 FIND v(dout1_25) AT=120.05n

.meas tran vdout1_26ck110 FIND v(dout1_26) AT=120.05n

.meas tran vdout1_27ck110 FIND v(dout1_27) AT=120.05n

.meas tran vdout1_28ck110 FIND v(dout1_28) AT=120.05n

.meas tran vdout1_29ck110 FIND v(dout1_29) AT=120.05n

.meas tran vdout1_30ck110 FIND v(dout1_30) AT=120.05n

.meas tran vdout1_31ck110 FIND v(dout1_31) AT=120.05n

.meas tran vdout0_0ck130 FIND v(dout0_0) AT=140.05n

.meas tran vdout0_1ck130 FIND v(dout0_1) AT=140.05n

.meas tran vdout0_2ck130 FIND v(dout0_2) AT=140.05n

.meas tran vdout0_3ck130 FIND v(dout0_3) AT=140.05n

.meas tran vdout0_4ck130 FIND v(dout0_4) AT=140.05n

.meas tran vdout0_5ck130 FIND v(dout0_5) AT=140.05n

.meas tran vdout0_6ck130 FIND v(dout0_6) AT=140.05n

.meas tran vdout0_7ck130 FIND v(dout0_7) AT=140.05n

.meas tran vdout0_8ck130 FIND v(dout0_8) AT=140.05n

.meas tran vdout0_9ck130 FIND v(dout0_9) AT=140.05n

.meas tran vdout0_10ck130 FIND v(dout0_10) AT=140.05n

.meas tran vdout0_11ck130 FIND v(dout0_11) AT=140.05n

.meas tran vdout0_12ck130 FIND v(dout0_12) AT=140.05n

.meas tran vdout0_13ck130 FIND v(dout0_13) AT=140.05n

.meas tran vdout0_14ck130 FIND v(dout0_14) AT=140.05n

.meas tran vdout0_15ck130 FIND v(dout0_15) AT=140.05n

.meas tran vdout0_16ck130 FIND v(dout0_16) AT=140.05n

.meas tran vdout0_17ck130 FIND v(dout0_17) AT=140.05n

.meas tran vdout0_18ck130 FIND v(dout0_18) AT=140.05n

.meas tran vdout0_19ck130 FIND v(dout0_19) AT=140.05n

.meas tran vdout0_20ck130 FIND v(dout0_20) AT=140.05n

.meas tran vdout0_21ck130 FIND v(dout0_21) AT=140.05n

.meas tran vdout0_22ck130 FIND v(dout0_22) AT=140.05n

.meas tran vdout0_23ck130 FIND v(dout0_23) AT=140.05n

.meas tran vdout0_24ck130 FIND v(dout0_24) AT=140.05n

.meas tran vdout0_25ck130 FIND v(dout0_25) AT=140.05n

.meas tran vdout0_26ck130 FIND v(dout0_26) AT=140.05n

.meas tran vdout0_27ck130 FIND v(dout0_27) AT=140.05n

.meas tran vdout0_28ck130 FIND v(dout0_28) AT=140.05n

.meas tran vdout0_29ck130 FIND v(dout0_29) AT=140.05n

.meas tran vdout0_30ck130 FIND v(dout0_30) AT=140.05n

.meas tran vdout0_31ck130 FIND v(dout0_31) AT=140.05n

.meas tran vdout0_0ck150 FIND v(dout0_0) AT=160.05n

.meas tran vdout0_1ck150 FIND v(dout0_1) AT=160.05n

.meas tran vdout0_2ck150 FIND v(dout0_2) AT=160.05n

.meas tran vdout0_3ck150 FIND v(dout0_3) AT=160.05n

.meas tran vdout0_4ck150 FIND v(dout0_4) AT=160.05n

.meas tran vdout0_5ck150 FIND v(dout0_5) AT=160.05n

.meas tran vdout0_6ck150 FIND v(dout0_6) AT=160.05n

.meas tran vdout0_7ck150 FIND v(dout0_7) AT=160.05n

.meas tran vdout0_8ck150 FIND v(dout0_8) AT=160.05n

.meas tran vdout0_9ck150 FIND v(dout0_9) AT=160.05n

.meas tran vdout0_10ck150 FIND v(dout0_10) AT=160.05n

.meas tran vdout0_11ck150 FIND v(dout0_11) AT=160.05n

.meas tran vdout0_12ck150 FIND v(dout0_12) AT=160.05n

.meas tran vdout0_13ck150 FIND v(dout0_13) AT=160.05n

.meas tran vdout0_14ck150 FIND v(dout0_14) AT=160.05n

.meas tran vdout0_15ck150 FIND v(dout0_15) AT=160.05n

.meas tran vdout0_16ck150 FIND v(dout0_16) AT=160.05n

.meas tran vdout0_17ck150 FIND v(dout0_17) AT=160.05n

.meas tran vdout0_18ck150 FIND v(dout0_18) AT=160.05n

.meas tran vdout0_19ck150 FIND v(dout0_19) AT=160.05n

.meas tran vdout0_20ck150 FIND v(dout0_20) AT=160.05n

.meas tran vdout0_21ck150 FIND v(dout0_21) AT=160.05n

.meas tran vdout0_22ck150 FIND v(dout0_22) AT=160.05n

.meas tran vdout0_23ck150 FIND v(dout0_23) AT=160.05n

.meas tran vdout0_24ck150 FIND v(dout0_24) AT=160.05n

.meas tran vdout0_25ck150 FIND v(dout0_25) AT=160.05n

.meas tran vdout0_26ck150 FIND v(dout0_26) AT=160.05n

.meas tran vdout0_27ck150 FIND v(dout0_27) AT=160.05n

.meas tran vdout0_28ck150 FIND v(dout0_28) AT=160.05n

.meas tran vdout0_29ck150 FIND v(dout0_29) AT=160.05n

.meas tran vdout0_30ck150 FIND v(dout0_30) AT=160.05n

.meas tran vdout0_31ck150 FIND v(dout0_31) AT=160.05n

.meas tran vdout0_0ck160 FIND v(dout0_0) AT=170.05n

.meas tran vdout0_1ck160 FIND v(dout0_1) AT=170.05n

.meas tran vdout0_2ck160 FIND v(dout0_2) AT=170.05n

.meas tran vdout0_3ck160 FIND v(dout0_3) AT=170.05n

.meas tran vdout0_4ck160 FIND v(dout0_4) AT=170.05n

.meas tran vdout0_5ck160 FIND v(dout0_5) AT=170.05n

.meas tran vdout0_6ck160 FIND v(dout0_6) AT=170.05n

.meas tran vdout0_7ck160 FIND v(dout0_7) AT=170.05n

.meas tran vdout0_8ck160 FIND v(dout0_8) AT=170.05n

.meas tran vdout0_9ck160 FIND v(dout0_9) AT=170.05n

.meas tran vdout0_10ck160 FIND v(dout0_10) AT=170.05n

.meas tran vdout0_11ck160 FIND v(dout0_11) AT=170.05n

.meas tran vdout0_12ck160 FIND v(dout0_12) AT=170.05n

.meas tran vdout0_13ck160 FIND v(dout0_13) AT=170.05n

.meas tran vdout0_14ck160 FIND v(dout0_14) AT=170.05n

.meas tran vdout0_15ck160 FIND v(dout0_15) AT=170.05n

.meas tran vdout0_16ck160 FIND v(dout0_16) AT=170.05n

.meas tran vdout0_17ck160 FIND v(dout0_17) AT=170.05n

.meas tran vdout0_18ck160 FIND v(dout0_18) AT=170.05n

.meas tran vdout0_19ck160 FIND v(dout0_19) AT=170.05n

.meas tran vdout0_20ck160 FIND v(dout0_20) AT=170.05n

.meas tran vdout0_21ck160 FIND v(dout0_21) AT=170.05n

.meas tran vdout0_22ck160 FIND v(dout0_22) AT=170.05n

.meas tran vdout0_23ck160 FIND v(dout0_23) AT=170.05n

.meas tran vdout0_24ck160 FIND v(dout0_24) AT=170.05n

.meas tran vdout0_25ck160 FIND v(dout0_25) AT=170.05n

.meas tran vdout0_26ck160 FIND v(dout0_26) AT=170.05n

.meas tran vdout0_27ck160 FIND v(dout0_27) AT=170.05n

.meas tran vdout0_28ck160 FIND v(dout0_28) AT=170.05n

.meas tran vdout0_29ck160 FIND v(dout0_29) AT=170.05n

.meas tran vdout0_30ck160 FIND v(dout0_30) AT=170.05n

.meas tran vdout0_31ck160 FIND v(dout0_31) AT=170.05n

.meas tran vdout1_0ck160 FIND v(dout1_0) AT=170.05n

.meas tran vdout1_1ck160 FIND v(dout1_1) AT=170.05n

.meas tran vdout1_2ck160 FIND v(dout1_2) AT=170.05n

.meas tran vdout1_3ck160 FIND v(dout1_3) AT=170.05n

.meas tran vdout1_4ck160 FIND v(dout1_4) AT=170.05n

.meas tran vdout1_5ck160 FIND v(dout1_5) AT=170.05n

.meas tran vdout1_6ck160 FIND v(dout1_6) AT=170.05n

.meas tran vdout1_7ck160 FIND v(dout1_7) AT=170.05n

.meas tran vdout1_8ck160 FIND v(dout1_8) AT=170.05n

.meas tran vdout1_9ck160 FIND v(dout1_9) AT=170.05n

.meas tran vdout1_10ck160 FIND v(dout1_10) AT=170.05n

.meas tran vdout1_11ck160 FIND v(dout1_11) AT=170.05n

.meas tran vdout1_12ck160 FIND v(dout1_12) AT=170.05n

.meas tran vdout1_13ck160 FIND v(dout1_13) AT=170.05n

.meas tran vdout1_14ck160 FIND v(dout1_14) AT=170.05n

.meas tran vdout1_15ck160 FIND v(dout1_15) AT=170.05n

.meas tran vdout1_16ck160 FIND v(dout1_16) AT=170.05n

.meas tran vdout1_17ck160 FIND v(dout1_17) AT=170.05n

.meas tran vdout1_18ck160 FIND v(dout1_18) AT=170.05n

.meas tran vdout1_19ck160 FIND v(dout1_19) AT=170.05n

.meas tran vdout1_20ck160 FIND v(dout1_20) AT=170.05n

.meas tran vdout1_21ck160 FIND v(dout1_21) AT=170.05n

.meas tran vdout1_22ck160 FIND v(dout1_22) AT=170.05n

.meas tran vdout1_23ck160 FIND v(dout1_23) AT=170.05n

.meas tran vdout1_24ck160 FIND v(dout1_24) AT=170.05n

.meas tran vdout1_25ck160 FIND v(dout1_25) AT=170.05n

.meas tran vdout1_26ck160 FIND v(dout1_26) AT=170.05n

.meas tran vdout1_27ck160 FIND v(dout1_27) AT=170.05n

.meas tran vdout1_28ck160 FIND v(dout1_28) AT=170.05n

.meas tran vdout1_29ck160 FIND v(dout1_29) AT=170.05n

.meas tran vdout1_30ck160 FIND v(dout1_30) AT=170.05n

.meas tran vdout1_31ck160 FIND v(dout1_31) AT=170.05n

.meas tran vdout1_0ck170 FIND v(dout1_0) AT=180.05n

.meas tran vdout1_1ck170 FIND v(dout1_1) AT=180.05n

.meas tran vdout1_2ck170 FIND v(dout1_2) AT=180.05n

.meas tran vdout1_3ck170 FIND v(dout1_3) AT=180.05n

.meas tran vdout1_4ck170 FIND v(dout1_4) AT=180.05n

.meas tran vdout1_5ck170 FIND v(dout1_5) AT=180.05n

.meas tran vdout1_6ck170 FIND v(dout1_6) AT=180.05n

.meas tran vdout1_7ck170 FIND v(dout1_7) AT=180.05n

.meas tran vdout1_8ck170 FIND v(dout1_8) AT=180.05n

.meas tran vdout1_9ck170 FIND v(dout1_9) AT=180.05n

.meas tran vdout1_10ck170 FIND v(dout1_10) AT=180.05n

.meas tran vdout1_11ck170 FIND v(dout1_11) AT=180.05n

.meas tran vdout1_12ck170 FIND v(dout1_12) AT=180.05n

.meas tran vdout1_13ck170 FIND v(dout1_13) AT=180.05n

.meas tran vdout1_14ck170 FIND v(dout1_14) AT=180.05n

.meas tran vdout1_15ck170 FIND v(dout1_15) AT=180.05n

.meas tran vdout1_16ck170 FIND v(dout1_16) AT=180.05n

.meas tran vdout1_17ck170 FIND v(dout1_17) AT=180.05n

.meas tran vdout1_18ck170 FIND v(dout1_18) AT=180.05n

.meas tran vdout1_19ck170 FIND v(dout1_19) AT=180.05n

.meas tran vdout1_20ck170 FIND v(dout1_20) AT=180.05n

.meas tran vdout1_21ck170 FIND v(dout1_21) AT=180.05n

.meas tran vdout1_22ck170 FIND v(dout1_22) AT=180.05n

.meas tran vdout1_23ck170 FIND v(dout1_23) AT=180.05n

.meas tran vdout1_24ck170 FIND v(dout1_24) AT=180.05n

.meas tran vdout1_25ck170 FIND v(dout1_25) AT=180.05n

.meas tran vdout1_26ck170 FIND v(dout1_26) AT=180.05n

.meas tran vdout1_27ck170 FIND v(dout1_27) AT=180.05n

.meas tran vdout1_28ck170 FIND v(dout1_28) AT=180.05n

.meas tran vdout1_29ck170 FIND v(dout1_29) AT=180.05n

.meas tran vdout1_30ck170 FIND v(dout1_30) AT=180.05n

.meas tran vdout1_31ck170 FIND v(dout1_31) AT=180.05n

.meas tran vdout1_0ck220 FIND v(dout1_0) AT=230.05n

.meas tran vdout1_1ck220 FIND v(dout1_1) AT=230.05n

.meas tran vdout1_2ck220 FIND v(dout1_2) AT=230.05n

.meas tran vdout1_3ck220 FIND v(dout1_3) AT=230.05n

.meas tran vdout1_4ck220 FIND v(dout1_4) AT=230.05n

.meas tran vdout1_5ck220 FIND v(dout1_5) AT=230.05n

.meas tran vdout1_6ck220 FIND v(dout1_6) AT=230.05n

.meas tran vdout1_7ck220 FIND v(dout1_7) AT=230.05n

.meas tran vdout1_8ck220 FIND v(dout1_8) AT=230.05n

.meas tran vdout1_9ck220 FIND v(dout1_9) AT=230.05n

.meas tran vdout1_10ck220 FIND v(dout1_10) AT=230.05n

.meas tran vdout1_11ck220 FIND v(dout1_11) AT=230.05n

.meas tran vdout1_12ck220 FIND v(dout1_12) AT=230.05n

.meas tran vdout1_13ck220 FIND v(dout1_13) AT=230.05n

.meas tran vdout1_14ck220 FIND v(dout1_14) AT=230.05n

.meas tran vdout1_15ck220 FIND v(dout1_15) AT=230.05n

.meas tran vdout1_16ck220 FIND v(dout1_16) AT=230.05n

.meas tran vdout1_17ck220 FIND v(dout1_17) AT=230.05n

.meas tran vdout1_18ck220 FIND v(dout1_18) AT=230.05n

.meas tran vdout1_19ck220 FIND v(dout1_19) AT=230.05n

.meas tran vdout1_20ck220 FIND v(dout1_20) AT=230.05n

.meas tran vdout1_21ck220 FIND v(dout1_21) AT=230.05n

.meas tran vdout1_22ck220 FIND v(dout1_22) AT=230.05n

.meas tran vdout1_23ck220 FIND v(dout1_23) AT=230.05n

.meas tran vdout1_24ck220 FIND v(dout1_24) AT=230.05n

.meas tran vdout1_25ck220 FIND v(dout1_25) AT=230.05n

.meas tran vdout1_26ck220 FIND v(dout1_26) AT=230.05n

.meas tran vdout1_27ck220 FIND v(dout1_27) AT=230.05n

.meas tran vdout1_28ck220 FIND v(dout1_28) AT=230.05n

.meas tran vdout1_29ck220 FIND v(dout1_29) AT=230.05n

.meas tran vdout1_30ck220 FIND v(dout1_30) AT=230.05n

.meas tran vdout1_31ck220 FIND v(dout1_31) AT=230.05n

.meas tran vdout1_0ck240 FIND v(dout1_0) AT=250.05n

.meas tran vdout1_1ck240 FIND v(dout1_1) AT=250.05n

.meas tran vdout1_2ck240 FIND v(dout1_2) AT=250.05n

.meas tran vdout1_3ck240 FIND v(dout1_3) AT=250.05n

.meas tran vdout1_4ck240 FIND v(dout1_4) AT=250.05n

.meas tran vdout1_5ck240 FIND v(dout1_5) AT=250.05n

.meas tran vdout1_6ck240 FIND v(dout1_6) AT=250.05n

.meas tran vdout1_7ck240 FIND v(dout1_7) AT=250.05n

.meas tran vdout1_8ck240 FIND v(dout1_8) AT=250.05n

.meas tran vdout1_9ck240 FIND v(dout1_9) AT=250.05n

.meas tran vdout1_10ck240 FIND v(dout1_10) AT=250.05n

.meas tran vdout1_11ck240 FIND v(dout1_11) AT=250.05n

.meas tran vdout1_12ck240 FIND v(dout1_12) AT=250.05n

.meas tran vdout1_13ck240 FIND v(dout1_13) AT=250.05n

.meas tran vdout1_14ck240 FIND v(dout1_14) AT=250.05n

.meas tran vdout1_15ck240 FIND v(dout1_15) AT=250.05n

.meas tran vdout1_16ck240 FIND v(dout1_16) AT=250.05n

.meas tran vdout1_17ck240 FIND v(dout1_17) AT=250.05n

.meas tran vdout1_18ck240 FIND v(dout1_18) AT=250.05n

.meas tran vdout1_19ck240 FIND v(dout1_19) AT=250.05n

.meas tran vdout1_20ck240 FIND v(dout1_20) AT=250.05n

.meas tran vdout1_21ck240 FIND v(dout1_21) AT=250.05n

.meas tran vdout1_22ck240 FIND v(dout1_22) AT=250.05n

.meas tran vdout1_23ck240 FIND v(dout1_23) AT=250.05n

.meas tran vdout1_24ck240 FIND v(dout1_24) AT=250.05n

.meas tran vdout1_25ck240 FIND v(dout1_25) AT=250.05n

.meas tran vdout1_26ck240 FIND v(dout1_26) AT=250.05n

.meas tran vdout1_27ck240 FIND v(dout1_27) AT=250.05n

.meas tran vdout1_28ck240 FIND v(dout1_28) AT=250.05n

.meas tran vdout1_29ck240 FIND v(dout1_29) AT=250.05n

.meas tran vdout1_30ck240 FIND v(dout1_30) AT=250.05n

.meas tran vdout1_31ck240 FIND v(dout1_31) AT=250.05n

.meas tran vdout0_0ck280 FIND v(dout0_0) AT=290.05n

.meas tran vdout0_1ck280 FIND v(dout0_1) AT=290.05n

.meas tran vdout0_2ck280 FIND v(dout0_2) AT=290.05n

.meas tran vdout0_3ck280 FIND v(dout0_3) AT=290.05n

.meas tran vdout0_4ck280 FIND v(dout0_4) AT=290.05n

.meas tran vdout0_5ck280 FIND v(dout0_5) AT=290.05n

.meas tran vdout0_6ck280 FIND v(dout0_6) AT=290.05n

.meas tran vdout0_7ck280 FIND v(dout0_7) AT=290.05n

.meas tran vdout0_8ck280 FIND v(dout0_8) AT=290.05n

.meas tran vdout0_9ck280 FIND v(dout0_9) AT=290.05n

.meas tran vdout0_10ck280 FIND v(dout0_10) AT=290.05n

.meas tran vdout0_11ck280 FIND v(dout0_11) AT=290.05n

.meas tran vdout0_12ck280 FIND v(dout0_12) AT=290.05n

.meas tran vdout0_13ck280 FIND v(dout0_13) AT=290.05n

.meas tran vdout0_14ck280 FIND v(dout0_14) AT=290.05n

.meas tran vdout0_15ck280 FIND v(dout0_15) AT=290.05n

.meas tran vdout0_16ck280 FIND v(dout0_16) AT=290.05n

.meas tran vdout0_17ck280 FIND v(dout0_17) AT=290.05n

.meas tran vdout0_18ck280 FIND v(dout0_18) AT=290.05n

.meas tran vdout0_19ck280 FIND v(dout0_19) AT=290.05n

.meas tran vdout0_20ck280 FIND v(dout0_20) AT=290.05n

.meas tran vdout0_21ck280 FIND v(dout0_21) AT=290.05n

.meas tran vdout0_22ck280 FIND v(dout0_22) AT=290.05n

.meas tran vdout0_23ck280 FIND v(dout0_23) AT=290.05n

.meas tran vdout0_24ck280 FIND v(dout0_24) AT=290.05n

.meas tran vdout0_25ck280 FIND v(dout0_25) AT=290.05n

.meas tran vdout0_26ck280 FIND v(dout0_26) AT=290.05n

.meas tran vdout0_27ck280 FIND v(dout0_27) AT=290.05n

.meas tran vdout0_28ck280 FIND v(dout0_28) AT=290.05n

.meas tran vdout0_29ck280 FIND v(dout0_29) AT=290.05n

.meas tran vdout0_30ck280 FIND v(dout0_30) AT=290.05n

.meas tran vdout0_31ck280 FIND v(dout0_31) AT=290.05n

.meas tran vdout1_0ck300 FIND v(dout1_0) AT=310.05n

.meas tran vdout1_1ck300 FIND v(dout1_1) AT=310.05n

.meas tran vdout1_2ck300 FIND v(dout1_2) AT=310.05n

.meas tran vdout1_3ck300 FIND v(dout1_3) AT=310.05n

.meas tran vdout1_4ck300 FIND v(dout1_4) AT=310.05n

.meas tran vdout1_5ck300 FIND v(dout1_5) AT=310.05n

.meas tran vdout1_6ck300 FIND v(dout1_6) AT=310.05n

.meas tran vdout1_7ck300 FIND v(dout1_7) AT=310.05n

.meas tran vdout1_8ck300 FIND v(dout1_8) AT=310.05n

.meas tran vdout1_9ck300 FIND v(dout1_9) AT=310.05n

.meas tran vdout1_10ck300 FIND v(dout1_10) AT=310.05n

.meas tran vdout1_11ck300 FIND v(dout1_11) AT=310.05n

.meas tran vdout1_12ck300 FIND v(dout1_12) AT=310.05n

.meas tran vdout1_13ck300 FIND v(dout1_13) AT=310.05n

.meas tran vdout1_14ck300 FIND v(dout1_14) AT=310.05n

.meas tran vdout1_15ck300 FIND v(dout1_15) AT=310.05n

.meas tran vdout1_16ck300 FIND v(dout1_16) AT=310.05n

.meas tran vdout1_17ck300 FIND v(dout1_17) AT=310.05n

.meas tran vdout1_18ck300 FIND v(dout1_18) AT=310.05n

.meas tran vdout1_19ck300 FIND v(dout1_19) AT=310.05n

.meas tran vdout1_20ck300 FIND v(dout1_20) AT=310.05n

.meas tran vdout1_21ck300 FIND v(dout1_21) AT=310.05n

.meas tran vdout1_22ck300 FIND v(dout1_22) AT=310.05n

.meas tran vdout1_23ck300 FIND v(dout1_23) AT=310.05n

.meas tran vdout1_24ck300 FIND v(dout1_24) AT=310.05n

.meas tran vdout1_25ck300 FIND v(dout1_25) AT=310.05n

.meas tran vdout1_26ck300 FIND v(dout1_26) AT=310.05n

.meas tran vdout1_27ck300 FIND v(dout1_27) AT=310.05n

.meas tran vdout1_28ck300 FIND v(dout1_28) AT=310.05n

.meas tran vdout1_29ck300 FIND v(dout1_29) AT=310.05n

.meas tran vdout1_30ck300 FIND v(dout1_30) AT=310.05n

.meas tran vdout1_31ck300 FIND v(dout1_31) AT=310.05n

.meas tran vdout1_0ck310 FIND v(dout1_0) AT=320.05n

.meas tran vdout1_1ck310 FIND v(dout1_1) AT=320.05n

.meas tran vdout1_2ck310 FIND v(dout1_2) AT=320.05n

.meas tran vdout1_3ck310 FIND v(dout1_3) AT=320.05n

.meas tran vdout1_4ck310 FIND v(dout1_4) AT=320.05n

.meas tran vdout1_5ck310 FIND v(dout1_5) AT=320.05n

.meas tran vdout1_6ck310 FIND v(dout1_6) AT=320.05n

.meas tran vdout1_7ck310 FIND v(dout1_7) AT=320.05n

.meas tran vdout1_8ck310 FIND v(dout1_8) AT=320.05n

.meas tran vdout1_9ck310 FIND v(dout1_9) AT=320.05n

.meas tran vdout1_10ck310 FIND v(dout1_10) AT=320.05n

.meas tran vdout1_11ck310 FIND v(dout1_11) AT=320.05n

.meas tran vdout1_12ck310 FIND v(dout1_12) AT=320.05n

.meas tran vdout1_13ck310 FIND v(dout1_13) AT=320.05n

.meas tran vdout1_14ck310 FIND v(dout1_14) AT=320.05n

.meas tran vdout1_15ck310 FIND v(dout1_15) AT=320.05n

.meas tran vdout1_16ck310 FIND v(dout1_16) AT=320.05n

.meas tran vdout1_17ck310 FIND v(dout1_17) AT=320.05n

.meas tran vdout1_18ck310 FIND v(dout1_18) AT=320.05n

.meas tran vdout1_19ck310 FIND v(dout1_19) AT=320.05n

.meas tran vdout1_20ck310 FIND v(dout1_20) AT=320.05n

.meas tran vdout1_21ck310 FIND v(dout1_21) AT=320.05n

.meas tran vdout1_22ck310 FIND v(dout1_22) AT=320.05n

.meas tran vdout1_23ck310 FIND v(dout1_23) AT=320.05n

.meas tran vdout1_24ck310 FIND v(dout1_24) AT=320.05n

.meas tran vdout1_25ck310 FIND v(dout1_25) AT=320.05n

.meas tran vdout1_26ck310 FIND v(dout1_26) AT=320.05n

.meas tran vdout1_27ck310 FIND v(dout1_27) AT=320.05n

.meas tran vdout1_28ck310 FIND v(dout1_28) AT=320.05n

.meas tran vdout1_29ck310 FIND v(dout1_29) AT=320.05n

.meas tran vdout1_30ck310 FIND v(dout1_30) AT=320.05n

.meas tran vdout1_31ck310 FIND v(dout1_31) AT=320.05n

.meas tran vdout0_0ck340 FIND v(dout0_0) AT=350.05n

.meas tran vdout0_1ck340 FIND v(dout0_1) AT=350.05n

.meas tran vdout0_2ck340 FIND v(dout0_2) AT=350.05n

.meas tran vdout0_3ck340 FIND v(dout0_3) AT=350.05n

.meas tran vdout0_4ck340 FIND v(dout0_4) AT=350.05n

.meas tran vdout0_5ck340 FIND v(dout0_5) AT=350.05n

.meas tran vdout0_6ck340 FIND v(dout0_6) AT=350.05n

.meas tran vdout0_7ck340 FIND v(dout0_7) AT=350.05n

.meas tran vdout0_8ck340 FIND v(dout0_8) AT=350.05n

.meas tran vdout0_9ck340 FIND v(dout0_9) AT=350.05n

.meas tran vdout0_10ck340 FIND v(dout0_10) AT=350.05n

.meas tran vdout0_11ck340 FIND v(dout0_11) AT=350.05n

.meas tran vdout0_12ck340 FIND v(dout0_12) AT=350.05n

.meas tran vdout0_13ck340 FIND v(dout0_13) AT=350.05n

.meas tran vdout0_14ck340 FIND v(dout0_14) AT=350.05n

.meas tran vdout0_15ck340 FIND v(dout0_15) AT=350.05n

.meas tran vdout0_16ck340 FIND v(dout0_16) AT=350.05n

.meas tran vdout0_17ck340 FIND v(dout0_17) AT=350.05n

.meas tran vdout0_18ck340 FIND v(dout0_18) AT=350.05n

.meas tran vdout0_19ck340 FIND v(dout0_19) AT=350.05n

.meas tran vdout0_20ck340 FIND v(dout0_20) AT=350.05n

.meas tran vdout0_21ck340 FIND v(dout0_21) AT=350.05n

.meas tran vdout0_22ck340 FIND v(dout0_22) AT=350.05n

.meas tran vdout0_23ck340 FIND v(dout0_23) AT=350.05n

.meas tran vdout0_24ck340 FIND v(dout0_24) AT=350.05n

.meas tran vdout0_25ck340 FIND v(dout0_25) AT=350.05n

.meas tran vdout0_26ck340 FIND v(dout0_26) AT=350.05n

.meas tran vdout0_27ck340 FIND v(dout0_27) AT=350.05n

.meas tran vdout0_28ck340 FIND v(dout0_28) AT=350.05n

.meas tran vdout0_29ck340 FIND v(dout0_29) AT=350.05n

.meas tran vdout0_30ck340 FIND v(dout0_30) AT=350.05n

.meas tran vdout0_31ck340 FIND v(dout0_31) AT=350.05n

.meas tran vdout0_0ck350 FIND v(dout0_0) AT=360.05n

.meas tran vdout0_1ck350 FIND v(dout0_1) AT=360.05n

.meas tran vdout0_2ck350 FIND v(dout0_2) AT=360.05n

.meas tran vdout0_3ck350 FIND v(dout0_3) AT=360.05n

.meas tran vdout0_4ck350 FIND v(dout0_4) AT=360.05n

.meas tran vdout0_5ck350 FIND v(dout0_5) AT=360.05n

.meas tran vdout0_6ck350 FIND v(dout0_6) AT=360.05n

.meas tran vdout0_7ck350 FIND v(dout0_7) AT=360.05n

.meas tran vdout0_8ck350 FIND v(dout0_8) AT=360.05n

.meas tran vdout0_9ck350 FIND v(dout0_9) AT=360.05n

.meas tran vdout0_10ck350 FIND v(dout0_10) AT=360.05n

.meas tran vdout0_11ck350 FIND v(dout0_11) AT=360.05n

.meas tran vdout0_12ck350 FIND v(dout0_12) AT=360.05n

.meas tran vdout0_13ck350 FIND v(dout0_13) AT=360.05n

.meas tran vdout0_14ck350 FIND v(dout0_14) AT=360.05n

.meas tran vdout0_15ck350 FIND v(dout0_15) AT=360.05n

.meas tran vdout0_16ck350 FIND v(dout0_16) AT=360.05n

.meas tran vdout0_17ck350 FIND v(dout0_17) AT=360.05n

.meas tran vdout0_18ck350 FIND v(dout0_18) AT=360.05n

.meas tran vdout0_19ck350 FIND v(dout0_19) AT=360.05n

.meas tran vdout0_20ck350 FIND v(dout0_20) AT=360.05n

.meas tran vdout0_21ck350 FIND v(dout0_21) AT=360.05n

.meas tran vdout0_22ck350 FIND v(dout0_22) AT=360.05n

.meas tran vdout0_23ck350 FIND v(dout0_23) AT=360.05n

.meas tran vdout0_24ck350 FIND v(dout0_24) AT=360.05n

.meas tran vdout0_25ck350 FIND v(dout0_25) AT=360.05n

.meas tran vdout0_26ck350 FIND v(dout0_26) AT=360.05n

.meas tran vdout0_27ck350 FIND v(dout0_27) AT=360.05n

.meas tran vdout0_28ck350 FIND v(dout0_28) AT=360.05n

.meas tran vdout0_29ck350 FIND v(dout0_29) AT=360.05n

.meas tran vdout0_30ck350 FIND v(dout0_30) AT=360.05n

.meas tran vdout0_31ck350 FIND v(dout0_31) AT=360.05n

.meas tran vdout1_0ck350 FIND v(dout1_0) AT=360.05n

.meas tran vdout1_1ck350 FIND v(dout1_1) AT=360.05n

.meas tran vdout1_2ck350 FIND v(dout1_2) AT=360.05n

.meas tran vdout1_3ck350 FIND v(dout1_3) AT=360.05n

.meas tran vdout1_4ck350 FIND v(dout1_4) AT=360.05n

.meas tran vdout1_5ck350 FIND v(dout1_5) AT=360.05n

.meas tran vdout1_6ck350 FIND v(dout1_6) AT=360.05n

.meas tran vdout1_7ck350 FIND v(dout1_7) AT=360.05n

.meas tran vdout1_8ck350 FIND v(dout1_8) AT=360.05n

.meas tran vdout1_9ck350 FIND v(dout1_9) AT=360.05n

.meas tran vdout1_10ck350 FIND v(dout1_10) AT=360.05n

.meas tran vdout1_11ck350 FIND v(dout1_11) AT=360.05n

.meas tran vdout1_12ck350 FIND v(dout1_12) AT=360.05n

.meas tran vdout1_13ck350 FIND v(dout1_13) AT=360.05n

.meas tran vdout1_14ck350 FIND v(dout1_14) AT=360.05n

.meas tran vdout1_15ck350 FIND v(dout1_15) AT=360.05n

.meas tran vdout1_16ck350 FIND v(dout1_16) AT=360.05n

.meas tran vdout1_17ck350 FIND v(dout1_17) AT=360.05n

.meas tran vdout1_18ck350 FIND v(dout1_18) AT=360.05n

.meas tran vdout1_19ck350 FIND v(dout1_19) AT=360.05n

.meas tran vdout1_20ck350 FIND v(dout1_20) AT=360.05n

.meas tran vdout1_21ck350 FIND v(dout1_21) AT=360.05n

.meas tran vdout1_22ck350 FIND v(dout1_22) AT=360.05n

.meas tran vdout1_23ck350 FIND v(dout1_23) AT=360.05n

.meas tran vdout1_24ck350 FIND v(dout1_24) AT=360.05n

.meas tran vdout1_25ck350 FIND v(dout1_25) AT=360.05n

.meas tran vdout1_26ck350 FIND v(dout1_26) AT=360.05n

.meas tran vdout1_27ck350 FIND v(dout1_27) AT=360.05n

.meas tran vdout1_28ck350 FIND v(dout1_28) AT=360.05n

.meas tran vdout1_29ck350 FIND v(dout1_29) AT=360.05n

.meas tran vdout1_30ck350 FIND v(dout1_30) AT=360.05n

.meas tran vdout1_31ck350 FIND v(dout1_31) AT=360.05n

.meas tran vdout0_0ck380 FIND v(dout0_0) AT=390.05n

.meas tran vdout0_1ck380 FIND v(dout0_1) AT=390.05n

.meas tran vdout0_2ck380 FIND v(dout0_2) AT=390.05n

.meas tran vdout0_3ck380 FIND v(dout0_3) AT=390.05n

.meas tran vdout0_4ck380 FIND v(dout0_4) AT=390.05n

.meas tran vdout0_5ck380 FIND v(dout0_5) AT=390.05n

.meas tran vdout0_6ck380 FIND v(dout0_6) AT=390.05n

.meas tran vdout0_7ck380 FIND v(dout0_7) AT=390.05n

.meas tran vdout0_8ck380 FIND v(dout0_8) AT=390.05n

.meas tran vdout0_9ck380 FIND v(dout0_9) AT=390.05n

.meas tran vdout0_10ck380 FIND v(dout0_10) AT=390.05n

.meas tran vdout0_11ck380 FIND v(dout0_11) AT=390.05n

.meas tran vdout0_12ck380 FIND v(dout0_12) AT=390.05n

.meas tran vdout0_13ck380 FIND v(dout0_13) AT=390.05n

.meas tran vdout0_14ck380 FIND v(dout0_14) AT=390.05n

.meas tran vdout0_15ck380 FIND v(dout0_15) AT=390.05n

.meas tran vdout0_16ck380 FIND v(dout0_16) AT=390.05n

.meas tran vdout0_17ck380 FIND v(dout0_17) AT=390.05n

.meas tran vdout0_18ck380 FIND v(dout0_18) AT=390.05n

.meas tran vdout0_19ck380 FIND v(dout0_19) AT=390.05n

.meas tran vdout0_20ck380 FIND v(dout0_20) AT=390.05n

.meas tran vdout0_21ck380 FIND v(dout0_21) AT=390.05n

.meas tran vdout0_22ck380 FIND v(dout0_22) AT=390.05n

.meas tran vdout0_23ck380 FIND v(dout0_23) AT=390.05n

.meas tran vdout0_24ck380 FIND v(dout0_24) AT=390.05n

.meas tran vdout0_25ck380 FIND v(dout0_25) AT=390.05n

.meas tran vdout0_26ck380 FIND v(dout0_26) AT=390.05n

.meas tran vdout0_27ck380 FIND v(dout0_27) AT=390.05n

.meas tran vdout0_28ck380 FIND v(dout0_28) AT=390.05n

.meas tran vdout0_29ck380 FIND v(dout0_29) AT=390.05n

.meas tran vdout0_30ck380 FIND v(dout0_30) AT=390.05n

.meas tran vdout0_31ck380 FIND v(dout0_31) AT=390.05n

.meas tran vdout0_0ck390 FIND v(dout0_0) AT=400.05n

.meas tran vdout0_1ck390 FIND v(dout0_1) AT=400.05n

.meas tran vdout0_2ck390 FIND v(dout0_2) AT=400.05n

.meas tran vdout0_3ck390 FIND v(dout0_3) AT=400.05n

.meas tran vdout0_4ck390 FIND v(dout0_4) AT=400.05n

.meas tran vdout0_5ck390 FIND v(dout0_5) AT=400.05n

.meas tran vdout0_6ck390 FIND v(dout0_6) AT=400.05n

.meas tran vdout0_7ck390 FIND v(dout0_7) AT=400.05n

.meas tran vdout0_8ck390 FIND v(dout0_8) AT=400.05n

.meas tran vdout0_9ck390 FIND v(dout0_9) AT=400.05n

.meas tran vdout0_10ck390 FIND v(dout0_10) AT=400.05n

.meas tran vdout0_11ck390 FIND v(dout0_11) AT=400.05n

.meas tran vdout0_12ck390 FIND v(dout0_12) AT=400.05n

.meas tran vdout0_13ck390 FIND v(dout0_13) AT=400.05n

.meas tran vdout0_14ck390 FIND v(dout0_14) AT=400.05n

.meas tran vdout0_15ck390 FIND v(dout0_15) AT=400.05n

.meas tran vdout0_16ck390 FIND v(dout0_16) AT=400.05n

.meas tran vdout0_17ck390 FIND v(dout0_17) AT=400.05n

.meas tran vdout0_18ck390 FIND v(dout0_18) AT=400.05n

.meas tran vdout0_19ck390 FIND v(dout0_19) AT=400.05n

.meas tran vdout0_20ck390 FIND v(dout0_20) AT=400.05n

.meas tran vdout0_21ck390 FIND v(dout0_21) AT=400.05n

.meas tran vdout0_22ck390 FIND v(dout0_22) AT=400.05n

.meas tran vdout0_23ck390 FIND v(dout0_23) AT=400.05n

.meas tran vdout0_24ck390 FIND v(dout0_24) AT=400.05n

.meas tran vdout0_25ck390 FIND v(dout0_25) AT=400.05n

.meas tran vdout0_26ck390 FIND v(dout0_26) AT=400.05n

.meas tran vdout0_27ck390 FIND v(dout0_27) AT=400.05n

.meas tran vdout0_28ck390 FIND v(dout0_28) AT=400.05n

.meas tran vdout0_29ck390 FIND v(dout0_29) AT=400.05n

.meas tran vdout0_30ck390 FIND v(dout0_30) AT=400.05n

.meas tran vdout0_31ck390 FIND v(dout0_31) AT=400.05n

.meas tran vdout1_0ck390 FIND v(dout1_0) AT=400.05n

.meas tran vdout1_1ck390 FIND v(dout1_1) AT=400.05n

.meas tran vdout1_2ck390 FIND v(dout1_2) AT=400.05n

.meas tran vdout1_3ck390 FIND v(dout1_3) AT=400.05n

.meas tran vdout1_4ck390 FIND v(dout1_4) AT=400.05n

.meas tran vdout1_5ck390 FIND v(dout1_5) AT=400.05n

.meas tran vdout1_6ck390 FIND v(dout1_6) AT=400.05n

.meas tran vdout1_7ck390 FIND v(dout1_7) AT=400.05n

.meas tran vdout1_8ck390 FIND v(dout1_8) AT=400.05n

.meas tran vdout1_9ck390 FIND v(dout1_9) AT=400.05n

.meas tran vdout1_10ck390 FIND v(dout1_10) AT=400.05n

.meas tran vdout1_11ck390 FIND v(dout1_11) AT=400.05n

.meas tran vdout1_12ck390 FIND v(dout1_12) AT=400.05n

.meas tran vdout1_13ck390 FIND v(dout1_13) AT=400.05n

.meas tran vdout1_14ck390 FIND v(dout1_14) AT=400.05n

.meas tran vdout1_15ck390 FIND v(dout1_15) AT=400.05n

.meas tran vdout1_16ck390 FIND v(dout1_16) AT=400.05n

.meas tran vdout1_17ck390 FIND v(dout1_17) AT=400.05n

.meas tran vdout1_18ck390 FIND v(dout1_18) AT=400.05n

.meas tran vdout1_19ck390 FIND v(dout1_19) AT=400.05n

.meas tran vdout1_20ck390 FIND v(dout1_20) AT=400.05n

.meas tran vdout1_21ck390 FIND v(dout1_21) AT=400.05n

.meas tran vdout1_22ck390 FIND v(dout1_22) AT=400.05n

.meas tran vdout1_23ck390 FIND v(dout1_23) AT=400.05n

.meas tran vdout1_24ck390 FIND v(dout1_24) AT=400.05n

.meas tran vdout1_25ck390 FIND v(dout1_25) AT=400.05n

.meas tran vdout1_26ck390 FIND v(dout1_26) AT=400.05n

.meas tran vdout1_27ck390 FIND v(dout1_27) AT=400.05n

.meas tran vdout1_28ck390 FIND v(dout1_28) AT=400.05n

.meas tran vdout1_29ck390 FIND v(dout1_29) AT=400.05n

.meas tran vdout1_30ck390 FIND v(dout1_30) AT=400.05n

.meas tran vdout1_31ck390 FIND v(dout1_31) AT=400.05n

.meas tran vdout0_0ck400 FIND v(dout0_0) AT=410.05n

.meas tran vdout0_1ck400 FIND v(dout0_1) AT=410.05n

.meas tran vdout0_2ck400 FIND v(dout0_2) AT=410.05n

.meas tran vdout0_3ck400 FIND v(dout0_3) AT=410.05n

.meas tran vdout0_4ck400 FIND v(dout0_4) AT=410.05n

.meas tran vdout0_5ck400 FIND v(dout0_5) AT=410.05n

.meas tran vdout0_6ck400 FIND v(dout0_6) AT=410.05n

.meas tran vdout0_7ck400 FIND v(dout0_7) AT=410.05n

.meas tran vdout0_8ck400 FIND v(dout0_8) AT=410.05n

.meas tran vdout0_9ck400 FIND v(dout0_9) AT=410.05n

.meas tran vdout0_10ck400 FIND v(dout0_10) AT=410.05n

.meas tran vdout0_11ck400 FIND v(dout0_11) AT=410.05n

.meas tran vdout0_12ck400 FIND v(dout0_12) AT=410.05n

.meas tran vdout0_13ck400 FIND v(dout0_13) AT=410.05n

.meas tran vdout0_14ck400 FIND v(dout0_14) AT=410.05n

.meas tran vdout0_15ck400 FIND v(dout0_15) AT=410.05n

.meas tran vdout0_16ck400 FIND v(dout0_16) AT=410.05n

.meas tran vdout0_17ck400 FIND v(dout0_17) AT=410.05n

.meas tran vdout0_18ck400 FIND v(dout0_18) AT=410.05n

.meas tran vdout0_19ck400 FIND v(dout0_19) AT=410.05n

.meas tran vdout0_20ck400 FIND v(dout0_20) AT=410.05n

.meas tran vdout0_21ck400 FIND v(dout0_21) AT=410.05n

.meas tran vdout0_22ck400 FIND v(dout0_22) AT=410.05n

.meas tran vdout0_23ck400 FIND v(dout0_23) AT=410.05n

.meas tran vdout0_24ck400 FIND v(dout0_24) AT=410.05n

.meas tran vdout0_25ck400 FIND v(dout0_25) AT=410.05n

.meas tran vdout0_26ck400 FIND v(dout0_26) AT=410.05n

.meas tran vdout0_27ck400 FIND v(dout0_27) AT=410.05n

.meas tran vdout0_28ck400 FIND v(dout0_28) AT=410.05n

.meas tran vdout0_29ck400 FIND v(dout0_29) AT=410.05n

.meas tran vdout0_30ck400 FIND v(dout0_30) AT=410.05n

.meas tran vdout0_31ck400 FIND v(dout0_31) AT=410.05n

.meas tran vdout1_0ck400 FIND v(dout1_0) AT=410.05n

.meas tran vdout1_1ck400 FIND v(dout1_1) AT=410.05n

.meas tran vdout1_2ck400 FIND v(dout1_2) AT=410.05n

.meas tran vdout1_3ck400 FIND v(dout1_3) AT=410.05n

.meas tran vdout1_4ck400 FIND v(dout1_4) AT=410.05n

.meas tran vdout1_5ck400 FIND v(dout1_5) AT=410.05n

.meas tran vdout1_6ck400 FIND v(dout1_6) AT=410.05n

.meas tran vdout1_7ck400 FIND v(dout1_7) AT=410.05n

.meas tran vdout1_8ck400 FIND v(dout1_8) AT=410.05n

.meas tran vdout1_9ck400 FIND v(dout1_9) AT=410.05n

.meas tran vdout1_10ck400 FIND v(dout1_10) AT=410.05n

.meas tran vdout1_11ck400 FIND v(dout1_11) AT=410.05n

.meas tran vdout1_12ck400 FIND v(dout1_12) AT=410.05n

.meas tran vdout1_13ck400 FIND v(dout1_13) AT=410.05n

.meas tran vdout1_14ck400 FIND v(dout1_14) AT=410.05n

.meas tran vdout1_15ck400 FIND v(dout1_15) AT=410.05n

.meas tran vdout1_16ck400 FIND v(dout1_16) AT=410.05n

.meas tran vdout1_17ck400 FIND v(dout1_17) AT=410.05n

.meas tran vdout1_18ck400 FIND v(dout1_18) AT=410.05n

.meas tran vdout1_19ck400 FIND v(dout1_19) AT=410.05n

.meas tran vdout1_20ck400 FIND v(dout1_20) AT=410.05n

.meas tran vdout1_21ck400 FIND v(dout1_21) AT=410.05n

.meas tran vdout1_22ck400 FIND v(dout1_22) AT=410.05n

.meas tran vdout1_23ck400 FIND v(dout1_23) AT=410.05n

.meas tran vdout1_24ck400 FIND v(dout1_24) AT=410.05n

.meas tran vdout1_25ck400 FIND v(dout1_25) AT=410.05n

.meas tran vdout1_26ck400 FIND v(dout1_26) AT=410.05n

.meas tran vdout1_27ck400 FIND v(dout1_27) AT=410.05n

.meas tran vdout1_28ck400 FIND v(dout1_28) AT=410.05n

.meas tran vdout1_29ck400 FIND v(dout1_29) AT=410.05n

.meas tran vdout1_30ck400 FIND v(dout1_30) AT=410.05n

.meas tran vdout1_31ck400 FIND v(dout1_31) AT=410.05n

.meas tran vdout1_0ck410 FIND v(dout1_0) AT=420.05n

.meas tran vdout1_1ck410 FIND v(dout1_1) AT=420.05n

.meas tran vdout1_2ck410 FIND v(dout1_2) AT=420.05n

.meas tran vdout1_3ck410 FIND v(dout1_3) AT=420.05n

.meas tran vdout1_4ck410 FIND v(dout1_4) AT=420.05n

.meas tran vdout1_5ck410 FIND v(dout1_5) AT=420.05n

.meas tran vdout1_6ck410 FIND v(dout1_6) AT=420.05n

.meas tran vdout1_7ck410 FIND v(dout1_7) AT=420.05n

.meas tran vdout1_8ck410 FIND v(dout1_8) AT=420.05n

.meas tran vdout1_9ck410 FIND v(dout1_9) AT=420.05n

.meas tran vdout1_10ck410 FIND v(dout1_10) AT=420.05n

.meas tran vdout1_11ck410 FIND v(dout1_11) AT=420.05n

.meas tran vdout1_12ck410 FIND v(dout1_12) AT=420.05n

.meas tran vdout1_13ck410 FIND v(dout1_13) AT=420.05n

.meas tran vdout1_14ck410 FIND v(dout1_14) AT=420.05n

.meas tran vdout1_15ck410 FIND v(dout1_15) AT=420.05n

.meas tran vdout1_16ck410 FIND v(dout1_16) AT=420.05n

.meas tran vdout1_17ck410 FIND v(dout1_17) AT=420.05n

.meas tran vdout1_18ck410 FIND v(dout1_18) AT=420.05n

.meas tran vdout1_19ck410 FIND v(dout1_19) AT=420.05n

.meas tran vdout1_20ck410 FIND v(dout1_20) AT=420.05n

.meas tran vdout1_21ck410 FIND v(dout1_21) AT=420.05n

.meas tran vdout1_22ck410 FIND v(dout1_22) AT=420.05n

.meas tran vdout1_23ck410 FIND v(dout1_23) AT=420.05n

.meas tran vdout1_24ck410 FIND v(dout1_24) AT=420.05n

.meas tran vdout1_25ck410 FIND v(dout1_25) AT=420.05n

.meas tran vdout1_26ck410 FIND v(dout1_26) AT=420.05n

.meas tran vdout1_27ck410 FIND v(dout1_27) AT=420.05n

.meas tran vdout1_28ck410 FIND v(dout1_28) AT=420.05n

.meas tran vdout1_29ck410 FIND v(dout1_29) AT=420.05n

.meas tran vdout1_30ck410 FIND v(dout1_30) AT=420.05n

.meas tran vdout1_31ck410 FIND v(dout1_31) AT=420.05n

.meas tran vdout0_0ck420 FIND v(dout0_0) AT=430.05n

.meas tran vdout0_1ck420 FIND v(dout0_1) AT=430.05n

.meas tran vdout0_2ck420 FIND v(dout0_2) AT=430.05n

.meas tran vdout0_3ck420 FIND v(dout0_3) AT=430.05n

.meas tran vdout0_4ck420 FIND v(dout0_4) AT=430.05n

.meas tran vdout0_5ck420 FIND v(dout0_5) AT=430.05n

.meas tran vdout0_6ck420 FIND v(dout0_6) AT=430.05n

.meas tran vdout0_7ck420 FIND v(dout0_7) AT=430.05n

.meas tran vdout0_8ck420 FIND v(dout0_8) AT=430.05n

.meas tran vdout0_9ck420 FIND v(dout0_9) AT=430.05n

.meas tran vdout0_10ck420 FIND v(dout0_10) AT=430.05n

.meas tran vdout0_11ck420 FIND v(dout0_11) AT=430.05n

.meas tran vdout0_12ck420 FIND v(dout0_12) AT=430.05n

.meas tran vdout0_13ck420 FIND v(dout0_13) AT=430.05n

.meas tran vdout0_14ck420 FIND v(dout0_14) AT=430.05n

.meas tran vdout0_15ck420 FIND v(dout0_15) AT=430.05n

.meas tran vdout0_16ck420 FIND v(dout0_16) AT=430.05n

.meas tran vdout0_17ck420 FIND v(dout0_17) AT=430.05n

.meas tran vdout0_18ck420 FIND v(dout0_18) AT=430.05n

.meas tran vdout0_19ck420 FIND v(dout0_19) AT=430.05n

.meas tran vdout0_20ck420 FIND v(dout0_20) AT=430.05n

.meas tran vdout0_21ck420 FIND v(dout0_21) AT=430.05n

.meas tran vdout0_22ck420 FIND v(dout0_22) AT=430.05n

.meas tran vdout0_23ck420 FIND v(dout0_23) AT=430.05n

.meas tran vdout0_24ck420 FIND v(dout0_24) AT=430.05n

.meas tran vdout0_25ck420 FIND v(dout0_25) AT=430.05n

.meas tran vdout0_26ck420 FIND v(dout0_26) AT=430.05n

.meas tran vdout0_27ck420 FIND v(dout0_27) AT=430.05n

.meas tran vdout0_28ck420 FIND v(dout0_28) AT=430.05n

.meas tran vdout0_29ck420 FIND v(dout0_29) AT=430.05n

.meas tran vdout0_30ck420 FIND v(dout0_30) AT=430.05n

.meas tran vdout0_31ck420 FIND v(dout0_31) AT=430.05n

.meas tran vdout1_0ck420 FIND v(dout1_0) AT=430.05n

.meas tran vdout1_1ck420 FIND v(dout1_1) AT=430.05n

.meas tran vdout1_2ck420 FIND v(dout1_2) AT=430.05n

.meas tran vdout1_3ck420 FIND v(dout1_3) AT=430.05n

.meas tran vdout1_4ck420 FIND v(dout1_4) AT=430.05n

.meas tran vdout1_5ck420 FIND v(dout1_5) AT=430.05n

.meas tran vdout1_6ck420 FIND v(dout1_6) AT=430.05n

.meas tran vdout1_7ck420 FIND v(dout1_7) AT=430.05n

.meas tran vdout1_8ck420 FIND v(dout1_8) AT=430.05n

.meas tran vdout1_9ck420 FIND v(dout1_9) AT=430.05n

.meas tran vdout1_10ck420 FIND v(dout1_10) AT=430.05n

.meas tran vdout1_11ck420 FIND v(dout1_11) AT=430.05n

.meas tran vdout1_12ck420 FIND v(dout1_12) AT=430.05n

.meas tran vdout1_13ck420 FIND v(dout1_13) AT=430.05n

.meas tran vdout1_14ck420 FIND v(dout1_14) AT=430.05n

.meas tran vdout1_15ck420 FIND v(dout1_15) AT=430.05n

.meas tran vdout1_16ck420 FIND v(dout1_16) AT=430.05n

.meas tran vdout1_17ck420 FIND v(dout1_17) AT=430.05n

.meas tran vdout1_18ck420 FIND v(dout1_18) AT=430.05n

.meas tran vdout1_19ck420 FIND v(dout1_19) AT=430.05n

.meas tran vdout1_20ck420 FIND v(dout1_20) AT=430.05n

.meas tran vdout1_21ck420 FIND v(dout1_21) AT=430.05n

.meas tran vdout1_22ck420 FIND v(dout1_22) AT=430.05n

.meas tran vdout1_23ck420 FIND v(dout1_23) AT=430.05n

.meas tran vdout1_24ck420 FIND v(dout1_24) AT=430.05n

.meas tran vdout1_25ck420 FIND v(dout1_25) AT=430.05n

.meas tran vdout1_26ck420 FIND v(dout1_26) AT=430.05n

.meas tran vdout1_27ck420 FIND v(dout1_27) AT=430.05n

.meas tran vdout1_28ck420 FIND v(dout1_28) AT=430.05n

.meas tran vdout1_29ck420 FIND v(dout1_29) AT=430.05n

.meas tran vdout1_30ck420 FIND v(dout1_30) AT=430.05n

.meas tran vdout1_31ck420 FIND v(dout1_31) AT=430.05n

.meas tran vdout0_0ck430 FIND v(dout0_0) AT=440.05n

.meas tran vdout0_1ck430 FIND v(dout0_1) AT=440.05n

.meas tran vdout0_2ck430 FIND v(dout0_2) AT=440.05n

.meas tran vdout0_3ck430 FIND v(dout0_3) AT=440.05n

.meas tran vdout0_4ck430 FIND v(dout0_4) AT=440.05n

.meas tran vdout0_5ck430 FIND v(dout0_5) AT=440.05n

.meas tran vdout0_6ck430 FIND v(dout0_6) AT=440.05n

.meas tran vdout0_7ck430 FIND v(dout0_7) AT=440.05n

.meas tran vdout0_8ck430 FIND v(dout0_8) AT=440.05n

.meas tran vdout0_9ck430 FIND v(dout0_9) AT=440.05n

.meas tran vdout0_10ck430 FIND v(dout0_10) AT=440.05n

.meas tran vdout0_11ck430 FIND v(dout0_11) AT=440.05n

.meas tran vdout0_12ck430 FIND v(dout0_12) AT=440.05n

.meas tran vdout0_13ck430 FIND v(dout0_13) AT=440.05n

.meas tran vdout0_14ck430 FIND v(dout0_14) AT=440.05n

.meas tran vdout0_15ck430 FIND v(dout0_15) AT=440.05n

.meas tran vdout0_16ck430 FIND v(dout0_16) AT=440.05n

.meas tran vdout0_17ck430 FIND v(dout0_17) AT=440.05n

.meas tran vdout0_18ck430 FIND v(dout0_18) AT=440.05n

.meas tran vdout0_19ck430 FIND v(dout0_19) AT=440.05n

.meas tran vdout0_20ck430 FIND v(dout0_20) AT=440.05n

.meas tran vdout0_21ck430 FIND v(dout0_21) AT=440.05n

.meas tran vdout0_22ck430 FIND v(dout0_22) AT=440.05n

.meas tran vdout0_23ck430 FIND v(dout0_23) AT=440.05n

.meas tran vdout0_24ck430 FIND v(dout0_24) AT=440.05n

.meas tran vdout0_25ck430 FIND v(dout0_25) AT=440.05n

.meas tran vdout0_26ck430 FIND v(dout0_26) AT=440.05n

.meas tran vdout0_27ck430 FIND v(dout0_27) AT=440.05n

.meas tran vdout0_28ck430 FIND v(dout0_28) AT=440.05n

.meas tran vdout0_29ck430 FIND v(dout0_29) AT=440.05n

.meas tran vdout0_30ck430 FIND v(dout0_30) AT=440.05n

.meas tran vdout0_31ck430 FIND v(dout0_31) AT=440.05n

.meas tran vdout1_0ck440 FIND v(dout1_0) AT=450.05n

.meas tran vdout1_1ck440 FIND v(dout1_1) AT=450.05n

.meas tran vdout1_2ck440 FIND v(dout1_2) AT=450.05n

.meas tran vdout1_3ck440 FIND v(dout1_3) AT=450.05n

.meas tran vdout1_4ck440 FIND v(dout1_4) AT=450.05n

.meas tran vdout1_5ck440 FIND v(dout1_5) AT=450.05n

.meas tran vdout1_6ck440 FIND v(dout1_6) AT=450.05n

.meas tran vdout1_7ck440 FIND v(dout1_7) AT=450.05n

.meas tran vdout1_8ck440 FIND v(dout1_8) AT=450.05n

.meas tran vdout1_9ck440 FIND v(dout1_9) AT=450.05n

.meas tran vdout1_10ck440 FIND v(dout1_10) AT=450.05n

.meas tran vdout1_11ck440 FIND v(dout1_11) AT=450.05n

.meas tran vdout1_12ck440 FIND v(dout1_12) AT=450.05n

.meas tran vdout1_13ck440 FIND v(dout1_13) AT=450.05n

.meas tran vdout1_14ck440 FIND v(dout1_14) AT=450.05n

.meas tran vdout1_15ck440 FIND v(dout1_15) AT=450.05n

.meas tran vdout1_16ck440 FIND v(dout1_16) AT=450.05n

.meas tran vdout1_17ck440 FIND v(dout1_17) AT=450.05n

.meas tran vdout1_18ck440 FIND v(dout1_18) AT=450.05n

.meas tran vdout1_19ck440 FIND v(dout1_19) AT=450.05n

.meas tran vdout1_20ck440 FIND v(dout1_20) AT=450.05n

.meas tran vdout1_21ck440 FIND v(dout1_21) AT=450.05n

.meas tran vdout1_22ck440 FIND v(dout1_22) AT=450.05n

.meas tran vdout1_23ck440 FIND v(dout1_23) AT=450.05n

.meas tran vdout1_24ck440 FIND v(dout1_24) AT=450.05n

.meas tran vdout1_25ck440 FIND v(dout1_25) AT=450.05n

.meas tran vdout1_26ck440 FIND v(dout1_26) AT=450.05n

.meas tran vdout1_27ck440 FIND v(dout1_27) AT=450.05n

.meas tran vdout1_28ck440 FIND v(dout1_28) AT=450.05n

.meas tran vdout1_29ck440 FIND v(dout1_29) AT=450.05n

.meas tran vdout1_30ck440 FIND v(dout1_30) AT=450.05n

.meas tran vdout1_31ck440 FIND v(dout1_31) AT=450.05n

.meas tran vdout1_0ck480 FIND v(dout1_0) AT=490.05n

.meas tran vdout1_1ck480 FIND v(dout1_1) AT=490.05n

.meas tran vdout1_2ck480 FIND v(dout1_2) AT=490.05n

.meas tran vdout1_3ck480 FIND v(dout1_3) AT=490.05n

.meas tran vdout1_4ck480 FIND v(dout1_4) AT=490.05n

.meas tran vdout1_5ck480 FIND v(dout1_5) AT=490.05n

.meas tran vdout1_6ck480 FIND v(dout1_6) AT=490.05n

.meas tran vdout1_7ck480 FIND v(dout1_7) AT=490.05n

.meas tran vdout1_8ck480 FIND v(dout1_8) AT=490.05n

.meas tran vdout1_9ck480 FIND v(dout1_9) AT=490.05n

.meas tran vdout1_10ck480 FIND v(dout1_10) AT=490.05n

.meas tran vdout1_11ck480 FIND v(dout1_11) AT=490.05n

.meas tran vdout1_12ck480 FIND v(dout1_12) AT=490.05n

.meas tran vdout1_13ck480 FIND v(dout1_13) AT=490.05n

.meas tran vdout1_14ck480 FIND v(dout1_14) AT=490.05n

.meas tran vdout1_15ck480 FIND v(dout1_15) AT=490.05n

.meas tran vdout1_16ck480 FIND v(dout1_16) AT=490.05n

.meas tran vdout1_17ck480 FIND v(dout1_17) AT=490.05n

.meas tran vdout1_18ck480 FIND v(dout1_18) AT=490.05n

.meas tran vdout1_19ck480 FIND v(dout1_19) AT=490.05n

.meas tran vdout1_20ck480 FIND v(dout1_20) AT=490.05n

.meas tran vdout1_21ck480 FIND v(dout1_21) AT=490.05n

.meas tran vdout1_22ck480 FIND v(dout1_22) AT=490.05n

.meas tran vdout1_23ck480 FIND v(dout1_23) AT=490.05n

.meas tran vdout1_24ck480 FIND v(dout1_24) AT=490.05n

.meas tran vdout1_25ck480 FIND v(dout1_25) AT=490.05n

.meas tran vdout1_26ck480 FIND v(dout1_26) AT=490.05n

.meas tran vdout1_27ck480 FIND v(dout1_27) AT=490.05n

.meas tran vdout1_28ck480 FIND v(dout1_28) AT=490.05n

.meas tran vdout1_29ck480 FIND v(dout1_29) AT=490.05n

.meas tran vdout1_30ck480 FIND v(dout1_30) AT=490.05n

.meas tran vdout1_31ck480 FIND v(dout1_31) AT=490.05n

.meas tran vdout0_0ck490 FIND v(dout0_0) AT=500.05n

.meas tran vdout0_1ck490 FIND v(dout0_1) AT=500.05n

.meas tran vdout0_2ck490 FIND v(dout0_2) AT=500.05n

.meas tran vdout0_3ck490 FIND v(dout0_3) AT=500.05n

.meas tran vdout0_4ck490 FIND v(dout0_4) AT=500.05n

.meas tran vdout0_5ck490 FIND v(dout0_5) AT=500.05n

.meas tran vdout0_6ck490 FIND v(dout0_6) AT=500.05n

.meas tran vdout0_7ck490 FIND v(dout0_7) AT=500.05n

.meas tran vdout0_8ck490 FIND v(dout0_8) AT=500.05n

.meas tran vdout0_9ck490 FIND v(dout0_9) AT=500.05n

.meas tran vdout0_10ck490 FIND v(dout0_10) AT=500.05n

.meas tran vdout0_11ck490 FIND v(dout0_11) AT=500.05n

.meas tran vdout0_12ck490 FIND v(dout0_12) AT=500.05n

.meas tran vdout0_13ck490 FIND v(dout0_13) AT=500.05n

.meas tran vdout0_14ck490 FIND v(dout0_14) AT=500.05n

.meas tran vdout0_15ck490 FIND v(dout0_15) AT=500.05n

.meas tran vdout0_16ck490 FIND v(dout0_16) AT=500.05n

.meas tran vdout0_17ck490 FIND v(dout0_17) AT=500.05n

.meas tran vdout0_18ck490 FIND v(dout0_18) AT=500.05n

.meas tran vdout0_19ck490 FIND v(dout0_19) AT=500.05n

.meas tran vdout0_20ck490 FIND v(dout0_20) AT=500.05n

.meas tran vdout0_21ck490 FIND v(dout0_21) AT=500.05n

.meas tran vdout0_22ck490 FIND v(dout0_22) AT=500.05n

.meas tran vdout0_23ck490 FIND v(dout0_23) AT=500.05n

.meas tran vdout0_24ck490 FIND v(dout0_24) AT=500.05n

.meas tran vdout0_25ck490 FIND v(dout0_25) AT=500.05n

.meas tran vdout0_26ck490 FIND v(dout0_26) AT=500.05n

.meas tran vdout0_27ck490 FIND v(dout0_27) AT=500.05n

.meas tran vdout0_28ck490 FIND v(dout0_28) AT=500.05n

.meas tran vdout0_29ck490 FIND v(dout0_29) AT=500.05n

.meas tran vdout0_30ck490 FIND v(dout0_30) AT=500.05n

.meas tran vdout0_31ck490 FIND v(dout0_31) AT=500.05n

.meas tran vdout0_0ck500 FIND v(dout0_0) AT=510.05n

.meas tran vdout0_1ck500 FIND v(dout0_1) AT=510.05n

.meas tran vdout0_2ck500 FIND v(dout0_2) AT=510.05n

.meas tran vdout0_3ck500 FIND v(dout0_3) AT=510.05n

.meas tran vdout0_4ck500 FIND v(dout0_4) AT=510.05n

.meas tran vdout0_5ck500 FIND v(dout0_5) AT=510.05n

.meas tran vdout0_6ck500 FIND v(dout0_6) AT=510.05n

.meas tran vdout0_7ck500 FIND v(dout0_7) AT=510.05n

.meas tran vdout0_8ck500 FIND v(dout0_8) AT=510.05n

.meas tran vdout0_9ck500 FIND v(dout0_9) AT=510.05n

.meas tran vdout0_10ck500 FIND v(dout0_10) AT=510.05n

.meas tran vdout0_11ck500 FIND v(dout0_11) AT=510.05n

.meas tran vdout0_12ck500 FIND v(dout0_12) AT=510.05n

.meas tran vdout0_13ck500 FIND v(dout0_13) AT=510.05n

.meas tran vdout0_14ck500 FIND v(dout0_14) AT=510.05n

.meas tran vdout0_15ck500 FIND v(dout0_15) AT=510.05n

.meas tran vdout0_16ck500 FIND v(dout0_16) AT=510.05n

.meas tran vdout0_17ck500 FIND v(dout0_17) AT=510.05n

.meas tran vdout0_18ck500 FIND v(dout0_18) AT=510.05n

.meas tran vdout0_19ck500 FIND v(dout0_19) AT=510.05n

.meas tran vdout0_20ck500 FIND v(dout0_20) AT=510.05n

.meas tran vdout0_21ck500 FIND v(dout0_21) AT=510.05n

.meas tran vdout0_22ck500 FIND v(dout0_22) AT=510.05n

.meas tran vdout0_23ck500 FIND v(dout0_23) AT=510.05n

.meas tran vdout0_24ck500 FIND v(dout0_24) AT=510.05n

.meas tran vdout0_25ck500 FIND v(dout0_25) AT=510.05n

.meas tran vdout0_26ck500 FIND v(dout0_26) AT=510.05n

.meas tran vdout0_27ck500 FIND v(dout0_27) AT=510.05n

.meas tran vdout0_28ck500 FIND v(dout0_28) AT=510.05n

.meas tran vdout0_29ck500 FIND v(dout0_29) AT=510.05n

.meas tran vdout0_30ck500 FIND v(dout0_30) AT=510.05n

.meas tran vdout0_31ck500 FIND v(dout0_31) AT=510.05n

.meas tran vdout1_0ck500 FIND v(dout1_0) AT=510.05n

.meas tran vdout1_1ck500 FIND v(dout1_1) AT=510.05n

.meas tran vdout1_2ck500 FIND v(dout1_2) AT=510.05n

.meas tran vdout1_3ck500 FIND v(dout1_3) AT=510.05n

.meas tran vdout1_4ck500 FIND v(dout1_4) AT=510.05n

.meas tran vdout1_5ck500 FIND v(dout1_5) AT=510.05n

.meas tran vdout1_6ck500 FIND v(dout1_6) AT=510.05n

.meas tran vdout1_7ck500 FIND v(dout1_7) AT=510.05n

.meas tran vdout1_8ck500 FIND v(dout1_8) AT=510.05n

.meas tran vdout1_9ck500 FIND v(dout1_9) AT=510.05n

.meas tran vdout1_10ck500 FIND v(dout1_10) AT=510.05n

.meas tran vdout1_11ck500 FIND v(dout1_11) AT=510.05n

.meas tran vdout1_12ck500 FIND v(dout1_12) AT=510.05n

.meas tran vdout1_13ck500 FIND v(dout1_13) AT=510.05n

.meas tran vdout1_14ck500 FIND v(dout1_14) AT=510.05n

.meas tran vdout1_15ck500 FIND v(dout1_15) AT=510.05n

.meas tran vdout1_16ck500 FIND v(dout1_16) AT=510.05n

.meas tran vdout1_17ck500 FIND v(dout1_17) AT=510.05n

.meas tran vdout1_18ck500 FIND v(dout1_18) AT=510.05n

.meas tran vdout1_19ck500 FIND v(dout1_19) AT=510.05n

.meas tran vdout1_20ck500 FIND v(dout1_20) AT=510.05n

.meas tran vdout1_21ck500 FIND v(dout1_21) AT=510.05n

.meas tran vdout1_22ck500 FIND v(dout1_22) AT=510.05n

.meas tran vdout1_23ck500 FIND v(dout1_23) AT=510.05n

.meas tran vdout1_24ck500 FIND v(dout1_24) AT=510.05n

.meas tran vdout1_25ck500 FIND v(dout1_25) AT=510.05n

.meas tran vdout1_26ck500 FIND v(dout1_26) AT=510.05n

.meas tran vdout1_27ck500 FIND v(dout1_27) AT=510.05n

.meas tran vdout1_28ck500 FIND v(dout1_28) AT=510.05n

.meas tran vdout1_29ck500 FIND v(dout1_29) AT=510.05n

.meas tran vdout1_30ck500 FIND v(dout1_30) AT=510.05n

.meas tran vdout1_31ck500 FIND v(dout1_31) AT=510.05n

.meas tran vdout1_0ck510 FIND v(dout1_0) AT=520.05n

.meas tran vdout1_1ck510 FIND v(dout1_1) AT=520.05n

.meas tran vdout1_2ck510 FIND v(dout1_2) AT=520.05n

.meas tran vdout1_3ck510 FIND v(dout1_3) AT=520.05n

.meas tran vdout1_4ck510 FIND v(dout1_4) AT=520.05n

.meas tran vdout1_5ck510 FIND v(dout1_5) AT=520.05n

.meas tran vdout1_6ck510 FIND v(dout1_6) AT=520.05n

.meas tran vdout1_7ck510 FIND v(dout1_7) AT=520.05n

.meas tran vdout1_8ck510 FIND v(dout1_8) AT=520.05n

.meas tran vdout1_9ck510 FIND v(dout1_9) AT=520.05n

.meas tran vdout1_10ck510 FIND v(dout1_10) AT=520.05n

.meas tran vdout1_11ck510 FIND v(dout1_11) AT=520.05n

.meas tran vdout1_12ck510 FIND v(dout1_12) AT=520.05n

.meas tran vdout1_13ck510 FIND v(dout1_13) AT=520.05n

.meas tran vdout1_14ck510 FIND v(dout1_14) AT=520.05n

.meas tran vdout1_15ck510 FIND v(dout1_15) AT=520.05n

.meas tran vdout1_16ck510 FIND v(dout1_16) AT=520.05n

.meas tran vdout1_17ck510 FIND v(dout1_17) AT=520.05n

.meas tran vdout1_18ck510 FIND v(dout1_18) AT=520.05n

.meas tran vdout1_19ck510 FIND v(dout1_19) AT=520.05n

.meas tran vdout1_20ck510 FIND v(dout1_20) AT=520.05n

.meas tran vdout1_21ck510 FIND v(dout1_21) AT=520.05n

.meas tran vdout1_22ck510 FIND v(dout1_22) AT=520.05n

.meas tran vdout1_23ck510 FIND v(dout1_23) AT=520.05n

.meas tran vdout1_24ck510 FIND v(dout1_24) AT=520.05n

.meas tran vdout1_25ck510 FIND v(dout1_25) AT=520.05n

.meas tran vdout1_26ck510 FIND v(dout1_26) AT=520.05n

.meas tran vdout1_27ck510 FIND v(dout1_27) AT=520.05n

.meas tran vdout1_28ck510 FIND v(dout1_28) AT=520.05n

.meas tran vdout1_29ck510 FIND v(dout1_29) AT=520.05n

.meas tran vdout1_30ck510 FIND v(dout1_30) AT=520.05n

.meas tran vdout1_31ck510 FIND v(dout1_31) AT=520.05n

.meas tran vdout0_0ck530 FIND v(dout0_0) AT=540.05n

.meas tran vdout0_1ck530 FIND v(dout0_1) AT=540.05n

.meas tran vdout0_2ck530 FIND v(dout0_2) AT=540.05n

.meas tran vdout0_3ck530 FIND v(dout0_3) AT=540.05n

.meas tran vdout0_4ck530 FIND v(dout0_4) AT=540.05n

.meas tran vdout0_5ck530 FIND v(dout0_5) AT=540.05n

.meas tran vdout0_6ck530 FIND v(dout0_6) AT=540.05n

.meas tran vdout0_7ck530 FIND v(dout0_7) AT=540.05n

.meas tran vdout0_8ck530 FIND v(dout0_8) AT=540.05n

.meas tran vdout0_9ck530 FIND v(dout0_9) AT=540.05n

.meas tran vdout0_10ck530 FIND v(dout0_10) AT=540.05n

.meas tran vdout0_11ck530 FIND v(dout0_11) AT=540.05n

.meas tran vdout0_12ck530 FIND v(dout0_12) AT=540.05n

.meas tran vdout0_13ck530 FIND v(dout0_13) AT=540.05n

.meas tran vdout0_14ck530 FIND v(dout0_14) AT=540.05n

.meas tran vdout0_15ck530 FIND v(dout0_15) AT=540.05n

.meas tran vdout0_16ck530 FIND v(dout0_16) AT=540.05n

.meas tran vdout0_17ck530 FIND v(dout0_17) AT=540.05n

.meas tran vdout0_18ck530 FIND v(dout0_18) AT=540.05n

.meas tran vdout0_19ck530 FIND v(dout0_19) AT=540.05n

.meas tran vdout0_20ck530 FIND v(dout0_20) AT=540.05n

.meas tran vdout0_21ck530 FIND v(dout0_21) AT=540.05n

.meas tran vdout0_22ck530 FIND v(dout0_22) AT=540.05n

.meas tran vdout0_23ck530 FIND v(dout0_23) AT=540.05n

.meas tran vdout0_24ck530 FIND v(dout0_24) AT=540.05n

.meas tran vdout0_25ck530 FIND v(dout0_25) AT=540.05n

.meas tran vdout0_26ck530 FIND v(dout0_26) AT=540.05n

.meas tran vdout0_27ck530 FIND v(dout0_27) AT=540.05n

.meas tran vdout0_28ck530 FIND v(dout0_28) AT=540.05n

.meas tran vdout0_29ck530 FIND v(dout0_29) AT=540.05n

.meas tran vdout0_30ck530 FIND v(dout0_30) AT=540.05n

.meas tran vdout0_31ck530 FIND v(dout0_31) AT=540.05n

.meas tran vdout1_0ck530 FIND v(dout1_0) AT=540.05n

.meas tran vdout1_1ck530 FIND v(dout1_1) AT=540.05n

.meas tran vdout1_2ck530 FIND v(dout1_2) AT=540.05n

.meas tran vdout1_3ck530 FIND v(dout1_3) AT=540.05n

.meas tran vdout1_4ck530 FIND v(dout1_4) AT=540.05n

.meas tran vdout1_5ck530 FIND v(dout1_5) AT=540.05n

.meas tran vdout1_6ck530 FIND v(dout1_6) AT=540.05n

.meas tran vdout1_7ck530 FIND v(dout1_7) AT=540.05n

.meas tran vdout1_8ck530 FIND v(dout1_8) AT=540.05n

.meas tran vdout1_9ck530 FIND v(dout1_9) AT=540.05n

.meas tran vdout1_10ck530 FIND v(dout1_10) AT=540.05n

.meas tran vdout1_11ck530 FIND v(dout1_11) AT=540.05n

.meas tran vdout1_12ck530 FIND v(dout1_12) AT=540.05n

.meas tran vdout1_13ck530 FIND v(dout1_13) AT=540.05n

.meas tran vdout1_14ck530 FIND v(dout1_14) AT=540.05n

.meas tran vdout1_15ck530 FIND v(dout1_15) AT=540.05n

.meas tran vdout1_16ck530 FIND v(dout1_16) AT=540.05n

.meas tran vdout1_17ck530 FIND v(dout1_17) AT=540.05n

.meas tran vdout1_18ck530 FIND v(dout1_18) AT=540.05n

.meas tran vdout1_19ck530 FIND v(dout1_19) AT=540.05n

.meas tran vdout1_20ck530 FIND v(dout1_20) AT=540.05n

.meas tran vdout1_21ck530 FIND v(dout1_21) AT=540.05n

.meas tran vdout1_22ck530 FIND v(dout1_22) AT=540.05n

.meas tran vdout1_23ck530 FIND v(dout1_23) AT=540.05n

.meas tran vdout1_24ck530 FIND v(dout1_24) AT=540.05n

.meas tran vdout1_25ck530 FIND v(dout1_25) AT=540.05n

.meas tran vdout1_26ck530 FIND v(dout1_26) AT=540.05n

.meas tran vdout1_27ck530 FIND v(dout1_27) AT=540.05n

.meas tran vdout1_28ck530 FIND v(dout1_28) AT=540.05n

.meas tran vdout1_29ck530 FIND v(dout1_29) AT=540.05n

.meas tran vdout1_30ck530 FIND v(dout1_30) AT=540.05n

.meas tran vdout1_31ck530 FIND v(dout1_31) AT=540.05n

.meas tran vdout0_0ck540 FIND v(dout0_0) AT=550.05n

.meas tran vdout0_1ck540 FIND v(dout0_1) AT=550.05n

.meas tran vdout0_2ck540 FIND v(dout0_2) AT=550.05n

.meas tran vdout0_3ck540 FIND v(dout0_3) AT=550.05n

.meas tran vdout0_4ck540 FIND v(dout0_4) AT=550.05n

.meas tran vdout0_5ck540 FIND v(dout0_5) AT=550.05n

.meas tran vdout0_6ck540 FIND v(dout0_6) AT=550.05n

.meas tran vdout0_7ck540 FIND v(dout0_7) AT=550.05n

.meas tran vdout0_8ck540 FIND v(dout0_8) AT=550.05n

.meas tran vdout0_9ck540 FIND v(dout0_9) AT=550.05n

.meas tran vdout0_10ck540 FIND v(dout0_10) AT=550.05n

.meas tran vdout0_11ck540 FIND v(dout0_11) AT=550.05n

.meas tran vdout0_12ck540 FIND v(dout0_12) AT=550.05n

.meas tran vdout0_13ck540 FIND v(dout0_13) AT=550.05n

.meas tran vdout0_14ck540 FIND v(dout0_14) AT=550.05n

.meas tran vdout0_15ck540 FIND v(dout0_15) AT=550.05n

.meas tran vdout0_16ck540 FIND v(dout0_16) AT=550.05n

.meas tran vdout0_17ck540 FIND v(dout0_17) AT=550.05n

.meas tran vdout0_18ck540 FIND v(dout0_18) AT=550.05n

.meas tran vdout0_19ck540 FIND v(dout0_19) AT=550.05n

.meas tran vdout0_20ck540 FIND v(dout0_20) AT=550.05n

.meas tran vdout0_21ck540 FIND v(dout0_21) AT=550.05n

.meas tran vdout0_22ck540 FIND v(dout0_22) AT=550.05n

.meas tran vdout0_23ck540 FIND v(dout0_23) AT=550.05n

.meas tran vdout0_24ck540 FIND v(dout0_24) AT=550.05n

.meas tran vdout0_25ck540 FIND v(dout0_25) AT=550.05n

.meas tran vdout0_26ck540 FIND v(dout0_26) AT=550.05n

.meas tran vdout0_27ck540 FIND v(dout0_27) AT=550.05n

.meas tran vdout0_28ck540 FIND v(dout0_28) AT=550.05n

.meas tran vdout0_29ck540 FIND v(dout0_29) AT=550.05n

.meas tran vdout0_30ck540 FIND v(dout0_30) AT=550.05n

.meas tran vdout0_31ck540 FIND v(dout0_31) AT=550.05n

.meas tran vdout1_0ck540 FIND v(dout1_0) AT=550.05n

.meas tran vdout1_1ck540 FIND v(dout1_1) AT=550.05n

.meas tran vdout1_2ck540 FIND v(dout1_2) AT=550.05n

.meas tran vdout1_3ck540 FIND v(dout1_3) AT=550.05n

.meas tran vdout1_4ck540 FIND v(dout1_4) AT=550.05n

.meas tran vdout1_5ck540 FIND v(dout1_5) AT=550.05n

.meas tran vdout1_6ck540 FIND v(dout1_6) AT=550.05n

.meas tran vdout1_7ck540 FIND v(dout1_7) AT=550.05n

.meas tran vdout1_8ck540 FIND v(dout1_8) AT=550.05n

.meas tran vdout1_9ck540 FIND v(dout1_9) AT=550.05n

.meas tran vdout1_10ck540 FIND v(dout1_10) AT=550.05n

.meas tran vdout1_11ck540 FIND v(dout1_11) AT=550.05n

.meas tran vdout1_12ck540 FIND v(dout1_12) AT=550.05n

.meas tran vdout1_13ck540 FIND v(dout1_13) AT=550.05n

.meas tran vdout1_14ck540 FIND v(dout1_14) AT=550.05n

.meas tran vdout1_15ck540 FIND v(dout1_15) AT=550.05n

.meas tran vdout1_16ck540 FIND v(dout1_16) AT=550.05n

.meas tran vdout1_17ck540 FIND v(dout1_17) AT=550.05n

.meas tran vdout1_18ck540 FIND v(dout1_18) AT=550.05n

.meas tran vdout1_19ck540 FIND v(dout1_19) AT=550.05n

.meas tran vdout1_20ck540 FIND v(dout1_20) AT=550.05n

.meas tran vdout1_21ck540 FIND v(dout1_21) AT=550.05n

.meas tran vdout1_22ck540 FIND v(dout1_22) AT=550.05n

.meas tran vdout1_23ck540 FIND v(dout1_23) AT=550.05n

.meas tran vdout1_24ck540 FIND v(dout1_24) AT=550.05n

.meas tran vdout1_25ck540 FIND v(dout1_25) AT=550.05n

.meas tran vdout1_26ck540 FIND v(dout1_26) AT=550.05n

.meas tran vdout1_27ck540 FIND v(dout1_27) AT=550.05n

.meas tran vdout1_28ck540 FIND v(dout1_28) AT=550.05n

.meas tran vdout1_29ck540 FIND v(dout1_29) AT=550.05n

.meas tran vdout1_30ck540 FIND v(dout1_30) AT=550.05n

.meas tran vdout1_31ck540 FIND v(dout1_31) AT=550.05n

.meas tran vdout0_0ck550 FIND v(dout0_0) AT=560.05n

.meas tran vdout0_1ck550 FIND v(dout0_1) AT=560.05n

.meas tran vdout0_2ck550 FIND v(dout0_2) AT=560.05n

.meas tran vdout0_3ck550 FIND v(dout0_3) AT=560.05n

.meas tran vdout0_4ck550 FIND v(dout0_4) AT=560.05n

.meas tran vdout0_5ck550 FIND v(dout0_5) AT=560.05n

.meas tran vdout0_6ck550 FIND v(dout0_6) AT=560.05n

.meas tran vdout0_7ck550 FIND v(dout0_7) AT=560.05n

.meas tran vdout0_8ck550 FIND v(dout0_8) AT=560.05n

.meas tran vdout0_9ck550 FIND v(dout0_9) AT=560.05n

.meas tran vdout0_10ck550 FIND v(dout0_10) AT=560.05n

.meas tran vdout0_11ck550 FIND v(dout0_11) AT=560.05n

.meas tran vdout0_12ck550 FIND v(dout0_12) AT=560.05n

.meas tran vdout0_13ck550 FIND v(dout0_13) AT=560.05n

.meas tran vdout0_14ck550 FIND v(dout0_14) AT=560.05n

.meas tran vdout0_15ck550 FIND v(dout0_15) AT=560.05n

.meas tran vdout0_16ck550 FIND v(dout0_16) AT=560.05n

.meas tran vdout0_17ck550 FIND v(dout0_17) AT=560.05n

.meas tran vdout0_18ck550 FIND v(dout0_18) AT=560.05n

.meas tran vdout0_19ck550 FIND v(dout0_19) AT=560.05n

.meas tran vdout0_20ck550 FIND v(dout0_20) AT=560.05n

.meas tran vdout0_21ck550 FIND v(dout0_21) AT=560.05n

.meas tran vdout0_22ck550 FIND v(dout0_22) AT=560.05n

.meas tran vdout0_23ck550 FIND v(dout0_23) AT=560.05n

.meas tran vdout0_24ck550 FIND v(dout0_24) AT=560.05n

.meas tran vdout0_25ck550 FIND v(dout0_25) AT=560.05n

.meas tran vdout0_26ck550 FIND v(dout0_26) AT=560.05n

.meas tran vdout0_27ck550 FIND v(dout0_27) AT=560.05n

.meas tran vdout0_28ck550 FIND v(dout0_28) AT=560.05n

.meas tran vdout0_29ck550 FIND v(dout0_29) AT=560.05n

.meas tran vdout0_30ck550 FIND v(dout0_30) AT=560.05n

.meas tran vdout0_31ck550 FIND v(dout0_31) AT=560.05n

.meas tran vdout1_0ck550 FIND v(dout1_0) AT=560.05n

.meas tran vdout1_1ck550 FIND v(dout1_1) AT=560.05n

.meas tran vdout1_2ck550 FIND v(dout1_2) AT=560.05n

.meas tran vdout1_3ck550 FIND v(dout1_3) AT=560.05n

.meas tran vdout1_4ck550 FIND v(dout1_4) AT=560.05n

.meas tran vdout1_5ck550 FIND v(dout1_5) AT=560.05n

.meas tran vdout1_6ck550 FIND v(dout1_6) AT=560.05n

.meas tran vdout1_7ck550 FIND v(dout1_7) AT=560.05n

.meas tran vdout1_8ck550 FIND v(dout1_8) AT=560.05n

.meas tran vdout1_9ck550 FIND v(dout1_9) AT=560.05n

.meas tran vdout1_10ck550 FIND v(dout1_10) AT=560.05n

.meas tran vdout1_11ck550 FIND v(dout1_11) AT=560.05n

.meas tran vdout1_12ck550 FIND v(dout1_12) AT=560.05n

.meas tran vdout1_13ck550 FIND v(dout1_13) AT=560.05n

.meas tran vdout1_14ck550 FIND v(dout1_14) AT=560.05n

.meas tran vdout1_15ck550 FIND v(dout1_15) AT=560.05n

.meas tran vdout1_16ck550 FIND v(dout1_16) AT=560.05n

.meas tran vdout1_17ck550 FIND v(dout1_17) AT=560.05n

.meas tran vdout1_18ck550 FIND v(dout1_18) AT=560.05n

.meas tran vdout1_19ck550 FIND v(dout1_19) AT=560.05n

.meas tran vdout1_20ck550 FIND v(dout1_20) AT=560.05n

.meas tran vdout1_21ck550 FIND v(dout1_21) AT=560.05n

.meas tran vdout1_22ck550 FIND v(dout1_22) AT=560.05n

.meas tran vdout1_23ck550 FIND v(dout1_23) AT=560.05n

.meas tran vdout1_24ck550 FIND v(dout1_24) AT=560.05n

.meas tran vdout1_25ck550 FIND v(dout1_25) AT=560.05n

.meas tran vdout1_26ck550 FIND v(dout1_26) AT=560.05n

.meas tran vdout1_27ck550 FIND v(dout1_27) AT=560.05n

.meas tran vdout1_28ck550 FIND v(dout1_28) AT=560.05n

.meas tran vdout1_29ck550 FIND v(dout1_29) AT=560.05n

.meas tran vdout1_30ck550 FIND v(dout1_30) AT=560.05n

.meas tran vdout1_31ck550 FIND v(dout1_31) AT=560.05n

.meas tran vdout1_0ck560 FIND v(dout1_0) AT=570.05n

.meas tran vdout1_1ck560 FIND v(dout1_1) AT=570.05n

.meas tran vdout1_2ck560 FIND v(dout1_2) AT=570.05n

.meas tran vdout1_3ck560 FIND v(dout1_3) AT=570.05n

.meas tran vdout1_4ck560 FIND v(dout1_4) AT=570.05n

.meas tran vdout1_5ck560 FIND v(dout1_5) AT=570.05n

.meas tran vdout1_6ck560 FIND v(dout1_6) AT=570.05n

.meas tran vdout1_7ck560 FIND v(dout1_7) AT=570.05n

.meas tran vdout1_8ck560 FIND v(dout1_8) AT=570.05n

.meas tran vdout1_9ck560 FIND v(dout1_9) AT=570.05n

.meas tran vdout1_10ck560 FIND v(dout1_10) AT=570.05n

.meas tran vdout1_11ck560 FIND v(dout1_11) AT=570.05n

.meas tran vdout1_12ck560 FIND v(dout1_12) AT=570.05n

.meas tran vdout1_13ck560 FIND v(dout1_13) AT=570.05n

.meas tran vdout1_14ck560 FIND v(dout1_14) AT=570.05n

.meas tran vdout1_15ck560 FIND v(dout1_15) AT=570.05n

.meas tran vdout1_16ck560 FIND v(dout1_16) AT=570.05n

.meas tran vdout1_17ck560 FIND v(dout1_17) AT=570.05n

.meas tran vdout1_18ck560 FIND v(dout1_18) AT=570.05n

.meas tran vdout1_19ck560 FIND v(dout1_19) AT=570.05n

.meas tran vdout1_20ck560 FIND v(dout1_20) AT=570.05n

.meas tran vdout1_21ck560 FIND v(dout1_21) AT=570.05n

.meas tran vdout1_22ck560 FIND v(dout1_22) AT=570.05n

.meas tran vdout1_23ck560 FIND v(dout1_23) AT=570.05n

.meas tran vdout1_24ck560 FIND v(dout1_24) AT=570.05n

.meas tran vdout1_25ck560 FIND v(dout1_25) AT=570.05n

.meas tran vdout1_26ck560 FIND v(dout1_26) AT=570.05n

.meas tran vdout1_27ck560 FIND v(dout1_27) AT=570.05n

.meas tran vdout1_28ck560 FIND v(dout1_28) AT=570.05n

.meas tran vdout1_29ck560 FIND v(dout1_29) AT=570.05n

.meas tran vdout1_30ck560 FIND v(dout1_30) AT=570.05n

.meas tran vdout1_31ck560 FIND v(dout1_31) AT=570.05n

.meas tran vdout0_0ck580 FIND v(dout0_0) AT=590.05n

.meas tran vdout0_1ck580 FIND v(dout0_1) AT=590.05n

.meas tran vdout0_2ck580 FIND v(dout0_2) AT=590.05n

.meas tran vdout0_3ck580 FIND v(dout0_3) AT=590.05n

.meas tran vdout0_4ck580 FIND v(dout0_4) AT=590.05n

.meas tran vdout0_5ck580 FIND v(dout0_5) AT=590.05n

.meas tran vdout0_6ck580 FIND v(dout0_6) AT=590.05n

.meas tran vdout0_7ck580 FIND v(dout0_7) AT=590.05n

.meas tran vdout0_8ck580 FIND v(dout0_8) AT=590.05n

.meas tran vdout0_9ck580 FIND v(dout0_9) AT=590.05n

.meas tran vdout0_10ck580 FIND v(dout0_10) AT=590.05n

.meas tran vdout0_11ck580 FIND v(dout0_11) AT=590.05n

.meas tran vdout0_12ck580 FIND v(dout0_12) AT=590.05n

.meas tran vdout0_13ck580 FIND v(dout0_13) AT=590.05n

.meas tran vdout0_14ck580 FIND v(dout0_14) AT=590.05n

.meas tran vdout0_15ck580 FIND v(dout0_15) AT=590.05n

.meas tran vdout0_16ck580 FIND v(dout0_16) AT=590.05n

.meas tran vdout0_17ck580 FIND v(dout0_17) AT=590.05n

.meas tran vdout0_18ck580 FIND v(dout0_18) AT=590.05n

.meas tran vdout0_19ck580 FIND v(dout0_19) AT=590.05n

.meas tran vdout0_20ck580 FIND v(dout0_20) AT=590.05n

.meas tran vdout0_21ck580 FIND v(dout0_21) AT=590.05n

.meas tran vdout0_22ck580 FIND v(dout0_22) AT=590.05n

.meas tran vdout0_23ck580 FIND v(dout0_23) AT=590.05n

.meas tran vdout0_24ck580 FIND v(dout0_24) AT=590.05n

.meas tran vdout0_25ck580 FIND v(dout0_25) AT=590.05n

.meas tran vdout0_26ck580 FIND v(dout0_26) AT=590.05n

.meas tran vdout0_27ck580 FIND v(dout0_27) AT=590.05n

.meas tran vdout0_28ck580 FIND v(dout0_28) AT=590.05n

.meas tran vdout0_29ck580 FIND v(dout0_29) AT=590.05n

.meas tran vdout0_30ck580 FIND v(dout0_30) AT=590.05n

.meas tran vdout0_31ck580 FIND v(dout0_31) AT=590.05n

.meas tran vdout0_0ck590 FIND v(dout0_0) AT=600.05n

.meas tran vdout0_1ck590 FIND v(dout0_1) AT=600.05n

.meas tran vdout0_2ck590 FIND v(dout0_2) AT=600.05n

.meas tran vdout0_3ck590 FIND v(dout0_3) AT=600.05n

.meas tran vdout0_4ck590 FIND v(dout0_4) AT=600.05n

.meas tran vdout0_5ck590 FIND v(dout0_5) AT=600.05n

.meas tran vdout0_6ck590 FIND v(dout0_6) AT=600.05n

.meas tran vdout0_7ck590 FIND v(dout0_7) AT=600.05n

.meas tran vdout0_8ck590 FIND v(dout0_8) AT=600.05n

.meas tran vdout0_9ck590 FIND v(dout0_9) AT=600.05n

.meas tran vdout0_10ck590 FIND v(dout0_10) AT=600.05n

.meas tran vdout0_11ck590 FIND v(dout0_11) AT=600.05n

.meas tran vdout0_12ck590 FIND v(dout0_12) AT=600.05n

.meas tran vdout0_13ck590 FIND v(dout0_13) AT=600.05n

.meas tran vdout0_14ck590 FIND v(dout0_14) AT=600.05n

.meas tran vdout0_15ck590 FIND v(dout0_15) AT=600.05n

.meas tran vdout0_16ck590 FIND v(dout0_16) AT=600.05n

.meas tran vdout0_17ck590 FIND v(dout0_17) AT=600.05n

.meas tran vdout0_18ck590 FIND v(dout0_18) AT=600.05n

.meas tran vdout0_19ck590 FIND v(dout0_19) AT=600.05n

.meas tran vdout0_20ck590 FIND v(dout0_20) AT=600.05n

.meas tran vdout0_21ck590 FIND v(dout0_21) AT=600.05n

.meas tran vdout0_22ck590 FIND v(dout0_22) AT=600.05n

.meas tran vdout0_23ck590 FIND v(dout0_23) AT=600.05n

.meas tran vdout0_24ck590 FIND v(dout0_24) AT=600.05n

.meas tran vdout0_25ck590 FIND v(dout0_25) AT=600.05n

.meas tran vdout0_26ck590 FIND v(dout0_26) AT=600.05n

.meas tran vdout0_27ck590 FIND v(dout0_27) AT=600.05n

.meas tran vdout0_28ck590 FIND v(dout0_28) AT=600.05n

.meas tran vdout0_29ck590 FIND v(dout0_29) AT=600.05n

.meas tran vdout0_30ck590 FIND v(dout0_30) AT=600.05n

.meas tran vdout0_31ck590 FIND v(dout0_31) AT=600.05n

.meas tran vdout1_0ck590 FIND v(dout1_0) AT=600.05n

.meas tran vdout1_1ck590 FIND v(dout1_1) AT=600.05n

.meas tran vdout1_2ck590 FIND v(dout1_2) AT=600.05n

.meas tran vdout1_3ck590 FIND v(dout1_3) AT=600.05n

.meas tran vdout1_4ck590 FIND v(dout1_4) AT=600.05n

.meas tran vdout1_5ck590 FIND v(dout1_5) AT=600.05n

.meas tran vdout1_6ck590 FIND v(dout1_6) AT=600.05n

.meas tran vdout1_7ck590 FIND v(dout1_7) AT=600.05n

.meas tran vdout1_8ck590 FIND v(dout1_8) AT=600.05n

.meas tran vdout1_9ck590 FIND v(dout1_9) AT=600.05n

.meas tran vdout1_10ck590 FIND v(dout1_10) AT=600.05n

.meas tran vdout1_11ck590 FIND v(dout1_11) AT=600.05n

.meas tran vdout1_12ck590 FIND v(dout1_12) AT=600.05n

.meas tran vdout1_13ck590 FIND v(dout1_13) AT=600.05n

.meas tran vdout1_14ck590 FIND v(dout1_14) AT=600.05n

.meas tran vdout1_15ck590 FIND v(dout1_15) AT=600.05n

.meas tran vdout1_16ck590 FIND v(dout1_16) AT=600.05n

.meas tran vdout1_17ck590 FIND v(dout1_17) AT=600.05n

.meas tran vdout1_18ck590 FIND v(dout1_18) AT=600.05n

.meas tran vdout1_19ck590 FIND v(dout1_19) AT=600.05n

.meas tran vdout1_20ck590 FIND v(dout1_20) AT=600.05n

.meas tran vdout1_21ck590 FIND v(dout1_21) AT=600.05n

.meas tran vdout1_22ck590 FIND v(dout1_22) AT=600.05n

.meas tran vdout1_23ck590 FIND v(dout1_23) AT=600.05n

.meas tran vdout1_24ck590 FIND v(dout1_24) AT=600.05n

.meas tran vdout1_25ck590 FIND v(dout1_25) AT=600.05n

.meas tran vdout1_26ck590 FIND v(dout1_26) AT=600.05n

.meas tran vdout1_27ck590 FIND v(dout1_27) AT=600.05n

.meas tran vdout1_28ck590 FIND v(dout1_28) AT=600.05n

.meas tran vdout1_29ck590 FIND v(dout1_29) AT=600.05n

.meas tran vdout1_30ck590 FIND v(dout1_30) AT=600.05n

.meas tran vdout1_31ck590 FIND v(dout1_31) AT=600.05n

.meas tran vdout0_0ck600 FIND v(dout0_0) AT=610.05n

.meas tran vdout0_1ck600 FIND v(dout0_1) AT=610.05n

.meas tran vdout0_2ck600 FIND v(dout0_2) AT=610.05n

.meas tran vdout0_3ck600 FIND v(dout0_3) AT=610.05n

.meas tran vdout0_4ck600 FIND v(dout0_4) AT=610.05n

.meas tran vdout0_5ck600 FIND v(dout0_5) AT=610.05n

.meas tran vdout0_6ck600 FIND v(dout0_6) AT=610.05n

.meas tran vdout0_7ck600 FIND v(dout0_7) AT=610.05n

.meas tran vdout0_8ck600 FIND v(dout0_8) AT=610.05n

.meas tran vdout0_9ck600 FIND v(dout0_9) AT=610.05n

.meas tran vdout0_10ck600 FIND v(dout0_10) AT=610.05n

.meas tran vdout0_11ck600 FIND v(dout0_11) AT=610.05n

.meas tran vdout0_12ck600 FIND v(dout0_12) AT=610.05n

.meas tran vdout0_13ck600 FIND v(dout0_13) AT=610.05n

.meas tran vdout0_14ck600 FIND v(dout0_14) AT=610.05n

.meas tran vdout0_15ck600 FIND v(dout0_15) AT=610.05n

.meas tran vdout0_16ck600 FIND v(dout0_16) AT=610.05n

.meas tran vdout0_17ck600 FIND v(dout0_17) AT=610.05n

.meas tran vdout0_18ck600 FIND v(dout0_18) AT=610.05n

.meas tran vdout0_19ck600 FIND v(dout0_19) AT=610.05n

.meas tran vdout0_20ck600 FIND v(dout0_20) AT=610.05n

.meas tran vdout0_21ck600 FIND v(dout0_21) AT=610.05n

.meas tran vdout0_22ck600 FIND v(dout0_22) AT=610.05n

.meas tran vdout0_23ck600 FIND v(dout0_23) AT=610.05n

.meas tran vdout0_24ck600 FIND v(dout0_24) AT=610.05n

.meas tran vdout0_25ck600 FIND v(dout0_25) AT=610.05n

.meas tran vdout0_26ck600 FIND v(dout0_26) AT=610.05n

.meas tran vdout0_27ck600 FIND v(dout0_27) AT=610.05n

.meas tran vdout0_28ck600 FIND v(dout0_28) AT=610.05n

.meas tran vdout0_29ck600 FIND v(dout0_29) AT=610.05n

.meas tran vdout0_30ck600 FIND v(dout0_30) AT=610.05n

.meas tran vdout0_31ck600 FIND v(dout0_31) AT=610.05n

.meas tran vdout0_0ck610 FIND v(dout0_0) AT=620.05n

.meas tran vdout0_1ck610 FIND v(dout0_1) AT=620.05n

.meas tran vdout0_2ck610 FIND v(dout0_2) AT=620.05n

.meas tran vdout0_3ck610 FIND v(dout0_3) AT=620.05n

.meas tran vdout0_4ck610 FIND v(dout0_4) AT=620.05n

.meas tran vdout0_5ck610 FIND v(dout0_5) AT=620.05n

.meas tran vdout0_6ck610 FIND v(dout0_6) AT=620.05n

.meas tran vdout0_7ck610 FIND v(dout0_7) AT=620.05n

.meas tran vdout0_8ck610 FIND v(dout0_8) AT=620.05n

.meas tran vdout0_9ck610 FIND v(dout0_9) AT=620.05n

.meas tran vdout0_10ck610 FIND v(dout0_10) AT=620.05n

.meas tran vdout0_11ck610 FIND v(dout0_11) AT=620.05n

.meas tran vdout0_12ck610 FIND v(dout0_12) AT=620.05n

.meas tran vdout0_13ck610 FIND v(dout0_13) AT=620.05n

.meas tran vdout0_14ck610 FIND v(dout0_14) AT=620.05n

.meas tran vdout0_15ck610 FIND v(dout0_15) AT=620.05n

.meas tran vdout0_16ck610 FIND v(dout0_16) AT=620.05n

.meas tran vdout0_17ck610 FIND v(dout0_17) AT=620.05n

.meas tran vdout0_18ck610 FIND v(dout0_18) AT=620.05n

.meas tran vdout0_19ck610 FIND v(dout0_19) AT=620.05n

.meas tran vdout0_20ck610 FIND v(dout0_20) AT=620.05n

.meas tran vdout0_21ck610 FIND v(dout0_21) AT=620.05n

.meas tran vdout0_22ck610 FIND v(dout0_22) AT=620.05n

.meas tran vdout0_23ck610 FIND v(dout0_23) AT=620.05n

.meas tran vdout0_24ck610 FIND v(dout0_24) AT=620.05n

.meas tran vdout0_25ck610 FIND v(dout0_25) AT=620.05n

.meas tran vdout0_26ck610 FIND v(dout0_26) AT=620.05n

.meas tran vdout0_27ck610 FIND v(dout0_27) AT=620.05n

.meas tran vdout0_28ck610 FIND v(dout0_28) AT=620.05n

.meas tran vdout0_29ck610 FIND v(dout0_29) AT=620.05n

.meas tran vdout0_30ck610 FIND v(dout0_30) AT=620.05n

.meas tran vdout0_31ck610 FIND v(dout0_31) AT=620.05n

.meas tran vdout0_0ck630 FIND v(dout0_0) AT=640.05n

.meas tran vdout0_1ck630 FIND v(dout0_1) AT=640.05n

.meas tran vdout0_2ck630 FIND v(dout0_2) AT=640.05n

.meas tran vdout0_3ck630 FIND v(dout0_3) AT=640.05n

.meas tran vdout0_4ck630 FIND v(dout0_4) AT=640.05n

.meas tran vdout0_5ck630 FIND v(dout0_5) AT=640.05n

.meas tran vdout0_6ck630 FIND v(dout0_6) AT=640.05n

.meas tran vdout0_7ck630 FIND v(dout0_7) AT=640.05n

.meas tran vdout0_8ck630 FIND v(dout0_8) AT=640.05n

.meas tran vdout0_9ck630 FIND v(dout0_9) AT=640.05n

.meas tran vdout0_10ck630 FIND v(dout0_10) AT=640.05n

.meas tran vdout0_11ck630 FIND v(dout0_11) AT=640.05n

.meas tran vdout0_12ck630 FIND v(dout0_12) AT=640.05n

.meas tran vdout0_13ck630 FIND v(dout0_13) AT=640.05n

.meas tran vdout0_14ck630 FIND v(dout0_14) AT=640.05n

.meas tran vdout0_15ck630 FIND v(dout0_15) AT=640.05n

.meas tran vdout0_16ck630 FIND v(dout0_16) AT=640.05n

.meas tran vdout0_17ck630 FIND v(dout0_17) AT=640.05n

.meas tran vdout0_18ck630 FIND v(dout0_18) AT=640.05n

.meas tran vdout0_19ck630 FIND v(dout0_19) AT=640.05n

.meas tran vdout0_20ck630 FIND v(dout0_20) AT=640.05n

.meas tran vdout0_21ck630 FIND v(dout0_21) AT=640.05n

.meas tran vdout0_22ck630 FIND v(dout0_22) AT=640.05n

.meas tran vdout0_23ck630 FIND v(dout0_23) AT=640.05n

.meas tran vdout0_24ck630 FIND v(dout0_24) AT=640.05n

.meas tran vdout0_25ck630 FIND v(dout0_25) AT=640.05n

.meas tran vdout0_26ck630 FIND v(dout0_26) AT=640.05n

.meas tran vdout0_27ck630 FIND v(dout0_27) AT=640.05n

.meas tran vdout0_28ck630 FIND v(dout0_28) AT=640.05n

.meas tran vdout0_29ck630 FIND v(dout0_29) AT=640.05n

.meas tran vdout0_30ck630 FIND v(dout0_30) AT=640.05n

.meas tran vdout0_31ck630 FIND v(dout0_31) AT=640.05n

.meas tran vdout1_0ck650 FIND v(dout1_0) AT=660.05n

.meas tran vdout1_1ck650 FIND v(dout1_1) AT=660.05n

.meas tran vdout1_2ck650 FIND v(dout1_2) AT=660.05n

.meas tran vdout1_3ck650 FIND v(dout1_3) AT=660.05n

.meas tran vdout1_4ck650 FIND v(dout1_4) AT=660.05n

.meas tran vdout1_5ck650 FIND v(dout1_5) AT=660.05n

.meas tran vdout1_6ck650 FIND v(dout1_6) AT=660.05n

.meas tran vdout1_7ck650 FIND v(dout1_7) AT=660.05n

.meas tran vdout1_8ck650 FIND v(dout1_8) AT=660.05n

.meas tran vdout1_9ck650 FIND v(dout1_9) AT=660.05n

.meas tran vdout1_10ck650 FIND v(dout1_10) AT=660.05n

.meas tran vdout1_11ck650 FIND v(dout1_11) AT=660.05n

.meas tran vdout1_12ck650 FIND v(dout1_12) AT=660.05n

.meas tran vdout1_13ck650 FIND v(dout1_13) AT=660.05n

.meas tran vdout1_14ck650 FIND v(dout1_14) AT=660.05n

.meas tran vdout1_15ck650 FIND v(dout1_15) AT=660.05n

.meas tran vdout1_16ck650 FIND v(dout1_16) AT=660.05n

.meas tran vdout1_17ck650 FIND v(dout1_17) AT=660.05n

.meas tran vdout1_18ck650 FIND v(dout1_18) AT=660.05n

.meas tran vdout1_19ck650 FIND v(dout1_19) AT=660.05n

.meas tran vdout1_20ck650 FIND v(dout1_20) AT=660.05n

.meas tran vdout1_21ck650 FIND v(dout1_21) AT=660.05n

.meas tran vdout1_22ck650 FIND v(dout1_22) AT=660.05n

.meas tran vdout1_23ck650 FIND v(dout1_23) AT=660.05n

.meas tran vdout1_24ck650 FIND v(dout1_24) AT=660.05n

.meas tran vdout1_25ck650 FIND v(dout1_25) AT=660.05n

.meas tran vdout1_26ck650 FIND v(dout1_26) AT=660.05n

.meas tran vdout1_27ck650 FIND v(dout1_27) AT=660.05n

.meas tran vdout1_28ck650 FIND v(dout1_28) AT=660.05n

.meas tran vdout1_29ck650 FIND v(dout1_29) AT=660.05n

.meas tran vdout1_30ck650 FIND v(dout1_30) AT=660.05n

.meas tran vdout1_31ck650 FIND v(dout1_31) AT=660.05n

.meas tran vdout0_0ck670 FIND v(dout0_0) AT=680.05n

.meas tran vdout0_1ck670 FIND v(dout0_1) AT=680.05n

.meas tran vdout0_2ck670 FIND v(dout0_2) AT=680.05n

.meas tran vdout0_3ck670 FIND v(dout0_3) AT=680.05n

.meas tran vdout0_4ck670 FIND v(dout0_4) AT=680.05n

.meas tran vdout0_5ck670 FIND v(dout0_5) AT=680.05n

.meas tran vdout0_6ck670 FIND v(dout0_6) AT=680.05n

.meas tran vdout0_7ck670 FIND v(dout0_7) AT=680.05n

.meas tran vdout0_8ck670 FIND v(dout0_8) AT=680.05n

.meas tran vdout0_9ck670 FIND v(dout0_9) AT=680.05n

.meas tran vdout0_10ck670 FIND v(dout0_10) AT=680.05n

.meas tran vdout0_11ck670 FIND v(dout0_11) AT=680.05n

.meas tran vdout0_12ck670 FIND v(dout0_12) AT=680.05n

.meas tran vdout0_13ck670 FIND v(dout0_13) AT=680.05n

.meas tran vdout0_14ck670 FIND v(dout0_14) AT=680.05n

.meas tran vdout0_15ck670 FIND v(dout0_15) AT=680.05n

.meas tran vdout0_16ck670 FIND v(dout0_16) AT=680.05n

.meas tran vdout0_17ck670 FIND v(dout0_17) AT=680.05n

.meas tran vdout0_18ck670 FIND v(dout0_18) AT=680.05n

.meas tran vdout0_19ck670 FIND v(dout0_19) AT=680.05n

.meas tran vdout0_20ck670 FIND v(dout0_20) AT=680.05n

.meas tran vdout0_21ck670 FIND v(dout0_21) AT=680.05n

.meas tran vdout0_22ck670 FIND v(dout0_22) AT=680.05n

.meas tran vdout0_23ck670 FIND v(dout0_23) AT=680.05n

.meas tran vdout0_24ck670 FIND v(dout0_24) AT=680.05n

.meas tran vdout0_25ck670 FIND v(dout0_25) AT=680.05n

.meas tran vdout0_26ck670 FIND v(dout0_26) AT=680.05n

.meas tran vdout0_27ck670 FIND v(dout0_27) AT=680.05n

.meas tran vdout0_28ck670 FIND v(dout0_28) AT=680.05n

.meas tran vdout0_29ck670 FIND v(dout0_29) AT=680.05n

.meas tran vdout0_30ck670 FIND v(dout0_30) AT=680.05n

.meas tran vdout0_31ck670 FIND v(dout0_31) AT=680.05n

.meas tran vdout1_0ck680 FIND v(dout1_0) AT=690.05n

.meas tran vdout1_1ck680 FIND v(dout1_1) AT=690.05n

.meas tran vdout1_2ck680 FIND v(dout1_2) AT=690.05n

.meas tran vdout1_3ck680 FIND v(dout1_3) AT=690.05n

.meas tran vdout1_4ck680 FIND v(dout1_4) AT=690.05n

.meas tran vdout1_5ck680 FIND v(dout1_5) AT=690.05n

.meas tran vdout1_6ck680 FIND v(dout1_6) AT=690.05n

.meas tran vdout1_7ck680 FIND v(dout1_7) AT=690.05n

.meas tran vdout1_8ck680 FIND v(dout1_8) AT=690.05n

.meas tran vdout1_9ck680 FIND v(dout1_9) AT=690.05n

.meas tran vdout1_10ck680 FIND v(dout1_10) AT=690.05n

.meas tran vdout1_11ck680 FIND v(dout1_11) AT=690.05n

.meas tran vdout1_12ck680 FIND v(dout1_12) AT=690.05n

.meas tran vdout1_13ck680 FIND v(dout1_13) AT=690.05n

.meas tran vdout1_14ck680 FIND v(dout1_14) AT=690.05n

.meas tran vdout1_15ck680 FIND v(dout1_15) AT=690.05n

.meas tran vdout1_16ck680 FIND v(dout1_16) AT=690.05n

.meas tran vdout1_17ck680 FIND v(dout1_17) AT=690.05n

.meas tran vdout1_18ck680 FIND v(dout1_18) AT=690.05n

.meas tran vdout1_19ck680 FIND v(dout1_19) AT=690.05n

.meas tran vdout1_20ck680 FIND v(dout1_20) AT=690.05n

.meas tran vdout1_21ck680 FIND v(dout1_21) AT=690.05n

.meas tran vdout1_22ck680 FIND v(dout1_22) AT=690.05n

.meas tran vdout1_23ck680 FIND v(dout1_23) AT=690.05n

.meas tran vdout1_24ck680 FIND v(dout1_24) AT=690.05n

.meas tran vdout1_25ck680 FIND v(dout1_25) AT=690.05n

.meas tran vdout1_26ck680 FIND v(dout1_26) AT=690.05n

.meas tran vdout1_27ck680 FIND v(dout1_27) AT=690.05n

.meas tran vdout1_28ck680 FIND v(dout1_28) AT=690.05n

.meas tran vdout1_29ck680 FIND v(dout1_29) AT=690.05n

.meas tran vdout1_30ck680 FIND v(dout1_30) AT=690.05n

.meas tran vdout1_31ck680 FIND v(dout1_31) AT=690.05n

.meas tran vdout0_0ck690 FIND v(dout0_0) AT=700.05n

.meas tran vdout0_1ck690 FIND v(dout0_1) AT=700.05n

.meas tran vdout0_2ck690 FIND v(dout0_2) AT=700.05n

.meas tran vdout0_3ck690 FIND v(dout0_3) AT=700.05n

.meas tran vdout0_4ck690 FIND v(dout0_4) AT=700.05n

.meas tran vdout0_5ck690 FIND v(dout0_5) AT=700.05n

.meas tran vdout0_6ck690 FIND v(dout0_6) AT=700.05n

.meas tran vdout0_7ck690 FIND v(dout0_7) AT=700.05n

.meas tran vdout0_8ck690 FIND v(dout0_8) AT=700.05n

.meas tran vdout0_9ck690 FIND v(dout0_9) AT=700.05n

.meas tran vdout0_10ck690 FIND v(dout0_10) AT=700.05n

.meas tran vdout0_11ck690 FIND v(dout0_11) AT=700.05n

.meas tran vdout0_12ck690 FIND v(dout0_12) AT=700.05n

.meas tran vdout0_13ck690 FIND v(dout0_13) AT=700.05n

.meas tran vdout0_14ck690 FIND v(dout0_14) AT=700.05n

.meas tran vdout0_15ck690 FIND v(dout0_15) AT=700.05n

.meas tran vdout0_16ck690 FIND v(dout0_16) AT=700.05n

.meas tran vdout0_17ck690 FIND v(dout0_17) AT=700.05n

.meas tran vdout0_18ck690 FIND v(dout0_18) AT=700.05n

.meas tran vdout0_19ck690 FIND v(dout0_19) AT=700.05n

.meas tran vdout0_20ck690 FIND v(dout0_20) AT=700.05n

.meas tran vdout0_21ck690 FIND v(dout0_21) AT=700.05n

.meas tran vdout0_22ck690 FIND v(dout0_22) AT=700.05n

.meas tran vdout0_23ck690 FIND v(dout0_23) AT=700.05n

.meas tran vdout0_24ck690 FIND v(dout0_24) AT=700.05n

.meas tran vdout0_25ck690 FIND v(dout0_25) AT=700.05n

.meas tran vdout0_26ck690 FIND v(dout0_26) AT=700.05n

.meas tran vdout0_27ck690 FIND v(dout0_27) AT=700.05n

.meas tran vdout0_28ck690 FIND v(dout0_28) AT=700.05n

.meas tran vdout0_29ck690 FIND v(dout0_29) AT=700.05n

.meas tran vdout0_30ck690 FIND v(dout0_30) AT=700.05n

.meas tran vdout0_31ck690 FIND v(dout0_31) AT=700.05n

.meas tran vdout0_0ck720 FIND v(dout0_0) AT=730.05n

.meas tran vdout0_1ck720 FIND v(dout0_1) AT=730.05n

.meas tran vdout0_2ck720 FIND v(dout0_2) AT=730.05n

.meas tran vdout0_3ck720 FIND v(dout0_3) AT=730.05n

.meas tran vdout0_4ck720 FIND v(dout0_4) AT=730.05n

.meas tran vdout0_5ck720 FIND v(dout0_5) AT=730.05n

.meas tran vdout0_6ck720 FIND v(dout0_6) AT=730.05n

.meas tran vdout0_7ck720 FIND v(dout0_7) AT=730.05n

.meas tran vdout0_8ck720 FIND v(dout0_8) AT=730.05n

.meas tran vdout0_9ck720 FIND v(dout0_9) AT=730.05n

.meas tran vdout0_10ck720 FIND v(dout0_10) AT=730.05n

.meas tran vdout0_11ck720 FIND v(dout0_11) AT=730.05n

.meas tran vdout0_12ck720 FIND v(dout0_12) AT=730.05n

.meas tran vdout0_13ck720 FIND v(dout0_13) AT=730.05n

.meas tran vdout0_14ck720 FIND v(dout0_14) AT=730.05n

.meas tran vdout0_15ck720 FIND v(dout0_15) AT=730.05n

.meas tran vdout0_16ck720 FIND v(dout0_16) AT=730.05n

.meas tran vdout0_17ck720 FIND v(dout0_17) AT=730.05n

.meas tran vdout0_18ck720 FIND v(dout0_18) AT=730.05n

.meas tran vdout0_19ck720 FIND v(dout0_19) AT=730.05n

.meas tran vdout0_20ck720 FIND v(dout0_20) AT=730.05n

.meas tran vdout0_21ck720 FIND v(dout0_21) AT=730.05n

.meas tran vdout0_22ck720 FIND v(dout0_22) AT=730.05n

.meas tran vdout0_23ck720 FIND v(dout0_23) AT=730.05n

.meas tran vdout0_24ck720 FIND v(dout0_24) AT=730.05n

.meas tran vdout0_25ck720 FIND v(dout0_25) AT=730.05n

.meas tran vdout0_26ck720 FIND v(dout0_26) AT=730.05n

.meas tran vdout0_27ck720 FIND v(dout0_27) AT=730.05n

.meas tran vdout0_28ck720 FIND v(dout0_28) AT=730.05n

.meas tran vdout0_29ck720 FIND v(dout0_29) AT=730.05n

.meas tran vdout0_30ck720 FIND v(dout0_30) AT=730.05n

.meas tran vdout0_31ck720 FIND v(dout0_31) AT=730.05n

.meas tran vdout1_0ck730 FIND v(dout1_0) AT=740.05n

.meas tran vdout1_1ck730 FIND v(dout1_1) AT=740.05n

.meas tran vdout1_2ck730 FIND v(dout1_2) AT=740.05n

.meas tran vdout1_3ck730 FIND v(dout1_3) AT=740.05n

.meas tran vdout1_4ck730 FIND v(dout1_4) AT=740.05n

.meas tran vdout1_5ck730 FIND v(dout1_5) AT=740.05n

.meas tran vdout1_6ck730 FIND v(dout1_6) AT=740.05n

.meas tran vdout1_7ck730 FIND v(dout1_7) AT=740.05n

.meas tran vdout1_8ck730 FIND v(dout1_8) AT=740.05n

.meas tran vdout1_9ck730 FIND v(dout1_9) AT=740.05n

.meas tran vdout1_10ck730 FIND v(dout1_10) AT=740.05n

.meas tran vdout1_11ck730 FIND v(dout1_11) AT=740.05n

.meas tran vdout1_12ck730 FIND v(dout1_12) AT=740.05n

.meas tran vdout1_13ck730 FIND v(dout1_13) AT=740.05n

.meas tran vdout1_14ck730 FIND v(dout1_14) AT=740.05n

.meas tran vdout1_15ck730 FIND v(dout1_15) AT=740.05n

.meas tran vdout1_16ck730 FIND v(dout1_16) AT=740.05n

.meas tran vdout1_17ck730 FIND v(dout1_17) AT=740.05n

.meas tran vdout1_18ck730 FIND v(dout1_18) AT=740.05n

.meas tran vdout1_19ck730 FIND v(dout1_19) AT=740.05n

.meas tran vdout1_20ck730 FIND v(dout1_20) AT=740.05n

.meas tran vdout1_21ck730 FIND v(dout1_21) AT=740.05n

.meas tran vdout1_22ck730 FIND v(dout1_22) AT=740.05n

.meas tran vdout1_23ck730 FIND v(dout1_23) AT=740.05n

.meas tran vdout1_24ck730 FIND v(dout1_24) AT=740.05n

.meas tran vdout1_25ck730 FIND v(dout1_25) AT=740.05n

.meas tran vdout1_26ck730 FIND v(dout1_26) AT=740.05n

.meas tran vdout1_27ck730 FIND v(dout1_27) AT=740.05n

.meas tran vdout1_28ck730 FIND v(dout1_28) AT=740.05n

.meas tran vdout1_29ck730 FIND v(dout1_29) AT=740.05n

.meas tran vdout1_30ck730 FIND v(dout1_30) AT=740.05n

.meas tran vdout1_31ck730 FIND v(dout1_31) AT=740.05n

.meas tran vdout1_0ck750 FIND v(dout1_0) AT=760.05n

.meas tran vdout1_1ck750 FIND v(dout1_1) AT=760.05n

.meas tran vdout1_2ck750 FIND v(dout1_2) AT=760.05n

.meas tran vdout1_3ck750 FIND v(dout1_3) AT=760.05n

.meas tran vdout1_4ck750 FIND v(dout1_4) AT=760.05n

.meas tran vdout1_5ck750 FIND v(dout1_5) AT=760.05n

.meas tran vdout1_6ck750 FIND v(dout1_6) AT=760.05n

.meas tran vdout1_7ck750 FIND v(dout1_7) AT=760.05n

.meas tran vdout1_8ck750 FIND v(dout1_8) AT=760.05n

.meas tran vdout1_9ck750 FIND v(dout1_9) AT=760.05n

.meas tran vdout1_10ck750 FIND v(dout1_10) AT=760.05n

.meas tran vdout1_11ck750 FIND v(dout1_11) AT=760.05n

.meas tran vdout1_12ck750 FIND v(dout1_12) AT=760.05n

.meas tran vdout1_13ck750 FIND v(dout1_13) AT=760.05n

.meas tran vdout1_14ck750 FIND v(dout1_14) AT=760.05n

.meas tran vdout1_15ck750 FIND v(dout1_15) AT=760.05n

.meas tran vdout1_16ck750 FIND v(dout1_16) AT=760.05n

.meas tran vdout1_17ck750 FIND v(dout1_17) AT=760.05n

.meas tran vdout1_18ck750 FIND v(dout1_18) AT=760.05n

.meas tran vdout1_19ck750 FIND v(dout1_19) AT=760.05n

.meas tran vdout1_20ck750 FIND v(dout1_20) AT=760.05n

.meas tran vdout1_21ck750 FIND v(dout1_21) AT=760.05n

.meas tran vdout1_22ck750 FIND v(dout1_22) AT=760.05n

.meas tran vdout1_23ck750 FIND v(dout1_23) AT=760.05n

.meas tran vdout1_24ck750 FIND v(dout1_24) AT=760.05n

.meas tran vdout1_25ck750 FIND v(dout1_25) AT=760.05n

.meas tran vdout1_26ck750 FIND v(dout1_26) AT=760.05n

.meas tran vdout1_27ck750 FIND v(dout1_27) AT=760.05n

.meas tran vdout1_28ck750 FIND v(dout1_28) AT=760.05n

.meas tran vdout1_29ck750 FIND v(dout1_29) AT=760.05n

.meas tran vdout1_30ck750 FIND v(dout1_30) AT=760.05n

.meas tran vdout1_31ck750 FIND v(dout1_31) AT=760.05n

.meas tran vdout1_0ck770 FIND v(dout1_0) AT=780.05n

.meas tran vdout1_1ck770 FIND v(dout1_1) AT=780.05n

.meas tran vdout1_2ck770 FIND v(dout1_2) AT=780.05n

.meas tran vdout1_3ck770 FIND v(dout1_3) AT=780.05n

.meas tran vdout1_4ck770 FIND v(dout1_4) AT=780.05n

.meas tran vdout1_5ck770 FIND v(dout1_5) AT=780.05n

.meas tran vdout1_6ck770 FIND v(dout1_6) AT=780.05n

.meas tran vdout1_7ck770 FIND v(dout1_7) AT=780.05n

.meas tran vdout1_8ck770 FIND v(dout1_8) AT=780.05n

.meas tran vdout1_9ck770 FIND v(dout1_9) AT=780.05n

.meas tran vdout1_10ck770 FIND v(dout1_10) AT=780.05n

.meas tran vdout1_11ck770 FIND v(dout1_11) AT=780.05n

.meas tran vdout1_12ck770 FIND v(dout1_12) AT=780.05n

.meas tran vdout1_13ck770 FIND v(dout1_13) AT=780.05n

.meas tran vdout1_14ck770 FIND v(dout1_14) AT=780.05n

.meas tran vdout1_15ck770 FIND v(dout1_15) AT=780.05n

.meas tran vdout1_16ck770 FIND v(dout1_16) AT=780.05n

.meas tran vdout1_17ck770 FIND v(dout1_17) AT=780.05n

.meas tran vdout1_18ck770 FIND v(dout1_18) AT=780.05n

.meas tran vdout1_19ck770 FIND v(dout1_19) AT=780.05n

.meas tran vdout1_20ck770 FIND v(dout1_20) AT=780.05n

.meas tran vdout1_21ck770 FIND v(dout1_21) AT=780.05n

.meas tran vdout1_22ck770 FIND v(dout1_22) AT=780.05n

.meas tran vdout1_23ck770 FIND v(dout1_23) AT=780.05n

.meas tran vdout1_24ck770 FIND v(dout1_24) AT=780.05n

.meas tran vdout1_25ck770 FIND v(dout1_25) AT=780.05n

.meas tran vdout1_26ck770 FIND v(dout1_26) AT=780.05n

.meas tran vdout1_27ck770 FIND v(dout1_27) AT=780.05n

.meas tran vdout1_28ck770 FIND v(dout1_28) AT=780.05n

.meas tran vdout1_29ck770 FIND v(dout1_29) AT=780.05n

.meas tran vdout1_30ck770 FIND v(dout1_30) AT=780.05n

.meas tran vdout1_31ck770 FIND v(dout1_31) AT=780.05n

.meas tran vdout0_0ck780 FIND v(dout0_0) AT=790.05n

.meas tran vdout0_1ck780 FIND v(dout0_1) AT=790.05n

.meas tran vdout0_2ck780 FIND v(dout0_2) AT=790.05n

.meas tran vdout0_3ck780 FIND v(dout0_3) AT=790.05n

.meas tran vdout0_4ck780 FIND v(dout0_4) AT=790.05n

.meas tran vdout0_5ck780 FIND v(dout0_5) AT=790.05n

.meas tran vdout0_6ck780 FIND v(dout0_6) AT=790.05n

.meas tran vdout0_7ck780 FIND v(dout0_7) AT=790.05n

.meas tran vdout0_8ck780 FIND v(dout0_8) AT=790.05n

.meas tran vdout0_9ck780 FIND v(dout0_9) AT=790.05n

.meas tran vdout0_10ck780 FIND v(dout0_10) AT=790.05n

.meas tran vdout0_11ck780 FIND v(dout0_11) AT=790.05n

.meas tran vdout0_12ck780 FIND v(dout0_12) AT=790.05n

.meas tran vdout0_13ck780 FIND v(dout0_13) AT=790.05n

.meas tran vdout0_14ck780 FIND v(dout0_14) AT=790.05n

.meas tran vdout0_15ck780 FIND v(dout0_15) AT=790.05n

.meas tran vdout0_16ck780 FIND v(dout0_16) AT=790.05n

.meas tran vdout0_17ck780 FIND v(dout0_17) AT=790.05n

.meas tran vdout0_18ck780 FIND v(dout0_18) AT=790.05n

.meas tran vdout0_19ck780 FIND v(dout0_19) AT=790.05n

.meas tran vdout0_20ck780 FIND v(dout0_20) AT=790.05n

.meas tran vdout0_21ck780 FIND v(dout0_21) AT=790.05n

.meas tran vdout0_22ck780 FIND v(dout0_22) AT=790.05n

.meas tran vdout0_23ck780 FIND v(dout0_23) AT=790.05n

.meas tran vdout0_24ck780 FIND v(dout0_24) AT=790.05n

.meas tran vdout0_25ck780 FIND v(dout0_25) AT=790.05n

.meas tran vdout0_26ck780 FIND v(dout0_26) AT=790.05n

.meas tran vdout0_27ck780 FIND v(dout0_27) AT=790.05n

.meas tran vdout0_28ck780 FIND v(dout0_28) AT=790.05n

.meas tran vdout0_29ck780 FIND v(dout0_29) AT=790.05n

.meas tran vdout0_30ck780 FIND v(dout0_30) AT=790.05n

.meas tran vdout0_31ck780 FIND v(dout0_31) AT=790.05n

.meas tran vdout1_0ck780 FIND v(dout1_0) AT=790.05n

.meas tran vdout1_1ck780 FIND v(dout1_1) AT=790.05n

.meas tran vdout1_2ck780 FIND v(dout1_2) AT=790.05n

.meas tran vdout1_3ck780 FIND v(dout1_3) AT=790.05n

.meas tran vdout1_4ck780 FIND v(dout1_4) AT=790.05n

.meas tran vdout1_5ck780 FIND v(dout1_5) AT=790.05n

.meas tran vdout1_6ck780 FIND v(dout1_6) AT=790.05n

.meas tran vdout1_7ck780 FIND v(dout1_7) AT=790.05n

.meas tran vdout1_8ck780 FIND v(dout1_8) AT=790.05n

.meas tran vdout1_9ck780 FIND v(dout1_9) AT=790.05n

.meas tran vdout1_10ck780 FIND v(dout1_10) AT=790.05n

.meas tran vdout1_11ck780 FIND v(dout1_11) AT=790.05n

.meas tran vdout1_12ck780 FIND v(dout1_12) AT=790.05n

.meas tran vdout1_13ck780 FIND v(dout1_13) AT=790.05n

.meas tran vdout1_14ck780 FIND v(dout1_14) AT=790.05n

.meas tran vdout1_15ck780 FIND v(dout1_15) AT=790.05n

.meas tran vdout1_16ck780 FIND v(dout1_16) AT=790.05n

.meas tran vdout1_17ck780 FIND v(dout1_17) AT=790.05n

.meas tran vdout1_18ck780 FIND v(dout1_18) AT=790.05n

.meas tran vdout1_19ck780 FIND v(dout1_19) AT=790.05n

.meas tran vdout1_20ck780 FIND v(dout1_20) AT=790.05n

.meas tran vdout1_21ck780 FIND v(dout1_21) AT=790.05n

.meas tran vdout1_22ck780 FIND v(dout1_22) AT=790.05n

.meas tran vdout1_23ck780 FIND v(dout1_23) AT=790.05n

.meas tran vdout1_24ck780 FIND v(dout1_24) AT=790.05n

.meas tran vdout1_25ck780 FIND v(dout1_25) AT=790.05n

.meas tran vdout1_26ck780 FIND v(dout1_26) AT=790.05n

.meas tran vdout1_27ck780 FIND v(dout1_27) AT=790.05n

.meas tran vdout1_28ck780 FIND v(dout1_28) AT=790.05n

.meas tran vdout1_29ck780 FIND v(dout1_29) AT=790.05n

.meas tran vdout1_30ck780 FIND v(dout1_30) AT=790.05n

.meas tran vdout1_31ck780 FIND v(dout1_31) AT=790.05n

.meas tran vdout0_0ck790 FIND v(dout0_0) AT=800.05n

.meas tran vdout0_1ck790 FIND v(dout0_1) AT=800.05n

.meas tran vdout0_2ck790 FIND v(dout0_2) AT=800.05n

.meas tran vdout0_3ck790 FIND v(dout0_3) AT=800.05n

.meas tran vdout0_4ck790 FIND v(dout0_4) AT=800.05n

.meas tran vdout0_5ck790 FIND v(dout0_5) AT=800.05n

.meas tran vdout0_6ck790 FIND v(dout0_6) AT=800.05n

.meas tran vdout0_7ck790 FIND v(dout0_7) AT=800.05n

.meas tran vdout0_8ck790 FIND v(dout0_8) AT=800.05n

.meas tran vdout0_9ck790 FIND v(dout0_9) AT=800.05n

.meas tran vdout0_10ck790 FIND v(dout0_10) AT=800.05n

.meas tran vdout0_11ck790 FIND v(dout0_11) AT=800.05n

.meas tran vdout0_12ck790 FIND v(dout0_12) AT=800.05n

.meas tran vdout0_13ck790 FIND v(dout0_13) AT=800.05n

.meas tran vdout0_14ck790 FIND v(dout0_14) AT=800.05n

.meas tran vdout0_15ck790 FIND v(dout0_15) AT=800.05n

.meas tran vdout0_16ck790 FIND v(dout0_16) AT=800.05n

.meas tran vdout0_17ck790 FIND v(dout0_17) AT=800.05n

.meas tran vdout0_18ck790 FIND v(dout0_18) AT=800.05n

.meas tran vdout0_19ck790 FIND v(dout0_19) AT=800.05n

.meas tran vdout0_20ck790 FIND v(dout0_20) AT=800.05n

.meas tran vdout0_21ck790 FIND v(dout0_21) AT=800.05n

.meas tran vdout0_22ck790 FIND v(dout0_22) AT=800.05n

.meas tran vdout0_23ck790 FIND v(dout0_23) AT=800.05n

.meas tran vdout0_24ck790 FIND v(dout0_24) AT=800.05n

.meas tran vdout0_25ck790 FIND v(dout0_25) AT=800.05n

.meas tran vdout0_26ck790 FIND v(dout0_26) AT=800.05n

.meas tran vdout0_27ck790 FIND v(dout0_27) AT=800.05n

.meas tran vdout0_28ck790 FIND v(dout0_28) AT=800.05n

.meas tran vdout0_29ck790 FIND v(dout0_29) AT=800.05n

.meas tran vdout0_30ck790 FIND v(dout0_30) AT=800.05n

.meas tran vdout0_31ck790 FIND v(dout0_31) AT=800.05n

.meas tran vdout1_0ck790 FIND v(dout1_0) AT=800.05n

.meas tran vdout1_1ck790 FIND v(dout1_1) AT=800.05n

.meas tran vdout1_2ck790 FIND v(dout1_2) AT=800.05n

.meas tran vdout1_3ck790 FIND v(dout1_3) AT=800.05n

.meas tran vdout1_4ck790 FIND v(dout1_4) AT=800.05n

.meas tran vdout1_5ck790 FIND v(dout1_5) AT=800.05n

.meas tran vdout1_6ck790 FIND v(dout1_6) AT=800.05n

.meas tran vdout1_7ck790 FIND v(dout1_7) AT=800.05n

.meas tran vdout1_8ck790 FIND v(dout1_8) AT=800.05n

.meas tran vdout1_9ck790 FIND v(dout1_9) AT=800.05n

.meas tran vdout1_10ck790 FIND v(dout1_10) AT=800.05n

.meas tran vdout1_11ck790 FIND v(dout1_11) AT=800.05n

.meas tran vdout1_12ck790 FIND v(dout1_12) AT=800.05n

.meas tran vdout1_13ck790 FIND v(dout1_13) AT=800.05n

.meas tran vdout1_14ck790 FIND v(dout1_14) AT=800.05n

.meas tran vdout1_15ck790 FIND v(dout1_15) AT=800.05n

.meas tran vdout1_16ck790 FIND v(dout1_16) AT=800.05n

.meas tran vdout1_17ck790 FIND v(dout1_17) AT=800.05n

.meas tran vdout1_18ck790 FIND v(dout1_18) AT=800.05n

.meas tran vdout1_19ck790 FIND v(dout1_19) AT=800.05n

.meas tran vdout1_20ck790 FIND v(dout1_20) AT=800.05n

.meas tran vdout1_21ck790 FIND v(dout1_21) AT=800.05n

.meas tran vdout1_22ck790 FIND v(dout1_22) AT=800.05n

.meas tran vdout1_23ck790 FIND v(dout1_23) AT=800.05n

.meas tran vdout1_24ck790 FIND v(dout1_24) AT=800.05n

.meas tran vdout1_25ck790 FIND v(dout1_25) AT=800.05n

.meas tran vdout1_26ck790 FIND v(dout1_26) AT=800.05n

.meas tran vdout1_27ck790 FIND v(dout1_27) AT=800.05n

.meas tran vdout1_28ck790 FIND v(dout1_28) AT=800.05n

.meas tran vdout1_29ck790 FIND v(dout1_29) AT=800.05n

.meas tran vdout1_30ck790 FIND v(dout1_30) AT=800.05n

.meas tran vdout1_31ck790 FIND v(dout1_31) AT=800.05n

.meas tran vdout0_0ck820 FIND v(dout0_0) AT=830.05n

.meas tran vdout0_1ck820 FIND v(dout0_1) AT=830.05n

.meas tran vdout0_2ck820 FIND v(dout0_2) AT=830.05n

.meas tran vdout0_3ck820 FIND v(dout0_3) AT=830.05n

.meas tran vdout0_4ck820 FIND v(dout0_4) AT=830.05n

.meas tran vdout0_5ck820 FIND v(dout0_5) AT=830.05n

.meas tran vdout0_6ck820 FIND v(dout0_6) AT=830.05n

.meas tran vdout0_7ck820 FIND v(dout0_7) AT=830.05n

.meas tran vdout0_8ck820 FIND v(dout0_8) AT=830.05n

.meas tran vdout0_9ck820 FIND v(dout0_9) AT=830.05n

.meas tran vdout0_10ck820 FIND v(dout0_10) AT=830.05n

.meas tran vdout0_11ck820 FIND v(dout0_11) AT=830.05n

.meas tran vdout0_12ck820 FIND v(dout0_12) AT=830.05n

.meas tran vdout0_13ck820 FIND v(dout0_13) AT=830.05n

.meas tran vdout0_14ck820 FIND v(dout0_14) AT=830.05n

.meas tran vdout0_15ck820 FIND v(dout0_15) AT=830.05n

.meas tran vdout0_16ck820 FIND v(dout0_16) AT=830.05n

.meas tran vdout0_17ck820 FIND v(dout0_17) AT=830.05n

.meas tran vdout0_18ck820 FIND v(dout0_18) AT=830.05n

.meas tran vdout0_19ck820 FIND v(dout0_19) AT=830.05n

.meas tran vdout0_20ck820 FIND v(dout0_20) AT=830.05n

.meas tran vdout0_21ck820 FIND v(dout0_21) AT=830.05n

.meas tran vdout0_22ck820 FIND v(dout0_22) AT=830.05n

.meas tran vdout0_23ck820 FIND v(dout0_23) AT=830.05n

.meas tran vdout0_24ck820 FIND v(dout0_24) AT=830.05n

.meas tran vdout0_25ck820 FIND v(dout0_25) AT=830.05n

.meas tran vdout0_26ck820 FIND v(dout0_26) AT=830.05n

.meas tran vdout0_27ck820 FIND v(dout0_27) AT=830.05n

.meas tran vdout0_28ck820 FIND v(dout0_28) AT=830.05n

.meas tran vdout0_29ck820 FIND v(dout0_29) AT=830.05n

.meas tran vdout0_30ck820 FIND v(dout0_30) AT=830.05n

.meas tran vdout0_31ck820 FIND v(dout0_31) AT=830.05n

.meas tran vdout1_0ck820 FIND v(dout1_0) AT=830.05n

.meas tran vdout1_1ck820 FIND v(dout1_1) AT=830.05n

.meas tran vdout1_2ck820 FIND v(dout1_2) AT=830.05n

.meas tran vdout1_3ck820 FIND v(dout1_3) AT=830.05n

.meas tran vdout1_4ck820 FIND v(dout1_4) AT=830.05n

.meas tran vdout1_5ck820 FIND v(dout1_5) AT=830.05n

.meas tran vdout1_6ck820 FIND v(dout1_6) AT=830.05n

.meas tran vdout1_7ck820 FIND v(dout1_7) AT=830.05n

.meas tran vdout1_8ck820 FIND v(dout1_8) AT=830.05n

.meas tran vdout1_9ck820 FIND v(dout1_9) AT=830.05n

.meas tran vdout1_10ck820 FIND v(dout1_10) AT=830.05n

.meas tran vdout1_11ck820 FIND v(dout1_11) AT=830.05n

.meas tran vdout1_12ck820 FIND v(dout1_12) AT=830.05n

.meas tran vdout1_13ck820 FIND v(dout1_13) AT=830.05n

.meas tran vdout1_14ck820 FIND v(dout1_14) AT=830.05n

.meas tran vdout1_15ck820 FIND v(dout1_15) AT=830.05n

.meas tran vdout1_16ck820 FIND v(dout1_16) AT=830.05n

.meas tran vdout1_17ck820 FIND v(dout1_17) AT=830.05n

.meas tran vdout1_18ck820 FIND v(dout1_18) AT=830.05n

.meas tran vdout1_19ck820 FIND v(dout1_19) AT=830.05n

.meas tran vdout1_20ck820 FIND v(dout1_20) AT=830.05n

.meas tran vdout1_21ck820 FIND v(dout1_21) AT=830.05n

.meas tran vdout1_22ck820 FIND v(dout1_22) AT=830.05n

.meas tran vdout1_23ck820 FIND v(dout1_23) AT=830.05n

.meas tran vdout1_24ck820 FIND v(dout1_24) AT=830.05n

.meas tran vdout1_25ck820 FIND v(dout1_25) AT=830.05n

.meas tran vdout1_26ck820 FIND v(dout1_26) AT=830.05n

.meas tran vdout1_27ck820 FIND v(dout1_27) AT=830.05n

.meas tran vdout1_28ck820 FIND v(dout1_28) AT=830.05n

.meas tran vdout1_29ck820 FIND v(dout1_29) AT=830.05n

.meas tran vdout1_30ck820 FIND v(dout1_30) AT=830.05n

.meas tran vdout1_31ck820 FIND v(dout1_31) AT=830.05n

.meas tran vdout0_0ck840 FIND v(dout0_0) AT=850.05n

.meas tran vdout0_1ck840 FIND v(dout0_1) AT=850.05n

.meas tran vdout0_2ck840 FIND v(dout0_2) AT=850.05n

.meas tran vdout0_3ck840 FIND v(dout0_3) AT=850.05n

.meas tran vdout0_4ck840 FIND v(dout0_4) AT=850.05n

.meas tran vdout0_5ck840 FIND v(dout0_5) AT=850.05n

.meas tran vdout0_6ck840 FIND v(dout0_6) AT=850.05n

.meas tran vdout0_7ck840 FIND v(dout0_7) AT=850.05n

.meas tran vdout0_8ck840 FIND v(dout0_8) AT=850.05n

.meas tran vdout0_9ck840 FIND v(dout0_9) AT=850.05n

.meas tran vdout0_10ck840 FIND v(dout0_10) AT=850.05n

.meas tran vdout0_11ck840 FIND v(dout0_11) AT=850.05n

.meas tran vdout0_12ck840 FIND v(dout0_12) AT=850.05n

.meas tran vdout0_13ck840 FIND v(dout0_13) AT=850.05n

.meas tran vdout0_14ck840 FIND v(dout0_14) AT=850.05n

.meas tran vdout0_15ck840 FIND v(dout0_15) AT=850.05n

.meas tran vdout0_16ck840 FIND v(dout0_16) AT=850.05n

.meas tran vdout0_17ck840 FIND v(dout0_17) AT=850.05n

.meas tran vdout0_18ck840 FIND v(dout0_18) AT=850.05n

.meas tran vdout0_19ck840 FIND v(dout0_19) AT=850.05n

.meas tran vdout0_20ck840 FIND v(dout0_20) AT=850.05n

.meas tran vdout0_21ck840 FIND v(dout0_21) AT=850.05n

.meas tran vdout0_22ck840 FIND v(dout0_22) AT=850.05n

.meas tran vdout0_23ck840 FIND v(dout0_23) AT=850.05n

.meas tran vdout0_24ck840 FIND v(dout0_24) AT=850.05n

.meas tran vdout0_25ck840 FIND v(dout0_25) AT=850.05n

.meas tran vdout0_26ck840 FIND v(dout0_26) AT=850.05n

.meas tran vdout0_27ck840 FIND v(dout0_27) AT=850.05n

.meas tran vdout0_28ck840 FIND v(dout0_28) AT=850.05n

.meas tran vdout0_29ck840 FIND v(dout0_29) AT=850.05n

.meas tran vdout0_30ck840 FIND v(dout0_30) AT=850.05n

.meas tran vdout0_31ck840 FIND v(dout0_31) AT=850.05n

.meas tran vdout1_0ck840 FIND v(dout1_0) AT=850.05n

.meas tran vdout1_1ck840 FIND v(dout1_1) AT=850.05n

.meas tran vdout1_2ck840 FIND v(dout1_2) AT=850.05n

.meas tran vdout1_3ck840 FIND v(dout1_3) AT=850.05n

.meas tran vdout1_4ck840 FIND v(dout1_4) AT=850.05n

.meas tran vdout1_5ck840 FIND v(dout1_5) AT=850.05n

.meas tran vdout1_6ck840 FIND v(dout1_6) AT=850.05n

.meas tran vdout1_7ck840 FIND v(dout1_7) AT=850.05n

.meas tran vdout1_8ck840 FIND v(dout1_8) AT=850.05n

.meas tran vdout1_9ck840 FIND v(dout1_9) AT=850.05n

.meas tran vdout1_10ck840 FIND v(dout1_10) AT=850.05n

.meas tran vdout1_11ck840 FIND v(dout1_11) AT=850.05n

.meas tran vdout1_12ck840 FIND v(dout1_12) AT=850.05n

.meas tran vdout1_13ck840 FIND v(dout1_13) AT=850.05n

.meas tran vdout1_14ck840 FIND v(dout1_14) AT=850.05n

.meas tran vdout1_15ck840 FIND v(dout1_15) AT=850.05n

.meas tran vdout1_16ck840 FIND v(dout1_16) AT=850.05n

.meas tran vdout1_17ck840 FIND v(dout1_17) AT=850.05n

.meas tran vdout1_18ck840 FIND v(dout1_18) AT=850.05n

.meas tran vdout1_19ck840 FIND v(dout1_19) AT=850.05n

.meas tran vdout1_20ck840 FIND v(dout1_20) AT=850.05n

.meas tran vdout1_21ck840 FIND v(dout1_21) AT=850.05n

.meas tran vdout1_22ck840 FIND v(dout1_22) AT=850.05n

.meas tran vdout1_23ck840 FIND v(dout1_23) AT=850.05n

.meas tran vdout1_24ck840 FIND v(dout1_24) AT=850.05n

.meas tran vdout1_25ck840 FIND v(dout1_25) AT=850.05n

.meas tran vdout1_26ck840 FIND v(dout1_26) AT=850.05n

.meas tran vdout1_27ck840 FIND v(dout1_27) AT=850.05n

.meas tran vdout1_28ck840 FIND v(dout1_28) AT=850.05n

.meas tran vdout1_29ck840 FIND v(dout1_29) AT=850.05n

.meas tran vdout1_30ck840 FIND v(dout1_30) AT=850.05n

.meas tran vdout1_31ck840 FIND v(dout1_31) AT=850.05n

.meas tran vdout0_0ck850 FIND v(dout0_0) AT=860.05n

.meas tran vdout0_1ck850 FIND v(dout0_1) AT=860.05n

.meas tran vdout0_2ck850 FIND v(dout0_2) AT=860.05n

.meas tran vdout0_3ck850 FIND v(dout0_3) AT=860.05n

.meas tran vdout0_4ck850 FIND v(dout0_4) AT=860.05n

.meas tran vdout0_5ck850 FIND v(dout0_5) AT=860.05n

.meas tran vdout0_6ck850 FIND v(dout0_6) AT=860.05n

.meas tran vdout0_7ck850 FIND v(dout0_7) AT=860.05n

.meas tran vdout0_8ck850 FIND v(dout0_8) AT=860.05n

.meas tran vdout0_9ck850 FIND v(dout0_9) AT=860.05n

.meas tran vdout0_10ck850 FIND v(dout0_10) AT=860.05n

.meas tran vdout0_11ck850 FIND v(dout0_11) AT=860.05n

.meas tran vdout0_12ck850 FIND v(dout0_12) AT=860.05n

.meas tran vdout0_13ck850 FIND v(dout0_13) AT=860.05n

.meas tran vdout0_14ck850 FIND v(dout0_14) AT=860.05n

.meas tran vdout0_15ck850 FIND v(dout0_15) AT=860.05n

.meas tran vdout0_16ck850 FIND v(dout0_16) AT=860.05n

.meas tran vdout0_17ck850 FIND v(dout0_17) AT=860.05n

.meas tran vdout0_18ck850 FIND v(dout0_18) AT=860.05n

.meas tran vdout0_19ck850 FIND v(dout0_19) AT=860.05n

.meas tran vdout0_20ck850 FIND v(dout0_20) AT=860.05n

.meas tran vdout0_21ck850 FIND v(dout0_21) AT=860.05n

.meas tran vdout0_22ck850 FIND v(dout0_22) AT=860.05n

.meas tran vdout0_23ck850 FIND v(dout0_23) AT=860.05n

.meas tran vdout0_24ck850 FIND v(dout0_24) AT=860.05n

.meas tran vdout0_25ck850 FIND v(dout0_25) AT=860.05n

.meas tran vdout0_26ck850 FIND v(dout0_26) AT=860.05n

.meas tran vdout0_27ck850 FIND v(dout0_27) AT=860.05n

.meas tran vdout0_28ck850 FIND v(dout0_28) AT=860.05n

.meas tran vdout0_29ck850 FIND v(dout0_29) AT=860.05n

.meas tran vdout0_30ck850 FIND v(dout0_30) AT=860.05n

.meas tran vdout0_31ck850 FIND v(dout0_31) AT=860.05n

.meas tran vdout1_0ck850 FIND v(dout1_0) AT=860.05n

.meas tran vdout1_1ck850 FIND v(dout1_1) AT=860.05n

.meas tran vdout1_2ck850 FIND v(dout1_2) AT=860.05n

.meas tran vdout1_3ck850 FIND v(dout1_3) AT=860.05n

.meas tran vdout1_4ck850 FIND v(dout1_4) AT=860.05n

.meas tran vdout1_5ck850 FIND v(dout1_5) AT=860.05n

.meas tran vdout1_6ck850 FIND v(dout1_6) AT=860.05n

.meas tran vdout1_7ck850 FIND v(dout1_7) AT=860.05n

.meas tran vdout1_8ck850 FIND v(dout1_8) AT=860.05n

.meas tran vdout1_9ck850 FIND v(dout1_9) AT=860.05n

.meas tran vdout1_10ck850 FIND v(dout1_10) AT=860.05n

.meas tran vdout1_11ck850 FIND v(dout1_11) AT=860.05n

.meas tran vdout1_12ck850 FIND v(dout1_12) AT=860.05n

.meas tran vdout1_13ck850 FIND v(dout1_13) AT=860.05n

.meas tran vdout1_14ck850 FIND v(dout1_14) AT=860.05n

.meas tran vdout1_15ck850 FIND v(dout1_15) AT=860.05n

.meas tran vdout1_16ck850 FIND v(dout1_16) AT=860.05n

.meas tran vdout1_17ck850 FIND v(dout1_17) AT=860.05n

.meas tran vdout1_18ck850 FIND v(dout1_18) AT=860.05n

.meas tran vdout1_19ck850 FIND v(dout1_19) AT=860.05n

.meas tran vdout1_20ck850 FIND v(dout1_20) AT=860.05n

.meas tran vdout1_21ck850 FIND v(dout1_21) AT=860.05n

.meas tran vdout1_22ck850 FIND v(dout1_22) AT=860.05n

.meas tran vdout1_23ck850 FIND v(dout1_23) AT=860.05n

.meas tran vdout1_24ck850 FIND v(dout1_24) AT=860.05n

.meas tran vdout1_25ck850 FIND v(dout1_25) AT=860.05n

.meas tran vdout1_26ck850 FIND v(dout1_26) AT=860.05n

.meas tran vdout1_27ck850 FIND v(dout1_27) AT=860.05n

.meas tran vdout1_28ck850 FIND v(dout1_28) AT=860.05n

.meas tran vdout1_29ck850 FIND v(dout1_29) AT=860.05n

.meas tran vdout1_30ck850 FIND v(dout1_30) AT=860.05n

.meas tran vdout1_31ck850 FIND v(dout1_31) AT=860.05n

.meas tran vdout0_0ck880 FIND v(dout0_0) AT=890.05n

.meas tran vdout0_1ck880 FIND v(dout0_1) AT=890.05n

.meas tran vdout0_2ck880 FIND v(dout0_2) AT=890.05n

.meas tran vdout0_3ck880 FIND v(dout0_3) AT=890.05n

.meas tran vdout0_4ck880 FIND v(dout0_4) AT=890.05n

.meas tran vdout0_5ck880 FIND v(dout0_5) AT=890.05n

.meas tran vdout0_6ck880 FIND v(dout0_6) AT=890.05n

.meas tran vdout0_7ck880 FIND v(dout0_7) AT=890.05n

.meas tran vdout0_8ck880 FIND v(dout0_8) AT=890.05n

.meas tran vdout0_9ck880 FIND v(dout0_9) AT=890.05n

.meas tran vdout0_10ck880 FIND v(dout0_10) AT=890.05n

.meas tran vdout0_11ck880 FIND v(dout0_11) AT=890.05n

.meas tran vdout0_12ck880 FIND v(dout0_12) AT=890.05n

.meas tran vdout0_13ck880 FIND v(dout0_13) AT=890.05n

.meas tran vdout0_14ck880 FIND v(dout0_14) AT=890.05n

.meas tran vdout0_15ck880 FIND v(dout0_15) AT=890.05n

.meas tran vdout0_16ck880 FIND v(dout0_16) AT=890.05n

.meas tran vdout0_17ck880 FIND v(dout0_17) AT=890.05n

.meas tran vdout0_18ck880 FIND v(dout0_18) AT=890.05n

.meas tran vdout0_19ck880 FIND v(dout0_19) AT=890.05n

.meas tran vdout0_20ck880 FIND v(dout0_20) AT=890.05n

.meas tran vdout0_21ck880 FIND v(dout0_21) AT=890.05n

.meas tran vdout0_22ck880 FIND v(dout0_22) AT=890.05n

.meas tran vdout0_23ck880 FIND v(dout0_23) AT=890.05n

.meas tran vdout0_24ck880 FIND v(dout0_24) AT=890.05n

.meas tran vdout0_25ck880 FIND v(dout0_25) AT=890.05n

.meas tran vdout0_26ck880 FIND v(dout0_26) AT=890.05n

.meas tran vdout0_27ck880 FIND v(dout0_27) AT=890.05n

.meas tran vdout0_28ck880 FIND v(dout0_28) AT=890.05n

.meas tran vdout0_29ck880 FIND v(dout0_29) AT=890.05n

.meas tran vdout0_30ck880 FIND v(dout0_30) AT=890.05n

.meas tran vdout0_31ck880 FIND v(dout0_31) AT=890.05n

.meas tran vdout1_0ck880 FIND v(dout1_0) AT=890.05n

.meas tran vdout1_1ck880 FIND v(dout1_1) AT=890.05n

.meas tran vdout1_2ck880 FIND v(dout1_2) AT=890.05n

.meas tran vdout1_3ck880 FIND v(dout1_3) AT=890.05n

.meas tran vdout1_4ck880 FIND v(dout1_4) AT=890.05n

.meas tran vdout1_5ck880 FIND v(dout1_5) AT=890.05n

.meas tran vdout1_6ck880 FIND v(dout1_6) AT=890.05n

.meas tran vdout1_7ck880 FIND v(dout1_7) AT=890.05n

.meas tran vdout1_8ck880 FIND v(dout1_8) AT=890.05n

.meas tran vdout1_9ck880 FIND v(dout1_9) AT=890.05n

.meas tran vdout1_10ck880 FIND v(dout1_10) AT=890.05n

.meas tran vdout1_11ck880 FIND v(dout1_11) AT=890.05n

.meas tran vdout1_12ck880 FIND v(dout1_12) AT=890.05n

.meas tran vdout1_13ck880 FIND v(dout1_13) AT=890.05n

.meas tran vdout1_14ck880 FIND v(dout1_14) AT=890.05n

.meas tran vdout1_15ck880 FIND v(dout1_15) AT=890.05n

.meas tran vdout1_16ck880 FIND v(dout1_16) AT=890.05n

.meas tran vdout1_17ck880 FIND v(dout1_17) AT=890.05n

.meas tran vdout1_18ck880 FIND v(dout1_18) AT=890.05n

.meas tran vdout1_19ck880 FIND v(dout1_19) AT=890.05n

.meas tran vdout1_20ck880 FIND v(dout1_20) AT=890.05n

.meas tran vdout1_21ck880 FIND v(dout1_21) AT=890.05n

.meas tran vdout1_22ck880 FIND v(dout1_22) AT=890.05n

.meas tran vdout1_23ck880 FIND v(dout1_23) AT=890.05n

.meas tran vdout1_24ck880 FIND v(dout1_24) AT=890.05n

.meas tran vdout1_25ck880 FIND v(dout1_25) AT=890.05n

.meas tran vdout1_26ck880 FIND v(dout1_26) AT=890.05n

.meas tran vdout1_27ck880 FIND v(dout1_27) AT=890.05n

.meas tran vdout1_28ck880 FIND v(dout1_28) AT=890.05n

.meas tran vdout1_29ck880 FIND v(dout1_29) AT=890.05n

.meas tran vdout1_30ck880 FIND v(dout1_30) AT=890.05n

.meas tran vdout1_31ck880 FIND v(dout1_31) AT=890.05n

.meas tran vdout0_0ck890 FIND v(dout0_0) AT=900.05n

.meas tran vdout0_1ck890 FIND v(dout0_1) AT=900.05n

.meas tran vdout0_2ck890 FIND v(dout0_2) AT=900.05n

.meas tran vdout0_3ck890 FIND v(dout0_3) AT=900.05n

.meas tran vdout0_4ck890 FIND v(dout0_4) AT=900.05n

.meas tran vdout0_5ck890 FIND v(dout0_5) AT=900.05n

.meas tran vdout0_6ck890 FIND v(dout0_6) AT=900.05n

.meas tran vdout0_7ck890 FIND v(dout0_7) AT=900.05n

.meas tran vdout0_8ck890 FIND v(dout0_8) AT=900.05n

.meas tran vdout0_9ck890 FIND v(dout0_9) AT=900.05n

.meas tran vdout0_10ck890 FIND v(dout0_10) AT=900.05n

.meas tran vdout0_11ck890 FIND v(dout0_11) AT=900.05n

.meas tran vdout0_12ck890 FIND v(dout0_12) AT=900.05n

.meas tran vdout0_13ck890 FIND v(dout0_13) AT=900.05n

.meas tran vdout0_14ck890 FIND v(dout0_14) AT=900.05n

.meas tran vdout0_15ck890 FIND v(dout0_15) AT=900.05n

.meas tran vdout0_16ck890 FIND v(dout0_16) AT=900.05n

.meas tran vdout0_17ck890 FIND v(dout0_17) AT=900.05n

.meas tran vdout0_18ck890 FIND v(dout0_18) AT=900.05n

.meas tran vdout0_19ck890 FIND v(dout0_19) AT=900.05n

.meas tran vdout0_20ck890 FIND v(dout0_20) AT=900.05n

.meas tran vdout0_21ck890 FIND v(dout0_21) AT=900.05n

.meas tran vdout0_22ck890 FIND v(dout0_22) AT=900.05n

.meas tran vdout0_23ck890 FIND v(dout0_23) AT=900.05n

.meas tran vdout0_24ck890 FIND v(dout0_24) AT=900.05n

.meas tran vdout0_25ck890 FIND v(dout0_25) AT=900.05n

.meas tran vdout0_26ck890 FIND v(dout0_26) AT=900.05n

.meas tran vdout0_27ck890 FIND v(dout0_27) AT=900.05n

.meas tran vdout0_28ck890 FIND v(dout0_28) AT=900.05n

.meas tran vdout0_29ck890 FIND v(dout0_29) AT=900.05n

.meas tran vdout0_30ck890 FIND v(dout0_30) AT=900.05n

.meas tran vdout0_31ck890 FIND v(dout0_31) AT=900.05n

.meas tran vdout1_0ck900 FIND v(dout1_0) AT=910.05n

.meas tran vdout1_1ck900 FIND v(dout1_1) AT=910.05n

.meas tran vdout1_2ck900 FIND v(dout1_2) AT=910.05n

.meas tran vdout1_3ck900 FIND v(dout1_3) AT=910.05n

.meas tran vdout1_4ck900 FIND v(dout1_4) AT=910.05n

.meas tran vdout1_5ck900 FIND v(dout1_5) AT=910.05n

.meas tran vdout1_6ck900 FIND v(dout1_6) AT=910.05n

.meas tran vdout1_7ck900 FIND v(dout1_7) AT=910.05n

.meas tran vdout1_8ck900 FIND v(dout1_8) AT=910.05n

.meas tran vdout1_9ck900 FIND v(dout1_9) AT=910.05n

.meas tran vdout1_10ck900 FIND v(dout1_10) AT=910.05n

.meas tran vdout1_11ck900 FIND v(dout1_11) AT=910.05n

.meas tran vdout1_12ck900 FIND v(dout1_12) AT=910.05n

.meas tran vdout1_13ck900 FIND v(dout1_13) AT=910.05n

.meas tran vdout1_14ck900 FIND v(dout1_14) AT=910.05n

.meas tran vdout1_15ck900 FIND v(dout1_15) AT=910.05n

.meas tran vdout1_16ck900 FIND v(dout1_16) AT=910.05n

.meas tran vdout1_17ck900 FIND v(dout1_17) AT=910.05n

.meas tran vdout1_18ck900 FIND v(dout1_18) AT=910.05n

.meas tran vdout1_19ck900 FIND v(dout1_19) AT=910.05n

.meas tran vdout1_20ck900 FIND v(dout1_20) AT=910.05n

.meas tran vdout1_21ck900 FIND v(dout1_21) AT=910.05n

.meas tran vdout1_22ck900 FIND v(dout1_22) AT=910.05n

.meas tran vdout1_23ck900 FIND v(dout1_23) AT=910.05n

.meas tran vdout1_24ck900 FIND v(dout1_24) AT=910.05n

.meas tran vdout1_25ck900 FIND v(dout1_25) AT=910.05n

.meas tran vdout1_26ck900 FIND v(dout1_26) AT=910.05n

.meas tran vdout1_27ck900 FIND v(dout1_27) AT=910.05n

.meas tran vdout1_28ck900 FIND v(dout1_28) AT=910.05n

.meas tran vdout1_29ck900 FIND v(dout1_29) AT=910.05n

.meas tran vdout1_30ck900 FIND v(dout1_30) AT=910.05n

.meas tran vdout1_31ck900 FIND v(dout1_31) AT=910.05n

.meas tran vdout0_0ck920 FIND v(dout0_0) AT=930.05n

.meas tran vdout0_1ck920 FIND v(dout0_1) AT=930.05n

.meas tran vdout0_2ck920 FIND v(dout0_2) AT=930.05n

.meas tran vdout0_3ck920 FIND v(dout0_3) AT=930.05n

.meas tran vdout0_4ck920 FIND v(dout0_4) AT=930.05n

.meas tran vdout0_5ck920 FIND v(dout0_5) AT=930.05n

.meas tran vdout0_6ck920 FIND v(dout0_6) AT=930.05n

.meas tran vdout0_7ck920 FIND v(dout0_7) AT=930.05n

.meas tran vdout0_8ck920 FIND v(dout0_8) AT=930.05n

.meas tran vdout0_9ck920 FIND v(dout0_9) AT=930.05n

.meas tran vdout0_10ck920 FIND v(dout0_10) AT=930.05n

.meas tran vdout0_11ck920 FIND v(dout0_11) AT=930.05n

.meas tran vdout0_12ck920 FIND v(dout0_12) AT=930.05n

.meas tran vdout0_13ck920 FIND v(dout0_13) AT=930.05n

.meas tran vdout0_14ck920 FIND v(dout0_14) AT=930.05n

.meas tran vdout0_15ck920 FIND v(dout0_15) AT=930.05n

.meas tran vdout0_16ck920 FIND v(dout0_16) AT=930.05n

.meas tran vdout0_17ck920 FIND v(dout0_17) AT=930.05n

.meas tran vdout0_18ck920 FIND v(dout0_18) AT=930.05n

.meas tran vdout0_19ck920 FIND v(dout0_19) AT=930.05n

.meas tran vdout0_20ck920 FIND v(dout0_20) AT=930.05n

.meas tran vdout0_21ck920 FIND v(dout0_21) AT=930.05n

.meas tran vdout0_22ck920 FIND v(dout0_22) AT=930.05n

.meas tran vdout0_23ck920 FIND v(dout0_23) AT=930.05n

.meas tran vdout0_24ck920 FIND v(dout0_24) AT=930.05n

.meas tran vdout0_25ck920 FIND v(dout0_25) AT=930.05n

.meas tran vdout0_26ck920 FIND v(dout0_26) AT=930.05n

.meas tran vdout0_27ck920 FIND v(dout0_27) AT=930.05n

.meas tran vdout0_28ck920 FIND v(dout0_28) AT=930.05n

.meas tran vdout0_29ck920 FIND v(dout0_29) AT=930.05n

.meas tran vdout0_30ck920 FIND v(dout0_30) AT=930.05n

.meas tran vdout0_31ck920 FIND v(dout0_31) AT=930.05n

.meas tran vdout1_0ck920 FIND v(dout1_0) AT=930.05n

.meas tran vdout1_1ck920 FIND v(dout1_1) AT=930.05n

.meas tran vdout1_2ck920 FIND v(dout1_2) AT=930.05n

.meas tran vdout1_3ck920 FIND v(dout1_3) AT=930.05n

.meas tran vdout1_4ck920 FIND v(dout1_4) AT=930.05n

.meas tran vdout1_5ck920 FIND v(dout1_5) AT=930.05n

.meas tran vdout1_6ck920 FIND v(dout1_6) AT=930.05n

.meas tran vdout1_7ck920 FIND v(dout1_7) AT=930.05n

.meas tran vdout1_8ck920 FIND v(dout1_8) AT=930.05n

.meas tran vdout1_9ck920 FIND v(dout1_9) AT=930.05n

.meas tran vdout1_10ck920 FIND v(dout1_10) AT=930.05n

.meas tran vdout1_11ck920 FIND v(dout1_11) AT=930.05n

.meas tran vdout1_12ck920 FIND v(dout1_12) AT=930.05n

.meas tran vdout1_13ck920 FIND v(dout1_13) AT=930.05n

.meas tran vdout1_14ck920 FIND v(dout1_14) AT=930.05n

.meas tran vdout1_15ck920 FIND v(dout1_15) AT=930.05n

.meas tran vdout1_16ck920 FIND v(dout1_16) AT=930.05n

.meas tran vdout1_17ck920 FIND v(dout1_17) AT=930.05n

.meas tran vdout1_18ck920 FIND v(dout1_18) AT=930.05n

.meas tran vdout1_19ck920 FIND v(dout1_19) AT=930.05n

.meas tran vdout1_20ck920 FIND v(dout1_20) AT=930.05n

.meas tran vdout1_21ck920 FIND v(dout1_21) AT=930.05n

.meas tran vdout1_22ck920 FIND v(dout1_22) AT=930.05n

.meas tran vdout1_23ck920 FIND v(dout1_23) AT=930.05n

.meas tran vdout1_24ck920 FIND v(dout1_24) AT=930.05n

.meas tran vdout1_25ck920 FIND v(dout1_25) AT=930.05n

.meas tran vdout1_26ck920 FIND v(dout1_26) AT=930.05n

.meas tran vdout1_27ck920 FIND v(dout1_27) AT=930.05n

.meas tran vdout1_28ck920 FIND v(dout1_28) AT=930.05n

.meas tran vdout1_29ck920 FIND v(dout1_29) AT=930.05n

.meas tran vdout1_30ck920 FIND v(dout1_30) AT=930.05n

.meas tran vdout1_31ck920 FIND v(dout1_31) AT=930.05n

.meas tran vdout0_0ck970 FIND v(dout0_0) AT=980.05n

.meas tran vdout0_1ck970 FIND v(dout0_1) AT=980.05n

.meas tran vdout0_2ck970 FIND v(dout0_2) AT=980.05n

.meas tran vdout0_3ck970 FIND v(dout0_3) AT=980.05n

.meas tran vdout0_4ck970 FIND v(dout0_4) AT=980.05n

.meas tran vdout0_5ck970 FIND v(dout0_5) AT=980.05n

.meas tran vdout0_6ck970 FIND v(dout0_6) AT=980.05n

.meas tran vdout0_7ck970 FIND v(dout0_7) AT=980.05n

.meas tran vdout0_8ck970 FIND v(dout0_8) AT=980.05n

.meas tran vdout0_9ck970 FIND v(dout0_9) AT=980.05n

.meas tran vdout0_10ck970 FIND v(dout0_10) AT=980.05n

.meas tran vdout0_11ck970 FIND v(dout0_11) AT=980.05n

.meas tran vdout0_12ck970 FIND v(dout0_12) AT=980.05n

.meas tran vdout0_13ck970 FIND v(dout0_13) AT=980.05n

.meas tran vdout0_14ck970 FIND v(dout0_14) AT=980.05n

.meas tran vdout0_15ck970 FIND v(dout0_15) AT=980.05n

.meas tran vdout0_16ck970 FIND v(dout0_16) AT=980.05n

.meas tran vdout0_17ck970 FIND v(dout0_17) AT=980.05n

.meas tran vdout0_18ck970 FIND v(dout0_18) AT=980.05n

.meas tran vdout0_19ck970 FIND v(dout0_19) AT=980.05n

.meas tran vdout0_20ck970 FIND v(dout0_20) AT=980.05n

.meas tran vdout0_21ck970 FIND v(dout0_21) AT=980.05n

.meas tran vdout0_22ck970 FIND v(dout0_22) AT=980.05n

.meas tran vdout0_23ck970 FIND v(dout0_23) AT=980.05n

.meas tran vdout0_24ck970 FIND v(dout0_24) AT=980.05n

.meas tran vdout0_25ck970 FIND v(dout0_25) AT=980.05n

.meas tran vdout0_26ck970 FIND v(dout0_26) AT=980.05n

.meas tran vdout0_27ck970 FIND v(dout0_27) AT=980.05n

.meas tran vdout0_28ck970 FIND v(dout0_28) AT=980.05n

.meas tran vdout0_29ck970 FIND v(dout0_29) AT=980.05n

.meas tran vdout0_30ck970 FIND v(dout0_30) AT=980.05n

.meas tran vdout0_31ck970 FIND v(dout0_31) AT=980.05n

.meas tran vdout0_0ck980 FIND v(dout0_0) AT=990.05n

.meas tran vdout0_1ck980 FIND v(dout0_1) AT=990.05n

.meas tran vdout0_2ck980 FIND v(dout0_2) AT=990.05n

.meas tran vdout0_3ck980 FIND v(dout0_3) AT=990.05n

.meas tran vdout0_4ck980 FIND v(dout0_4) AT=990.05n

.meas tran vdout0_5ck980 FIND v(dout0_5) AT=990.05n

.meas tran vdout0_6ck980 FIND v(dout0_6) AT=990.05n

.meas tran vdout0_7ck980 FIND v(dout0_7) AT=990.05n

.meas tran vdout0_8ck980 FIND v(dout0_8) AT=990.05n

.meas tran vdout0_9ck980 FIND v(dout0_9) AT=990.05n

.meas tran vdout0_10ck980 FIND v(dout0_10) AT=990.05n

.meas tran vdout0_11ck980 FIND v(dout0_11) AT=990.05n

.meas tran vdout0_12ck980 FIND v(dout0_12) AT=990.05n

.meas tran vdout0_13ck980 FIND v(dout0_13) AT=990.05n

.meas tran vdout0_14ck980 FIND v(dout0_14) AT=990.05n

.meas tran vdout0_15ck980 FIND v(dout0_15) AT=990.05n

.meas tran vdout0_16ck980 FIND v(dout0_16) AT=990.05n

.meas tran vdout0_17ck980 FIND v(dout0_17) AT=990.05n

.meas tran vdout0_18ck980 FIND v(dout0_18) AT=990.05n

.meas tran vdout0_19ck980 FIND v(dout0_19) AT=990.05n

.meas tran vdout0_20ck980 FIND v(dout0_20) AT=990.05n

.meas tran vdout0_21ck980 FIND v(dout0_21) AT=990.05n

.meas tran vdout0_22ck980 FIND v(dout0_22) AT=990.05n

.meas tran vdout0_23ck980 FIND v(dout0_23) AT=990.05n

.meas tran vdout0_24ck980 FIND v(dout0_24) AT=990.05n

.meas tran vdout0_25ck980 FIND v(dout0_25) AT=990.05n

.meas tran vdout0_26ck980 FIND v(dout0_26) AT=990.05n

.meas tran vdout0_27ck980 FIND v(dout0_27) AT=990.05n

.meas tran vdout0_28ck980 FIND v(dout0_28) AT=990.05n

.meas tran vdout0_29ck980 FIND v(dout0_29) AT=990.05n

.meas tran vdout0_30ck980 FIND v(dout0_30) AT=990.05n

.meas tran vdout0_31ck980 FIND v(dout0_31) AT=990.05n

.meas tran vdout0_0ck990 FIND v(dout0_0) AT=1000.05n

.meas tran vdout0_1ck990 FIND v(dout0_1) AT=1000.05n

.meas tran vdout0_2ck990 FIND v(dout0_2) AT=1000.05n

.meas tran vdout0_3ck990 FIND v(dout0_3) AT=1000.05n

.meas tran vdout0_4ck990 FIND v(dout0_4) AT=1000.05n

.meas tran vdout0_5ck990 FIND v(dout0_5) AT=1000.05n

.meas tran vdout0_6ck990 FIND v(dout0_6) AT=1000.05n

.meas tran vdout0_7ck990 FIND v(dout0_7) AT=1000.05n

.meas tran vdout0_8ck990 FIND v(dout0_8) AT=1000.05n

.meas tran vdout0_9ck990 FIND v(dout0_9) AT=1000.05n

.meas tran vdout0_10ck990 FIND v(dout0_10) AT=1000.05n

.meas tran vdout0_11ck990 FIND v(dout0_11) AT=1000.05n

.meas tran vdout0_12ck990 FIND v(dout0_12) AT=1000.05n

.meas tran vdout0_13ck990 FIND v(dout0_13) AT=1000.05n

.meas tran vdout0_14ck990 FIND v(dout0_14) AT=1000.05n

.meas tran vdout0_15ck990 FIND v(dout0_15) AT=1000.05n

.meas tran vdout0_16ck990 FIND v(dout0_16) AT=1000.05n

.meas tran vdout0_17ck990 FIND v(dout0_17) AT=1000.05n

.meas tran vdout0_18ck990 FIND v(dout0_18) AT=1000.05n

.meas tran vdout0_19ck990 FIND v(dout0_19) AT=1000.05n

.meas tran vdout0_20ck990 FIND v(dout0_20) AT=1000.05n

.meas tran vdout0_21ck990 FIND v(dout0_21) AT=1000.05n

.meas tran vdout0_22ck990 FIND v(dout0_22) AT=1000.05n

.meas tran vdout0_23ck990 FIND v(dout0_23) AT=1000.05n

.meas tran vdout0_24ck990 FIND v(dout0_24) AT=1000.05n

.meas tran vdout0_25ck990 FIND v(dout0_25) AT=1000.05n

.meas tran vdout0_26ck990 FIND v(dout0_26) AT=1000.05n

.meas tran vdout0_27ck990 FIND v(dout0_27) AT=1000.05n

.meas tran vdout0_28ck990 FIND v(dout0_28) AT=1000.05n

.meas tran vdout0_29ck990 FIND v(dout0_29) AT=1000.05n

.meas tran vdout0_30ck990 FIND v(dout0_30) AT=1000.05n

.meas tran vdout0_31ck990 FIND v(dout0_31) AT=1000.05n

.meas tran vdout1_0ck990 FIND v(dout1_0) AT=1000.05n

.meas tran vdout1_1ck990 FIND v(dout1_1) AT=1000.05n

.meas tran vdout1_2ck990 FIND v(dout1_2) AT=1000.05n

.meas tran vdout1_3ck990 FIND v(dout1_3) AT=1000.05n

.meas tran vdout1_4ck990 FIND v(dout1_4) AT=1000.05n

.meas tran vdout1_5ck990 FIND v(dout1_5) AT=1000.05n

.meas tran vdout1_6ck990 FIND v(dout1_6) AT=1000.05n

.meas tran vdout1_7ck990 FIND v(dout1_7) AT=1000.05n

.meas tran vdout1_8ck990 FIND v(dout1_8) AT=1000.05n

.meas tran vdout1_9ck990 FIND v(dout1_9) AT=1000.05n

.meas tran vdout1_10ck990 FIND v(dout1_10) AT=1000.05n

.meas tran vdout1_11ck990 FIND v(dout1_11) AT=1000.05n

.meas tran vdout1_12ck990 FIND v(dout1_12) AT=1000.05n

.meas tran vdout1_13ck990 FIND v(dout1_13) AT=1000.05n

.meas tran vdout1_14ck990 FIND v(dout1_14) AT=1000.05n

.meas tran vdout1_15ck990 FIND v(dout1_15) AT=1000.05n

.meas tran vdout1_16ck990 FIND v(dout1_16) AT=1000.05n

.meas tran vdout1_17ck990 FIND v(dout1_17) AT=1000.05n

.meas tran vdout1_18ck990 FIND v(dout1_18) AT=1000.05n

.meas tran vdout1_19ck990 FIND v(dout1_19) AT=1000.05n

.meas tran vdout1_20ck990 FIND v(dout1_20) AT=1000.05n

.meas tran vdout1_21ck990 FIND v(dout1_21) AT=1000.05n

.meas tran vdout1_22ck990 FIND v(dout1_22) AT=1000.05n

.meas tran vdout1_23ck990 FIND v(dout1_23) AT=1000.05n

.meas tran vdout1_24ck990 FIND v(dout1_24) AT=1000.05n

.meas tran vdout1_25ck990 FIND v(dout1_25) AT=1000.05n

.meas tran vdout1_26ck990 FIND v(dout1_26) AT=1000.05n

.meas tran vdout1_27ck990 FIND v(dout1_27) AT=1000.05n

.meas tran vdout1_28ck990 FIND v(dout1_28) AT=1000.05n

.meas tran vdout1_29ck990 FIND v(dout1_29) AT=1000.05n

.meas tran vdout1_30ck990 FIND v(dout1_30) AT=1000.05n

.meas tran vdout1_31ck990 FIND v(dout1_31) AT=1000.05n

.meas tran vdout1_0ck1010 FIND v(dout1_0) AT=1020.05n

.meas tran vdout1_1ck1010 FIND v(dout1_1) AT=1020.05n

.meas tran vdout1_2ck1010 FIND v(dout1_2) AT=1020.05n

.meas tran vdout1_3ck1010 FIND v(dout1_3) AT=1020.05n

.meas tran vdout1_4ck1010 FIND v(dout1_4) AT=1020.05n

.meas tran vdout1_5ck1010 FIND v(dout1_5) AT=1020.05n

.meas tran vdout1_6ck1010 FIND v(dout1_6) AT=1020.05n

.meas tran vdout1_7ck1010 FIND v(dout1_7) AT=1020.05n

.meas tran vdout1_8ck1010 FIND v(dout1_8) AT=1020.05n

.meas tran vdout1_9ck1010 FIND v(dout1_9) AT=1020.05n

.meas tran vdout1_10ck1010 FIND v(dout1_10) AT=1020.05n

.meas tran vdout1_11ck1010 FIND v(dout1_11) AT=1020.05n

.meas tran vdout1_12ck1010 FIND v(dout1_12) AT=1020.05n

.meas tran vdout1_13ck1010 FIND v(dout1_13) AT=1020.05n

.meas tran vdout1_14ck1010 FIND v(dout1_14) AT=1020.05n

.meas tran vdout1_15ck1010 FIND v(dout1_15) AT=1020.05n

.meas tran vdout1_16ck1010 FIND v(dout1_16) AT=1020.05n

.meas tran vdout1_17ck1010 FIND v(dout1_17) AT=1020.05n

.meas tran vdout1_18ck1010 FIND v(dout1_18) AT=1020.05n

.meas tran vdout1_19ck1010 FIND v(dout1_19) AT=1020.05n

.meas tran vdout1_20ck1010 FIND v(dout1_20) AT=1020.05n

.meas tran vdout1_21ck1010 FIND v(dout1_21) AT=1020.05n

.meas tran vdout1_22ck1010 FIND v(dout1_22) AT=1020.05n

.meas tran vdout1_23ck1010 FIND v(dout1_23) AT=1020.05n

.meas tran vdout1_24ck1010 FIND v(dout1_24) AT=1020.05n

.meas tran vdout1_25ck1010 FIND v(dout1_25) AT=1020.05n

.meas tran vdout1_26ck1010 FIND v(dout1_26) AT=1020.05n

.meas tran vdout1_27ck1010 FIND v(dout1_27) AT=1020.05n

.meas tran vdout1_28ck1010 FIND v(dout1_28) AT=1020.05n

.meas tran vdout1_29ck1010 FIND v(dout1_29) AT=1020.05n

.meas tran vdout1_30ck1010 FIND v(dout1_30) AT=1020.05n

.meas tran vdout1_31ck1010 FIND v(dout1_31) AT=1020.05n

.meas tran vdout0_0ck1020 FIND v(dout0_0) AT=1030.05n

.meas tran vdout0_1ck1020 FIND v(dout0_1) AT=1030.05n

.meas tran vdout0_2ck1020 FIND v(dout0_2) AT=1030.05n

.meas tran vdout0_3ck1020 FIND v(dout0_3) AT=1030.05n

.meas tran vdout0_4ck1020 FIND v(dout0_4) AT=1030.05n

.meas tran vdout0_5ck1020 FIND v(dout0_5) AT=1030.05n

.meas tran vdout0_6ck1020 FIND v(dout0_6) AT=1030.05n

.meas tran vdout0_7ck1020 FIND v(dout0_7) AT=1030.05n

.meas tran vdout0_8ck1020 FIND v(dout0_8) AT=1030.05n

.meas tran vdout0_9ck1020 FIND v(dout0_9) AT=1030.05n

.meas tran vdout0_10ck1020 FIND v(dout0_10) AT=1030.05n

.meas tran vdout0_11ck1020 FIND v(dout0_11) AT=1030.05n

.meas tran vdout0_12ck1020 FIND v(dout0_12) AT=1030.05n

.meas tran vdout0_13ck1020 FIND v(dout0_13) AT=1030.05n

.meas tran vdout0_14ck1020 FIND v(dout0_14) AT=1030.05n

.meas tran vdout0_15ck1020 FIND v(dout0_15) AT=1030.05n

.meas tran vdout0_16ck1020 FIND v(dout0_16) AT=1030.05n

.meas tran vdout0_17ck1020 FIND v(dout0_17) AT=1030.05n

.meas tran vdout0_18ck1020 FIND v(dout0_18) AT=1030.05n

.meas tran vdout0_19ck1020 FIND v(dout0_19) AT=1030.05n

.meas tran vdout0_20ck1020 FIND v(dout0_20) AT=1030.05n

.meas tran vdout0_21ck1020 FIND v(dout0_21) AT=1030.05n

.meas tran vdout0_22ck1020 FIND v(dout0_22) AT=1030.05n

.meas tran vdout0_23ck1020 FIND v(dout0_23) AT=1030.05n

.meas tran vdout0_24ck1020 FIND v(dout0_24) AT=1030.05n

.meas tran vdout0_25ck1020 FIND v(dout0_25) AT=1030.05n

.meas tran vdout0_26ck1020 FIND v(dout0_26) AT=1030.05n

.meas tran vdout0_27ck1020 FIND v(dout0_27) AT=1030.05n

.meas tran vdout0_28ck1020 FIND v(dout0_28) AT=1030.05n

.meas tran vdout0_29ck1020 FIND v(dout0_29) AT=1030.05n

.meas tran vdout0_30ck1020 FIND v(dout0_30) AT=1030.05n

.meas tran vdout0_31ck1020 FIND v(dout0_31) AT=1030.05n

.meas tran vdout1_0ck1020 FIND v(dout1_0) AT=1030.05n

.meas tran vdout1_1ck1020 FIND v(dout1_1) AT=1030.05n

.meas tran vdout1_2ck1020 FIND v(dout1_2) AT=1030.05n

.meas tran vdout1_3ck1020 FIND v(dout1_3) AT=1030.05n

.meas tran vdout1_4ck1020 FIND v(dout1_4) AT=1030.05n

.meas tran vdout1_5ck1020 FIND v(dout1_5) AT=1030.05n

.meas tran vdout1_6ck1020 FIND v(dout1_6) AT=1030.05n

.meas tran vdout1_7ck1020 FIND v(dout1_7) AT=1030.05n

.meas tran vdout1_8ck1020 FIND v(dout1_8) AT=1030.05n

.meas tran vdout1_9ck1020 FIND v(dout1_9) AT=1030.05n

.meas tran vdout1_10ck1020 FIND v(dout1_10) AT=1030.05n

.meas tran vdout1_11ck1020 FIND v(dout1_11) AT=1030.05n

.meas tran vdout1_12ck1020 FIND v(dout1_12) AT=1030.05n

.meas tran vdout1_13ck1020 FIND v(dout1_13) AT=1030.05n

.meas tran vdout1_14ck1020 FIND v(dout1_14) AT=1030.05n

.meas tran vdout1_15ck1020 FIND v(dout1_15) AT=1030.05n

.meas tran vdout1_16ck1020 FIND v(dout1_16) AT=1030.05n

.meas tran vdout1_17ck1020 FIND v(dout1_17) AT=1030.05n

.meas tran vdout1_18ck1020 FIND v(dout1_18) AT=1030.05n

.meas tran vdout1_19ck1020 FIND v(dout1_19) AT=1030.05n

.meas tran vdout1_20ck1020 FIND v(dout1_20) AT=1030.05n

.meas tran vdout1_21ck1020 FIND v(dout1_21) AT=1030.05n

.meas tran vdout1_22ck1020 FIND v(dout1_22) AT=1030.05n

.meas tran vdout1_23ck1020 FIND v(dout1_23) AT=1030.05n

.meas tran vdout1_24ck1020 FIND v(dout1_24) AT=1030.05n

.meas tran vdout1_25ck1020 FIND v(dout1_25) AT=1030.05n

.meas tran vdout1_26ck1020 FIND v(dout1_26) AT=1030.05n

.meas tran vdout1_27ck1020 FIND v(dout1_27) AT=1030.05n

.meas tran vdout1_28ck1020 FIND v(dout1_28) AT=1030.05n

.meas tran vdout1_29ck1020 FIND v(dout1_29) AT=1030.05n

.meas tran vdout1_30ck1020 FIND v(dout1_30) AT=1030.05n

.meas tran vdout1_31ck1020 FIND v(dout1_31) AT=1030.05n

.meas tran vdout1_0ck1040 FIND v(dout1_0) AT=1050.05n

.meas tran vdout1_1ck1040 FIND v(dout1_1) AT=1050.05n

.meas tran vdout1_2ck1040 FIND v(dout1_2) AT=1050.05n

.meas tran vdout1_3ck1040 FIND v(dout1_3) AT=1050.05n

.meas tran vdout1_4ck1040 FIND v(dout1_4) AT=1050.05n

.meas tran vdout1_5ck1040 FIND v(dout1_5) AT=1050.05n

.meas tran vdout1_6ck1040 FIND v(dout1_6) AT=1050.05n

.meas tran vdout1_7ck1040 FIND v(dout1_7) AT=1050.05n

.meas tran vdout1_8ck1040 FIND v(dout1_8) AT=1050.05n

.meas tran vdout1_9ck1040 FIND v(dout1_9) AT=1050.05n

.meas tran vdout1_10ck1040 FIND v(dout1_10) AT=1050.05n

.meas tran vdout1_11ck1040 FIND v(dout1_11) AT=1050.05n

.meas tran vdout1_12ck1040 FIND v(dout1_12) AT=1050.05n

.meas tran vdout1_13ck1040 FIND v(dout1_13) AT=1050.05n

.meas tran vdout1_14ck1040 FIND v(dout1_14) AT=1050.05n

.meas tran vdout1_15ck1040 FIND v(dout1_15) AT=1050.05n

.meas tran vdout1_16ck1040 FIND v(dout1_16) AT=1050.05n

.meas tran vdout1_17ck1040 FIND v(dout1_17) AT=1050.05n

.meas tran vdout1_18ck1040 FIND v(dout1_18) AT=1050.05n

.meas tran vdout1_19ck1040 FIND v(dout1_19) AT=1050.05n

.meas tran vdout1_20ck1040 FIND v(dout1_20) AT=1050.05n

.meas tran vdout1_21ck1040 FIND v(dout1_21) AT=1050.05n

.meas tran vdout1_22ck1040 FIND v(dout1_22) AT=1050.05n

.meas tran vdout1_23ck1040 FIND v(dout1_23) AT=1050.05n

.meas tran vdout1_24ck1040 FIND v(dout1_24) AT=1050.05n

.meas tran vdout1_25ck1040 FIND v(dout1_25) AT=1050.05n

.meas tran vdout1_26ck1040 FIND v(dout1_26) AT=1050.05n

.meas tran vdout1_27ck1040 FIND v(dout1_27) AT=1050.05n

.meas tran vdout1_28ck1040 FIND v(dout1_28) AT=1050.05n

.meas tran vdout1_29ck1040 FIND v(dout1_29) AT=1050.05n

.meas tran vdout1_30ck1040 FIND v(dout1_30) AT=1050.05n

.meas tran vdout1_31ck1040 FIND v(dout1_31) AT=1050.05n

.meas tran vdout0_0ck1080 FIND v(dout0_0) AT=1090.05n

.meas tran vdout0_1ck1080 FIND v(dout0_1) AT=1090.05n

.meas tran vdout0_2ck1080 FIND v(dout0_2) AT=1090.05n

.meas tran vdout0_3ck1080 FIND v(dout0_3) AT=1090.05n

.meas tran vdout0_4ck1080 FIND v(dout0_4) AT=1090.05n

.meas tran vdout0_5ck1080 FIND v(dout0_5) AT=1090.05n

.meas tran vdout0_6ck1080 FIND v(dout0_6) AT=1090.05n

.meas tran vdout0_7ck1080 FIND v(dout0_7) AT=1090.05n

.meas tran vdout0_8ck1080 FIND v(dout0_8) AT=1090.05n

.meas tran vdout0_9ck1080 FIND v(dout0_9) AT=1090.05n

.meas tran vdout0_10ck1080 FIND v(dout0_10) AT=1090.05n

.meas tran vdout0_11ck1080 FIND v(dout0_11) AT=1090.05n

.meas tran vdout0_12ck1080 FIND v(dout0_12) AT=1090.05n

.meas tran vdout0_13ck1080 FIND v(dout0_13) AT=1090.05n

.meas tran vdout0_14ck1080 FIND v(dout0_14) AT=1090.05n

.meas tran vdout0_15ck1080 FIND v(dout0_15) AT=1090.05n

.meas tran vdout0_16ck1080 FIND v(dout0_16) AT=1090.05n

.meas tran vdout0_17ck1080 FIND v(dout0_17) AT=1090.05n

.meas tran vdout0_18ck1080 FIND v(dout0_18) AT=1090.05n

.meas tran vdout0_19ck1080 FIND v(dout0_19) AT=1090.05n

.meas tran vdout0_20ck1080 FIND v(dout0_20) AT=1090.05n

.meas tran vdout0_21ck1080 FIND v(dout0_21) AT=1090.05n

.meas tran vdout0_22ck1080 FIND v(dout0_22) AT=1090.05n

.meas tran vdout0_23ck1080 FIND v(dout0_23) AT=1090.05n

.meas tran vdout0_24ck1080 FIND v(dout0_24) AT=1090.05n

.meas tran vdout0_25ck1080 FIND v(dout0_25) AT=1090.05n

.meas tran vdout0_26ck1080 FIND v(dout0_26) AT=1090.05n

.meas tran vdout0_27ck1080 FIND v(dout0_27) AT=1090.05n

.meas tran vdout0_28ck1080 FIND v(dout0_28) AT=1090.05n

.meas tran vdout0_29ck1080 FIND v(dout0_29) AT=1090.05n

.meas tran vdout0_30ck1080 FIND v(dout0_30) AT=1090.05n

.meas tran vdout0_31ck1080 FIND v(dout0_31) AT=1090.05n

.meas tran vdout0_0ck1100 FIND v(dout0_0) AT=1110.05n

.meas tran vdout0_1ck1100 FIND v(dout0_1) AT=1110.05n

.meas tran vdout0_2ck1100 FIND v(dout0_2) AT=1110.05n

.meas tran vdout0_3ck1100 FIND v(dout0_3) AT=1110.05n

.meas tran vdout0_4ck1100 FIND v(dout0_4) AT=1110.05n

.meas tran vdout0_5ck1100 FIND v(dout0_5) AT=1110.05n

.meas tran vdout0_6ck1100 FIND v(dout0_6) AT=1110.05n

.meas tran vdout0_7ck1100 FIND v(dout0_7) AT=1110.05n

.meas tran vdout0_8ck1100 FIND v(dout0_8) AT=1110.05n

.meas tran vdout0_9ck1100 FIND v(dout0_9) AT=1110.05n

.meas tran vdout0_10ck1100 FIND v(dout0_10) AT=1110.05n

.meas tran vdout0_11ck1100 FIND v(dout0_11) AT=1110.05n

.meas tran vdout0_12ck1100 FIND v(dout0_12) AT=1110.05n

.meas tran vdout0_13ck1100 FIND v(dout0_13) AT=1110.05n

.meas tran vdout0_14ck1100 FIND v(dout0_14) AT=1110.05n

.meas tran vdout0_15ck1100 FIND v(dout0_15) AT=1110.05n

.meas tran vdout0_16ck1100 FIND v(dout0_16) AT=1110.05n

.meas tran vdout0_17ck1100 FIND v(dout0_17) AT=1110.05n

.meas tran vdout0_18ck1100 FIND v(dout0_18) AT=1110.05n

.meas tran vdout0_19ck1100 FIND v(dout0_19) AT=1110.05n

.meas tran vdout0_20ck1100 FIND v(dout0_20) AT=1110.05n

.meas tran vdout0_21ck1100 FIND v(dout0_21) AT=1110.05n

.meas tran vdout0_22ck1100 FIND v(dout0_22) AT=1110.05n

.meas tran vdout0_23ck1100 FIND v(dout0_23) AT=1110.05n

.meas tran vdout0_24ck1100 FIND v(dout0_24) AT=1110.05n

.meas tran vdout0_25ck1100 FIND v(dout0_25) AT=1110.05n

.meas tran vdout0_26ck1100 FIND v(dout0_26) AT=1110.05n

.meas tran vdout0_27ck1100 FIND v(dout0_27) AT=1110.05n

.meas tran vdout0_28ck1100 FIND v(dout0_28) AT=1110.05n

.meas tran vdout0_29ck1100 FIND v(dout0_29) AT=1110.05n

.meas tran vdout0_30ck1100 FIND v(dout0_30) AT=1110.05n

.meas tran vdout0_31ck1100 FIND v(dout0_31) AT=1110.05n

.meas tran vdout0_0ck1110 FIND v(dout0_0) AT=1120.05n

.meas tran vdout0_1ck1110 FIND v(dout0_1) AT=1120.05n

.meas tran vdout0_2ck1110 FIND v(dout0_2) AT=1120.05n

.meas tran vdout0_3ck1110 FIND v(dout0_3) AT=1120.05n

.meas tran vdout0_4ck1110 FIND v(dout0_4) AT=1120.05n

.meas tran vdout0_5ck1110 FIND v(dout0_5) AT=1120.05n

.meas tran vdout0_6ck1110 FIND v(dout0_6) AT=1120.05n

.meas tran vdout0_7ck1110 FIND v(dout0_7) AT=1120.05n

.meas tran vdout0_8ck1110 FIND v(dout0_8) AT=1120.05n

.meas tran vdout0_9ck1110 FIND v(dout0_9) AT=1120.05n

.meas tran vdout0_10ck1110 FIND v(dout0_10) AT=1120.05n

.meas tran vdout0_11ck1110 FIND v(dout0_11) AT=1120.05n

.meas tran vdout0_12ck1110 FIND v(dout0_12) AT=1120.05n

.meas tran vdout0_13ck1110 FIND v(dout0_13) AT=1120.05n

.meas tran vdout0_14ck1110 FIND v(dout0_14) AT=1120.05n

.meas tran vdout0_15ck1110 FIND v(dout0_15) AT=1120.05n

.meas tran vdout0_16ck1110 FIND v(dout0_16) AT=1120.05n

.meas tran vdout0_17ck1110 FIND v(dout0_17) AT=1120.05n

.meas tran vdout0_18ck1110 FIND v(dout0_18) AT=1120.05n

.meas tran vdout0_19ck1110 FIND v(dout0_19) AT=1120.05n

.meas tran vdout0_20ck1110 FIND v(dout0_20) AT=1120.05n

.meas tran vdout0_21ck1110 FIND v(dout0_21) AT=1120.05n

.meas tran vdout0_22ck1110 FIND v(dout0_22) AT=1120.05n

.meas tran vdout0_23ck1110 FIND v(dout0_23) AT=1120.05n

.meas tran vdout0_24ck1110 FIND v(dout0_24) AT=1120.05n

.meas tran vdout0_25ck1110 FIND v(dout0_25) AT=1120.05n

.meas tran vdout0_26ck1110 FIND v(dout0_26) AT=1120.05n

.meas tran vdout0_27ck1110 FIND v(dout0_27) AT=1120.05n

.meas tran vdout0_28ck1110 FIND v(dout0_28) AT=1120.05n

.meas tran vdout0_29ck1110 FIND v(dout0_29) AT=1120.05n

.meas tran vdout0_30ck1110 FIND v(dout0_30) AT=1120.05n

.meas tran vdout0_31ck1110 FIND v(dout0_31) AT=1120.05n

.meas tran vdout1_0ck1110 FIND v(dout1_0) AT=1120.05n

.meas tran vdout1_1ck1110 FIND v(dout1_1) AT=1120.05n

.meas tran vdout1_2ck1110 FIND v(dout1_2) AT=1120.05n

.meas tran vdout1_3ck1110 FIND v(dout1_3) AT=1120.05n

.meas tran vdout1_4ck1110 FIND v(dout1_4) AT=1120.05n

.meas tran vdout1_5ck1110 FIND v(dout1_5) AT=1120.05n

.meas tran vdout1_6ck1110 FIND v(dout1_6) AT=1120.05n

.meas tran vdout1_7ck1110 FIND v(dout1_7) AT=1120.05n

.meas tran vdout1_8ck1110 FIND v(dout1_8) AT=1120.05n

.meas tran vdout1_9ck1110 FIND v(dout1_9) AT=1120.05n

.meas tran vdout1_10ck1110 FIND v(dout1_10) AT=1120.05n

.meas tran vdout1_11ck1110 FIND v(dout1_11) AT=1120.05n

.meas tran vdout1_12ck1110 FIND v(dout1_12) AT=1120.05n

.meas tran vdout1_13ck1110 FIND v(dout1_13) AT=1120.05n

.meas tran vdout1_14ck1110 FIND v(dout1_14) AT=1120.05n

.meas tran vdout1_15ck1110 FIND v(dout1_15) AT=1120.05n

.meas tran vdout1_16ck1110 FIND v(dout1_16) AT=1120.05n

.meas tran vdout1_17ck1110 FIND v(dout1_17) AT=1120.05n

.meas tran vdout1_18ck1110 FIND v(dout1_18) AT=1120.05n

.meas tran vdout1_19ck1110 FIND v(dout1_19) AT=1120.05n

.meas tran vdout1_20ck1110 FIND v(dout1_20) AT=1120.05n

.meas tran vdout1_21ck1110 FIND v(dout1_21) AT=1120.05n

.meas tran vdout1_22ck1110 FIND v(dout1_22) AT=1120.05n

.meas tran vdout1_23ck1110 FIND v(dout1_23) AT=1120.05n

.meas tran vdout1_24ck1110 FIND v(dout1_24) AT=1120.05n

.meas tran vdout1_25ck1110 FIND v(dout1_25) AT=1120.05n

.meas tran vdout1_26ck1110 FIND v(dout1_26) AT=1120.05n

.meas tran vdout1_27ck1110 FIND v(dout1_27) AT=1120.05n

.meas tran vdout1_28ck1110 FIND v(dout1_28) AT=1120.05n

.meas tran vdout1_29ck1110 FIND v(dout1_29) AT=1120.05n

.meas tran vdout1_30ck1110 FIND v(dout1_30) AT=1120.05n

.meas tran vdout1_31ck1110 FIND v(dout1_31) AT=1120.05n

.meas tran vdout0_0ck1120 FIND v(dout0_0) AT=1130.05n

.meas tran vdout0_1ck1120 FIND v(dout0_1) AT=1130.05n

.meas tran vdout0_2ck1120 FIND v(dout0_2) AT=1130.05n

.meas tran vdout0_3ck1120 FIND v(dout0_3) AT=1130.05n

.meas tran vdout0_4ck1120 FIND v(dout0_4) AT=1130.05n

.meas tran vdout0_5ck1120 FIND v(dout0_5) AT=1130.05n

.meas tran vdout0_6ck1120 FIND v(dout0_6) AT=1130.05n

.meas tran vdout0_7ck1120 FIND v(dout0_7) AT=1130.05n

.meas tran vdout0_8ck1120 FIND v(dout0_8) AT=1130.05n

.meas tran vdout0_9ck1120 FIND v(dout0_9) AT=1130.05n

.meas tran vdout0_10ck1120 FIND v(dout0_10) AT=1130.05n

.meas tran vdout0_11ck1120 FIND v(dout0_11) AT=1130.05n

.meas tran vdout0_12ck1120 FIND v(dout0_12) AT=1130.05n

.meas tran vdout0_13ck1120 FIND v(dout0_13) AT=1130.05n

.meas tran vdout0_14ck1120 FIND v(dout0_14) AT=1130.05n

.meas tran vdout0_15ck1120 FIND v(dout0_15) AT=1130.05n

.meas tran vdout0_16ck1120 FIND v(dout0_16) AT=1130.05n

.meas tran vdout0_17ck1120 FIND v(dout0_17) AT=1130.05n

.meas tran vdout0_18ck1120 FIND v(dout0_18) AT=1130.05n

.meas tran vdout0_19ck1120 FIND v(dout0_19) AT=1130.05n

.meas tran vdout0_20ck1120 FIND v(dout0_20) AT=1130.05n

.meas tran vdout0_21ck1120 FIND v(dout0_21) AT=1130.05n

.meas tran vdout0_22ck1120 FIND v(dout0_22) AT=1130.05n

.meas tran vdout0_23ck1120 FIND v(dout0_23) AT=1130.05n

.meas tran vdout0_24ck1120 FIND v(dout0_24) AT=1130.05n

.meas tran vdout0_25ck1120 FIND v(dout0_25) AT=1130.05n

.meas tran vdout0_26ck1120 FIND v(dout0_26) AT=1130.05n

.meas tran vdout0_27ck1120 FIND v(dout0_27) AT=1130.05n

.meas tran vdout0_28ck1120 FIND v(dout0_28) AT=1130.05n

.meas tran vdout0_29ck1120 FIND v(dout0_29) AT=1130.05n

.meas tran vdout0_30ck1120 FIND v(dout0_30) AT=1130.05n

.meas tran vdout0_31ck1120 FIND v(dout0_31) AT=1130.05n

.meas tran vdout0_0ck1130 FIND v(dout0_0) AT=1140.05n

.meas tran vdout0_1ck1130 FIND v(dout0_1) AT=1140.05n

.meas tran vdout0_2ck1130 FIND v(dout0_2) AT=1140.05n

.meas tran vdout0_3ck1130 FIND v(dout0_3) AT=1140.05n

.meas tran vdout0_4ck1130 FIND v(dout0_4) AT=1140.05n

.meas tran vdout0_5ck1130 FIND v(dout0_5) AT=1140.05n

.meas tran vdout0_6ck1130 FIND v(dout0_6) AT=1140.05n

.meas tran vdout0_7ck1130 FIND v(dout0_7) AT=1140.05n

.meas tran vdout0_8ck1130 FIND v(dout0_8) AT=1140.05n

.meas tran vdout0_9ck1130 FIND v(dout0_9) AT=1140.05n

.meas tran vdout0_10ck1130 FIND v(dout0_10) AT=1140.05n

.meas tran vdout0_11ck1130 FIND v(dout0_11) AT=1140.05n

.meas tran vdout0_12ck1130 FIND v(dout0_12) AT=1140.05n

.meas tran vdout0_13ck1130 FIND v(dout0_13) AT=1140.05n

.meas tran vdout0_14ck1130 FIND v(dout0_14) AT=1140.05n

.meas tran vdout0_15ck1130 FIND v(dout0_15) AT=1140.05n

.meas tran vdout0_16ck1130 FIND v(dout0_16) AT=1140.05n

.meas tran vdout0_17ck1130 FIND v(dout0_17) AT=1140.05n

.meas tran vdout0_18ck1130 FIND v(dout0_18) AT=1140.05n

.meas tran vdout0_19ck1130 FIND v(dout0_19) AT=1140.05n

.meas tran vdout0_20ck1130 FIND v(dout0_20) AT=1140.05n

.meas tran vdout0_21ck1130 FIND v(dout0_21) AT=1140.05n

.meas tran vdout0_22ck1130 FIND v(dout0_22) AT=1140.05n

.meas tran vdout0_23ck1130 FIND v(dout0_23) AT=1140.05n

.meas tran vdout0_24ck1130 FIND v(dout0_24) AT=1140.05n

.meas tran vdout0_25ck1130 FIND v(dout0_25) AT=1140.05n

.meas tran vdout0_26ck1130 FIND v(dout0_26) AT=1140.05n

.meas tran vdout0_27ck1130 FIND v(dout0_27) AT=1140.05n

.meas tran vdout0_28ck1130 FIND v(dout0_28) AT=1140.05n

.meas tran vdout0_29ck1130 FIND v(dout0_29) AT=1140.05n

.meas tran vdout0_30ck1130 FIND v(dout0_30) AT=1140.05n

.meas tran vdout0_31ck1130 FIND v(dout0_31) AT=1140.05n

.meas tran vdout1_0ck1130 FIND v(dout1_0) AT=1140.05n

.meas tran vdout1_1ck1130 FIND v(dout1_1) AT=1140.05n

.meas tran vdout1_2ck1130 FIND v(dout1_2) AT=1140.05n

.meas tran vdout1_3ck1130 FIND v(dout1_3) AT=1140.05n

.meas tran vdout1_4ck1130 FIND v(dout1_4) AT=1140.05n

.meas tran vdout1_5ck1130 FIND v(dout1_5) AT=1140.05n

.meas tran vdout1_6ck1130 FIND v(dout1_6) AT=1140.05n

.meas tran vdout1_7ck1130 FIND v(dout1_7) AT=1140.05n

.meas tran vdout1_8ck1130 FIND v(dout1_8) AT=1140.05n

.meas tran vdout1_9ck1130 FIND v(dout1_9) AT=1140.05n

.meas tran vdout1_10ck1130 FIND v(dout1_10) AT=1140.05n

.meas tran vdout1_11ck1130 FIND v(dout1_11) AT=1140.05n

.meas tran vdout1_12ck1130 FIND v(dout1_12) AT=1140.05n

.meas tran vdout1_13ck1130 FIND v(dout1_13) AT=1140.05n

.meas tran vdout1_14ck1130 FIND v(dout1_14) AT=1140.05n

.meas tran vdout1_15ck1130 FIND v(dout1_15) AT=1140.05n

.meas tran vdout1_16ck1130 FIND v(dout1_16) AT=1140.05n

.meas tran vdout1_17ck1130 FIND v(dout1_17) AT=1140.05n

.meas tran vdout1_18ck1130 FIND v(dout1_18) AT=1140.05n

.meas tran vdout1_19ck1130 FIND v(dout1_19) AT=1140.05n

.meas tran vdout1_20ck1130 FIND v(dout1_20) AT=1140.05n

.meas tran vdout1_21ck1130 FIND v(dout1_21) AT=1140.05n

.meas tran vdout1_22ck1130 FIND v(dout1_22) AT=1140.05n

.meas tran vdout1_23ck1130 FIND v(dout1_23) AT=1140.05n

.meas tran vdout1_24ck1130 FIND v(dout1_24) AT=1140.05n

.meas tran vdout1_25ck1130 FIND v(dout1_25) AT=1140.05n

.meas tran vdout1_26ck1130 FIND v(dout1_26) AT=1140.05n

.meas tran vdout1_27ck1130 FIND v(dout1_27) AT=1140.05n

.meas tran vdout1_28ck1130 FIND v(dout1_28) AT=1140.05n

.meas tran vdout1_29ck1130 FIND v(dout1_29) AT=1140.05n

.meas tran vdout1_30ck1130 FIND v(dout1_30) AT=1140.05n

.meas tran vdout1_31ck1130 FIND v(dout1_31) AT=1140.05n

.meas tran vdout0_0ck1170 FIND v(dout0_0) AT=1180.05n

.meas tran vdout0_1ck1170 FIND v(dout0_1) AT=1180.05n

.meas tran vdout0_2ck1170 FIND v(dout0_2) AT=1180.05n

.meas tran vdout0_3ck1170 FIND v(dout0_3) AT=1180.05n

.meas tran vdout0_4ck1170 FIND v(dout0_4) AT=1180.05n

.meas tran vdout0_5ck1170 FIND v(dout0_5) AT=1180.05n

.meas tran vdout0_6ck1170 FIND v(dout0_6) AT=1180.05n

.meas tran vdout0_7ck1170 FIND v(dout0_7) AT=1180.05n

.meas tran vdout0_8ck1170 FIND v(dout0_8) AT=1180.05n

.meas tran vdout0_9ck1170 FIND v(dout0_9) AT=1180.05n

.meas tran vdout0_10ck1170 FIND v(dout0_10) AT=1180.05n

.meas tran vdout0_11ck1170 FIND v(dout0_11) AT=1180.05n

.meas tran vdout0_12ck1170 FIND v(dout0_12) AT=1180.05n

.meas tran vdout0_13ck1170 FIND v(dout0_13) AT=1180.05n

.meas tran vdout0_14ck1170 FIND v(dout0_14) AT=1180.05n

.meas tran vdout0_15ck1170 FIND v(dout0_15) AT=1180.05n

.meas tran vdout0_16ck1170 FIND v(dout0_16) AT=1180.05n

.meas tran vdout0_17ck1170 FIND v(dout0_17) AT=1180.05n

.meas tran vdout0_18ck1170 FIND v(dout0_18) AT=1180.05n

.meas tran vdout0_19ck1170 FIND v(dout0_19) AT=1180.05n

.meas tran vdout0_20ck1170 FIND v(dout0_20) AT=1180.05n

.meas tran vdout0_21ck1170 FIND v(dout0_21) AT=1180.05n

.meas tran vdout0_22ck1170 FIND v(dout0_22) AT=1180.05n

.meas tran vdout0_23ck1170 FIND v(dout0_23) AT=1180.05n

.meas tran vdout0_24ck1170 FIND v(dout0_24) AT=1180.05n

.meas tran vdout0_25ck1170 FIND v(dout0_25) AT=1180.05n

.meas tran vdout0_26ck1170 FIND v(dout0_26) AT=1180.05n

.meas tran vdout0_27ck1170 FIND v(dout0_27) AT=1180.05n

.meas tran vdout0_28ck1170 FIND v(dout0_28) AT=1180.05n

.meas tran vdout0_29ck1170 FIND v(dout0_29) AT=1180.05n

.meas tran vdout0_30ck1170 FIND v(dout0_30) AT=1180.05n

.meas tran vdout0_31ck1170 FIND v(dout0_31) AT=1180.05n

.meas tran vdout1_0ck1170 FIND v(dout1_0) AT=1180.05n

.meas tran vdout1_1ck1170 FIND v(dout1_1) AT=1180.05n

.meas tran vdout1_2ck1170 FIND v(dout1_2) AT=1180.05n

.meas tran vdout1_3ck1170 FIND v(dout1_3) AT=1180.05n

.meas tran vdout1_4ck1170 FIND v(dout1_4) AT=1180.05n

.meas tran vdout1_5ck1170 FIND v(dout1_5) AT=1180.05n

.meas tran vdout1_6ck1170 FIND v(dout1_6) AT=1180.05n

.meas tran vdout1_7ck1170 FIND v(dout1_7) AT=1180.05n

.meas tran vdout1_8ck1170 FIND v(dout1_8) AT=1180.05n

.meas tran vdout1_9ck1170 FIND v(dout1_9) AT=1180.05n

.meas tran vdout1_10ck1170 FIND v(dout1_10) AT=1180.05n

.meas tran vdout1_11ck1170 FIND v(dout1_11) AT=1180.05n

.meas tran vdout1_12ck1170 FIND v(dout1_12) AT=1180.05n

.meas tran vdout1_13ck1170 FIND v(dout1_13) AT=1180.05n

.meas tran vdout1_14ck1170 FIND v(dout1_14) AT=1180.05n

.meas tran vdout1_15ck1170 FIND v(dout1_15) AT=1180.05n

.meas tran vdout1_16ck1170 FIND v(dout1_16) AT=1180.05n

.meas tran vdout1_17ck1170 FIND v(dout1_17) AT=1180.05n

.meas tran vdout1_18ck1170 FIND v(dout1_18) AT=1180.05n

.meas tran vdout1_19ck1170 FIND v(dout1_19) AT=1180.05n

.meas tran vdout1_20ck1170 FIND v(dout1_20) AT=1180.05n

.meas tran vdout1_21ck1170 FIND v(dout1_21) AT=1180.05n

.meas tran vdout1_22ck1170 FIND v(dout1_22) AT=1180.05n

.meas tran vdout1_23ck1170 FIND v(dout1_23) AT=1180.05n

.meas tran vdout1_24ck1170 FIND v(dout1_24) AT=1180.05n

.meas tran vdout1_25ck1170 FIND v(dout1_25) AT=1180.05n

.meas tran vdout1_26ck1170 FIND v(dout1_26) AT=1180.05n

.meas tran vdout1_27ck1170 FIND v(dout1_27) AT=1180.05n

.meas tran vdout1_28ck1170 FIND v(dout1_28) AT=1180.05n

.meas tran vdout1_29ck1170 FIND v(dout1_29) AT=1180.05n

.meas tran vdout1_30ck1170 FIND v(dout1_30) AT=1180.05n

.meas tran vdout1_31ck1170 FIND v(dout1_31) AT=1180.05n

.meas tran vdout0_0ck1180 FIND v(dout0_0) AT=1190.05n

.meas tran vdout0_1ck1180 FIND v(dout0_1) AT=1190.05n

.meas tran vdout0_2ck1180 FIND v(dout0_2) AT=1190.05n

.meas tran vdout0_3ck1180 FIND v(dout0_3) AT=1190.05n

.meas tran vdout0_4ck1180 FIND v(dout0_4) AT=1190.05n

.meas tran vdout0_5ck1180 FIND v(dout0_5) AT=1190.05n

.meas tran vdout0_6ck1180 FIND v(dout0_6) AT=1190.05n

.meas tran vdout0_7ck1180 FIND v(dout0_7) AT=1190.05n

.meas tran vdout0_8ck1180 FIND v(dout0_8) AT=1190.05n

.meas tran vdout0_9ck1180 FIND v(dout0_9) AT=1190.05n

.meas tran vdout0_10ck1180 FIND v(dout0_10) AT=1190.05n

.meas tran vdout0_11ck1180 FIND v(dout0_11) AT=1190.05n

.meas tran vdout0_12ck1180 FIND v(dout0_12) AT=1190.05n

.meas tran vdout0_13ck1180 FIND v(dout0_13) AT=1190.05n

.meas tran vdout0_14ck1180 FIND v(dout0_14) AT=1190.05n

.meas tran vdout0_15ck1180 FIND v(dout0_15) AT=1190.05n

.meas tran vdout0_16ck1180 FIND v(dout0_16) AT=1190.05n

.meas tran vdout0_17ck1180 FIND v(dout0_17) AT=1190.05n

.meas tran vdout0_18ck1180 FIND v(dout0_18) AT=1190.05n

.meas tran vdout0_19ck1180 FIND v(dout0_19) AT=1190.05n

.meas tran vdout0_20ck1180 FIND v(dout0_20) AT=1190.05n

.meas tran vdout0_21ck1180 FIND v(dout0_21) AT=1190.05n

.meas tran vdout0_22ck1180 FIND v(dout0_22) AT=1190.05n

.meas tran vdout0_23ck1180 FIND v(dout0_23) AT=1190.05n

.meas tran vdout0_24ck1180 FIND v(dout0_24) AT=1190.05n

.meas tran vdout0_25ck1180 FIND v(dout0_25) AT=1190.05n

.meas tran vdout0_26ck1180 FIND v(dout0_26) AT=1190.05n

.meas tran vdout0_27ck1180 FIND v(dout0_27) AT=1190.05n

.meas tran vdout0_28ck1180 FIND v(dout0_28) AT=1190.05n

.meas tran vdout0_29ck1180 FIND v(dout0_29) AT=1190.05n

.meas tran vdout0_30ck1180 FIND v(dout0_30) AT=1190.05n

.meas tran vdout0_31ck1180 FIND v(dout0_31) AT=1190.05n

.meas tran vdout1_0ck1180 FIND v(dout1_0) AT=1190.05n

.meas tran vdout1_1ck1180 FIND v(dout1_1) AT=1190.05n

.meas tran vdout1_2ck1180 FIND v(dout1_2) AT=1190.05n

.meas tran vdout1_3ck1180 FIND v(dout1_3) AT=1190.05n

.meas tran vdout1_4ck1180 FIND v(dout1_4) AT=1190.05n

.meas tran vdout1_5ck1180 FIND v(dout1_5) AT=1190.05n

.meas tran vdout1_6ck1180 FIND v(dout1_6) AT=1190.05n

.meas tran vdout1_7ck1180 FIND v(dout1_7) AT=1190.05n

.meas tran vdout1_8ck1180 FIND v(dout1_8) AT=1190.05n

.meas tran vdout1_9ck1180 FIND v(dout1_9) AT=1190.05n

.meas tran vdout1_10ck1180 FIND v(dout1_10) AT=1190.05n

.meas tran vdout1_11ck1180 FIND v(dout1_11) AT=1190.05n

.meas tran vdout1_12ck1180 FIND v(dout1_12) AT=1190.05n

.meas tran vdout1_13ck1180 FIND v(dout1_13) AT=1190.05n

.meas tran vdout1_14ck1180 FIND v(dout1_14) AT=1190.05n

.meas tran vdout1_15ck1180 FIND v(dout1_15) AT=1190.05n

.meas tran vdout1_16ck1180 FIND v(dout1_16) AT=1190.05n

.meas tran vdout1_17ck1180 FIND v(dout1_17) AT=1190.05n

.meas tran vdout1_18ck1180 FIND v(dout1_18) AT=1190.05n

.meas tran vdout1_19ck1180 FIND v(dout1_19) AT=1190.05n

.meas tran vdout1_20ck1180 FIND v(dout1_20) AT=1190.05n

.meas tran vdout1_21ck1180 FIND v(dout1_21) AT=1190.05n

.meas tran vdout1_22ck1180 FIND v(dout1_22) AT=1190.05n

.meas tran vdout1_23ck1180 FIND v(dout1_23) AT=1190.05n

.meas tran vdout1_24ck1180 FIND v(dout1_24) AT=1190.05n

.meas tran vdout1_25ck1180 FIND v(dout1_25) AT=1190.05n

.meas tran vdout1_26ck1180 FIND v(dout1_26) AT=1190.05n

.meas tran vdout1_27ck1180 FIND v(dout1_27) AT=1190.05n

.meas tran vdout1_28ck1180 FIND v(dout1_28) AT=1190.05n

.meas tran vdout1_29ck1180 FIND v(dout1_29) AT=1190.05n

.meas tran vdout1_30ck1180 FIND v(dout1_30) AT=1190.05n

.meas tran vdout1_31ck1180 FIND v(dout1_31) AT=1190.05n

.meas tran vdout0_0ck1190 FIND v(dout0_0) AT=1200.05n

.meas tran vdout0_1ck1190 FIND v(dout0_1) AT=1200.05n

.meas tran vdout0_2ck1190 FIND v(dout0_2) AT=1200.05n

.meas tran vdout0_3ck1190 FIND v(dout0_3) AT=1200.05n

.meas tran vdout0_4ck1190 FIND v(dout0_4) AT=1200.05n

.meas tran vdout0_5ck1190 FIND v(dout0_5) AT=1200.05n

.meas tran vdout0_6ck1190 FIND v(dout0_6) AT=1200.05n

.meas tran vdout0_7ck1190 FIND v(dout0_7) AT=1200.05n

.meas tran vdout0_8ck1190 FIND v(dout0_8) AT=1200.05n

.meas tran vdout0_9ck1190 FIND v(dout0_9) AT=1200.05n

.meas tran vdout0_10ck1190 FIND v(dout0_10) AT=1200.05n

.meas tran vdout0_11ck1190 FIND v(dout0_11) AT=1200.05n

.meas tran vdout0_12ck1190 FIND v(dout0_12) AT=1200.05n

.meas tran vdout0_13ck1190 FIND v(dout0_13) AT=1200.05n

.meas tran vdout0_14ck1190 FIND v(dout0_14) AT=1200.05n

.meas tran vdout0_15ck1190 FIND v(dout0_15) AT=1200.05n

.meas tran vdout0_16ck1190 FIND v(dout0_16) AT=1200.05n

.meas tran vdout0_17ck1190 FIND v(dout0_17) AT=1200.05n

.meas tran vdout0_18ck1190 FIND v(dout0_18) AT=1200.05n

.meas tran vdout0_19ck1190 FIND v(dout0_19) AT=1200.05n

.meas tran vdout0_20ck1190 FIND v(dout0_20) AT=1200.05n

.meas tran vdout0_21ck1190 FIND v(dout0_21) AT=1200.05n

.meas tran vdout0_22ck1190 FIND v(dout0_22) AT=1200.05n

.meas tran vdout0_23ck1190 FIND v(dout0_23) AT=1200.05n

.meas tran vdout0_24ck1190 FIND v(dout0_24) AT=1200.05n

.meas tran vdout0_25ck1190 FIND v(dout0_25) AT=1200.05n

.meas tran vdout0_26ck1190 FIND v(dout0_26) AT=1200.05n

.meas tran vdout0_27ck1190 FIND v(dout0_27) AT=1200.05n

.meas tran vdout0_28ck1190 FIND v(dout0_28) AT=1200.05n

.meas tran vdout0_29ck1190 FIND v(dout0_29) AT=1200.05n

.meas tran vdout0_30ck1190 FIND v(dout0_30) AT=1200.05n

.meas tran vdout0_31ck1190 FIND v(dout0_31) AT=1200.05n

.meas tran vdout1_0ck1190 FIND v(dout1_0) AT=1200.05n

.meas tran vdout1_1ck1190 FIND v(dout1_1) AT=1200.05n

.meas tran vdout1_2ck1190 FIND v(dout1_2) AT=1200.05n

.meas tran vdout1_3ck1190 FIND v(dout1_3) AT=1200.05n

.meas tran vdout1_4ck1190 FIND v(dout1_4) AT=1200.05n

.meas tran vdout1_5ck1190 FIND v(dout1_5) AT=1200.05n

.meas tran vdout1_6ck1190 FIND v(dout1_6) AT=1200.05n

.meas tran vdout1_7ck1190 FIND v(dout1_7) AT=1200.05n

.meas tran vdout1_8ck1190 FIND v(dout1_8) AT=1200.05n

.meas tran vdout1_9ck1190 FIND v(dout1_9) AT=1200.05n

.meas tran vdout1_10ck1190 FIND v(dout1_10) AT=1200.05n

.meas tran vdout1_11ck1190 FIND v(dout1_11) AT=1200.05n

.meas tran vdout1_12ck1190 FIND v(dout1_12) AT=1200.05n

.meas tran vdout1_13ck1190 FIND v(dout1_13) AT=1200.05n

.meas tran vdout1_14ck1190 FIND v(dout1_14) AT=1200.05n

.meas tran vdout1_15ck1190 FIND v(dout1_15) AT=1200.05n

.meas tran vdout1_16ck1190 FIND v(dout1_16) AT=1200.05n

.meas tran vdout1_17ck1190 FIND v(dout1_17) AT=1200.05n

.meas tran vdout1_18ck1190 FIND v(dout1_18) AT=1200.05n

.meas tran vdout1_19ck1190 FIND v(dout1_19) AT=1200.05n

.meas tran vdout1_20ck1190 FIND v(dout1_20) AT=1200.05n

.meas tran vdout1_21ck1190 FIND v(dout1_21) AT=1200.05n

.meas tran vdout1_22ck1190 FIND v(dout1_22) AT=1200.05n

.meas tran vdout1_23ck1190 FIND v(dout1_23) AT=1200.05n

.meas tran vdout1_24ck1190 FIND v(dout1_24) AT=1200.05n

.meas tran vdout1_25ck1190 FIND v(dout1_25) AT=1200.05n

.meas tran vdout1_26ck1190 FIND v(dout1_26) AT=1200.05n

.meas tran vdout1_27ck1190 FIND v(dout1_27) AT=1200.05n

.meas tran vdout1_28ck1190 FIND v(dout1_28) AT=1200.05n

.meas tran vdout1_29ck1190 FIND v(dout1_29) AT=1200.05n

.meas tran vdout1_30ck1190 FIND v(dout1_30) AT=1200.05n

.meas tran vdout1_31ck1190 FIND v(dout1_31) AT=1200.05n

.meas tran vdout0_0ck1200 FIND v(dout0_0) AT=1210.05n

.meas tran vdout0_1ck1200 FIND v(dout0_1) AT=1210.05n

.meas tran vdout0_2ck1200 FIND v(dout0_2) AT=1210.05n

.meas tran vdout0_3ck1200 FIND v(dout0_3) AT=1210.05n

.meas tran vdout0_4ck1200 FIND v(dout0_4) AT=1210.05n

.meas tran vdout0_5ck1200 FIND v(dout0_5) AT=1210.05n

.meas tran vdout0_6ck1200 FIND v(dout0_6) AT=1210.05n

.meas tran vdout0_7ck1200 FIND v(dout0_7) AT=1210.05n

.meas tran vdout0_8ck1200 FIND v(dout0_8) AT=1210.05n

.meas tran vdout0_9ck1200 FIND v(dout0_9) AT=1210.05n

.meas tran vdout0_10ck1200 FIND v(dout0_10) AT=1210.05n

.meas tran vdout0_11ck1200 FIND v(dout0_11) AT=1210.05n

.meas tran vdout0_12ck1200 FIND v(dout0_12) AT=1210.05n

.meas tran vdout0_13ck1200 FIND v(dout0_13) AT=1210.05n

.meas tran vdout0_14ck1200 FIND v(dout0_14) AT=1210.05n

.meas tran vdout0_15ck1200 FIND v(dout0_15) AT=1210.05n

.meas tran vdout0_16ck1200 FIND v(dout0_16) AT=1210.05n

.meas tran vdout0_17ck1200 FIND v(dout0_17) AT=1210.05n

.meas tran vdout0_18ck1200 FIND v(dout0_18) AT=1210.05n

.meas tran vdout0_19ck1200 FIND v(dout0_19) AT=1210.05n

.meas tran vdout0_20ck1200 FIND v(dout0_20) AT=1210.05n

.meas tran vdout0_21ck1200 FIND v(dout0_21) AT=1210.05n

.meas tran vdout0_22ck1200 FIND v(dout0_22) AT=1210.05n

.meas tran vdout0_23ck1200 FIND v(dout0_23) AT=1210.05n

.meas tran vdout0_24ck1200 FIND v(dout0_24) AT=1210.05n

.meas tran vdout0_25ck1200 FIND v(dout0_25) AT=1210.05n

.meas tran vdout0_26ck1200 FIND v(dout0_26) AT=1210.05n

.meas tran vdout0_27ck1200 FIND v(dout0_27) AT=1210.05n

.meas tran vdout0_28ck1200 FIND v(dout0_28) AT=1210.05n

.meas tran vdout0_29ck1200 FIND v(dout0_29) AT=1210.05n

.meas tran vdout0_30ck1200 FIND v(dout0_30) AT=1210.05n

.meas tran vdout0_31ck1200 FIND v(dout0_31) AT=1210.05n

.meas tran vdout1_0ck1200 FIND v(dout1_0) AT=1210.05n

.meas tran vdout1_1ck1200 FIND v(dout1_1) AT=1210.05n

.meas tran vdout1_2ck1200 FIND v(dout1_2) AT=1210.05n

.meas tran vdout1_3ck1200 FIND v(dout1_3) AT=1210.05n

.meas tran vdout1_4ck1200 FIND v(dout1_4) AT=1210.05n

.meas tran vdout1_5ck1200 FIND v(dout1_5) AT=1210.05n

.meas tran vdout1_6ck1200 FIND v(dout1_6) AT=1210.05n

.meas tran vdout1_7ck1200 FIND v(dout1_7) AT=1210.05n

.meas tran vdout1_8ck1200 FIND v(dout1_8) AT=1210.05n

.meas tran vdout1_9ck1200 FIND v(dout1_9) AT=1210.05n

.meas tran vdout1_10ck1200 FIND v(dout1_10) AT=1210.05n

.meas tran vdout1_11ck1200 FIND v(dout1_11) AT=1210.05n

.meas tran vdout1_12ck1200 FIND v(dout1_12) AT=1210.05n

.meas tran vdout1_13ck1200 FIND v(dout1_13) AT=1210.05n

.meas tran vdout1_14ck1200 FIND v(dout1_14) AT=1210.05n

.meas tran vdout1_15ck1200 FIND v(dout1_15) AT=1210.05n

.meas tran vdout1_16ck1200 FIND v(dout1_16) AT=1210.05n

.meas tran vdout1_17ck1200 FIND v(dout1_17) AT=1210.05n

.meas tran vdout1_18ck1200 FIND v(dout1_18) AT=1210.05n

.meas tran vdout1_19ck1200 FIND v(dout1_19) AT=1210.05n

.meas tran vdout1_20ck1200 FIND v(dout1_20) AT=1210.05n

.meas tran vdout1_21ck1200 FIND v(dout1_21) AT=1210.05n

.meas tran vdout1_22ck1200 FIND v(dout1_22) AT=1210.05n

.meas tran vdout1_23ck1200 FIND v(dout1_23) AT=1210.05n

.meas tran vdout1_24ck1200 FIND v(dout1_24) AT=1210.05n

.meas tran vdout1_25ck1200 FIND v(dout1_25) AT=1210.05n

.meas tran vdout1_26ck1200 FIND v(dout1_26) AT=1210.05n

.meas tran vdout1_27ck1200 FIND v(dout1_27) AT=1210.05n

.meas tran vdout1_28ck1200 FIND v(dout1_28) AT=1210.05n

.meas tran vdout1_29ck1200 FIND v(dout1_29) AT=1210.05n

.meas tran vdout1_30ck1200 FIND v(dout1_30) AT=1210.05n

.meas tran vdout1_31ck1200 FIND v(dout1_31) AT=1210.05n

.meas tran vdout0_0ck1210 FIND v(dout0_0) AT=1220.05n

.meas tran vdout0_1ck1210 FIND v(dout0_1) AT=1220.05n

.meas tran vdout0_2ck1210 FIND v(dout0_2) AT=1220.05n

.meas tran vdout0_3ck1210 FIND v(dout0_3) AT=1220.05n

.meas tran vdout0_4ck1210 FIND v(dout0_4) AT=1220.05n

.meas tran vdout0_5ck1210 FIND v(dout0_5) AT=1220.05n

.meas tran vdout0_6ck1210 FIND v(dout0_6) AT=1220.05n

.meas tran vdout0_7ck1210 FIND v(dout0_7) AT=1220.05n

.meas tran vdout0_8ck1210 FIND v(dout0_8) AT=1220.05n

.meas tran vdout0_9ck1210 FIND v(dout0_9) AT=1220.05n

.meas tran vdout0_10ck1210 FIND v(dout0_10) AT=1220.05n

.meas tran vdout0_11ck1210 FIND v(dout0_11) AT=1220.05n

.meas tran vdout0_12ck1210 FIND v(dout0_12) AT=1220.05n

.meas tran vdout0_13ck1210 FIND v(dout0_13) AT=1220.05n

.meas tran vdout0_14ck1210 FIND v(dout0_14) AT=1220.05n

.meas tran vdout0_15ck1210 FIND v(dout0_15) AT=1220.05n

.meas tran vdout0_16ck1210 FIND v(dout0_16) AT=1220.05n

.meas tran vdout0_17ck1210 FIND v(dout0_17) AT=1220.05n

.meas tran vdout0_18ck1210 FIND v(dout0_18) AT=1220.05n

.meas tran vdout0_19ck1210 FIND v(dout0_19) AT=1220.05n

.meas tran vdout0_20ck1210 FIND v(dout0_20) AT=1220.05n

.meas tran vdout0_21ck1210 FIND v(dout0_21) AT=1220.05n

.meas tran vdout0_22ck1210 FIND v(dout0_22) AT=1220.05n

.meas tran vdout0_23ck1210 FIND v(dout0_23) AT=1220.05n

.meas tran vdout0_24ck1210 FIND v(dout0_24) AT=1220.05n

.meas tran vdout0_25ck1210 FIND v(dout0_25) AT=1220.05n

.meas tran vdout0_26ck1210 FIND v(dout0_26) AT=1220.05n

.meas tran vdout0_27ck1210 FIND v(dout0_27) AT=1220.05n

.meas tran vdout0_28ck1210 FIND v(dout0_28) AT=1220.05n

.meas tran vdout0_29ck1210 FIND v(dout0_29) AT=1220.05n

.meas tran vdout0_30ck1210 FIND v(dout0_30) AT=1220.05n

.meas tran vdout0_31ck1210 FIND v(dout0_31) AT=1220.05n

.meas tran vdout1_0ck1220 FIND v(dout1_0) AT=1230.05n

.meas tran vdout1_1ck1220 FIND v(dout1_1) AT=1230.05n

.meas tran vdout1_2ck1220 FIND v(dout1_2) AT=1230.05n

.meas tran vdout1_3ck1220 FIND v(dout1_3) AT=1230.05n

.meas tran vdout1_4ck1220 FIND v(dout1_4) AT=1230.05n

.meas tran vdout1_5ck1220 FIND v(dout1_5) AT=1230.05n

.meas tran vdout1_6ck1220 FIND v(dout1_6) AT=1230.05n

.meas tran vdout1_7ck1220 FIND v(dout1_7) AT=1230.05n

.meas tran vdout1_8ck1220 FIND v(dout1_8) AT=1230.05n

.meas tran vdout1_9ck1220 FIND v(dout1_9) AT=1230.05n

.meas tran vdout1_10ck1220 FIND v(dout1_10) AT=1230.05n

.meas tran vdout1_11ck1220 FIND v(dout1_11) AT=1230.05n

.meas tran vdout1_12ck1220 FIND v(dout1_12) AT=1230.05n

.meas tran vdout1_13ck1220 FIND v(dout1_13) AT=1230.05n

.meas tran vdout1_14ck1220 FIND v(dout1_14) AT=1230.05n

.meas tran vdout1_15ck1220 FIND v(dout1_15) AT=1230.05n

.meas tran vdout1_16ck1220 FIND v(dout1_16) AT=1230.05n

.meas tran vdout1_17ck1220 FIND v(dout1_17) AT=1230.05n

.meas tran vdout1_18ck1220 FIND v(dout1_18) AT=1230.05n

.meas tran vdout1_19ck1220 FIND v(dout1_19) AT=1230.05n

.meas tran vdout1_20ck1220 FIND v(dout1_20) AT=1230.05n

.meas tran vdout1_21ck1220 FIND v(dout1_21) AT=1230.05n

.meas tran vdout1_22ck1220 FIND v(dout1_22) AT=1230.05n

.meas tran vdout1_23ck1220 FIND v(dout1_23) AT=1230.05n

.meas tran vdout1_24ck1220 FIND v(dout1_24) AT=1230.05n

.meas tran vdout1_25ck1220 FIND v(dout1_25) AT=1230.05n

.meas tran vdout1_26ck1220 FIND v(dout1_26) AT=1230.05n

.meas tran vdout1_27ck1220 FIND v(dout1_27) AT=1230.05n

.meas tran vdout1_28ck1220 FIND v(dout1_28) AT=1230.05n

.meas tran vdout1_29ck1220 FIND v(dout1_29) AT=1230.05n

.meas tran vdout1_30ck1220 FIND v(dout1_30) AT=1230.05n

.meas tran vdout1_31ck1220 FIND v(dout1_31) AT=1230.05n

.meas tran vdout0_0ck1230 FIND v(dout0_0) AT=1240.05n

.meas tran vdout0_1ck1230 FIND v(dout0_1) AT=1240.05n

.meas tran vdout0_2ck1230 FIND v(dout0_2) AT=1240.05n

.meas tran vdout0_3ck1230 FIND v(dout0_3) AT=1240.05n

.meas tran vdout0_4ck1230 FIND v(dout0_4) AT=1240.05n

.meas tran vdout0_5ck1230 FIND v(dout0_5) AT=1240.05n

.meas tran vdout0_6ck1230 FIND v(dout0_6) AT=1240.05n

.meas tran vdout0_7ck1230 FIND v(dout0_7) AT=1240.05n

.meas tran vdout0_8ck1230 FIND v(dout0_8) AT=1240.05n

.meas tran vdout0_9ck1230 FIND v(dout0_9) AT=1240.05n

.meas tran vdout0_10ck1230 FIND v(dout0_10) AT=1240.05n

.meas tran vdout0_11ck1230 FIND v(dout0_11) AT=1240.05n

.meas tran vdout0_12ck1230 FIND v(dout0_12) AT=1240.05n

.meas tran vdout0_13ck1230 FIND v(dout0_13) AT=1240.05n

.meas tran vdout0_14ck1230 FIND v(dout0_14) AT=1240.05n

.meas tran vdout0_15ck1230 FIND v(dout0_15) AT=1240.05n

.meas tran vdout0_16ck1230 FIND v(dout0_16) AT=1240.05n

.meas tran vdout0_17ck1230 FIND v(dout0_17) AT=1240.05n

.meas tran vdout0_18ck1230 FIND v(dout0_18) AT=1240.05n

.meas tran vdout0_19ck1230 FIND v(dout0_19) AT=1240.05n

.meas tran vdout0_20ck1230 FIND v(dout0_20) AT=1240.05n

.meas tran vdout0_21ck1230 FIND v(dout0_21) AT=1240.05n

.meas tran vdout0_22ck1230 FIND v(dout0_22) AT=1240.05n

.meas tran vdout0_23ck1230 FIND v(dout0_23) AT=1240.05n

.meas tran vdout0_24ck1230 FIND v(dout0_24) AT=1240.05n

.meas tran vdout0_25ck1230 FIND v(dout0_25) AT=1240.05n

.meas tran vdout0_26ck1230 FIND v(dout0_26) AT=1240.05n

.meas tran vdout0_27ck1230 FIND v(dout0_27) AT=1240.05n

.meas tran vdout0_28ck1230 FIND v(dout0_28) AT=1240.05n

.meas tran vdout0_29ck1230 FIND v(dout0_29) AT=1240.05n

.meas tran vdout0_30ck1230 FIND v(dout0_30) AT=1240.05n

.meas tran vdout0_31ck1230 FIND v(dout0_31) AT=1240.05n

.meas tran vdout1_0ck1230 FIND v(dout1_0) AT=1240.05n

.meas tran vdout1_1ck1230 FIND v(dout1_1) AT=1240.05n

.meas tran vdout1_2ck1230 FIND v(dout1_2) AT=1240.05n

.meas tran vdout1_3ck1230 FIND v(dout1_3) AT=1240.05n

.meas tran vdout1_4ck1230 FIND v(dout1_4) AT=1240.05n

.meas tran vdout1_5ck1230 FIND v(dout1_5) AT=1240.05n

.meas tran vdout1_6ck1230 FIND v(dout1_6) AT=1240.05n

.meas tran vdout1_7ck1230 FIND v(dout1_7) AT=1240.05n

.meas tran vdout1_8ck1230 FIND v(dout1_8) AT=1240.05n

.meas tran vdout1_9ck1230 FIND v(dout1_9) AT=1240.05n

.meas tran vdout1_10ck1230 FIND v(dout1_10) AT=1240.05n

.meas tran vdout1_11ck1230 FIND v(dout1_11) AT=1240.05n

.meas tran vdout1_12ck1230 FIND v(dout1_12) AT=1240.05n

.meas tran vdout1_13ck1230 FIND v(dout1_13) AT=1240.05n

.meas tran vdout1_14ck1230 FIND v(dout1_14) AT=1240.05n

.meas tran vdout1_15ck1230 FIND v(dout1_15) AT=1240.05n

.meas tran vdout1_16ck1230 FIND v(dout1_16) AT=1240.05n

.meas tran vdout1_17ck1230 FIND v(dout1_17) AT=1240.05n

.meas tran vdout1_18ck1230 FIND v(dout1_18) AT=1240.05n

.meas tran vdout1_19ck1230 FIND v(dout1_19) AT=1240.05n

.meas tran vdout1_20ck1230 FIND v(dout1_20) AT=1240.05n

.meas tran vdout1_21ck1230 FIND v(dout1_21) AT=1240.05n

.meas tran vdout1_22ck1230 FIND v(dout1_22) AT=1240.05n

.meas tran vdout1_23ck1230 FIND v(dout1_23) AT=1240.05n

.meas tran vdout1_24ck1230 FIND v(dout1_24) AT=1240.05n

.meas tran vdout1_25ck1230 FIND v(dout1_25) AT=1240.05n

.meas tran vdout1_26ck1230 FIND v(dout1_26) AT=1240.05n

.meas tran vdout1_27ck1230 FIND v(dout1_27) AT=1240.05n

.meas tran vdout1_28ck1230 FIND v(dout1_28) AT=1240.05n

.meas tran vdout1_29ck1230 FIND v(dout1_29) AT=1240.05n

.meas tran vdout1_30ck1230 FIND v(dout1_30) AT=1240.05n

.meas tran vdout1_31ck1230 FIND v(dout1_31) AT=1240.05n

.meas tran vdout0_0ck1240 FIND v(dout0_0) AT=1250.05n

.meas tran vdout0_1ck1240 FIND v(dout0_1) AT=1250.05n

.meas tran vdout0_2ck1240 FIND v(dout0_2) AT=1250.05n

.meas tran vdout0_3ck1240 FIND v(dout0_3) AT=1250.05n

.meas tran vdout0_4ck1240 FIND v(dout0_4) AT=1250.05n

.meas tran vdout0_5ck1240 FIND v(dout0_5) AT=1250.05n

.meas tran vdout0_6ck1240 FIND v(dout0_6) AT=1250.05n

.meas tran vdout0_7ck1240 FIND v(dout0_7) AT=1250.05n

.meas tran vdout0_8ck1240 FIND v(dout0_8) AT=1250.05n

.meas tran vdout0_9ck1240 FIND v(dout0_9) AT=1250.05n

.meas tran vdout0_10ck1240 FIND v(dout0_10) AT=1250.05n

.meas tran vdout0_11ck1240 FIND v(dout0_11) AT=1250.05n

.meas tran vdout0_12ck1240 FIND v(dout0_12) AT=1250.05n

.meas tran vdout0_13ck1240 FIND v(dout0_13) AT=1250.05n

.meas tran vdout0_14ck1240 FIND v(dout0_14) AT=1250.05n

.meas tran vdout0_15ck1240 FIND v(dout0_15) AT=1250.05n

.meas tran vdout0_16ck1240 FIND v(dout0_16) AT=1250.05n

.meas tran vdout0_17ck1240 FIND v(dout0_17) AT=1250.05n

.meas tran vdout0_18ck1240 FIND v(dout0_18) AT=1250.05n

.meas tran vdout0_19ck1240 FIND v(dout0_19) AT=1250.05n

.meas tran vdout0_20ck1240 FIND v(dout0_20) AT=1250.05n

.meas tran vdout0_21ck1240 FIND v(dout0_21) AT=1250.05n

.meas tran vdout0_22ck1240 FIND v(dout0_22) AT=1250.05n

.meas tran vdout0_23ck1240 FIND v(dout0_23) AT=1250.05n

.meas tran vdout0_24ck1240 FIND v(dout0_24) AT=1250.05n

.meas tran vdout0_25ck1240 FIND v(dout0_25) AT=1250.05n

.meas tran vdout0_26ck1240 FIND v(dout0_26) AT=1250.05n

.meas tran vdout0_27ck1240 FIND v(dout0_27) AT=1250.05n

.meas tran vdout0_28ck1240 FIND v(dout0_28) AT=1250.05n

.meas tran vdout0_29ck1240 FIND v(dout0_29) AT=1250.05n

.meas tran vdout0_30ck1240 FIND v(dout0_30) AT=1250.05n

.meas tran vdout0_31ck1240 FIND v(dout0_31) AT=1250.05n

.meas tran vdout1_0ck1240 FIND v(dout1_0) AT=1250.05n

.meas tran vdout1_1ck1240 FIND v(dout1_1) AT=1250.05n

.meas tran vdout1_2ck1240 FIND v(dout1_2) AT=1250.05n

.meas tran vdout1_3ck1240 FIND v(dout1_3) AT=1250.05n

.meas tran vdout1_4ck1240 FIND v(dout1_4) AT=1250.05n

.meas tran vdout1_5ck1240 FIND v(dout1_5) AT=1250.05n

.meas tran vdout1_6ck1240 FIND v(dout1_6) AT=1250.05n

.meas tran vdout1_7ck1240 FIND v(dout1_7) AT=1250.05n

.meas tran vdout1_8ck1240 FIND v(dout1_8) AT=1250.05n

.meas tran vdout1_9ck1240 FIND v(dout1_9) AT=1250.05n

.meas tran vdout1_10ck1240 FIND v(dout1_10) AT=1250.05n

.meas tran vdout1_11ck1240 FIND v(dout1_11) AT=1250.05n

.meas tran vdout1_12ck1240 FIND v(dout1_12) AT=1250.05n

.meas tran vdout1_13ck1240 FIND v(dout1_13) AT=1250.05n

.meas tran vdout1_14ck1240 FIND v(dout1_14) AT=1250.05n

.meas tran vdout1_15ck1240 FIND v(dout1_15) AT=1250.05n

.meas tran vdout1_16ck1240 FIND v(dout1_16) AT=1250.05n

.meas tran vdout1_17ck1240 FIND v(dout1_17) AT=1250.05n

.meas tran vdout1_18ck1240 FIND v(dout1_18) AT=1250.05n

.meas tran vdout1_19ck1240 FIND v(dout1_19) AT=1250.05n

.meas tran vdout1_20ck1240 FIND v(dout1_20) AT=1250.05n

.meas tran vdout1_21ck1240 FIND v(dout1_21) AT=1250.05n

.meas tran vdout1_22ck1240 FIND v(dout1_22) AT=1250.05n

.meas tran vdout1_23ck1240 FIND v(dout1_23) AT=1250.05n

.meas tran vdout1_24ck1240 FIND v(dout1_24) AT=1250.05n

.meas tran vdout1_25ck1240 FIND v(dout1_25) AT=1250.05n

.meas tran vdout1_26ck1240 FIND v(dout1_26) AT=1250.05n

.meas tran vdout1_27ck1240 FIND v(dout1_27) AT=1250.05n

.meas tran vdout1_28ck1240 FIND v(dout1_28) AT=1250.05n

.meas tran vdout1_29ck1240 FIND v(dout1_29) AT=1250.05n

.meas tran vdout1_30ck1240 FIND v(dout1_30) AT=1250.05n

.meas tran vdout1_31ck1240 FIND v(dout1_31) AT=1250.05n

.meas tran vdout1_0ck1250 FIND v(dout1_0) AT=1260.05n

.meas tran vdout1_1ck1250 FIND v(dout1_1) AT=1260.05n

.meas tran vdout1_2ck1250 FIND v(dout1_2) AT=1260.05n

.meas tran vdout1_3ck1250 FIND v(dout1_3) AT=1260.05n

.meas tran vdout1_4ck1250 FIND v(dout1_4) AT=1260.05n

.meas tran vdout1_5ck1250 FIND v(dout1_5) AT=1260.05n

.meas tran vdout1_6ck1250 FIND v(dout1_6) AT=1260.05n

.meas tran vdout1_7ck1250 FIND v(dout1_7) AT=1260.05n

.meas tran vdout1_8ck1250 FIND v(dout1_8) AT=1260.05n

.meas tran vdout1_9ck1250 FIND v(dout1_9) AT=1260.05n

.meas tran vdout1_10ck1250 FIND v(dout1_10) AT=1260.05n

.meas tran vdout1_11ck1250 FIND v(dout1_11) AT=1260.05n

.meas tran vdout1_12ck1250 FIND v(dout1_12) AT=1260.05n

.meas tran vdout1_13ck1250 FIND v(dout1_13) AT=1260.05n

.meas tran vdout1_14ck1250 FIND v(dout1_14) AT=1260.05n

.meas tran vdout1_15ck1250 FIND v(dout1_15) AT=1260.05n

.meas tran vdout1_16ck1250 FIND v(dout1_16) AT=1260.05n

.meas tran vdout1_17ck1250 FIND v(dout1_17) AT=1260.05n

.meas tran vdout1_18ck1250 FIND v(dout1_18) AT=1260.05n

.meas tran vdout1_19ck1250 FIND v(dout1_19) AT=1260.05n

.meas tran vdout1_20ck1250 FIND v(dout1_20) AT=1260.05n

.meas tran vdout1_21ck1250 FIND v(dout1_21) AT=1260.05n

.meas tran vdout1_22ck1250 FIND v(dout1_22) AT=1260.05n

.meas tran vdout1_23ck1250 FIND v(dout1_23) AT=1260.05n

.meas tran vdout1_24ck1250 FIND v(dout1_24) AT=1260.05n

.meas tran vdout1_25ck1250 FIND v(dout1_25) AT=1260.05n

.meas tran vdout1_26ck1250 FIND v(dout1_26) AT=1260.05n

.meas tran vdout1_27ck1250 FIND v(dout1_27) AT=1260.05n

.meas tran vdout1_28ck1250 FIND v(dout1_28) AT=1260.05n

.meas tran vdout1_29ck1250 FIND v(dout1_29) AT=1260.05n

.meas tran vdout1_30ck1250 FIND v(dout1_30) AT=1260.05n

.meas tran vdout1_31ck1250 FIND v(dout1_31) AT=1260.05n

.meas tran vdout0_0ck1270 FIND v(dout0_0) AT=1280.05n

.meas tran vdout0_1ck1270 FIND v(dout0_1) AT=1280.05n

.meas tran vdout0_2ck1270 FIND v(dout0_2) AT=1280.05n

.meas tran vdout0_3ck1270 FIND v(dout0_3) AT=1280.05n

.meas tran vdout0_4ck1270 FIND v(dout0_4) AT=1280.05n

.meas tran vdout0_5ck1270 FIND v(dout0_5) AT=1280.05n

.meas tran vdout0_6ck1270 FIND v(dout0_6) AT=1280.05n

.meas tran vdout0_7ck1270 FIND v(dout0_7) AT=1280.05n

.meas tran vdout0_8ck1270 FIND v(dout0_8) AT=1280.05n

.meas tran vdout0_9ck1270 FIND v(dout0_9) AT=1280.05n

.meas tran vdout0_10ck1270 FIND v(dout0_10) AT=1280.05n

.meas tran vdout0_11ck1270 FIND v(dout0_11) AT=1280.05n

.meas tran vdout0_12ck1270 FIND v(dout0_12) AT=1280.05n

.meas tran vdout0_13ck1270 FIND v(dout0_13) AT=1280.05n

.meas tran vdout0_14ck1270 FIND v(dout0_14) AT=1280.05n

.meas tran vdout0_15ck1270 FIND v(dout0_15) AT=1280.05n

.meas tran vdout0_16ck1270 FIND v(dout0_16) AT=1280.05n

.meas tran vdout0_17ck1270 FIND v(dout0_17) AT=1280.05n

.meas tran vdout0_18ck1270 FIND v(dout0_18) AT=1280.05n

.meas tran vdout0_19ck1270 FIND v(dout0_19) AT=1280.05n

.meas tran vdout0_20ck1270 FIND v(dout0_20) AT=1280.05n

.meas tran vdout0_21ck1270 FIND v(dout0_21) AT=1280.05n

.meas tran vdout0_22ck1270 FIND v(dout0_22) AT=1280.05n

.meas tran vdout0_23ck1270 FIND v(dout0_23) AT=1280.05n

.meas tran vdout0_24ck1270 FIND v(dout0_24) AT=1280.05n

.meas tran vdout0_25ck1270 FIND v(dout0_25) AT=1280.05n

.meas tran vdout0_26ck1270 FIND v(dout0_26) AT=1280.05n

.meas tran vdout0_27ck1270 FIND v(dout0_27) AT=1280.05n

.meas tran vdout0_28ck1270 FIND v(dout0_28) AT=1280.05n

.meas tran vdout0_29ck1270 FIND v(dout0_29) AT=1280.05n

.meas tran vdout0_30ck1270 FIND v(dout0_30) AT=1280.05n

.meas tran vdout0_31ck1270 FIND v(dout0_31) AT=1280.05n

.meas tran vdout0_0ck1290 FIND v(dout0_0) AT=1300.05n

.meas tran vdout0_1ck1290 FIND v(dout0_1) AT=1300.05n

.meas tran vdout0_2ck1290 FIND v(dout0_2) AT=1300.05n

.meas tran vdout0_3ck1290 FIND v(dout0_3) AT=1300.05n

.meas tran vdout0_4ck1290 FIND v(dout0_4) AT=1300.05n

.meas tran vdout0_5ck1290 FIND v(dout0_5) AT=1300.05n

.meas tran vdout0_6ck1290 FIND v(dout0_6) AT=1300.05n

.meas tran vdout0_7ck1290 FIND v(dout0_7) AT=1300.05n

.meas tran vdout0_8ck1290 FIND v(dout0_8) AT=1300.05n

.meas tran vdout0_9ck1290 FIND v(dout0_9) AT=1300.05n

.meas tran vdout0_10ck1290 FIND v(dout0_10) AT=1300.05n

.meas tran vdout0_11ck1290 FIND v(dout0_11) AT=1300.05n

.meas tran vdout0_12ck1290 FIND v(dout0_12) AT=1300.05n

.meas tran vdout0_13ck1290 FIND v(dout0_13) AT=1300.05n

.meas tran vdout0_14ck1290 FIND v(dout0_14) AT=1300.05n

.meas tran vdout0_15ck1290 FIND v(dout0_15) AT=1300.05n

.meas tran vdout0_16ck1290 FIND v(dout0_16) AT=1300.05n

.meas tran vdout0_17ck1290 FIND v(dout0_17) AT=1300.05n

.meas tran vdout0_18ck1290 FIND v(dout0_18) AT=1300.05n

.meas tran vdout0_19ck1290 FIND v(dout0_19) AT=1300.05n

.meas tran vdout0_20ck1290 FIND v(dout0_20) AT=1300.05n

.meas tran vdout0_21ck1290 FIND v(dout0_21) AT=1300.05n

.meas tran vdout0_22ck1290 FIND v(dout0_22) AT=1300.05n

.meas tran vdout0_23ck1290 FIND v(dout0_23) AT=1300.05n

.meas tran vdout0_24ck1290 FIND v(dout0_24) AT=1300.05n

.meas tran vdout0_25ck1290 FIND v(dout0_25) AT=1300.05n

.meas tran vdout0_26ck1290 FIND v(dout0_26) AT=1300.05n

.meas tran vdout0_27ck1290 FIND v(dout0_27) AT=1300.05n

.meas tran vdout0_28ck1290 FIND v(dout0_28) AT=1300.05n

.meas tran vdout0_29ck1290 FIND v(dout0_29) AT=1300.05n

.meas tran vdout0_30ck1290 FIND v(dout0_30) AT=1300.05n

.meas tran vdout0_31ck1290 FIND v(dout0_31) AT=1300.05n

.meas tran vdout1_0ck1290 FIND v(dout1_0) AT=1300.05n

.meas tran vdout1_1ck1290 FIND v(dout1_1) AT=1300.05n

.meas tran vdout1_2ck1290 FIND v(dout1_2) AT=1300.05n

.meas tran vdout1_3ck1290 FIND v(dout1_3) AT=1300.05n

.meas tran vdout1_4ck1290 FIND v(dout1_4) AT=1300.05n

.meas tran vdout1_5ck1290 FIND v(dout1_5) AT=1300.05n

.meas tran vdout1_6ck1290 FIND v(dout1_6) AT=1300.05n

.meas tran vdout1_7ck1290 FIND v(dout1_7) AT=1300.05n

.meas tran vdout1_8ck1290 FIND v(dout1_8) AT=1300.05n

.meas tran vdout1_9ck1290 FIND v(dout1_9) AT=1300.05n

.meas tran vdout1_10ck1290 FIND v(dout1_10) AT=1300.05n

.meas tran vdout1_11ck1290 FIND v(dout1_11) AT=1300.05n

.meas tran vdout1_12ck1290 FIND v(dout1_12) AT=1300.05n

.meas tran vdout1_13ck1290 FIND v(dout1_13) AT=1300.05n

.meas tran vdout1_14ck1290 FIND v(dout1_14) AT=1300.05n

.meas tran vdout1_15ck1290 FIND v(dout1_15) AT=1300.05n

.meas tran vdout1_16ck1290 FIND v(dout1_16) AT=1300.05n

.meas tran vdout1_17ck1290 FIND v(dout1_17) AT=1300.05n

.meas tran vdout1_18ck1290 FIND v(dout1_18) AT=1300.05n

.meas tran vdout1_19ck1290 FIND v(dout1_19) AT=1300.05n

.meas tran vdout1_20ck1290 FIND v(dout1_20) AT=1300.05n

.meas tran vdout1_21ck1290 FIND v(dout1_21) AT=1300.05n

.meas tran vdout1_22ck1290 FIND v(dout1_22) AT=1300.05n

.meas tran vdout1_23ck1290 FIND v(dout1_23) AT=1300.05n

.meas tran vdout1_24ck1290 FIND v(dout1_24) AT=1300.05n

.meas tran vdout1_25ck1290 FIND v(dout1_25) AT=1300.05n

.meas tran vdout1_26ck1290 FIND v(dout1_26) AT=1300.05n

.meas tran vdout1_27ck1290 FIND v(dout1_27) AT=1300.05n

.meas tran vdout1_28ck1290 FIND v(dout1_28) AT=1300.05n

.meas tran vdout1_29ck1290 FIND v(dout1_29) AT=1300.05n

.meas tran vdout1_30ck1290 FIND v(dout1_30) AT=1300.05n

.meas tran vdout1_31ck1290 FIND v(dout1_31) AT=1300.05n

.meas tran vdout0_0ck1310 FIND v(dout0_0) AT=1320.05n

.meas tran vdout0_1ck1310 FIND v(dout0_1) AT=1320.05n

.meas tran vdout0_2ck1310 FIND v(dout0_2) AT=1320.05n

.meas tran vdout0_3ck1310 FIND v(dout0_3) AT=1320.05n

.meas tran vdout0_4ck1310 FIND v(dout0_4) AT=1320.05n

.meas tran vdout0_5ck1310 FIND v(dout0_5) AT=1320.05n

.meas tran vdout0_6ck1310 FIND v(dout0_6) AT=1320.05n

.meas tran vdout0_7ck1310 FIND v(dout0_7) AT=1320.05n

.meas tran vdout0_8ck1310 FIND v(dout0_8) AT=1320.05n

.meas tran vdout0_9ck1310 FIND v(dout0_9) AT=1320.05n

.meas tran vdout0_10ck1310 FIND v(dout0_10) AT=1320.05n

.meas tran vdout0_11ck1310 FIND v(dout0_11) AT=1320.05n

.meas tran vdout0_12ck1310 FIND v(dout0_12) AT=1320.05n

.meas tran vdout0_13ck1310 FIND v(dout0_13) AT=1320.05n

.meas tran vdout0_14ck1310 FIND v(dout0_14) AT=1320.05n

.meas tran vdout0_15ck1310 FIND v(dout0_15) AT=1320.05n

.meas tran vdout0_16ck1310 FIND v(dout0_16) AT=1320.05n

.meas tran vdout0_17ck1310 FIND v(dout0_17) AT=1320.05n

.meas tran vdout0_18ck1310 FIND v(dout0_18) AT=1320.05n

.meas tran vdout0_19ck1310 FIND v(dout0_19) AT=1320.05n

.meas tran vdout0_20ck1310 FIND v(dout0_20) AT=1320.05n

.meas tran vdout0_21ck1310 FIND v(dout0_21) AT=1320.05n

.meas tran vdout0_22ck1310 FIND v(dout0_22) AT=1320.05n

.meas tran vdout0_23ck1310 FIND v(dout0_23) AT=1320.05n

.meas tran vdout0_24ck1310 FIND v(dout0_24) AT=1320.05n

.meas tran vdout0_25ck1310 FIND v(dout0_25) AT=1320.05n

.meas tran vdout0_26ck1310 FIND v(dout0_26) AT=1320.05n

.meas tran vdout0_27ck1310 FIND v(dout0_27) AT=1320.05n

.meas tran vdout0_28ck1310 FIND v(dout0_28) AT=1320.05n

.meas tran vdout0_29ck1310 FIND v(dout0_29) AT=1320.05n

.meas tran vdout0_30ck1310 FIND v(dout0_30) AT=1320.05n

.meas tran vdout0_31ck1310 FIND v(dout0_31) AT=1320.05n

.meas tran vdout0_0ck1320 FIND v(dout0_0) AT=1330.05n

.meas tran vdout0_1ck1320 FIND v(dout0_1) AT=1330.05n

.meas tran vdout0_2ck1320 FIND v(dout0_2) AT=1330.05n

.meas tran vdout0_3ck1320 FIND v(dout0_3) AT=1330.05n

.meas tran vdout0_4ck1320 FIND v(dout0_4) AT=1330.05n

.meas tran vdout0_5ck1320 FIND v(dout0_5) AT=1330.05n

.meas tran vdout0_6ck1320 FIND v(dout0_6) AT=1330.05n

.meas tran vdout0_7ck1320 FIND v(dout0_7) AT=1330.05n

.meas tran vdout0_8ck1320 FIND v(dout0_8) AT=1330.05n

.meas tran vdout0_9ck1320 FIND v(dout0_9) AT=1330.05n

.meas tran vdout0_10ck1320 FIND v(dout0_10) AT=1330.05n

.meas tran vdout0_11ck1320 FIND v(dout0_11) AT=1330.05n

.meas tran vdout0_12ck1320 FIND v(dout0_12) AT=1330.05n

.meas tran vdout0_13ck1320 FIND v(dout0_13) AT=1330.05n

.meas tran vdout0_14ck1320 FIND v(dout0_14) AT=1330.05n

.meas tran vdout0_15ck1320 FIND v(dout0_15) AT=1330.05n

.meas tran vdout0_16ck1320 FIND v(dout0_16) AT=1330.05n

.meas tran vdout0_17ck1320 FIND v(dout0_17) AT=1330.05n

.meas tran vdout0_18ck1320 FIND v(dout0_18) AT=1330.05n

.meas tran vdout0_19ck1320 FIND v(dout0_19) AT=1330.05n

.meas tran vdout0_20ck1320 FIND v(dout0_20) AT=1330.05n

.meas tran vdout0_21ck1320 FIND v(dout0_21) AT=1330.05n

.meas tran vdout0_22ck1320 FIND v(dout0_22) AT=1330.05n

.meas tran vdout0_23ck1320 FIND v(dout0_23) AT=1330.05n

.meas tran vdout0_24ck1320 FIND v(dout0_24) AT=1330.05n

.meas tran vdout0_25ck1320 FIND v(dout0_25) AT=1330.05n

.meas tran vdout0_26ck1320 FIND v(dout0_26) AT=1330.05n

.meas tran vdout0_27ck1320 FIND v(dout0_27) AT=1330.05n

.meas tran vdout0_28ck1320 FIND v(dout0_28) AT=1330.05n

.meas tran vdout0_29ck1320 FIND v(dout0_29) AT=1330.05n

.meas tran vdout0_30ck1320 FIND v(dout0_30) AT=1330.05n

.meas tran vdout0_31ck1320 FIND v(dout0_31) AT=1330.05n

.meas tran vdout1_0ck1340 FIND v(dout1_0) AT=1350.05n

.meas tran vdout1_1ck1340 FIND v(dout1_1) AT=1350.05n

.meas tran vdout1_2ck1340 FIND v(dout1_2) AT=1350.05n

.meas tran vdout1_3ck1340 FIND v(dout1_3) AT=1350.05n

.meas tran vdout1_4ck1340 FIND v(dout1_4) AT=1350.05n

.meas tran vdout1_5ck1340 FIND v(dout1_5) AT=1350.05n

.meas tran vdout1_6ck1340 FIND v(dout1_6) AT=1350.05n

.meas tran vdout1_7ck1340 FIND v(dout1_7) AT=1350.05n

.meas tran vdout1_8ck1340 FIND v(dout1_8) AT=1350.05n

.meas tran vdout1_9ck1340 FIND v(dout1_9) AT=1350.05n

.meas tran vdout1_10ck1340 FIND v(dout1_10) AT=1350.05n

.meas tran vdout1_11ck1340 FIND v(dout1_11) AT=1350.05n

.meas tran vdout1_12ck1340 FIND v(dout1_12) AT=1350.05n

.meas tran vdout1_13ck1340 FIND v(dout1_13) AT=1350.05n

.meas tran vdout1_14ck1340 FIND v(dout1_14) AT=1350.05n

.meas tran vdout1_15ck1340 FIND v(dout1_15) AT=1350.05n

.meas tran vdout1_16ck1340 FIND v(dout1_16) AT=1350.05n

.meas tran vdout1_17ck1340 FIND v(dout1_17) AT=1350.05n

.meas tran vdout1_18ck1340 FIND v(dout1_18) AT=1350.05n

.meas tran vdout1_19ck1340 FIND v(dout1_19) AT=1350.05n

.meas tran vdout1_20ck1340 FIND v(dout1_20) AT=1350.05n

.meas tran vdout1_21ck1340 FIND v(dout1_21) AT=1350.05n

.meas tran vdout1_22ck1340 FIND v(dout1_22) AT=1350.05n

.meas tran vdout1_23ck1340 FIND v(dout1_23) AT=1350.05n

.meas tran vdout1_24ck1340 FIND v(dout1_24) AT=1350.05n

.meas tran vdout1_25ck1340 FIND v(dout1_25) AT=1350.05n

.meas tran vdout1_26ck1340 FIND v(dout1_26) AT=1350.05n

.meas tran vdout1_27ck1340 FIND v(dout1_27) AT=1350.05n

.meas tran vdout1_28ck1340 FIND v(dout1_28) AT=1350.05n

.meas tran vdout1_29ck1340 FIND v(dout1_29) AT=1350.05n

.meas tran vdout1_30ck1340 FIND v(dout1_30) AT=1350.05n

.meas tran vdout1_31ck1340 FIND v(dout1_31) AT=1350.05n

.meas tran vdout0_0ck1350 FIND v(dout0_0) AT=1360.05n

.meas tran vdout0_1ck1350 FIND v(dout0_1) AT=1360.05n

.meas tran vdout0_2ck1350 FIND v(dout0_2) AT=1360.05n

.meas tran vdout0_3ck1350 FIND v(dout0_3) AT=1360.05n

.meas tran vdout0_4ck1350 FIND v(dout0_4) AT=1360.05n

.meas tran vdout0_5ck1350 FIND v(dout0_5) AT=1360.05n

.meas tran vdout0_6ck1350 FIND v(dout0_6) AT=1360.05n

.meas tran vdout0_7ck1350 FIND v(dout0_7) AT=1360.05n

.meas tran vdout0_8ck1350 FIND v(dout0_8) AT=1360.05n

.meas tran vdout0_9ck1350 FIND v(dout0_9) AT=1360.05n

.meas tran vdout0_10ck1350 FIND v(dout0_10) AT=1360.05n

.meas tran vdout0_11ck1350 FIND v(dout0_11) AT=1360.05n

.meas tran vdout0_12ck1350 FIND v(dout0_12) AT=1360.05n

.meas tran vdout0_13ck1350 FIND v(dout0_13) AT=1360.05n

.meas tran vdout0_14ck1350 FIND v(dout0_14) AT=1360.05n

.meas tran vdout0_15ck1350 FIND v(dout0_15) AT=1360.05n

.meas tran vdout0_16ck1350 FIND v(dout0_16) AT=1360.05n

.meas tran vdout0_17ck1350 FIND v(dout0_17) AT=1360.05n

.meas tran vdout0_18ck1350 FIND v(dout0_18) AT=1360.05n

.meas tran vdout0_19ck1350 FIND v(dout0_19) AT=1360.05n

.meas tran vdout0_20ck1350 FIND v(dout0_20) AT=1360.05n

.meas tran vdout0_21ck1350 FIND v(dout0_21) AT=1360.05n

.meas tran vdout0_22ck1350 FIND v(dout0_22) AT=1360.05n

.meas tran vdout0_23ck1350 FIND v(dout0_23) AT=1360.05n

.meas tran vdout0_24ck1350 FIND v(dout0_24) AT=1360.05n

.meas tran vdout0_25ck1350 FIND v(dout0_25) AT=1360.05n

.meas tran vdout0_26ck1350 FIND v(dout0_26) AT=1360.05n

.meas tran vdout0_27ck1350 FIND v(dout0_27) AT=1360.05n

.meas tran vdout0_28ck1350 FIND v(dout0_28) AT=1360.05n

.meas tran vdout0_29ck1350 FIND v(dout0_29) AT=1360.05n

.meas tran vdout0_30ck1350 FIND v(dout0_30) AT=1360.05n

.meas tran vdout0_31ck1350 FIND v(dout0_31) AT=1360.05n

.meas tran vdout1_0ck1350 FIND v(dout1_0) AT=1360.05n

.meas tran vdout1_1ck1350 FIND v(dout1_1) AT=1360.05n

.meas tran vdout1_2ck1350 FIND v(dout1_2) AT=1360.05n

.meas tran vdout1_3ck1350 FIND v(dout1_3) AT=1360.05n

.meas tran vdout1_4ck1350 FIND v(dout1_4) AT=1360.05n

.meas tran vdout1_5ck1350 FIND v(dout1_5) AT=1360.05n

.meas tran vdout1_6ck1350 FIND v(dout1_6) AT=1360.05n

.meas tran vdout1_7ck1350 FIND v(dout1_7) AT=1360.05n

.meas tran vdout1_8ck1350 FIND v(dout1_8) AT=1360.05n

.meas tran vdout1_9ck1350 FIND v(dout1_9) AT=1360.05n

.meas tran vdout1_10ck1350 FIND v(dout1_10) AT=1360.05n

.meas tran vdout1_11ck1350 FIND v(dout1_11) AT=1360.05n

.meas tran vdout1_12ck1350 FIND v(dout1_12) AT=1360.05n

.meas tran vdout1_13ck1350 FIND v(dout1_13) AT=1360.05n

.meas tran vdout1_14ck1350 FIND v(dout1_14) AT=1360.05n

.meas tran vdout1_15ck1350 FIND v(dout1_15) AT=1360.05n

.meas tran vdout1_16ck1350 FIND v(dout1_16) AT=1360.05n

.meas tran vdout1_17ck1350 FIND v(dout1_17) AT=1360.05n

.meas tran vdout1_18ck1350 FIND v(dout1_18) AT=1360.05n

.meas tran vdout1_19ck1350 FIND v(dout1_19) AT=1360.05n

.meas tran vdout1_20ck1350 FIND v(dout1_20) AT=1360.05n

.meas tran vdout1_21ck1350 FIND v(dout1_21) AT=1360.05n

.meas tran vdout1_22ck1350 FIND v(dout1_22) AT=1360.05n

.meas tran vdout1_23ck1350 FIND v(dout1_23) AT=1360.05n

.meas tran vdout1_24ck1350 FIND v(dout1_24) AT=1360.05n

.meas tran vdout1_25ck1350 FIND v(dout1_25) AT=1360.05n

.meas tran vdout1_26ck1350 FIND v(dout1_26) AT=1360.05n

.meas tran vdout1_27ck1350 FIND v(dout1_27) AT=1360.05n

.meas tran vdout1_28ck1350 FIND v(dout1_28) AT=1360.05n

.meas tran vdout1_29ck1350 FIND v(dout1_29) AT=1360.05n

.meas tran vdout1_30ck1350 FIND v(dout1_30) AT=1360.05n

.meas tran vdout1_31ck1350 FIND v(dout1_31) AT=1360.05n

.meas tran vdout0_0ck1360 FIND v(dout0_0) AT=1370.05n

.meas tran vdout0_1ck1360 FIND v(dout0_1) AT=1370.05n

.meas tran vdout0_2ck1360 FIND v(dout0_2) AT=1370.05n

.meas tran vdout0_3ck1360 FIND v(dout0_3) AT=1370.05n

.meas tran vdout0_4ck1360 FIND v(dout0_4) AT=1370.05n

.meas tran vdout0_5ck1360 FIND v(dout0_5) AT=1370.05n

.meas tran vdout0_6ck1360 FIND v(dout0_6) AT=1370.05n

.meas tran vdout0_7ck1360 FIND v(dout0_7) AT=1370.05n

.meas tran vdout0_8ck1360 FIND v(dout0_8) AT=1370.05n

.meas tran vdout0_9ck1360 FIND v(dout0_9) AT=1370.05n

.meas tran vdout0_10ck1360 FIND v(dout0_10) AT=1370.05n

.meas tran vdout0_11ck1360 FIND v(dout0_11) AT=1370.05n

.meas tran vdout0_12ck1360 FIND v(dout0_12) AT=1370.05n

.meas tran vdout0_13ck1360 FIND v(dout0_13) AT=1370.05n

.meas tran vdout0_14ck1360 FIND v(dout0_14) AT=1370.05n

.meas tran vdout0_15ck1360 FIND v(dout0_15) AT=1370.05n

.meas tran vdout0_16ck1360 FIND v(dout0_16) AT=1370.05n

.meas tran vdout0_17ck1360 FIND v(dout0_17) AT=1370.05n

.meas tran vdout0_18ck1360 FIND v(dout0_18) AT=1370.05n

.meas tran vdout0_19ck1360 FIND v(dout0_19) AT=1370.05n

.meas tran vdout0_20ck1360 FIND v(dout0_20) AT=1370.05n

.meas tran vdout0_21ck1360 FIND v(dout0_21) AT=1370.05n

.meas tran vdout0_22ck1360 FIND v(dout0_22) AT=1370.05n

.meas tran vdout0_23ck1360 FIND v(dout0_23) AT=1370.05n

.meas tran vdout0_24ck1360 FIND v(dout0_24) AT=1370.05n

.meas tran vdout0_25ck1360 FIND v(dout0_25) AT=1370.05n

.meas tran vdout0_26ck1360 FIND v(dout0_26) AT=1370.05n

.meas tran vdout0_27ck1360 FIND v(dout0_27) AT=1370.05n

.meas tran vdout0_28ck1360 FIND v(dout0_28) AT=1370.05n

.meas tran vdout0_29ck1360 FIND v(dout0_29) AT=1370.05n

.meas tran vdout0_30ck1360 FIND v(dout0_30) AT=1370.05n

.meas tran vdout0_31ck1360 FIND v(dout0_31) AT=1370.05n

.meas tran vdout0_0ck1380 FIND v(dout0_0) AT=1390.05n

.meas tran vdout0_1ck1380 FIND v(dout0_1) AT=1390.05n

.meas tran vdout0_2ck1380 FIND v(dout0_2) AT=1390.05n

.meas tran vdout0_3ck1380 FIND v(dout0_3) AT=1390.05n

.meas tran vdout0_4ck1380 FIND v(dout0_4) AT=1390.05n

.meas tran vdout0_5ck1380 FIND v(dout0_5) AT=1390.05n

.meas tran vdout0_6ck1380 FIND v(dout0_6) AT=1390.05n

.meas tran vdout0_7ck1380 FIND v(dout0_7) AT=1390.05n

.meas tran vdout0_8ck1380 FIND v(dout0_8) AT=1390.05n

.meas tran vdout0_9ck1380 FIND v(dout0_9) AT=1390.05n

.meas tran vdout0_10ck1380 FIND v(dout0_10) AT=1390.05n

.meas tran vdout0_11ck1380 FIND v(dout0_11) AT=1390.05n

.meas tran vdout0_12ck1380 FIND v(dout0_12) AT=1390.05n

.meas tran vdout0_13ck1380 FIND v(dout0_13) AT=1390.05n

.meas tran vdout0_14ck1380 FIND v(dout0_14) AT=1390.05n

.meas tran vdout0_15ck1380 FIND v(dout0_15) AT=1390.05n

.meas tran vdout0_16ck1380 FIND v(dout0_16) AT=1390.05n

.meas tran vdout0_17ck1380 FIND v(dout0_17) AT=1390.05n

.meas tran vdout0_18ck1380 FIND v(dout0_18) AT=1390.05n

.meas tran vdout0_19ck1380 FIND v(dout0_19) AT=1390.05n

.meas tran vdout0_20ck1380 FIND v(dout0_20) AT=1390.05n

.meas tran vdout0_21ck1380 FIND v(dout0_21) AT=1390.05n

.meas tran vdout0_22ck1380 FIND v(dout0_22) AT=1390.05n

.meas tran vdout0_23ck1380 FIND v(dout0_23) AT=1390.05n

.meas tran vdout0_24ck1380 FIND v(dout0_24) AT=1390.05n

.meas tran vdout0_25ck1380 FIND v(dout0_25) AT=1390.05n

.meas tran vdout0_26ck1380 FIND v(dout0_26) AT=1390.05n

.meas tran vdout0_27ck1380 FIND v(dout0_27) AT=1390.05n

.meas tran vdout0_28ck1380 FIND v(dout0_28) AT=1390.05n

.meas tran vdout0_29ck1380 FIND v(dout0_29) AT=1390.05n

.meas tran vdout0_30ck1380 FIND v(dout0_30) AT=1390.05n

.meas tran vdout0_31ck1380 FIND v(dout0_31) AT=1390.05n

.meas tran vdout1_0ck1390 FIND v(dout1_0) AT=1400.05n

.meas tran vdout1_1ck1390 FIND v(dout1_1) AT=1400.05n

.meas tran vdout1_2ck1390 FIND v(dout1_2) AT=1400.05n

.meas tran vdout1_3ck1390 FIND v(dout1_3) AT=1400.05n

.meas tran vdout1_4ck1390 FIND v(dout1_4) AT=1400.05n

.meas tran vdout1_5ck1390 FIND v(dout1_5) AT=1400.05n

.meas tran vdout1_6ck1390 FIND v(dout1_6) AT=1400.05n

.meas tran vdout1_7ck1390 FIND v(dout1_7) AT=1400.05n

.meas tran vdout1_8ck1390 FIND v(dout1_8) AT=1400.05n

.meas tran vdout1_9ck1390 FIND v(dout1_9) AT=1400.05n

.meas tran vdout1_10ck1390 FIND v(dout1_10) AT=1400.05n

.meas tran vdout1_11ck1390 FIND v(dout1_11) AT=1400.05n

.meas tran vdout1_12ck1390 FIND v(dout1_12) AT=1400.05n

.meas tran vdout1_13ck1390 FIND v(dout1_13) AT=1400.05n

.meas tran vdout1_14ck1390 FIND v(dout1_14) AT=1400.05n

.meas tran vdout1_15ck1390 FIND v(dout1_15) AT=1400.05n

.meas tran vdout1_16ck1390 FIND v(dout1_16) AT=1400.05n

.meas tran vdout1_17ck1390 FIND v(dout1_17) AT=1400.05n

.meas tran vdout1_18ck1390 FIND v(dout1_18) AT=1400.05n

.meas tran vdout1_19ck1390 FIND v(dout1_19) AT=1400.05n

.meas tran vdout1_20ck1390 FIND v(dout1_20) AT=1400.05n

.meas tran vdout1_21ck1390 FIND v(dout1_21) AT=1400.05n

.meas tran vdout1_22ck1390 FIND v(dout1_22) AT=1400.05n

.meas tran vdout1_23ck1390 FIND v(dout1_23) AT=1400.05n

.meas tran vdout1_24ck1390 FIND v(dout1_24) AT=1400.05n

.meas tran vdout1_25ck1390 FIND v(dout1_25) AT=1400.05n

.meas tran vdout1_26ck1390 FIND v(dout1_26) AT=1400.05n

.meas tran vdout1_27ck1390 FIND v(dout1_27) AT=1400.05n

.meas tran vdout1_28ck1390 FIND v(dout1_28) AT=1400.05n

.meas tran vdout1_29ck1390 FIND v(dout1_29) AT=1400.05n

.meas tran vdout1_30ck1390 FIND v(dout1_30) AT=1400.05n

.meas tran vdout1_31ck1390 FIND v(dout1_31) AT=1400.05n

.meas tran vdout1_0ck1400 FIND v(dout1_0) AT=1410.05n

.meas tran vdout1_1ck1400 FIND v(dout1_1) AT=1410.05n

.meas tran vdout1_2ck1400 FIND v(dout1_2) AT=1410.05n

.meas tran vdout1_3ck1400 FIND v(dout1_3) AT=1410.05n

.meas tran vdout1_4ck1400 FIND v(dout1_4) AT=1410.05n

.meas tran vdout1_5ck1400 FIND v(dout1_5) AT=1410.05n

.meas tran vdout1_6ck1400 FIND v(dout1_6) AT=1410.05n

.meas tran vdout1_7ck1400 FIND v(dout1_7) AT=1410.05n

.meas tran vdout1_8ck1400 FIND v(dout1_8) AT=1410.05n

.meas tran vdout1_9ck1400 FIND v(dout1_9) AT=1410.05n

.meas tran vdout1_10ck1400 FIND v(dout1_10) AT=1410.05n

.meas tran vdout1_11ck1400 FIND v(dout1_11) AT=1410.05n

.meas tran vdout1_12ck1400 FIND v(dout1_12) AT=1410.05n

.meas tran vdout1_13ck1400 FIND v(dout1_13) AT=1410.05n

.meas tran vdout1_14ck1400 FIND v(dout1_14) AT=1410.05n

.meas tran vdout1_15ck1400 FIND v(dout1_15) AT=1410.05n

.meas tran vdout1_16ck1400 FIND v(dout1_16) AT=1410.05n

.meas tran vdout1_17ck1400 FIND v(dout1_17) AT=1410.05n

.meas tran vdout1_18ck1400 FIND v(dout1_18) AT=1410.05n

.meas tran vdout1_19ck1400 FIND v(dout1_19) AT=1410.05n

.meas tran vdout1_20ck1400 FIND v(dout1_20) AT=1410.05n

.meas tran vdout1_21ck1400 FIND v(dout1_21) AT=1410.05n

.meas tran vdout1_22ck1400 FIND v(dout1_22) AT=1410.05n

.meas tran vdout1_23ck1400 FIND v(dout1_23) AT=1410.05n

.meas tran vdout1_24ck1400 FIND v(dout1_24) AT=1410.05n

.meas tran vdout1_25ck1400 FIND v(dout1_25) AT=1410.05n

.meas tran vdout1_26ck1400 FIND v(dout1_26) AT=1410.05n

.meas tran vdout1_27ck1400 FIND v(dout1_27) AT=1410.05n

.meas tran vdout1_28ck1400 FIND v(dout1_28) AT=1410.05n

.meas tran vdout1_29ck1400 FIND v(dout1_29) AT=1410.05n

.meas tran vdout1_30ck1400 FIND v(dout1_30) AT=1410.05n

.meas tran vdout1_31ck1400 FIND v(dout1_31) AT=1410.05n

.meas tran vdout1_0ck1430 FIND v(dout1_0) AT=1440.05n

.meas tran vdout1_1ck1430 FIND v(dout1_1) AT=1440.05n

.meas tran vdout1_2ck1430 FIND v(dout1_2) AT=1440.05n

.meas tran vdout1_3ck1430 FIND v(dout1_3) AT=1440.05n

.meas tran vdout1_4ck1430 FIND v(dout1_4) AT=1440.05n

.meas tran vdout1_5ck1430 FIND v(dout1_5) AT=1440.05n

.meas tran vdout1_6ck1430 FIND v(dout1_6) AT=1440.05n

.meas tran vdout1_7ck1430 FIND v(dout1_7) AT=1440.05n

.meas tran vdout1_8ck1430 FIND v(dout1_8) AT=1440.05n

.meas tran vdout1_9ck1430 FIND v(dout1_9) AT=1440.05n

.meas tran vdout1_10ck1430 FIND v(dout1_10) AT=1440.05n

.meas tran vdout1_11ck1430 FIND v(dout1_11) AT=1440.05n

.meas tran vdout1_12ck1430 FIND v(dout1_12) AT=1440.05n

.meas tran vdout1_13ck1430 FIND v(dout1_13) AT=1440.05n

.meas tran vdout1_14ck1430 FIND v(dout1_14) AT=1440.05n

.meas tran vdout1_15ck1430 FIND v(dout1_15) AT=1440.05n

.meas tran vdout1_16ck1430 FIND v(dout1_16) AT=1440.05n

.meas tran vdout1_17ck1430 FIND v(dout1_17) AT=1440.05n

.meas tran vdout1_18ck1430 FIND v(dout1_18) AT=1440.05n

.meas tran vdout1_19ck1430 FIND v(dout1_19) AT=1440.05n

.meas tran vdout1_20ck1430 FIND v(dout1_20) AT=1440.05n

.meas tran vdout1_21ck1430 FIND v(dout1_21) AT=1440.05n

.meas tran vdout1_22ck1430 FIND v(dout1_22) AT=1440.05n

.meas tran vdout1_23ck1430 FIND v(dout1_23) AT=1440.05n

.meas tran vdout1_24ck1430 FIND v(dout1_24) AT=1440.05n

.meas tran vdout1_25ck1430 FIND v(dout1_25) AT=1440.05n

.meas tran vdout1_26ck1430 FIND v(dout1_26) AT=1440.05n

.meas tran vdout1_27ck1430 FIND v(dout1_27) AT=1440.05n

.meas tran vdout1_28ck1430 FIND v(dout1_28) AT=1440.05n

.meas tran vdout1_29ck1430 FIND v(dout1_29) AT=1440.05n

.meas tran vdout1_30ck1430 FIND v(dout1_30) AT=1440.05n

.meas tran vdout1_31ck1430 FIND v(dout1_31) AT=1440.05n

.meas tran vdout0_0ck1440 FIND v(dout0_0) AT=1450.05n

.meas tran vdout0_1ck1440 FIND v(dout0_1) AT=1450.05n

.meas tran vdout0_2ck1440 FIND v(dout0_2) AT=1450.05n

.meas tran vdout0_3ck1440 FIND v(dout0_3) AT=1450.05n

.meas tran vdout0_4ck1440 FIND v(dout0_4) AT=1450.05n

.meas tran vdout0_5ck1440 FIND v(dout0_5) AT=1450.05n

.meas tran vdout0_6ck1440 FIND v(dout0_6) AT=1450.05n

.meas tran vdout0_7ck1440 FIND v(dout0_7) AT=1450.05n

.meas tran vdout0_8ck1440 FIND v(dout0_8) AT=1450.05n

.meas tran vdout0_9ck1440 FIND v(dout0_9) AT=1450.05n

.meas tran vdout0_10ck1440 FIND v(dout0_10) AT=1450.05n

.meas tran vdout0_11ck1440 FIND v(dout0_11) AT=1450.05n

.meas tran vdout0_12ck1440 FIND v(dout0_12) AT=1450.05n

.meas tran vdout0_13ck1440 FIND v(dout0_13) AT=1450.05n

.meas tran vdout0_14ck1440 FIND v(dout0_14) AT=1450.05n

.meas tran vdout0_15ck1440 FIND v(dout0_15) AT=1450.05n

.meas tran vdout0_16ck1440 FIND v(dout0_16) AT=1450.05n

.meas tran vdout0_17ck1440 FIND v(dout0_17) AT=1450.05n

.meas tran vdout0_18ck1440 FIND v(dout0_18) AT=1450.05n

.meas tran vdout0_19ck1440 FIND v(dout0_19) AT=1450.05n

.meas tran vdout0_20ck1440 FIND v(dout0_20) AT=1450.05n

.meas tran vdout0_21ck1440 FIND v(dout0_21) AT=1450.05n

.meas tran vdout0_22ck1440 FIND v(dout0_22) AT=1450.05n

.meas tran vdout0_23ck1440 FIND v(dout0_23) AT=1450.05n

.meas tran vdout0_24ck1440 FIND v(dout0_24) AT=1450.05n

.meas tran vdout0_25ck1440 FIND v(dout0_25) AT=1450.05n

.meas tran vdout0_26ck1440 FIND v(dout0_26) AT=1450.05n

.meas tran vdout0_27ck1440 FIND v(dout0_27) AT=1450.05n

.meas tran vdout0_28ck1440 FIND v(dout0_28) AT=1450.05n

.meas tran vdout0_29ck1440 FIND v(dout0_29) AT=1450.05n

.meas tran vdout0_30ck1440 FIND v(dout0_30) AT=1450.05n

.meas tran vdout0_31ck1440 FIND v(dout0_31) AT=1450.05n

.meas tran vdout1_0ck1440 FIND v(dout1_0) AT=1450.05n

.meas tran vdout1_1ck1440 FIND v(dout1_1) AT=1450.05n

.meas tran vdout1_2ck1440 FIND v(dout1_2) AT=1450.05n

.meas tran vdout1_3ck1440 FIND v(dout1_3) AT=1450.05n

.meas tran vdout1_4ck1440 FIND v(dout1_4) AT=1450.05n

.meas tran vdout1_5ck1440 FIND v(dout1_5) AT=1450.05n

.meas tran vdout1_6ck1440 FIND v(dout1_6) AT=1450.05n

.meas tran vdout1_7ck1440 FIND v(dout1_7) AT=1450.05n

.meas tran vdout1_8ck1440 FIND v(dout1_8) AT=1450.05n

.meas tran vdout1_9ck1440 FIND v(dout1_9) AT=1450.05n

.meas tran vdout1_10ck1440 FIND v(dout1_10) AT=1450.05n

.meas tran vdout1_11ck1440 FIND v(dout1_11) AT=1450.05n

.meas tran vdout1_12ck1440 FIND v(dout1_12) AT=1450.05n

.meas tran vdout1_13ck1440 FIND v(dout1_13) AT=1450.05n

.meas tran vdout1_14ck1440 FIND v(dout1_14) AT=1450.05n

.meas tran vdout1_15ck1440 FIND v(dout1_15) AT=1450.05n

.meas tran vdout1_16ck1440 FIND v(dout1_16) AT=1450.05n

.meas tran vdout1_17ck1440 FIND v(dout1_17) AT=1450.05n

.meas tran vdout1_18ck1440 FIND v(dout1_18) AT=1450.05n

.meas tran vdout1_19ck1440 FIND v(dout1_19) AT=1450.05n

.meas tran vdout1_20ck1440 FIND v(dout1_20) AT=1450.05n

.meas tran vdout1_21ck1440 FIND v(dout1_21) AT=1450.05n

.meas tran vdout1_22ck1440 FIND v(dout1_22) AT=1450.05n

.meas tran vdout1_23ck1440 FIND v(dout1_23) AT=1450.05n

.meas tran vdout1_24ck1440 FIND v(dout1_24) AT=1450.05n

.meas tran vdout1_25ck1440 FIND v(dout1_25) AT=1450.05n

.meas tran vdout1_26ck1440 FIND v(dout1_26) AT=1450.05n

.meas tran vdout1_27ck1440 FIND v(dout1_27) AT=1450.05n

.meas tran vdout1_28ck1440 FIND v(dout1_28) AT=1450.05n

.meas tran vdout1_29ck1440 FIND v(dout1_29) AT=1450.05n

.meas tran vdout1_30ck1440 FIND v(dout1_30) AT=1450.05n

.meas tran vdout1_31ck1440 FIND v(dout1_31) AT=1450.05n

.meas tran vdout0_0ck1450 FIND v(dout0_0) AT=1460.05n

.meas tran vdout0_1ck1450 FIND v(dout0_1) AT=1460.05n

.meas tran vdout0_2ck1450 FIND v(dout0_2) AT=1460.05n

.meas tran vdout0_3ck1450 FIND v(dout0_3) AT=1460.05n

.meas tran vdout0_4ck1450 FIND v(dout0_4) AT=1460.05n

.meas tran vdout0_5ck1450 FIND v(dout0_5) AT=1460.05n

.meas tran vdout0_6ck1450 FIND v(dout0_6) AT=1460.05n

.meas tran vdout0_7ck1450 FIND v(dout0_7) AT=1460.05n

.meas tran vdout0_8ck1450 FIND v(dout0_8) AT=1460.05n

.meas tran vdout0_9ck1450 FIND v(dout0_9) AT=1460.05n

.meas tran vdout0_10ck1450 FIND v(dout0_10) AT=1460.05n

.meas tran vdout0_11ck1450 FIND v(dout0_11) AT=1460.05n

.meas tran vdout0_12ck1450 FIND v(dout0_12) AT=1460.05n

.meas tran vdout0_13ck1450 FIND v(dout0_13) AT=1460.05n

.meas tran vdout0_14ck1450 FIND v(dout0_14) AT=1460.05n

.meas tran vdout0_15ck1450 FIND v(dout0_15) AT=1460.05n

.meas tran vdout0_16ck1450 FIND v(dout0_16) AT=1460.05n

.meas tran vdout0_17ck1450 FIND v(dout0_17) AT=1460.05n

.meas tran vdout0_18ck1450 FIND v(dout0_18) AT=1460.05n

.meas tran vdout0_19ck1450 FIND v(dout0_19) AT=1460.05n

.meas tran vdout0_20ck1450 FIND v(dout0_20) AT=1460.05n

.meas tran vdout0_21ck1450 FIND v(dout0_21) AT=1460.05n

.meas tran vdout0_22ck1450 FIND v(dout0_22) AT=1460.05n

.meas tran vdout0_23ck1450 FIND v(dout0_23) AT=1460.05n

.meas tran vdout0_24ck1450 FIND v(dout0_24) AT=1460.05n

.meas tran vdout0_25ck1450 FIND v(dout0_25) AT=1460.05n

.meas tran vdout0_26ck1450 FIND v(dout0_26) AT=1460.05n

.meas tran vdout0_27ck1450 FIND v(dout0_27) AT=1460.05n

.meas tran vdout0_28ck1450 FIND v(dout0_28) AT=1460.05n

.meas tran vdout0_29ck1450 FIND v(dout0_29) AT=1460.05n

.meas tran vdout0_30ck1450 FIND v(dout0_30) AT=1460.05n

.meas tran vdout0_31ck1450 FIND v(dout0_31) AT=1460.05n

.meas tran vdout1_0ck1450 FIND v(dout1_0) AT=1460.05n

.meas tran vdout1_1ck1450 FIND v(dout1_1) AT=1460.05n

.meas tran vdout1_2ck1450 FIND v(dout1_2) AT=1460.05n

.meas tran vdout1_3ck1450 FIND v(dout1_3) AT=1460.05n

.meas tran vdout1_4ck1450 FIND v(dout1_4) AT=1460.05n

.meas tran vdout1_5ck1450 FIND v(dout1_5) AT=1460.05n

.meas tran vdout1_6ck1450 FIND v(dout1_6) AT=1460.05n

.meas tran vdout1_7ck1450 FIND v(dout1_7) AT=1460.05n

.meas tran vdout1_8ck1450 FIND v(dout1_8) AT=1460.05n

.meas tran vdout1_9ck1450 FIND v(dout1_9) AT=1460.05n

.meas tran vdout1_10ck1450 FIND v(dout1_10) AT=1460.05n

.meas tran vdout1_11ck1450 FIND v(dout1_11) AT=1460.05n

.meas tran vdout1_12ck1450 FIND v(dout1_12) AT=1460.05n

.meas tran vdout1_13ck1450 FIND v(dout1_13) AT=1460.05n

.meas tran vdout1_14ck1450 FIND v(dout1_14) AT=1460.05n

.meas tran vdout1_15ck1450 FIND v(dout1_15) AT=1460.05n

.meas tran vdout1_16ck1450 FIND v(dout1_16) AT=1460.05n

.meas tran vdout1_17ck1450 FIND v(dout1_17) AT=1460.05n

.meas tran vdout1_18ck1450 FIND v(dout1_18) AT=1460.05n

.meas tran vdout1_19ck1450 FIND v(dout1_19) AT=1460.05n

.meas tran vdout1_20ck1450 FIND v(dout1_20) AT=1460.05n

.meas tran vdout1_21ck1450 FIND v(dout1_21) AT=1460.05n

.meas tran vdout1_22ck1450 FIND v(dout1_22) AT=1460.05n

.meas tran vdout1_23ck1450 FIND v(dout1_23) AT=1460.05n

.meas tran vdout1_24ck1450 FIND v(dout1_24) AT=1460.05n

.meas tran vdout1_25ck1450 FIND v(dout1_25) AT=1460.05n

.meas tran vdout1_26ck1450 FIND v(dout1_26) AT=1460.05n

.meas tran vdout1_27ck1450 FIND v(dout1_27) AT=1460.05n

.meas tran vdout1_28ck1450 FIND v(dout1_28) AT=1460.05n

.meas tran vdout1_29ck1450 FIND v(dout1_29) AT=1460.05n

.meas tran vdout1_30ck1450 FIND v(dout1_30) AT=1460.05n

.meas tran vdout1_31ck1450 FIND v(dout1_31) AT=1460.05n

.meas tran vdout0_0ck1460 FIND v(dout0_0) AT=1470.05n

.meas tran vdout0_1ck1460 FIND v(dout0_1) AT=1470.05n

.meas tran vdout0_2ck1460 FIND v(dout0_2) AT=1470.05n

.meas tran vdout0_3ck1460 FIND v(dout0_3) AT=1470.05n

.meas tran vdout0_4ck1460 FIND v(dout0_4) AT=1470.05n

.meas tran vdout0_5ck1460 FIND v(dout0_5) AT=1470.05n

.meas tran vdout0_6ck1460 FIND v(dout0_6) AT=1470.05n

.meas tran vdout0_7ck1460 FIND v(dout0_7) AT=1470.05n

.meas tran vdout0_8ck1460 FIND v(dout0_8) AT=1470.05n

.meas tran vdout0_9ck1460 FIND v(dout0_9) AT=1470.05n

.meas tran vdout0_10ck1460 FIND v(dout0_10) AT=1470.05n

.meas tran vdout0_11ck1460 FIND v(dout0_11) AT=1470.05n

.meas tran vdout0_12ck1460 FIND v(dout0_12) AT=1470.05n

.meas tran vdout0_13ck1460 FIND v(dout0_13) AT=1470.05n

.meas tran vdout0_14ck1460 FIND v(dout0_14) AT=1470.05n

.meas tran vdout0_15ck1460 FIND v(dout0_15) AT=1470.05n

.meas tran vdout0_16ck1460 FIND v(dout0_16) AT=1470.05n

.meas tran vdout0_17ck1460 FIND v(dout0_17) AT=1470.05n

.meas tran vdout0_18ck1460 FIND v(dout0_18) AT=1470.05n

.meas tran vdout0_19ck1460 FIND v(dout0_19) AT=1470.05n

.meas tran vdout0_20ck1460 FIND v(dout0_20) AT=1470.05n

.meas tran vdout0_21ck1460 FIND v(dout0_21) AT=1470.05n

.meas tran vdout0_22ck1460 FIND v(dout0_22) AT=1470.05n

.meas tran vdout0_23ck1460 FIND v(dout0_23) AT=1470.05n

.meas tran vdout0_24ck1460 FIND v(dout0_24) AT=1470.05n

.meas tran vdout0_25ck1460 FIND v(dout0_25) AT=1470.05n

.meas tran vdout0_26ck1460 FIND v(dout0_26) AT=1470.05n

.meas tran vdout0_27ck1460 FIND v(dout0_27) AT=1470.05n

.meas tran vdout0_28ck1460 FIND v(dout0_28) AT=1470.05n

.meas tran vdout0_29ck1460 FIND v(dout0_29) AT=1470.05n

.meas tran vdout0_30ck1460 FIND v(dout0_30) AT=1470.05n

.meas tran vdout0_31ck1460 FIND v(dout0_31) AT=1470.05n

.meas tran vdout1_0ck1490 FIND v(dout1_0) AT=1500.05n

.meas tran vdout1_1ck1490 FIND v(dout1_1) AT=1500.05n

.meas tran vdout1_2ck1490 FIND v(dout1_2) AT=1500.05n

.meas tran vdout1_3ck1490 FIND v(dout1_3) AT=1500.05n

.meas tran vdout1_4ck1490 FIND v(dout1_4) AT=1500.05n

.meas tran vdout1_5ck1490 FIND v(dout1_5) AT=1500.05n

.meas tran vdout1_6ck1490 FIND v(dout1_6) AT=1500.05n

.meas tran vdout1_7ck1490 FIND v(dout1_7) AT=1500.05n

.meas tran vdout1_8ck1490 FIND v(dout1_8) AT=1500.05n

.meas tran vdout1_9ck1490 FIND v(dout1_9) AT=1500.05n

.meas tran vdout1_10ck1490 FIND v(dout1_10) AT=1500.05n

.meas tran vdout1_11ck1490 FIND v(dout1_11) AT=1500.05n

.meas tran vdout1_12ck1490 FIND v(dout1_12) AT=1500.05n

.meas tran vdout1_13ck1490 FIND v(dout1_13) AT=1500.05n

.meas tran vdout1_14ck1490 FIND v(dout1_14) AT=1500.05n

.meas tran vdout1_15ck1490 FIND v(dout1_15) AT=1500.05n

.meas tran vdout1_16ck1490 FIND v(dout1_16) AT=1500.05n

.meas tran vdout1_17ck1490 FIND v(dout1_17) AT=1500.05n

.meas tran vdout1_18ck1490 FIND v(dout1_18) AT=1500.05n

.meas tran vdout1_19ck1490 FIND v(dout1_19) AT=1500.05n

.meas tran vdout1_20ck1490 FIND v(dout1_20) AT=1500.05n

.meas tran vdout1_21ck1490 FIND v(dout1_21) AT=1500.05n

.meas tran vdout1_22ck1490 FIND v(dout1_22) AT=1500.05n

.meas tran vdout1_23ck1490 FIND v(dout1_23) AT=1500.05n

.meas tran vdout1_24ck1490 FIND v(dout1_24) AT=1500.05n

.meas tran vdout1_25ck1490 FIND v(dout1_25) AT=1500.05n

.meas tran vdout1_26ck1490 FIND v(dout1_26) AT=1500.05n

.meas tran vdout1_27ck1490 FIND v(dout1_27) AT=1500.05n

.meas tran vdout1_28ck1490 FIND v(dout1_28) AT=1500.05n

.meas tran vdout1_29ck1490 FIND v(dout1_29) AT=1500.05n

.meas tran vdout1_30ck1490 FIND v(dout1_30) AT=1500.05n

.meas tran vdout1_31ck1490 FIND v(dout1_31) AT=1500.05n

.meas tran vdout0_0ck1510 FIND v(dout0_0) AT=1520.05n

.meas tran vdout0_1ck1510 FIND v(dout0_1) AT=1520.05n

.meas tran vdout0_2ck1510 FIND v(dout0_2) AT=1520.05n

.meas tran vdout0_3ck1510 FIND v(dout0_3) AT=1520.05n

.meas tran vdout0_4ck1510 FIND v(dout0_4) AT=1520.05n

.meas tran vdout0_5ck1510 FIND v(dout0_5) AT=1520.05n

.meas tran vdout0_6ck1510 FIND v(dout0_6) AT=1520.05n

.meas tran vdout0_7ck1510 FIND v(dout0_7) AT=1520.05n

.meas tran vdout0_8ck1510 FIND v(dout0_8) AT=1520.05n

.meas tran vdout0_9ck1510 FIND v(dout0_9) AT=1520.05n

.meas tran vdout0_10ck1510 FIND v(dout0_10) AT=1520.05n

.meas tran vdout0_11ck1510 FIND v(dout0_11) AT=1520.05n

.meas tran vdout0_12ck1510 FIND v(dout0_12) AT=1520.05n

.meas tran vdout0_13ck1510 FIND v(dout0_13) AT=1520.05n

.meas tran vdout0_14ck1510 FIND v(dout0_14) AT=1520.05n

.meas tran vdout0_15ck1510 FIND v(dout0_15) AT=1520.05n

.meas tran vdout0_16ck1510 FIND v(dout0_16) AT=1520.05n

.meas tran vdout0_17ck1510 FIND v(dout0_17) AT=1520.05n

.meas tran vdout0_18ck1510 FIND v(dout0_18) AT=1520.05n

.meas tran vdout0_19ck1510 FIND v(dout0_19) AT=1520.05n

.meas tran vdout0_20ck1510 FIND v(dout0_20) AT=1520.05n

.meas tran vdout0_21ck1510 FIND v(dout0_21) AT=1520.05n

.meas tran vdout0_22ck1510 FIND v(dout0_22) AT=1520.05n

.meas tran vdout0_23ck1510 FIND v(dout0_23) AT=1520.05n

.meas tran vdout0_24ck1510 FIND v(dout0_24) AT=1520.05n

.meas tran vdout0_25ck1510 FIND v(dout0_25) AT=1520.05n

.meas tran vdout0_26ck1510 FIND v(dout0_26) AT=1520.05n

.meas tran vdout0_27ck1510 FIND v(dout0_27) AT=1520.05n

.meas tran vdout0_28ck1510 FIND v(dout0_28) AT=1520.05n

.meas tran vdout0_29ck1510 FIND v(dout0_29) AT=1520.05n

.meas tran vdout0_30ck1510 FIND v(dout0_30) AT=1520.05n

.meas tran vdout0_31ck1510 FIND v(dout0_31) AT=1520.05n

.meas tran vdout1_0ck1510 FIND v(dout1_0) AT=1520.05n

.meas tran vdout1_1ck1510 FIND v(dout1_1) AT=1520.05n

.meas tran vdout1_2ck1510 FIND v(dout1_2) AT=1520.05n

.meas tran vdout1_3ck1510 FIND v(dout1_3) AT=1520.05n

.meas tran vdout1_4ck1510 FIND v(dout1_4) AT=1520.05n

.meas tran vdout1_5ck1510 FIND v(dout1_5) AT=1520.05n

.meas tran vdout1_6ck1510 FIND v(dout1_6) AT=1520.05n

.meas tran vdout1_7ck1510 FIND v(dout1_7) AT=1520.05n

.meas tran vdout1_8ck1510 FIND v(dout1_8) AT=1520.05n

.meas tran vdout1_9ck1510 FIND v(dout1_9) AT=1520.05n

.meas tran vdout1_10ck1510 FIND v(dout1_10) AT=1520.05n

.meas tran vdout1_11ck1510 FIND v(dout1_11) AT=1520.05n

.meas tran vdout1_12ck1510 FIND v(dout1_12) AT=1520.05n

.meas tran vdout1_13ck1510 FIND v(dout1_13) AT=1520.05n

.meas tran vdout1_14ck1510 FIND v(dout1_14) AT=1520.05n

.meas tran vdout1_15ck1510 FIND v(dout1_15) AT=1520.05n

.meas tran vdout1_16ck1510 FIND v(dout1_16) AT=1520.05n

.meas tran vdout1_17ck1510 FIND v(dout1_17) AT=1520.05n

.meas tran vdout1_18ck1510 FIND v(dout1_18) AT=1520.05n

.meas tran vdout1_19ck1510 FIND v(dout1_19) AT=1520.05n

.meas tran vdout1_20ck1510 FIND v(dout1_20) AT=1520.05n

.meas tran vdout1_21ck1510 FIND v(dout1_21) AT=1520.05n

.meas tran vdout1_22ck1510 FIND v(dout1_22) AT=1520.05n

.meas tran vdout1_23ck1510 FIND v(dout1_23) AT=1520.05n

.meas tran vdout1_24ck1510 FIND v(dout1_24) AT=1520.05n

.meas tran vdout1_25ck1510 FIND v(dout1_25) AT=1520.05n

.meas tran vdout1_26ck1510 FIND v(dout1_26) AT=1520.05n

.meas tran vdout1_27ck1510 FIND v(dout1_27) AT=1520.05n

.meas tran vdout1_28ck1510 FIND v(dout1_28) AT=1520.05n

.meas tran vdout1_29ck1510 FIND v(dout1_29) AT=1520.05n

.meas tran vdout1_30ck1510 FIND v(dout1_30) AT=1520.05n

.meas tran vdout1_31ck1510 FIND v(dout1_31) AT=1520.05n

.meas tran vdout0_0ck1520 FIND v(dout0_0) AT=1530.05n

.meas tran vdout0_1ck1520 FIND v(dout0_1) AT=1530.05n

.meas tran vdout0_2ck1520 FIND v(dout0_2) AT=1530.05n

.meas tran vdout0_3ck1520 FIND v(dout0_3) AT=1530.05n

.meas tran vdout0_4ck1520 FIND v(dout0_4) AT=1530.05n

.meas tran vdout0_5ck1520 FIND v(dout0_5) AT=1530.05n

.meas tran vdout0_6ck1520 FIND v(dout0_6) AT=1530.05n

.meas tran vdout0_7ck1520 FIND v(dout0_7) AT=1530.05n

.meas tran vdout0_8ck1520 FIND v(dout0_8) AT=1530.05n

.meas tran vdout0_9ck1520 FIND v(dout0_9) AT=1530.05n

.meas tran vdout0_10ck1520 FIND v(dout0_10) AT=1530.05n

.meas tran vdout0_11ck1520 FIND v(dout0_11) AT=1530.05n

.meas tran vdout0_12ck1520 FIND v(dout0_12) AT=1530.05n

.meas tran vdout0_13ck1520 FIND v(dout0_13) AT=1530.05n

.meas tran vdout0_14ck1520 FIND v(dout0_14) AT=1530.05n

.meas tran vdout0_15ck1520 FIND v(dout0_15) AT=1530.05n

.meas tran vdout0_16ck1520 FIND v(dout0_16) AT=1530.05n

.meas tran vdout0_17ck1520 FIND v(dout0_17) AT=1530.05n

.meas tran vdout0_18ck1520 FIND v(dout0_18) AT=1530.05n

.meas tran vdout0_19ck1520 FIND v(dout0_19) AT=1530.05n

.meas tran vdout0_20ck1520 FIND v(dout0_20) AT=1530.05n

.meas tran vdout0_21ck1520 FIND v(dout0_21) AT=1530.05n

.meas tran vdout0_22ck1520 FIND v(dout0_22) AT=1530.05n

.meas tran vdout0_23ck1520 FIND v(dout0_23) AT=1530.05n

.meas tran vdout0_24ck1520 FIND v(dout0_24) AT=1530.05n

.meas tran vdout0_25ck1520 FIND v(dout0_25) AT=1530.05n

.meas tran vdout0_26ck1520 FIND v(dout0_26) AT=1530.05n

.meas tran vdout0_27ck1520 FIND v(dout0_27) AT=1530.05n

.meas tran vdout0_28ck1520 FIND v(dout0_28) AT=1530.05n

.meas tran vdout0_29ck1520 FIND v(dout0_29) AT=1530.05n

.meas tran vdout0_30ck1520 FIND v(dout0_30) AT=1530.05n

.meas tran vdout0_31ck1520 FIND v(dout0_31) AT=1530.05n

.meas tran vdout1_0ck1520 FIND v(dout1_0) AT=1530.05n

.meas tran vdout1_1ck1520 FIND v(dout1_1) AT=1530.05n

.meas tran vdout1_2ck1520 FIND v(dout1_2) AT=1530.05n

.meas tran vdout1_3ck1520 FIND v(dout1_3) AT=1530.05n

.meas tran vdout1_4ck1520 FIND v(dout1_4) AT=1530.05n

.meas tran vdout1_5ck1520 FIND v(dout1_5) AT=1530.05n

.meas tran vdout1_6ck1520 FIND v(dout1_6) AT=1530.05n

.meas tran vdout1_7ck1520 FIND v(dout1_7) AT=1530.05n

.meas tran vdout1_8ck1520 FIND v(dout1_8) AT=1530.05n

.meas tran vdout1_9ck1520 FIND v(dout1_9) AT=1530.05n

.meas tran vdout1_10ck1520 FIND v(dout1_10) AT=1530.05n

.meas tran vdout1_11ck1520 FIND v(dout1_11) AT=1530.05n

.meas tran vdout1_12ck1520 FIND v(dout1_12) AT=1530.05n

.meas tran vdout1_13ck1520 FIND v(dout1_13) AT=1530.05n

.meas tran vdout1_14ck1520 FIND v(dout1_14) AT=1530.05n

.meas tran vdout1_15ck1520 FIND v(dout1_15) AT=1530.05n

.meas tran vdout1_16ck1520 FIND v(dout1_16) AT=1530.05n

.meas tran vdout1_17ck1520 FIND v(dout1_17) AT=1530.05n

.meas tran vdout1_18ck1520 FIND v(dout1_18) AT=1530.05n

.meas tran vdout1_19ck1520 FIND v(dout1_19) AT=1530.05n

.meas tran vdout1_20ck1520 FIND v(dout1_20) AT=1530.05n

.meas tran vdout1_21ck1520 FIND v(dout1_21) AT=1530.05n

.meas tran vdout1_22ck1520 FIND v(dout1_22) AT=1530.05n

.meas tran vdout1_23ck1520 FIND v(dout1_23) AT=1530.05n

.meas tran vdout1_24ck1520 FIND v(dout1_24) AT=1530.05n

.meas tran vdout1_25ck1520 FIND v(dout1_25) AT=1530.05n

.meas tran vdout1_26ck1520 FIND v(dout1_26) AT=1530.05n

.meas tran vdout1_27ck1520 FIND v(dout1_27) AT=1530.05n

.meas tran vdout1_28ck1520 FIND v(dout1_28) AT=1530.05n

.meas tran vdout1_29ck1520 FIND v(dout1_29) AT=1530.05n

.meas tran vdout1_30ck1520 FIND v(dout1_30) AT=1530.05n

.meas tran vdout1_31ck1520 FIND v(dout1_31) AT=1530.05n

.meas tran vdout0_0ck1530 FIND v(dout0_0) AT=1540.05n

.meas tran vdout0_1ck1530 FIND v(dout0_1) AT=1540.05n

.meas tran vdout0_2ck1530 FIND v(dout0_2) AT=1540.05n

.meas tran vdout0_3ck1530 FIND v(dout0_3) AT=1540.05n

.meas tran vdout0_4ck1530 FIND v(dout0_4) AT=1540.05n

.meas tran vdout0_5ck1530 FIND v(dout0_5) AT=1540.05n

.meas tran vdout0_6ck1530 FIND v(dout0_6) AT=1540.05n

.meas tran vdout0_7ck1530 FIND v(dout0_7) AT=1540.05n

.meas tran vdout0_8ck1530 FIND v(dout0_8) AT=1540.05n

.meas tran vdout0_9ck1530 FIND v(dout0_9) AT=1540.05n

.meas tran vdout0_10ck1530 FIND v(dout0_10) AT=1540.05n

.meas tran vdout0_11ck1530 FIND v(dout0_11) AT=1540.05n

.meas tran vdout0_12ck1530 FIND v(dout0_12) AT=1540.05n

.meas tran vdout0_13ck1530 FIND v(dout0_13) AT=1540.05n

.meas tran vdout0_14ck1530 FIND v(dout0_14) AT=1540.05n

.meas tran vdout0_15ck1530 FIND v(dout0_15) AT=1540.05n

.meas tran vdout0_16ck1530 FIND v(dout0_16) AT=1540.05n

.meas tran vdout0_17ck1530 FIND v(dout0_17) AT=1540.05n

.meas tran vdout0_18ck1530 FIND v(dout0_18) AT=1540.05n

.meas tran vdout0_19ck1530 FIND v(dout0_19) AT=1540.05n

.meas tran vdout0_20ck1530 FIND v(dout0_20) AT=1540.05n

.meas tran vdout0_21ck1530 FIND v(dout0_21) AT=1540.05n

.meas tran vdout0_22ck1530 FIND v(dout0_22) AT=1540.05n

.meas tran vdout0_23ck1530 FIND v(dout0_23) AT=1540.05n

.meas tran vdout0_24ck1530 FIND v(dout0_24) AT=1540.05n

.meas tran vdout0_25ck1530 FIND v(dout0_25) AT=1540.05n

.meas tran vdout0_26ck1530 FIND v(dout0_26) AT=1540.05n

.meas tran vdout0_27ck1530 FIND v(dout0_27) AT=1540.05n

.meas tran vdout0_28ck1530 FIND v(dout0_28) AT=1540.05n

.meas tran vdout0_29ck1530 FIND v(dout0_29) AT=1540.05n

.meas tran vdout0_30ck1530 FIND v(dout0_30) AT=1540.05n

.meas tran vdout0_31ck1530 FIND v(dout0_31) AT=1540.05n

.meas tran vdout1_0ck1530 FIND v(dout1_0) AT=1540.05n

.meas tran vdout1_1ck1530 FIND v(dout1_1) AT=1540.05n

.meas tran vdout1_2ck1530 FIND v(dout1_2) AT=1540.05n

.meas tran vdout1_3ck1530 FIND v(dout1_3) AT=1540.05n

.meas tran vdout1_4ck1530 FIND v(dout1_4) AT=1540.05n

.meas tran vdout1_5ck1530 FIND v(dout1_5) AT=1540.05n

.meas tran vdout1_6ck1530 FIND v(dout1_6) AT=1540.05n

.meas tran vdout1_7ck1530 FIND v(dout1_7) AT=1540.05n

.meas tran vdout1_8ck1530 FIND v(dout1_8) AT=1540.05n

.meas tran vdout1_9ck1530 FIND v(dout1_9) AT=1540.05n

.meas tran vdout1_10ck1530 FIND v(dout1_10) AT=1540.05n

.meas tran vdout1_11ck1530 FIND v(dout1_11) AT=1540.05n

.meas tran vdout1_12ck1530 FIND v(dout1_12) AT=1540.05n

.meas tran vdout1_13ck1530 FIND v(dout1_13) AT=1540.05n

.meas tran vdout1_14ck1530 FIND v(dout1_14) AT=1540.05n

.meas tran vdout1_15ck1530 FIND v(dout1_15) AT=1540.05n

.meas tran vdout1_16ck1530 FIND v(dout1_16) AT=1540.05n

.meas tran vdout1_17ck1530 FIND v(dout1_17) AT=1540.05n

.meas tran vdout1_18ck1530 FIND v(dout1_18) AT=1540.05n

.meas tran vdout1_19ck1530 FIND v(dout1_19) AT=1540.05n

.meas tran vdout1_20ck1530 FIND v(dout1_20) AT=1540.05n

.meas tran vdout1_21ck1530 FIND v(dout1_21) AT=1540.05n

.meas tran vdout1_22ck1530 FIND v(dout1_22) AT=1540.05n

.meas tran vdout1_23ck1530 FIND v(dout1_23) AT=1540.05n

.meas tran vdout1_24ck1530 FIND v(dout1_24) AT=1540.05n

.meas tran vdout1_25ck1530 FIND v(dout1_25) AT=1540.05n

.meas tran vdout1_26ck1530 FIND v(dout1_26) AT=1540.05n

.meas tran vdout1_27ck1530 FIND v(dout1_27) AT=1540.05n

.meas tran vdout1_28ck1530 FIND v(dout1_28) AT=1540.05n

.meas tran vdout1_29ck1530 FIND v(dout1_29) AT=1540.05n

.meas tran vdout1_30ck1530 FIND v(dout1_30) AT=1540.05n

.meas tran vdout1_31ck1530 FIND v(dout1_31) AT=1540.05n

.meas tran vdout0_0ck1540 FIND v(dout0_0) AT=1550.05n

.meas tran vdout0_1ck1540 FIND v(dout0_1) AT=1550.05n

.meas tran vdout0_2ck1540 FIND v(dout0_2) AT=1550.05n

.meas tran vdout0_3ck1540 FIND v(dout0_3) AT=1550.05n

.meas tran vdout0_4ck1540 FIND v(dout0_4) AT=1550.05n

.meas tran vdout0_5ck1540 FIND v(dout0_5) AT=1550.05n

.meas tran vdout0_6ck1540 FIND v(dout0_6) AT=1550.05n

.meas tran vdout0_7ck1540 FIND v(dout0_7) AT=1550.05n

.meas tran vdout0_8ck1540 FIND v(dout0_8) AT=1550.05n

.meas tran vdout0_9ck1540 FIND v(dout0_9) AT=1550.05n

.meas tran vdout0_10ck1540 FIND v(dout0_10) AT=1550.05n

.meas tran vdout0_11ck1540 FIND v(dout0_11) AT=1550.05n

.meas tran vdout0_12ck1540 FIND v(dout0_12) AT=1550.05n

.meas tran vdout0_13ck1540 FIND v(dout0_13) AT=1550.05n

.meas tran vdout0_14ck1540 FIND v(dout0_14) AT=1550.05n

.meas tran vdout0_15ck1540 FIND v(dout0_15) AT=1550.05n

.meas tran vdout0_16ck1540 FIND v(dout0_16) AT=1550.05n

.meas tran vdout0_17ck1540 FIND v(dout0_17) AT=1550.05n

.meas tran vdout0_18ck1540 FIND v(dout0_18) AT=1550.05n

.meas tran vdout0_19ck1540 FIND v(dout0_19) AT=1550.05n

.meas tran vdout0_20ck1540 FIND v(dout0_20) AT=1550.05n

.meas tran vdout0_21ck1540 FIND v(dout0_21) AT=1550.05n

.meas tran vdout0_22ck1540 FIND v(dout0_22) AT=1550.05n

.meas tran vdout0_23ck1540 FIND v(dout0_23) AT=1550.05n

.meas tran vdout0_24ck1540 FIND v(dout0_24) AT=1550.05n

.meas tran vdout0_25ck1540 FIND v(dout0_25) AT=1550.05n

.meas tran vdout0_26ck1540 FIND v(dout0_26) AT=1550.05n

.meas tran vdout0_27ck1540 FIND v(dout0_27) AT=1550.05n

.meas tran vdout0_28ck1540 FIND v(dout0_28) AT=1550.05n

.meas tran vdout0_29ck1540 FIND v(dout0_29) AT=1550.05n

.meas tran vdout0_30ck1540 FIND v(dout0_30) AT=1550.05n

.meas tran vdout0_31ck1540 FIND v(dout0_31) AT=1550.05n

.meas tran vdout0_0ck1560 FIND v(dout0_0) AT=1570.05n

.meas tran vdout0_1ck1560 FIND v(dout0_1) AT=1570.05n

.meas tran vdout0_2ck1560 FIND v(dout0_2) AT=1570.05n

.meas tran vdout0_3ck1560 FIND v(dout0_3) AT=1570.05n

.meas tran vdout0_4ck1560 FIND v(dout0_4) AT=1570.05n

.meas tran vdout0_5ck1560 FIND v(dout0_5) AT=1570.05n

.meas tran vdout0_6ck1560 FIND v(dout0_6) AT=1570.05n

.meas tran vdout0_7ck1560 FIND v(dout0_7) AT=1570.05n

.meas tran vdout0_8ck1560 FIND v(dout0_8) AT=1570.05n

.meas tran vdout0_9ck1560 FIND v(dout0_9) AT=1570.05n

.meas tran vdout0_10ck1560 FIND v(dout0_10) AT=1570.05n

.meas tran vdout0_11ck1560 FIND v(dout0_11) AT=1570.05n

.meas tran vdout0_12ck1560 FIND v(dout0_12) AT=1570.05n

.meas tran vdout0_13ck1560 FIND v(dout0_13) AT=1570.05n

.meas tran vdout0_14ck1560 FIND v(dout0_14) AT=1570.05n

.meas tran vdout0_15ck1560 FIND v(dout0_15) AT=1570.05n

.meas tran vdout0_16ck1560 FIND v(dout0_16) AT=1570.05n

.meas tran vdout0_17ck1560 FIND v(dout0_17) AT=1570.05n

.meas tran vdout0_18ck1560 FIND v(dout0_18) AT=1570.05n

.meas tran vdout0_19ck1560 FIND v(dout0_19) AT=1570.05n

.meas tran vdout0_20ck1560 FIND v(dout0_20) AT=1570.05n

.meas tran vdout0_21ck1560 FIND v(dout0_21) AT=1570.05n

.meas tran vdout0_22ck1560 FIND v(dout0_22) AT=1570.05n

.meas tran vdout0_23ck1560 FIND v(dout0_23) AT=1570.05n

.meas tran vdout0_24ck1560 FIND v(dout0_24) AT=1570.05n

.meas tran vdout0_25ck1560 FIND v(dout0_25) AT=1570.05n

.meas tran vdout0_26ck1560 FIND v(dout0_26) AT=1570.05n

.meas tran vdout0_27ck1560 FIND v(dout0_27) AT=1570.05n

.meas tran vdout0_28ck1560 FIND v(dout0_28) AT=1570.05n

.meas tran vdout0_29ck1560 FIND v(dout0_29) AT=1570.05n

.meas tran vdout0_30ck1560 FIND v(dout0_30) AT=1570.05n

.meas tran vdout0_31ck1560 FIND v(dout0_31) AT=1570.05n

.meas tran vdout1_0ck1560 FIND v(dout1_0) AT=1570.05n

.meas tran vdout1_1ck1560 FIND v(dout1_1) AT=1570.05n

.meas tran vdout1_2ck1560 FIND v(dout1_2) AT=1570.05n

.meas tran vdout1_3ck1560 FIND v(dout1_3) AT=1570.05n

.meas tran vdout1_4ck1560 FIND v(dout1_4) AT=1570.05n

.meas tran vdout1_5ck1560 FIND v(dout1_5) AT=1570.05n

.meas tran vdout1_6ck1560 FIND v(dout1_6) AT=1570.05n

.meas tran vdout1_7ck1560 FIND v(dout1_7) AT=1570.05n

.meas tran vdout1_8ck1560 FIND v(dout1_8) AT=1570.05n

.meas tran vdout1_9ck1560 FIND v(dout1_9) AT=1570.05n

.meas tran vdout1_10ck1560 FIND v(dout1_10) AT=1570.05n

.meas tran vdout1_11ck1560 FIND v(dout1_11) AT=1570.05n

.meas tran vdout1_12ck1560 FIND v(dout1_12) AT=1570.05n

.meas tran vdout1_13ck1560 FIND v(dout1_13) AT=1570.05n

.meas tran vdout1_14ck1560 FIND v(dout1_14) AT=1570.05n

.meas tran vdout1_15ck1560 FIND v(dout1_15) AT=1570.05n

.meas tran vdout1_16ck1560 FIND v(dout1_16) AT=1570.05n

.meas tran vdout1_17ck1560 FIND v(dout1_17) AT=1570.05n

.meas tran vdout1_18ck1560 FIND v(dout1_18) AT=1570.05n

.meas tran vdout1_19ck1560 FIND v(dout1_19) AT=1570.05n

.meas tran vdout1_20ck1560 FIND v(dout1_20) AT=1570.05n

.meas tran vdout1_21ck1560 FIND v(dout1_21) AT=1570.05n

.meas tran vdout1_22ck1560 FIND v(dout1_22) AT=1570.05n

.meas tran vdout1_23ck1560 FIND v(dout1_23) AT=1570.05n

.meas tran vdout1_24ck1560 FIND v(dout1_24) AT=1570.05n

.meas tran vdout1_25ck1560 FIND v(dout1_25) AT=1570.05n

.meas tran vdout1_26ck1560 FIND v(dout1_26) AT=1570.05n

.meas tran vdout1_27ck1560 FIND v(dout1_27) AT=1570.05n

.meas tran vdout1_28ck1560 FIND v(dout1_28) AT=1570.05n

.meas tran vdout1_29ck1560 FIND v(dout1_29) AT=1570.05n

.meas tran vdout1_30ck1560 FIND v(dout1_30) AT=1570.05n

.meas tran vdout1_31ck1560 FIND v(dout1_31) AT=1570.05n

.meas tran vdout0_0ck1600 FIND v(dout0_0) AT=1610.05n

.meas tran vdout0_1ck1600 FIND v(dout0_1) AT=1610.05n

.meas tran vdout0_2ck1600 FIND v(dout0_2) AT=1610.05n

.meas tran vdout0_3ck1600 FIND v(dout0_3) AT=1610.05n

.meas tran vdout0_4ck1600 FIND v(dout0_4) AT=1610.05n

.meas tran vdout0_5ck1600 FIND v(dout0_5) AT=1610.05n

.meas tran vdout0_6ck1600 FIND v(dout0_6) AT=1610.05n

.meas tran vdout0_7ck1600 FIND v(dout0_7) AT=1610.05n

.meas tran vdout0_8ck1600 FIND v(dout0_8) AT=1610.05n

.meas tran vdout0_9ck1600 FIND v(dout0_9) AT=1610.05n

.meas tran vdout0_10ck1600 FIND v(dout0_10) AT=1610.05n

.meas tran vdout0_11ck1600 FIND v(dout0_11) AT=1610.05n

.meas tran vdout0_12ck1600 FIND v(dout0_12) AT=1610.05n

.meas tran vdout0_13ck1600 FIND v(dout0_13) AT=1610.05n

.meas tran vdout0_14ck1600 FIND v(dout0_14) AT=1610.05n

.meas tran vdout0_15ck1600 FIND v(dout0_15) AT=1610.05n

.meas tran vdout0_16ck1600 FIND v(dout0_16) AT=1610.05n

.meas tran vdout0_17ck1600 FIND v(dout0_17) AT=1610.05n

.meas tran vdout0_18ck1600 FIND v(dout0_18) AT=1610.05n

.meas tran vdout0_19ck1600 FIND v(dout0_19) AT=1610.05n

.meas tran vdout0_20ck1600 FIND v(dout0_20) AT=1610.05n

.meas tran vdout0_21ck1600 FIND v(dout0_21) AT=1610.05n

.meas tran vdout0_22ck1600 FIND v(dout0_22) AT=1610.05n

.meas tran vdout0_23ck1600 FIND v(dout0_23) AT=1610.05n

.meas tran vdout0_24ck1600 FIND v(dout0_24) AT=1610.05n

.meas tran vdout0_25ck1600 FIND v(dout0_25) AT=1610.05n

.meas tran vdout0_26ck1600 FIND v(dout0_26) AT=1610.05n

.meas tran vdout0_27ck1600 FIND v(dout0_27) AT=1610.05n

.meas tran vdout0_28ck1600 FIND v(dout0_28) AT=1610.05n

.meas tran vdout0_29ck1600 FIND v(dout0_29) AT=1610.05n

.meas tran vdout0_30ck1600 FIND v(dout0_30) AT=1610.05n

.meas tran vdout0_31ck1600 FIND v(dout0_31) AT=1610.05n

.meas tran vdout1_0ck1610 FIND v(dout1_0) AT=1620.05n

.meas tran vdout1_1ck1610 FIND v(dout1_1) AT=1620.05n

.meas tran vdout1_2ck1610 FIND v(dout1_2) AT=1620.05n

.meas tran vdout1_3ck1610 FIND v(dout1_3) AT=1620.05n

.meas tran vdout1_4ck1610 FIND v(dout1_4) AT=1620.05n

.meas tran vdout1_5ck1610 FIND v(dout1_5) AT=1620.05n

.meas tran vdout1_6ck1610 FIND v(dout1_6) AT=1620.05n

.meas tran vdout1_7ck1610 FIND v(dout1_7) AT=1620.05n

.meas tran vdout1_8ck1610 FIND v(dout1_8) AT=1620.05n

.meas tran vdout1_9ck1610 FIND v(dout1_9) AT=1620.05n

.meas tran vdout1_10ck1610 FIND v(dout1_10) AT=1620.05n

.meas tran vdout1_11ck1610 FIND v(dout1_11) AT=1620.05n

.meas tran vdout1_12ck1610 FIND v(dout1_12) AT=1620.05n

.meas tran vdout1_13ck1610 FIND v(dout1_13) AT=1620.05n

.meas tran vdout1_14ck1610 FIND v(dout1_14) AT=1620.05n

.meas tran vdout1_15ck1610 FIND v(dout1_15) AT=1620.05n

.meas tran vdout1_16ck1610 FIND v(dout1_16) AT=1620.05n

.meas tran vdout1_17ck1610 FIND v(dout1_17) AT=1620.05n

.meas tran vdout1_18ck1610 FIND v(dout1_18) AT=1620.05n

.meas tran vdout1_19ck1610 FIND v(dout1_19) AT=1620.05n

.meas tran vdout1_20ck1610 FIND v(dout1_20) AT=1620.05n

.meas tran vdout1_21ck1610 FIND v(dout1_21) AT=1620.05n

.meas tran vdout1_22ck1610 FIND v(dout1_22) AT=1620.05n

.meas tran vdout1_23ck1610 FIND v(dout1_23) AT=1620.05n

.meas tran vdout1_24ck1610 FIND v(dout1_24) AT=1620.05n

.meas tran vdout1_25ck1610 FIND v(dout1_25) AT=1620.05n

.meas tran vdout1_26ck1610 FIND v(dout1_26) AT=1620.05n

.meas tran vdout1_27ck1610 FIND v(dout1_27) AT=1620.05n

.meas tran vdout1_28ck1610 FIND v(dout1_28) AT=1620.05n

.meas tran vdout1_29ck1610 FIND v(dout1_29) AT=1620.05n

.meas tran vdout1_30ck1610 FIND v(dout1_30) AT=1620.05n

.meas tran vdout1_31ck1610 FIND v(dout1_31) AT=1620.05n

.meas tran vdout0_0ck1620 FIND v(dout0_0) AT=1630.05n

.meas tran vdout0_1ck1620 FIND v(dout0_1) AT=1630.05n

.meas tran vdout0_2ck1620 FIND v(dout0_2) AT=1630.05n

.meas tran vdout0_3ck1620 FIND v(dout0_3) AT=1630.05n

.meas tran vdout0_4ck1620 FIND v(dout0_4) AT=1630.05n

.meas tran vdout0_5ck1620 FIND v(dout0_5) AT=1630.05n

.meas tran vdout0_6ck1620 FIND v(dout0_6) AT=1630.05n

.meas tran vdout0_7ck1620 FIND v(dout0_7) AT=1630.05n

.meas tran vdout0_8ck1620 FIND v(dout0_8) AT=1630.05n

.meas tran vdout0_9ck1620 FIND v(dout0_9) AT=1630.05n

.meas tran vdout0_10ck1620 FIND v(dout0_10) AT=1630.05n

.meas tran vdout0_11ck1620 FIND v(dout0_11) AT=1630.05n

.meas tran vdout0_12ck1620 FIND v(dout0_12) AT=1630.05n

.meas tran vdout0_13ck1620 FIND v(dout0_13) AT=1630.05n

.meas tran vdout0_14ck1620 FIND v(dout0_14) AT=1630.05n

.meas tran vdout0_15ck1620 FIND v(dout0_15) AT=1630.05n

.meas tran vdout0_16ck1620 FIND v(dout0_16) AT=1630.05n

.meas tran vdout0_17ck1620 FIND v(dout0_17) AT=1630.05n

.meas tran vdout0_18ck1620 FIND v(dout0_18) AT=1630.05n

.meas tran vdout0_19ck1620 FIND v(dout0_19) AT=1630.05n

.meas tran vdout0_20ck1620 FIND v(dout0_20) AT=1630.05n

.meas tran vdout0_21ck1620 FIND v(dout0_21) AT=1630.05n

.meas tran vdout0_22ck1620 FIND v(dout0_22) AT=1630.05n

.meas tran vdout0_23ck1620 FIND v(dout0_23) AT=1630.05n

.meas tran vdout0_24ck1620 FIND v(dout0_24) AT=1630.05n

.meas tran vdout0_25ck1620 FIND v(dout0_25) AT=1630.05n

.meas tran vdout0_26ck1620 FIND v(dout0_26) AT=1630.05n

.meas tran vdout0_27ck1620 FIND v(dout0_27) AT=1630.05n

.meas tran vdout0_28ck1620 FIND v(dout0_28) AT=1630.05n

.meas tran vdout0_29ck1620 FIND v(dout0_29) AT=1630.05n

.meas tran vdout0_30ck1620 FIND v(dout0_30) AT=1630.05n

.meas tran vdout0_31ck1620 FIND v(dout0_31) AT=1630.05n

.meas tran vdout0_0ck1630 FIND v(dout0_0) AT=1640.05n

.meas tran vdout0_1ck1630 FIND v(dout0_1) AT=1640.05n

.meas tran vdout0_2ck1630 FIND v(dout0_2) AT=1640.05n

.meas tran vdout0_3ck1630 FIND v(dout0_3) AT=1640.05n

.meas tran vdout0_4ck1630 FIND v(dout0_4) AT=1640.05n

.meas tran vdout0_5ck1630 FIND v(dout0_5) AT=1640.05n

.meas tran vdout0_6ck1630 FIND v(dout0_6) AT=1640.05n

.meas tran vdout0_7ck1630 FIND v(dout0_7) AT=1640.05n

.meas tran vdout0_8ck1630 FIND v(dout0_8) AT=1640.05n

.meas tran vdout0_9ck1630 FIND v(dout0_9) AT=1640.05n

.meas tran vdout0_10ck1630 FIND v(dout0_10) AT=1640.05n

.meas tran vdout0_11ck1630 FIND v(dout0_11) AT=1640.05n

.meas tran vdout0_12ck1630 FIND v(dout0_12) AT=1640.05n

.meas tran vdout0_13ck1630 FIND v(dout0_13) AT=1640.05n

.meas tran vdout0_14ck1630 FIND v(dout0_14) AT=1640.05n

.meas tran vdout0_15ck1630 FIND v(dout0_15) AT=1640.05n

.meas tran vdout0_16ck1630 FIND v(dout0_16) AT=1640.05n

.meas tran vdout0_17ck1630 FIND v(dout0_17) AT=1640.05n

.meas tran vdout0_18ck1630 FIND v(dout0_18) AT=1640.05n

.meas tran vdout0_19ck1630 FIND v(dout0_19) AT=1640.05n

.meas tran vdout0_20ck1630 FIND v(dout0_20) AT=1640.05n

.meas tran vdout0_21ck1630 FIND v(dout0_21) AT=1640.05n

.meas tran vdout0_22ck1630 FIND v(dout0_22) AT=1640.05n

.meas tran vdout0_23ck1630 FIND v(dout0_23) AT=1640.05n

.meas tran vdout0_24ck1630 FIND v(dout0_24) AT=1640.05n

.meas tran vdout0_25ck1630 FIND v(dout0_25) AT=1640.05n

.meas tran vdout0_26ck1630 FIND v(dout0_26) AT=1640.05n

.meas tran vdout0_27ck1630 FIND v(dout0_27) AT=1640.05n

.meas tran vdout0_28ck1630 FIND v(dout0_28) AT=1640.05n

.meas tran vdout0_29ck1630 FIND v(dout0_29) AT=1640.05n

.meas tran vdout0_30ck1630 FIND v(dout0_30) AT=1640.05n

.meas tran vdout0_31ck1630 FIND v(dout0_31) AT=1640.05n

.meas tran vdout0_0ck1640 FIND v(dout0_0) AT=1650.05n

.meas tran vdout0_1ck1640 FIND v(dout0_1) AT=1650.05n

.meas tran vdout0_2ck1640 FIND v(dout0_2) AT=1650.05n

.meas tran vdout0_3ck1640 FIND v(dout0_3) AT=1650.05n

.meas tran vdout0_4ck1640 FIND v(dout0_4) AT=1650.05n

.meas tran vdout0_5ck1640 FIND v(dout0_5) AT=1650.05n

.meas tran vdout0_6ck1640 FIND v(dout0_6) AT=1650.05n

.meas tran vdout0_7ck1640 FIND v(dout0_7) AT=1650.05n

.meas tran vdout0_8ck1640 FIND v(dout0_8) AT=1650.05n

.meas tran vdout0_9ck1640 FIND v(dout0_9) AT=1650.05n

.meas tran vdout0_10ck1640 FIND v(dout0_10) AT=1650.05n

.meas tran vdout0_11ck1640 FIND v(dout0_11) AT=1650.05n

.meas tran vdout0_12ck1640 FIND v(dout0_12) AT=1650.05n

.meas tran vdout0_13ck1640 FIND v(dout0_13) AT=1650.05n

.meas tran vdout0_14ck1640 FIND v(dout0_14) AT=1650.05n

.meas tran vdout0_15ck1640 FIND v(dout0_15) AT=1650.05n

.meas tran vdout0_16ck1640 FIND v(dout0_16) AT=1650.05n

.meas tran vdout0_17ck1640 FIND v(dout0_17) AT=1650.05n

.meas tran vdout0_18ck1640 FIND v(dout0_18) AT=1650.05n

.meas tran vdout0_19ck1640 FIND v(dout0_19) AT=1650.05n

.meas tran vdout0_20ck1640 FIND v(dout0_20) AT=1650.05n

.meas tran vdout0_21ck1640 FIND v(dout0_21) AT=1650.05n

.meas tran vdout0_22ck1640 FIND v(dout0_22) AT=1650.05n

.meas tran vdout0_23ck1640 FIND v(dout0_23) AT=1650.05n

.meas tran vdout0_24ck1640 FIND v(dout0_24) AT=1650.05n

.meas tran vdout0_25ck1640 FIND v(dout0_25) AT=1650.05n

.meas tran vdout0_26ck1640 FIND v(dout0_26) AT=1650.05n

.meas tran vdout0_27ck1640 FIND v(dout0_27) AT=1650.05n

.meas tran vdout0_28ck1640 FIND v(dout0_28) AT=1650.05n

.meas tran vdout0_29ck1640 FIND v(dout0_29) AT=1650.05n

.meas tran vdout0_30ck1640 FIND v(dout0_30) AT=1650.05n

.meas tran vdout0_31ck1640 FIND v(dout0_31) AT=1650.05n

.meas tran vdout1_0ck1640 FIND v(dout1_0) AT=1650.05n

.meas tran vdout1_1ck1640 FIND v(dout1_1) AT=1650.05n

.meas tran vdout1_2ck1640 FIND v(dout1_2) AT=1650.05n

.meas tran vdout1_3ck1640 FIND v(dout1_3) AT=1650.05n

.meas tran vdout1_4ck1640 FIND v(dout1_4) AT=1650.05n

.meas tran vdout1_5ck1640 FIND v(dout1_5) AT=1650.05n

.meas tran vdout1_6ck1640 FIND v(dout1_6) AT=1650.05n

.meas tran vdout1_7ck1640 FIND v(dout1_7) AT=1650.05n

.meas tran vdout1_8ck1640 FIND v(dout1_8) AT=1650.05n

.meas tran vdout1_9ck1640 FIND v(dout1_9) AT=1650.05n

.meas tran vdout1_10ck1640 FIND v(dout1_10) AT=1650.05n

.meas tran vdout1_11ck1640 FIND v(dout1_11) AT=1650.05n

.meas tran vdout1_12ck1640 FIND v(dout1_12) AT=1650.05n

.meas tran vdout1_13ck1640 FIND v(dout1_13) AT=1650.05n

.meas tran vdout1_14ck1640 FIND v(dout1_14) AT=1650.05n

.meas tran vdout1_15ck1640 FIND v(dout1_15) AT=1650.05n

.meas tran vdout1_16ck1640 FIND v(dout1_16) AT=1650.05n

.meas tran vdout1_17ck1640 FIND v(dout1_17) AT=1650.05n

.meas tran vdout1_18ck1640 FIND v(dout1_18) AT=1650.05n

.meas tran vdout1_19ck1640 FIND v(dout1_19) AT=1650.05n

.meas tran vdout1_20ck1640 FIND v(dout1_20) AT=1650.05n

.meas tran vdout1_21ck1640 FIND v(dout1_21) AT=1650.05n

.meas tran vdout1_22ck1640 FIND v(dout1_22) AT=1650.05n

.meas tran vdout1_23ck1640 FIND v(dout1_23) AT=1650.05n

.meas tran vdout1_24ck1640 FIND v(dout1_24) AT=1650.05n

.meas tran vdout1_25ck1640 FIND v(dout1_25) AT=1650.05n

.meas tran vdout1_26ck1640 FIND v(dout1_26) AT=1650.05n

.meas tran vdout1_27ck1640 FIND v(dout1_27) AT=1650.05n

.meas tran vdout1_28ck1640 FIND v(dout1_28) AT=1650.05n

.meas tran vdout1_29ck1640 FIND v(dout1_29) AT=1650.05n

.meas tran vdout1_30ck1640 FIND v(dout1_30) AT=1650.05n

.meas tran vdout1_31ck1640 FIND v(dout1_31) AT=1650.05n

.meas tran vdout1_0ck1660 FIND v(dout1_0) AT=1670.05n

.meas tran vdout1_1ck1660 FIND v(dout1_1) AT=1670.05n

.meas tran vdout1_2ck1660 FIND v(dout1_2) AT=1670.05n

.meas tran vdout1_3ck1660 FIND v(dout1_3) AT=1670.05n

.meas tran vdout1_4ck1660 FIND v(dout1_4) AT=1670.05n

.meas tran vdout1_5ck1660 FIND v(dout1_5) AT=1670.05n

.meas tran vdout1_6ck1660 FIND v(dout1_6) AT=1670.05n

.meas tran vdout1_7ck1660 FIND v(dout1_7) AT=1670.05n

.meas tran vdout1_8ck1660 FIND v(dout1_8) AT=1670.05n

.meas tran vdout1_9ck1660 FIND v(dout1_9) AT=1670.05n

.meas tran vdout1_10ck1660 FIND v(dout1_10) AT=1670.05n

.meas tran vdout1_11ck1660 FIND v(dout1_11) AT=1670.05n

.meas tran vdout1_12ck1660 FIND v(dout1_12) AT=1670.05n

.meas tran vdout1_13ck1660 FIND v(dout1_13) AT=1670.05n

.meas tran vdout1_14ck1660 FIND v(dout1_14) AT=1670.05n

.meas tran vdout1_15ck1660 FIND v(dout1_15) AT=1670.05n

.meas tran vdout1_16ck1660 FIND v(dout1_16) AT=1670.05n

.meas tran vdout1_17ck1660 FIND v(dout1_17) AT=1670.05n

.meas tran vdout1_18ck1660 FIND v(dout1_18) AT=1670.05n

.meas tran vdout1_19ck1660 FIND v(dout1_19) AT=1670.05n

.meas tran vdout1_20ck1660 FIND v(dout1_20) AT=1670.05n

.meas tran vdout1_21ck1660 FIND v(dout1_21) AT=1670.05n

.meas tran vdout1_22ck1660 FIND v(dout1_22) AT=1670.05n

.meas tran vdout1_23ck1660 FIND v(dout1_23) AT=1670.05n

.meas tran vdout1_24ck1660 FIND v(dout1_24) AT=1670.05n

.meas tran vdout1_25ck1660 FIND v(dout1_25) AT=1670.05n

.meas tran vdout1_26ck1660 FIND v(dout1_26) AT=1670.05n

.meas tran vdout1_27ck1660 FIND v(dout1_27) AT=1670.05n

.meas tran vdout1_28ck1660 FIND v(dout1_28) AT=1670.05n

.meas tran vdout1_29ck1660 FIND v(dout1_29) AT=1670.05n

.meas tran vdout1_30ck1660 FIND v(dout1_30) AT=1670.05n

.meas tran vdout1_31ck1660 FIND v(dout1_31) AT=1670.05n

.meas tran vdout0_0ck1670 FIND v(dout0_0) AT=1680.05n

.meas tran vdout0_1ck1670 FIND v(dout0_1) AT=1680.05n

.meas tran vdout0_2ck1670 FIND v(dout0_2) AT=1680.05n

.meas tran vdout0_3ck1670 FIND v(dout0_3) AT=1680.05n

.meas tran vdout0_4ck1670 FIND v(dout0_4) AT=1680.05n

.meas tran vdout0_5ck1670 FIND v(dout0_5) AT=1680.05n

.meas tran vdout0_6ck1670 FIND v(dout0_6) AT=1680.05n

.meas tran vdout0_7ck1670 FIND v(dout0_7) AT=1680.05n

.meas tran vdout0_8ck1670 FIND v(dout0_8) AT=1680.05n

.meas tran vdout0_9ck1670 FIND v(dout0_9) AT=1680.05n

.meas tran vdout0_10ck1670 FIND v(dout0_10) AT=1680.05n

.meas tran vdout0_11ck1670 FIND v(dout0_11) AT=1680.05n

.meas tran vdout0_12ck1670 FIND v(dout0_12) AT=1680.05n

.meas tran vdout0_13ck1670 FIND v(dout0_13) AT=1680.05n

.meas tran vdout0_14ck1670 FIND v(dout0_14) AT=1680.05n

.meas tran vdout0_15ck1670 FIND v(dout0_15) AT=1680.05n

.meas tran vdout0_16ck1670 FIND v(dout0_16) AT=1680.05n

.meas tran vdout0_17ck1670 FIND v(dout0_17) AT=1680.05n

.meas tran vdout0_18ck1670 FIND v(dout0_18) AT=1680.05n

.meas tran vdout0_19ck1670 FIND v(dout0_19) AT=1680.05n

.meas tran vdout0_20ck1670 FIND v(dout0_20) AT=1680.05n

.meas tran vdout0_21ck1670 FIND v(dout0_21) AT=1680.05n

.meas tran vdout0_22ck1670 FIND v(dout0_22) AT=1680.05n

.meas tran vdout0_23ck1670 FIND v(dout0_23) AT=1680.05n

.meas tran vdout0_24ck1670 FIND v(dout0_24) AT=1680.05n

.meas tran vdout0_25ck1670 FIND v(dout0_25) AT=1680.05n

.meas tran vdout0_26ck1670 FIND v(dout0_26) AT=1680.05n

.meas tran vdout0_27ck1670 FIND v(dout0_27) AT=1680.05n

.meas tran vdout0_28ck1670 FIND v(dout0_28) AT=1680.05n

.meas tran vdout0_29ck1670 FIND v(dout0_29) AT=1680.05n

.meas tran vdout0_30ck1670 FIND v(dout0_30) AT=1680.05n

.meas tran vdout0_31ck1670 FIND v(dout0_31) AT=1680.05n

.meas tran vdout1_0ck1670 FIND v(dout1_0) AT=1680.05n

.meas tran vdout1_1ck1670 FIND v(dout1_1) AT=1680.05n

.meas tran vdout1_2ck1670 FIND v(dout1_2) AT=1680.05n

.meas tran vdout1_3ck1670 FIND v(dout1_3) AT=1680.05n

.meas tran vdout1_4ck1670 FIND v(dout1_4) AT=1680.05n

.meas tran vdout1_5ck1670 FIND v(dout1_5) AT=1680.05n

.meas tran vdout1_6ck1670 FIND v(dout1_6) AT=1680.05n

.meas tran vdout1_7ck1670 FIND v(dout1_7) AT=1680.05n

.meas tran vdout1_8ck1670 FIND v(dout1_8) AT=1680.05n

.meas tran vdout1_9ck1670 FIND v(dout1_9) AT=1680.05n

.meas tran vdout1_10ck1670 FIND v(dout1_10) AT=1680.05n

.meas tran vdout1_11ck1670 FIND v(dout1_11) AT=1680.05n

.meas tran vdout1_12ck1670 FIND v(dout1_12) AT=1680.05n

.meas tran vdout1_13ck1670 FIND v(dout1_13) AT=1680.05n

.meas tran vdout1_14ck1670 FIND v(dout1_14) AT=1680.05n

.meas tran vdout1_15ck1670 FIND v(dout1_15) AT=1680.05n

.meas tran vdout1_16ck1670 FIND v(dout1_16) AT=1680.05n

.meas tran vdout1_17ck1670 FIND v(dout1_17) AT=1680.05n

.meas tran vdout1_18ck1670 FIND v(dout1_18) AT=1680.05n

.meas tran vdout1_19ck1670 FIND v(dout1_19) AT=1680.05n

.meas tran vdout1_20ck1670 FIND v(dout1_20) AT=1680.05n

.meas tran vdout1_21ck1670 FIND v(dout1_21) AT=1680.05n

.meas tran vdout1_22ck1670 FIND v(dout1_22) AT=1680.05n

.meas tran vdout1_23ck1670 FIND v(dout1_23) AT=1680.05n

.meas tran vdout1_24ck1670 FIND v(dout1_24) AT=1680.05n

.meas tran vdout1_25ck1670 FIND v(dout1_25) AT=1680.05n

.meas tran vdout1_26ck1670 FIND v(dout1_26) AT=1680.05n

.meas tran vdout1_27ck1670 FIND v(dout1_27) AT=1680.05n

.meas tran vdout1_28ck1670 FIND v(dout1_28) AT=1680.05n

.meas tran vdout1_29ck1670 FIND v(dout1_29) AT=1680.05n

.meas tran vdout1_30ck1670 FIND v(dout1_30) AT=1680.05n

.meas tran vdout1_31ck1670 FIND v(dout1_31) AT=1680.05n

.meas tran vdout0_0ck1680 FIND v(dout0_0) AT=1690.05n

.meas tran vdout0_1ck1680 FIND v(dout0_1) AT=1690.05n

.meas tran vdout0_2ck1680 FIND v(dout0_2) AT=1690.05n

.meas tran vdout0_3ck1680 FIND v(dout0_3) AT=1690.05n

.meas tran vdout0_4ck1680 FIND v(dout0_4) AT=1690.05n

.meas tran vdout0_5ck1680 FIND v(dout0_5) AT=1690.05n

.meas tran vdout0_6ck1680 FIND v(dout0_6) AT=1690.05n

.meas tran vdout0_7ck1680 FIND v(dout0_7) AT=1690.05n

.meas tran vdout0_8ck1680 FIND v(dout0_8) AT=1690.05n

.meas tran vdout0_9ck1680 FIND v(dout0_9) AT=1690.05n

.meas tran vdout0_10ck1680 FIND v(dout0_10) AT=1690.05n

.meas tran vdout0_11ck1680 FIND v(dout0_11) AT=1690.05n

.meas tran vdout0_12ck1680 FIND v(dout0_12) AT=1690.05n

.meas tran vdout0_13ck1680 FIND v(dout0_13) AT=1690.05n

.meas tran vdout0_14ck1680 FIND v(dout0_14) AT=1690.05n

.meas tran vdout0_15ck1680 FIND v(dout0_15) AT=1690.05n

.meas tran vdout0_16ck1680 FIND v(dout0_16) AT=1690.05n

.meas tran vdout0_17ck1680 FIND v(dout0_17) AT=1690.05n

.meas tran vdout0_18ck1680 FIND v(dout0_18) AT=1690.05n

.meas tran vdout0_19ck1680 FIND v(dout0_19) AT=1690.05n

.meas tran vdout0_20ck1680 FIND v(dout0_20) AT=1690.05n

.meas tran vdout0_21ck1680 FIND v(dout0_21) AT=1690.05n

.meas tran vdout0_22ck1680 FIND v(dout0_22) AT=1690.05n

.meas tran vdout0_23ck1680 FIND v(dout0_23) AT=1690.05n

.meas tran vdout0_24ck1680 FIND v(dout0_24) AT=1690.05n

.meas tran vdout0_25ck1680 FIND v(dout0_25) AT=1690.05n

.meas tran vdout0_26ck1680 FIND v(dout0_26) AT=1690.05n

.meas tran vdout0_27ck1680 FIND v(dout0_27) AT=1690.05n

.meas tran vdout0_28ck1680 FIND v(dout0_28) AT=1690.05n

.meas tran vdout0_29ck1680 FIND v(dout0_29) AT=1690.05n

.meas tran vdout0_30ck1680 FIND v(dout0_30) AT=1690.05n

.meas tran vdout0_31ck1680 FIND v(dout0_31) AT=1690.05n

.meas tran vdout1_0ck1680 FIND v(dout1_0) AT=1690.05n

.meas tran vdout1_1ck1680 FIND v(dout1_1) AT=1690.05n

.meas tran vdout1_2ck1680 FIND v(dout1_2) AT=1690.05n

.meas tran vdout1_3ck1680 FIND v(dout1_3) AT=1690.05n

.meas tran vdout1_4ck1680 FIND v(dout1_4) AT=1690.05n

.meas tran vdout1_5ck1680 FIND v(dout1_5) AT=1690.05n

.meas tran vdout1_6ck1680 FIND v(dout1_6) AT=1690.05n

.meas tran vdout1_7ck1680 FIND v(dout1_7) AT=1690.05n

.meas tran vdout1_8ck1680 FIND v(dout1_8) AT=1690.05n

.meas tran vdout1_9ck1680 FIND v(dout1_9) AT=1690.05n

.meas tran vdout1_10ck1680 FIND v(dout1_10) AT=1690.05n

.meas tran vdout1_11ck1680 FIND v(dout1_11) AT=1690.05n

.meas tran vdout1_12ck1680 FIND v(dout1_12) AT=1690.05n

.meas tran vdout1_13ck1680 FIND v(dout1_13) AT=1690.05n

.meas tran vdout1_14ck1680 FIND v(dout1_14) AT=1690.05n

.meas tran vdout1_15ck1680 FIND v(dout1_15) AT=1690.05n

.meas tran vdout1_16ck1680 FIND v(dout1_16) AT=1690.05n

.meas tran vdout1_17ck1680 FIND v(dout1_17) AT=1690.05n

.meas tran vdout1_18ck1680 FIND v(dout1_18) AT=1690.05n

.meas tran vdout1_19ck1680 FIND v(dout1_19) AT=1690.05n

.meas tran vdout1_20ck1680 FIND v(dout1_20) AT=1690.05n

.meas tran vdout1_21ck1680 FIND v(dout1_21) AT=1690.05n

.meas tran vdout1_22ck1680 FIND v(dout1_22) AT=1690.05n

.meas tran vdout1_23ck1680 FIND v(dout1_23) AT=1690.05n

.meas tran vdout1_24ck1680 FIND v(dout1_24) AT=1690.05n

.meas tran vdout1_25ck1680 FIND v(dout1_25) AT=1690.05n

.meas tran vdout1_26ck1680 FIND v(dout1_26) AT=1690.05n

.meas tran vdout1_27ck1680 FIND v(dout1_27) AT=1690.05n

.meas tran vdout1_28ck1680 FIND v(dout1_28) AT=1690.05n

.meas tran vdout1_29ck1680 FIND v(dout1_29) AT=1690.05n

.meas tran vdout1_30ck1680 FIND v(dout1_30) AT=1690.05n

.meas tran vdout1_31ck1680 FIND v(dout1_31) AT=1690.05n

.meas tran vdout1_0ck1690 FIND v(dout1_0) AT=1700.05n

.meas tran vdout1_1ck1690 FIND v(dout1_1) AT=1700.05n

.meas tran vdout1_2ck1690 FIND v(dout1_2) AT=1700.05n

.meas tran vdout1_3ck1690 FIND v(dout1_3) AT=1700.05n

.meas tran vdout1_4ck1690 FIND v(dout1_4) AT=1700.05n

.meas tran vdout1_5ck1690 FIND v(dout1_5) AT=1700.05n

.meas tran vdout1_6ck1690 FIND v(dout1_6) AT=1700.05n

.meas tran vdout1_7ck1690 FIND v(dout1_7) AT=1700.05n

.meas tran vdout1_8ck1690 FIND v(dout1_8) AT=1700.05n

.meas tran vdout1_9ck1690 FIND v(dout1_9) AT=1700.05n

.meas tran vdout1_10ck1690 FIND v(dout1_10) AT=1700.05n

.meas tran vdout1_11ck1690 FIND v(dout1_11) AT=1700.05n

.meas tran vdout1_12ck1690 FIND v(dout1_12) AT=1700.05n

.meas tran vdout1_13ck1690 FIND v(dout1_13) AT=1700.05n

.meas tran vdout1_14ck1690 FIND v(dout1_14) AT=1700.05n

.meas tran vdout1_15ck1690 FIND v(dout1_15) AT=1700.05n

.meas tran vdout1_16ck1690 FIND v(dout1_16) AT=1700.05n

.meas tran vdout1_17ck1690 FIND v(dout1_17) AT=1700.05n

.meas tran vdout1_18ck1690 FIND v(dout1_18) AT=1700.05n

.meas tran vdout1_19ck1690 FIND v(dout1_19) AT=1700.05n

.meas tran vdout1_20ck1690 FIND v(dout1_20) AT=1700.05n

.meas tran vdout1_21ck1690 FIND v(dout1_21) AT=1700.05n

.meas tran vdout1_22ck1690 FIND v(dout1_22) AT=1700.05n

.meas tran vdout1_23ck1690 FIND v(dout1_23) AT=1700.05n

.meas tran vdout1_24ck1690 FIND v(dout1_24) AT=1700.05n

.meas tran vdout1_25ck1690 FIND v(dout1_25) AT=1700.05n

.meas tran vdout1_26ck1690 FIND v(dout1_26) AT=1700.05n

.meas tran vdout1_27ck1690 FIND v(dout1_27) AT=1700.05n

.meas tran vdout1_28ck1690 FIND v(dout1_28) AT=1700.05n

.meas tran vdout1_29ck1690 FIND v(dout1_29) AT=1700.05n

.meas tran vdout1_30ck1690 FIND v(dout1_30) AT=1700.05n

.meas tran vdout1_31ck1690 FIND v(dout1_31) AT=1700.05n

.meas tran vdout0_0ck1710 FIND v(dout0_0) AT=1720.05n

.meas tran vdout0_1ck1710 FIND v(dout0_1) AT=1720.05n

.meas tran vdout0_2ck1710 FIND v(dout0_2) AT=1720.05n

.meas tran vdout0_3ck1710 FIND v(dout0_3) AT=1720.05n

.meas tran vdout0_4ck1710 FIND v(dout0_4) AT=1720.05n

.meas tran vdout0_5ck1710 FIND v(dout0_5) AT=1720.05n

.meas tran vdout0_6ck1710 FIND v(dout0_6) AT=1720.05n

.meas tran vdout0_7ck1710 FIND v(dout0_7) AT=1720.05n

.meas tran vdout0_8ck1710 FIND v(dout0_8) AT=1720.05n

.meas tran vdout0_9ck1710 FIND v(dout0_9) AT=1720.05n

.meas tran vdout0_10ck1710 FIND v(dout0_10) AT=1720.05n

.meas tran vdout0_11ck1710 FIND v(dout0_11) AT=1720.05n

.meas tran vdout0_12ck1710 FIND v(dout0_12) AT=1720.05n

.meas tran vdout0_13ck1710 FIND v(dout0_13) AT=1720.05n

.meas tran vdout0_14ck1710 FIND v(dout0_14) AT=1720.05n

.meas tran vdout0_15ck1710 FIND v(dout0_15) AT=1720.05n

.meas tran vdout0_16ck1710 FIND v(dout0_16) AT=1720.05n

.meas tran vdout0_17ck1710 FIND v(dout0_17) AT=1720.05n

.meas tran vdout0_18ck1710 FIND v(dout0_18) AT=1720.05n

.meas tran vdout0_19ck1710 FIND v(dout0_19) AT=1720.05n

.meas tran vdout0_20ck1710 FIND v(dout0_20) AT=1720.05n

.meas tran vdout0_21ck1710 FIND v(dout0_21) AT=1720.05n

.meas tran vdout0_22ck1710 FIND v(dout0_22) AT=1720.05n

.meas tran vdout0_23ck1710 FIND v(dout0_23) AT=1720.05n

.meas tran vdout0_24ck1710 FIND v(dout0_24) AT=1720.05n

.meas tran vdout0_25ck1710 FIND v(dout0_25) AT=1720.05n

.meas tran vdout0_26ck1710 FIND v(dout0_26) AT=1720.05n

.meas tran vdout0_27ck1710 FIND v(dout0_27) AT=1720.05n

.meas tran vdout0_28ck1710 FIND v(dout0_28) AT=1720.05n

.meas tran vdout0_29ck1710 FIND v(dout0_29) AT=1720.05n

.meas tran vdout0_30ck1710 FIND v(dout0_30) AT=1720.05n

.meas tran vdout0_31ck1710 FIND v(dout0_31) AT=1720.05n

.meas tran vdout1_0ck1720 FIND v(dout1_0) AT=1730.05n

.meas tran vdout1_1ck1720 FIND v(dout1_1) AT=1730.05n

.meas tran vdout1_2ck1720 FIND v(dout1_2) AT=1730.05n

.meas tran vdout1_3ck1720 FIND v(dout1_3) AT=1730.05n

.meas tran vdout1_4ck1720 FIND v(dout1_4) AT=1730.05n

.meas tran vdout1_5ck1720 FIND v(dout1_5) AT=1730.05n

.meas tran vdout1_6ck1720 FIND v(dout1_6) AT=1730.05n

.meas tran vdout1_7ck1720 FIND v(dout1_7) AT=1730.05n

.meas tran vdout1_8ck1720 FIND v(dout1_8) AT=1730.05n

.meas tran vdout1_9ck1720 FIND v(dout1_9) AT=1730.05n

.meas tran vdout1_10ck1720 FIND v(dout1_10) AT=1730.05n

.meas tran vdout1_11ck1720 FIND v(dout1_11) AT=1730.05n

.meas tran vdout1_12ck1720 FIND v(dout1_12) AT=1730.05n

.meas tran vdout1_13ck1720 FIND v(dout1_13) AT=1730.05n

.meas tran vdout1_14ck1720 FIND v(dout1_14) AT=1730.05n

.meas tran vdout1_15ck1720 FIND v(dout1_15) AT=1730.05n

.meas tran vdout1_16ck1720 FIND v(dout1_16) AT=1730.05n

.meas tran vdout1_17ck1720 FIND v(dout1_17) AT=1730.05n

.meas tran vdout1_18ck1720 FIND v(dout1_18) AT=1730.05n

.meas tran vdout1_19ck1720 FIND v(dout1_19) AT=1730.05n

.meas tran vdout1_20ck1720 FIND v(dout1_20) AT=1730.05n

.meas tran vdout1_21ck1720 FIND v(dout1_21) AT=1730.05n

.meas tran vdout1_22ck1720 FIND v(dout1_22) AT=1730.05n

.meas tran vdout1_23ck1720 FIND v(dout1_23) AT=1730.05n

.meas tran vdout1_24ck1720 FIND v(dout1_24) AT=1730.05n

.meas tran vdout1_25ck1720 FIND v(dout1_25) AT=1730.05n

.meas tran vdout1_26ck1720 FIND v(dout1_26) AT=1730.05n

.meas tran vdout1_27ck1720 FIND v(dout1_27) AT=1730.05n

.meas tran vdout1_28ck1720 FIND v(dout1_28) AT=1730.05n

.meas tran vdout1_29ck1720 FIND v(dout1_29) AT=1730.05n

.meas tran vdout1_30ck1720 FIND v(dout1_30) AT=1730.05n

.meas tran vdout1_31ck1720 FIND v(dout1_31) AT=1730.05n

.meas tran vdout0_0ck1730 FIND v(dout0_0) AT=1740.05n

.meas tran vdout0_1ck1730 FIND v(dout0_1) AT=1740.05n

.meas tran vdout0_2ck1730 FIND v(dout0_2) AT=1740.05n

.meas tran vdout0_3ck1730 FIND v(dout0_3) AT=1740.05n

.meas tran vdout0_4ck1730 FIND v(dout0_4) AT=1740.05n

.meas tran vdout0_5ck1730 FIND v(dout0_5) AT=1740.05n

.meas tran vdout0_6ck1730 FIND v(dout0_6) AT=1740.05n

.meas tran vdout0_7ck1730 FIND v(dout0_7) AT=1740.05n

.meas tran vdout0_8ck1730 FIND v(dout0_8) AT=1740.05n

.meas tran vdout0_9ck1730 FIND v(dout0_9) AT=1740.05n

.meas tran vdout0_10ck1730 FIND v(dout0_10) AT=1740.05n

.meas tran vdout0_11ck1730 FIND v(dout0_11) AT=1740.05n

.meas tran vdout0_12ck1730 FIND v(dout0_12) AT=1740.05n

.meas tran vdout0_13ck1730 FIND v(dout0_13) AT=1740.05n

.meas tran vdout0_14ck1730 FIND v(dout0_14) AT=1740.05n

.meas tran vdout0_15ck1730 FIND v(dout0_15) AT=1740.05n

.meas tran vdout0_16ck1730 FIND v(dout0_16) AT=1740.05n

.meas tran vdout0_17ck1730 FIND v(dout0_17) AT=1740.05n

.meas tran vdout0_18ck1730 FIND v(dout0_18) AT=1740.05n

.meas tran vdout0_19ck1730 FIND v(dout0_19) AT=1740.05n

.meas tran vdout0_20ck1730 FIND v(dout0_20) AT=1740.05n

.meas tran vdout0_21ck1730 FIND v(dout0_21) AT=1740.05n

.meas tran vdout0_22ck1730 FIND v(dout0_22) AT=1740.05n

.meas tran vdout0_23ck1730 FIND v(dout0_23) AT=1740.05n

.meas tran vdout0_24ck1730 FIND v(dout0_24) AT=1740.05n

.meas tran vdout0_25ck1730 FIND v(dout0_25) AT=1740.05n

.meas tran vdout0_26ck1730 FIND v(dout0_26) AT=1740.05n

.meas tran vdout0_27ck1730 FIND v(dout0_27) AT=1740.05n

.meas tran vdout0_28ck1730 FIND v(dout0_28) AT=1740.05n

.meas tran vdout0_29ck1730 FIND v(dout0_29) AT=1740.05n

.meas tran vdout0_30ck1730 FIND v(dout0_30) AT=1740.05n

.meas tran vdout0_31ck1730 FIND v(dout0_31) AT=1740.05n

.meas tran vdout1_0ck1730 FIND v(dout1_0) AT=1740.05n

.meas tran vdout1_1ck1730 FIND v(dout1_1) AT=1740.05n

.meas tran vdout1_2ck1730 FIND v(dout1_2) AT=1740.05n

.meas tran vdout1_3ck1730 FIND v(dout1_3) AT=1740.05n

.meas tran vdout1_4ck1730 FIND v(dout1_4) AT=1740.05n

.meas tran vdout1_5ck1730 FIND v(dout1_5) AT=1740.05n

.meas tran vdout1_6ck1730 FIND v(dout1_6) AT=1740.05n

.meas tran vdout1_7ck1730 FIND v(dout1_7) AT=1740.05n

.meas tran vdout1_8ck1730 FIND v(dout1_8) AT=1740.05n

.meas tran vdout1_9ck1730 FIND v(dout1_9) AT=1740.05n

.meas tran vdout1_10ck1730 FIND v(dout1_10) AT=1740.05n

.meas tran vdout1_11ck1730 FIND v(dout1_11) AT=1740.05n

.meas tran vdout1_12ck1730 FIND v(dout1_12) AT=1740.05n

.meas tran vdout1_13ck1730 FIND v(dout1_13) AT=1740.05n

.meas tran vdout1_14ck1730 FIND v(dout1_14) AT=1740.05n

.meas tran vdout1_15ck1730 FIND v(dout1_15) AT=1740.05n

.meas tran vdout1_16ck1730 FIND v(dout1_16) AT=1740.05n

.meas tran vdout1_17ck1730 FIND v(dout1_17) AT=1740.05n

.meas tran vdout1_18ck1730 FIND v(dout1_18) AT=1740.05n

.meas tran vdout1_19ck1730 FIND v(dout1_19) AT=1740.05n

.meas tran vdout1_20ck1730 FIND v(dout1_20) AT=1740.05n

.meas tran vdout1_21ck1730 FIND v(dout1_21) AT=1740.05n

.meas tran vdout1_22ck1730 FIND v(dout1_22) AT=1740.05n

.meas tran vdout1_23ck1730 FIND v(dout1_23) AT=1740.05n

.meas tran vdout1_24ck1730 FIND v(dout1_24) AT=1740.05n

.meas tran vdout1_25ck1730 FIND v(dout1_25) AT=1740.05n

.meas tran vdout1_26ck1730 FIND v(dout1_26) AT=1740.05n

.meas tran vdout1_27ck1730 FIND v(dout1_27) AT=1740.05n

.meas tran vdout1_28ck1730 FIND v(dout1_28) AT=1740.05n

.meas tran vdout1_29ck1730 FIND v(dout1_29) AT=1740.05n

.meas tran vdout1_30ck1730 FIND v(dout1_30) AT=1740.05n

.meas tran vdout1_31ck1730 FIND v(dout1_31) AT=1740.05n

.meas tran vdout1_0ck1740 FIND v(dout1_0) AT=1750.05n

.meas tran vdout1_1ck1740 FIND v(dout1_1) AT=1750.05n

.meas tran vdout1_2ck1740 FIND v(dout1_2) AT=1750.05n

.meas tran vdout1_3ck1740 FIND v(dout1_3) AT=1750.05n

.meas tran vdout1_4ck1740 FIND v(dout1_4) AT=1750.05n

.meas tran vdout1_5ck1740 FIND v(dout1_5) AT=1750.05n

.meas tran vdout1_6ck1740 FIND v(dout1_6) AT=1750.05n

.meas tran vdout1_7ck1740 FIND v(dout1_7) AT=1750.05n

.meas tran vdout1_8ck1740 FIND v(dout1_8) AT=1750.05n

.meas tran vdout1_9ck1740 FIND v(dout1_9) AT=1750.05n

.meas tran vdout1_10ck1740 FIND v(dout1_10) AT=1750.05n

.meas tran vdout1_11ck1740 FIND v(dout1_11) AT=1750.05n

.meas tran vdout1_12ck1740 FIND v(dout1_12) AT=1750.05n

.meas tran vdout1_13ck1740 FIND v(dout1_13) AT=1750.05n

.meas tran vdout1_14ck1740 FIND v(dout1_14) AT=1750.05n

.meas tran vdout1_15ck1740 FIND v(dout1_15) AT=1750.05n

.meas tran vdout1_16ck1740 FIND v(dout1_16) AT=1750.05n

.meas tran vdout1_17ck1740 FIND v(dout1_17) AT=1750.05n

.meas tran vdout1_18ck1740 FIND v(dout1_18) AT=1750.05n

.meas tran vdout1_19ck1740 FIND v(dout1_19) AT=1750.05n

.meas tran vdout1_20ck1740 FIND v(dout1_20) AT=1750.05n

.meas tran vdout1_21ck1740 FIND v(dout1_21) AT=1750.05n

.meas tran vdout1_22ck1740 FIND v(dout1_22) AT=1750.05n

.meas tran vdout1_23ck1740 FIND v(dout1_23) AT=1750.05n

.meas tran vdout1_24ck1740 FIND v(dout1_24) AT=1750.05n

.meas tran vdout1_25ck1740 FIND v(dout1_25) AT=1750.05n

.meas tran vdout1_26ck1740 FIND v(dout1_26) AT=1750.05n

.meas tran vdout1_27ck1740 FIND v(dout1_27) AT=1750.05n

.meas tran vdout1_28ck1740 FIND v(dout1_28) AT=1750.05n

.meas tran vdout1_29ck1740 FIND v(dout1_29) AT=1750.05n

.meas tran vdout1_30ck1740 FIND v(dout1_30) AT=1750.05n

.meas tran vdout1_31ck1740 FIND v(dout1_31) AT=1750.05n

.meas tran vdout1_0ck1750 FIND v(dout1_0) AT=1760.05n

.meas tran vdout1_1ck1750 FIND v(dout1_1) AT=1760.05n

.meas tran vdout1_2ck1750 FIND v(dout1_2) AT=1760.05n

.meas tran vdout1_3ck1750 FIND v(dout1_3) AT=1760.05n

.meas tran vdout1_4ck1750 FIND v(dout1_4) AT=1760.05n

.meas tran vdout1_5ck1750 FIND v(dout1_5) AT=1760.05n

.meas tran vdout1_6ck1750 FIND v(dout1_6) AT=1760.05n

.meas tran vdout1_7ck1750 FIND v(dout1_7) AT=1760.05n

.meas tran vdout1_8ck1750 FIND v(dout1_8) AT=1760.05n

.meas tran vdout1_9ck1750 FIND v(dout1_9) AT=1760.05n

.meas tran vdout1_10ck1750 FIND v(dout1_10) AT=1760.05n

.meas tran vdout1_11ck1750 FIND v(dout1_11) AT=1760.05n

.meas tran vdout1_12ck1750 FIND v(dout1_12) AT=1760.05n

.meas tran vdout1_13ck1750 FIND v(dout1_13) AT=1760.05n

.meas tran vdout1_14ck1750 FIND v(dout1_14) AT=1760.05n

.meas tran vdout1_15ck1750 FIND v(dout1_15) AT=1760.05n

.meas tran vdout1_16ck1750 FIND v(dout1_16) AT=1760.05n

.meas tran vdout1_17ck1750 FIND v(dout1_17) AT=1760.05n

.meas tran vdout1_18ck1750 FIND v(dout1_18) AT=1760.05n

.meas tran vdout1_19ck1750 FIND v(dout1_19) AT=1760.05n

.meas tran vdout1_20ck1750 FIND v(dout1_20) AT=1760.05n

.meas tran vdout1_21ck1750 FIND v(dout1_21) AT=1760.05n

.meas tran vdout1_22ck1750 FIND v(dout1_22) AT=1760.05n

.meas tran vdout1_23ck1750 FIND v(dout1_23) AT=1760.05n

.meas tran vdout1_24ck1750 FIND v(dout1_24) AT=1760.05n

.meas tran vdout1_25ck1750 FIND v(dout1_25) AT=1760.05n

.meas tran vdout1_26ck1750 FIND v(dout1_26) AT=1760.05n

.meas tran vdout1_27ck1750 FIND v(dout1_27) AT=1760.05n

.meas tran vdout1_28ck1750 FIND v(dout1_28) AT=1760.05n

.meas tran vdout1_29ck1750 FIND v(dout1_29) AT=1760.05n

.meas tran vdout1_30ck1750 FIND v(dout1_30) AT=1760.05n

.meas tran vdout1_31ck1750 FIND v(dout1_31) AT=1760.05n

.meas tran vdout1_0ck1760 FIND v(dout1_0) AT=1770.05n

.meas tran vdout1_1ck1760 FIND v(dout1_1) AT=1770.05n

.meas tran vdout1_2ck1760 FIND v(dout1_2) AT=1770.05n

.meas tran vdout1_3ck1760 FIND v(dout1_3) AT=1770.05n

.meas tran vdout1_4ck1760 FIND v(dout1_4) AT=1770.05n

.meas tran vdout1_5ck1760 FIND v(dout1_5) AT=1770.05n

.meas tran vdout1_6ck1760 FIND v(dout1_6) AT=1770.05n

.meas tran vdout1_7ck1760 FIND v(dout1_7) AT=1770.05n

.meas tran vdout1_8ck1760 FIND v(dout1_8) AT=1770.05n

.meas tran vdout1_9ck1760 FIND v(dout1_9) AT=1770.05n

.meas tran vdout1_10ck1760 FIND v(dout1_10) AT=1770.05n

.meas tran vdout1_11ck1760 FIND v(dout1_11) AT=1770.05n

.meas tran vdout1_12ck1760 FIND v(dout1_12) AT=1770.05n

.meas tran vdout1_13ck1760 FIND v(dout1_13) AT=1770.05n

.meas tran vdout1_14ck1760 FIND v(dout1_14) AT=1770.05n

.meas tran vdout1_15ck1760 FIND v(dout1_15) AT=1770.05n

.meas tran vdout1_16ck1760 FIND v(dout1_16) AT=1770.05n

.meas tran vdout1_17ck1760 FIND v(dout1_17) AT=1770.05n

.meas tran vdout1_18ck1760 FIND v(dout1_18) AT=1770.05n

.meas tran vdout1_19ck1760 FIND v(dout1_19) AT=1770.05n

.meas tran vdout1_20ck1760 FIND v(dout1_20) AT=1770.05n

.meas tran vdout1_21ck1760 FIND v(dout1_21) AT=1770.05n

.meas tran vdout1_22ck1760 FIND v(dout1_22) AT=1770.05n

.meas tran vdout1_23ck1760 FIND v(dout1_23) AT=1770.05n

.meas tran vdout1_24ck1760 FIND v(dout1_24) AT=1770.05n

.meas tran vdout1_25ck1760 FIND v(dout1_25) AT=1770.05n

.meas tran vdout1_26ck1760 FIND v(dout1_26) AT=1770.05n

.meas tran vdout1_27ck1760 FIND v(dout1_27) AT=1770.05n

.meas tran vdout1_28ck1760 FIND v(dout1_28) AT=1770.05n

.meas tran vdout1_29ck1760 FIND v(dout1_29) AT=1770.05n

.meas tran vdout1_30ck1760 FIND v(dout1_30) AT=1770.05n

.meas tran vdout1_31ck1760 FIND v(dout1_31) AT=1770.05n

.meas tran vdout0_0ck1770 FIND v(dout0_0) AT=1780.05n

.meas tran vdout0_1ck1770 FIND v(dout0_1) AT=1780.05n

.meas tran vdout0_2ck1770 FIND v(dout0_2) AT=1780.05n

.meas tran vdout0_3ck1770 FIND v(dout0_3) AT=1780.05n

.meas tran vdout0_4ck1770 FIND v(dout0_4) AT=1780.05n

.meas tran vdout0_5ck1770 FIND v(dout0_5) AT=1780.05n

.meas tran vdout0_6ck1770 FIND v(dout0_6) AT=1780.05n

.meas tran vdout0_7ck1770 FIND v(dout0_7) AT=1780.05n

.meas tran vdout0_8ck1770 FIND v(dout0_8) AT=1780.05n

.meas tran vdout0_9ck1770 FIND v(dout0_9) AT=1780.05n

.meas tran vdout0_10ck1770 FIND v(dout0_10) AT=1780.05n

.meas tran vdout0_11ck1770 FIND v(dout0_11) AT=1780.05n

.meas tran vdout0_12ck1770 FIND v(dout0_12) AT=1780.05n

.meas tran vdout0_13ck1770 FIND v(dout0_13) AT=1780.05n

.meas tran vdout0_14ck1770 FIND v(dout0_14) AT=1780.05n

.meas tran vdout0_15ck1770 FIND v(dout0_15) AT=1780.05n

.meas tran vdout0_16ck1770 FIND v(dout0_16) AT=1780.05n

.meas tran vdout0_17ck1770 FIND v(dout0_17) AT=1780.05n

.meas tran vdout0_18ck1770 FIND v(dout0_18) AT=1780.05n

.meas tran vdout0_19ck1770 FIND v(dout0_19) AT=1780.05n

.meas tran vdout0_20ck1770 FIND v(dout0_20) AT=1780.05n

.meas tran vdout0_21ck1770 FIND v(dout0_21) AT=1780.05n

.meas tran vdout0_22ck1770 FIND v(dout0_22) AT=1780.05n

.meas tran vdout0_23ck1770 FIND v(dout0_23) AT=1780.05n

.meas tran vdout0_24ck1770 FIND v(dout0_24) AT=1780.05n

.meas tran vdout0_25ck1770 FIND v(dout0_25) AT=1780.05n

.meas tran vdout0_26ck1770 FIND v(dout0_26) AT=1780.05n

.meas tran vdout0_27ck1770 FIND v(dout0_27) AT=1780.05n

.meas tran vdout0_28ck1770 FIND v(dout0_28) AT=1780.05n

.meas tran vdout0_29ck1770 FIND v(dout0_29) AT=1780.05n

.meas tran vdout0_30ck1770 FIND v(dout0_30) AT=1780.05n

.meas tran vdout0_31ck1770 FIND v(dout0_31) AT=1780.05n

.meas tran vdout1_0ck1770 FIND v(dout1_0) AT=1780.05n

.meas tran vdout1_1ck1770 FIND v(dout1_1) AT=1780.05n

.meas tran vdout1_2ck1770 FIND v(dout1_2) AT=1780.05n

.meas tran vdout1_3ck1770 FIND v(dout1_3) AT=1780.05n

.meas tran vdout1_4ck1770 FIND v(dout1_4) AT=1780.05n

.meas tran vdout1_5ck1770 FIND v(dout1_5) AT=1780.05n

.meas tran vdout1_6ck1770 FIND v(dout1_6) AT=1780.05n

.meas tran vdout1_7ck1770 FIND v(dout1_7) AT=1780.05n

.meas tran vdout1_8ck1770 FIND v(dout1_8) AT=1780.05n

.meas tran vdout1_9ck1770 FIND v(dout1_9) AT=1780.05n

.meas tran vdout1_10ck1770 FIND v(dout1_10) AT=1780.05n

.meas tran vdout1_11ck1770 FIND v(dout1_11) AT=1780.05n

.meas tran vdout1_12ck1770 FIND v(dout1_12) AT=1780.05n

.meas tran vdout1_13ck1770 FIND v(dout1_13) AT=1780.05n

.meas tran vdout1_14ck1770 FIND v(dout1_14) AT=1780.05n

.meas tran vdout1_15ck1770 FIND v(dout1_15) AT=1780.05n

.meas tran vdout1_16ck1770 FIND v(dout1_16) AT=1780.05n

.meas tran vdout1_17ck1770 FIND v(dout1_17) AT=1780.05n

.meas tran vdout1_18ck1770 FIND v(dout1_18) AT=1780.05n

.meas tran vdout1_19ck1770 FIND v(dout1_19) AT=1780.05n

.meas tran vdout1_20ck1770 FIND v(dout1_20) AT=1780.05n

.meas tran vdout1_21ck1770 FIND v(dout1_21) AT=1780.05n

.meas tran vdout1_22ck1770 FIND v(dout1_22) AT=1780.05n

.meas tran vdout1_23ck1770 FIND v(dout1_23) AT=1780.05n

.meas tran vdout1_24ck1770 FIND v(dout1_24) AT=1780.05n

.meas tran vdout1_25ck1770 FIND v(dout1_25) AT=1780.05n

.meas tran vdout1_26ck1770 FIND v(dout1_26) AT=1780.05n

.meas tran vdout1_27ck1770 FIND v(dout1_27) AT=1780.05n

.meas tran vdout1_28ck1770 FIND v(dout1_28) AT=1780.05n

.meas tran vdout1_29ck1770 FIND v(dout1_29) AT=1780.05n

.meas tran vdout1_30ck1770 FIND v(dout1_30) AT=1780.05n

.meas tran vdout1_31ck1770 FIND v(dout1_31) AT=1780.05n

.meas tran vdout0_0ck1780 FIND v(dout0_0) AT=1790.05n

.meas tran vdout0_1ck1780 FIND v(dout0_1) AT=1790.05n

.meas tran vdout0_2ck1780 FIND v(dout0_2) AT=1790.05n

.meas tran vdout0_3ck1780 FIND v(dout0_3) AT=1790.05n

.meas tran vdout0_4ck1780 FIND v(dout0_4) AT=1790.05n

.meas tran vdout0_5ck1780 FIND v(dout0_5) AT=1790.05n

.meas tran vdout0_6ck1780 FIND v(dout0_6) AT=1790.05n

.meas tran vdout0_7ck1780 FIND v(dout0_7) AT=1790.05n

.meas tran vdout0_8ck1780 FIND v(dout0_8) AT=1790.05n

.meas tran vdout0_9ck1780 FIND v(dout0_9) AT=1790.05n

.meas tran vdout0_10ck1780 FIND v(dout0_10) AT=1790.05n

.meas tran vdout0_11ck1780 FIND v(dout0_11) AT=1790.05n

.meas tran vdout0_12ck1780 FIND v(dout0_12) AT=1790.05n

.meas tran vdout0_13ck1780 FIND v(dout0_13) AT=1790.05n

.meas tran vdout0_14ck1780 FIND v(dout0_14) AT=1790.05n

.meas tran vdout0_15ck1780 FIND v(dout0_15) AT=1790.05n

.meas tran vdout0_16ck1780 FIND v(dout0_16) AT=1790.05n

.meas tran vdout0_17ck1780 FIND v(dout0_17) AT=1790.05n

.meas tran vdout0_18ck1780 FIND v(dout0_18) AT=1790.05n

.meas tran vdout0_19ck1780 FIND v(dout0_19) AT=1790.05n

.meas tran vdout0_20ck1780 FIND v(dout0_20) AT=1790.05n

.meas tran vdout0_21ck1780 FIND v(dout0_21) AT=1790.05n

.meas tran vdout0_22ck1780 FIND v(dout0_22) AT=1790.05n

.meas tran vdout0_23ck1780 FIND v(dout0_23) AT=1790.05n

.meas tran vdout0_24ck1780 FIND v(dout0_24) AT=1790.05n

.meas tran vdout0_25ck1780 FIND v(dout0_25) AT=1790.05n

.meas tran vdout0_26ck1780 FIND v(dout0_26) AT=1790.05n

.meas tran vdout0_27ck1780 FIND v(dout0_27) AT=1790.05n

.meas tran vdout0_28ck1780 FIND v(dout0_28) AT=1790.05n

.meas tran vdout0_29ck1780 FIND v(dout0_29) AT=1790.05n

.meas tran vdout0_30ck1780 FIND v(dout0_30) AT=1790.05n

.meas tran vdout0_31ck1780 FIND v(dout0_31) AT=1790.05n

.meas tran vdout0_0ck1800 FIND v(dout0_0) AT=1810.05n

.meas tran vdout0_1ck1800 FIND v(dout0_1) AT=1810.05n

.meas tran vdout0_2ck1800 FIND v(dout0_2) AT=1810.05n

.meas tran vdout0_3ck1800 FIND v(dout0_3) AT=1810.05n

.meas tran vdout0_4ck1800 FIND v(dout0_4) AT=1810.05n

.meas tran vdout0_5ck1800 FIND v(dout0_5) AT=1810.05n

.meas tran vdout0_6ck1800 FIND v(dout0_6) AT=1810.05n

.meas tran vdout0_7ck1800 FIND v(dout0_7) AT=1810.05n

.meas tran vdout0_8ck1800 FIND v(dout0_8) AT=1810.05n

.meas tran vdout0_9ck1800 FIND v(dout0_9) AT=1810.05n

.meas tran vdout0_10ck1800 FIND v(dout0_10) AT=1810.05n

.meas tran vdout0_11ck1800 FIND v(dout0_11) AT=1810.05n

.meas tran vdout0_12ck1800 FIND v(dout0_12) AT=1810.05n

.meas tran vdout0_13ck1800 FIND v(dout0_13) AT=1810.05n

.meas tran vdout0_14ck1800 FIND v(dout0_14) AT=1810.05n

.meas tran vdout0_15ck1800 FIND v(dout0_15) AT=1810.05n

.meas tran vdout0_16ck1800 FIND v(dout0_16) AT=1810.05n

.meas tran vdout0_17ck1800 FIND v(dout0_17) AT=1810.05n

.meas tran vdout0_18ck1800 FIND v(dout0_18) AT=1810.05n

.meas tran vdout0_19ck1800 FIND v(dout0_19) AT=1810.05n

.meas tran vdout0_20ck1800 FIND v(dout0_20) AT=1810.05n

.meas tran vdout0_21ck1800 FIND v(dout0_21) AT=1810.05n

.meas tran vdout0_22ck1800 FIND v(dout0_22) AT=1810.05n

.meas tran vdout0_23ck1800 FIND v(dout0_23) AT=1810.05n

.meas tran vdout0_24ck1800 FIND v(dout0_24) AT=1810.05n

.meas tran vdout0_25ck1800 FIND v(dout0_25) AT=1810.05n

.meas tran vdout0_26ck1800 FIND v(dout0_26) AT=1810.05n

.meas tran vdout0_27ck1800 FIND v(dout0_27) AT=1810.05n

.meas tran vdout0_28ck1800 FIND v(dout0_28) AT=1810.05n

.meas tran vdout0_29ck1800 FIND v(dout0_29) AT=1810.05n

.meas tran vdout0_30ck1800 FIND v(dout0_30) AT=1810.05n

.meas tran vdout0_31ck1800 FIND v(dout0_31) AT=1810.05n

.meas tran vdout1_0ck1800 FIND v(dout1_0) AT=1810.05n

.meas tran vdout1_1ck1800 FIND v(dout1_1) AT=1810.05n

.meas tran vdout1_2ck1800 FIND v(dout1_2) AT=1810.05n

.meas tran vdout1_3ck1800 FIND v(dout1_3) AT=1810.05n

.meas tran vdout1_4ck1800 FIND v(dout1_4) AT=1810.05n

.meas tran vdout1_5ck1800 FIND v(dout1_5) AT=1810.05n

.meas tran vdout1_6ck1800 FIND v(dout1_6) AT=1810.05n

.meas tran vdout1_7ck1800 FIND v(dout1_7) AT=1810.05n

.meas tran vdout1_8ck1800 FIND v(dout1_8) AT=1810.05n

.meas tran vdout1_9ck1800 FIND v(dout1_9) AT=1810.05n

.meas tran vdout1_10ck1800 FIND v(dout1_10) AT=1810.05n

.meas tran vdout1_11ck1800 FIND v(dout1_11) AT=1810.05n

.meas tran vdout1_12ck1800 FIND v(dout1_12) AT=1810.05n

.meas tran vdout1_13ck1800 FIND v(dout1_13) AT=1810.05n

.meas tran vdout1_14ck1800 FIND v(dout1_14) AT=1810.05n

.meas tran vdout1_15ck1800 FIND v(dout1_15) AT=1810.05n

.meas tran vdout1_16ck1800 FIND v(dout1_16) AT=1810.05n

.meas tran vdout1_17ck1800 FIND v(dout1_17) AT=1810.05n

.meas tran vdout1_18ck1800 FIND v(dout1_18) AT=1810.05n

.meas tran vdout1_19ck1800 FIND v(dout1_19) AT=1810.05n

.meas tran vdout1_20ck1800 FIND v(dout1_20) AT=1810.05n

.meas tran vdout1_21ck1800 FIND v(dout1_21) AT=1810.05n

.meas tran vdout1_22ck1800 FIND v(dout1_22) AT=1810.05n

.meas tran vdout1_23ck1800 FIND v(dout1_23) AT=1810.05n

.meas tran vdout1_24ck1800 FIND v(dout1_24) AT=1810.05n

.meas tran vdout1_25ck1800 FIND v(dout1_25) AT=1810.05n

.meas tran vdout1_26ck1800 FIND v(dout1_26) AT=1810.05n

.meas tran vdout1_27ck1800 FIND v(dout1_27) AT=1810.05n

.meas tran vdout1_28ck1800 FIND v(dout1_28) AT=1810.05n

.meas tran vdout1_29ck1800 FIND v(dout1_29) AT=1810.05n

.meas tran vdout1_30ck1800 FIND v(dout1_30) AT=1810.05n

.meas tran vdout1_31ck1800 FIND v(dout1_31) AT=1810.05n

.meas tran vdout0_0ck1810 FIND v(dout0_0) AT=1820.05n

.meas tran vdout0_1ck1810 FIND v(dout0_1) AT=1820.05n

.meas tran vdout0_2ck1810 FIND v(dout0_2) AT=1820.05n

.meas tran vdout0_3ck1810 FIND v(dout0_3) AT=1820.05n

.meas tran vdout0_4ck1810 FIND v(dout0_4) AT=1820.05n

.meas tran vdout0_5ck1810 FIND v(dout0_5) AT=1820.05n

.meas tran vdout0_6ck1810 FIND v(dout0_6) AT=1820.05n

.meas tran vdout0_7ck1810 FIND v(dout0_7) AT=1820.05n

.meas tran vdout0_8ck1810 FIND v(dout0_8) AT=1820.05n

.meas tran vdout0_9ck1810 FIND v(dout0_9) AT=1820.05n

.meas tran vdout0_10ck1810 FIND v(dout0_10) AT=1820.05n

.meas tran vdout0_11ck1810 FIND v(dout0_11) AT=1820.05n

.meas tran vdout0_12ck1810 FIND v(dout0_12) AT=1820.05n

.meas tran vdout0_13ck1810 FIND v(dout0_13) AT=1820.05n

.meas tran vdout0_14ck1810 FIND v(dout0_14) AT=1820.05n

.meas tran vdout0_15ck1810 FIND v(dout0_15) AT=1820.05n

.meas tran vdout0_16ck1810 FIND v(dout0_16) AT=1820.05n

.meas tran vdout0_17ck1810 FIND v(dout0_17) AT=1820.05n

.meas tran vdout0_18ck1810 FIND v(dout0_18) AT=1820.05n

.meas tran vdout0_19ck1810 FIND v(dout0_19) AT=1820.05n

.meas tran vdout0_20ck1810 FIND v(dout0_20) AT=1820.05n

.meas tran vdout0_21ck1810 FIND v(dout0_21) AT=1820.05n

.meas tran vdout0_22ck1810 FIND v(dout0_22) AT=1820.05n

.meas tran vdout0_23ck1810 FIND v(dout0_23) AT=1820.05n

.meas tran vdout0_24ck1810 FIND v(dout0_24) AT=1820.05n

.meas tran vdout0_25ck1810 FIND v(dout0_25) AT=1820.05n

.meas tran vdout0_26ck1810 FIND v(dout0_26) AT=1820.05n

.meas tran vdout0_27ck1810 FIND v(dout0_27) AT=1820.05n

.meas tran vdout0_28ck1810 FIND v(dout0_28) AT=1820.05n

.meas tran vdout0_29ck1810 FIND v(dout0_29) AT=1820.05n

.meas tran vdout0_30ck1810 FIND v(dout0_30) AT=1820.05n

.meas tran vdout0_31ck1810 FIND v(dout0_31) AT=1820.05n

.meas tran vdout0_0ck1830 FIND v(dout0_0) AT=1840.05n

.meas tran vdout0_1ck1830 FIND v(dout0_1) AT=1840.05n

.meas tran vdout0_2ck1830 FIND v(dout0_2) AT=1840.05n

.meas tran vdout0_3ck1830 FIND v(dout0_3) AT=1840.05n

.meas tran vdout0_4ck1830 FIND v(dout0_4) AT=1840.05n

.meas tran vdout0_5ck1830 FIND v(dout0_5) AT=1840.05n

.meas tran vdout0_6ck1830 FIND v(dout0_6) AT=1840.05n

.meas tran vdout0_7ck1830 FIND v(dout0_7) AT=1840.05n

.meas tran vdout0_8ck1830 FIND v(dout0_8) AT=1840.05n

.meas tran vdout0_9ck1830 FIND v(dout0_9) AT=1840.05n

.meas tran vdout0_10ck1830 FIND v(dout0_10) AT=1840.05n

.meas tran vdout0_11ck1830 FIND v(dout0_11) AT=1840.05n

.meas tran vdout0_12ck1830 FIND v(dout0_12) AT=1840.05n

.meas tran vdout0_13ck1830 FIND v(dout0_13) AT=1840.05n

.meas tran vdout0_14ck1830 FIND v(dout0_14) AT=1840.05n

.meas tran vdout0_15ck1830 FIND v(dout0_15) AT=1840.05n

.meas tran vdout0_16ck1830 FIND v(dout0_16) AT=1840.05n

.meas tran vdout0_17ck1830 FIND v(dout0_17) AT=1840.05n

.meas tran vdout0_18ck1830 FIND v(dout0_18) AT=1840.05n

.meas tran vdout0_19ck1830 FIND v(dout0_19) AT=1840.05n

.meas tran vdout0_20ck1830 FIND v(dout0_20) AT=1840.05n

.meas tran vdout0_21ck1830 FIND v(dout0_21) AT=1840.05n

.meas tran vdout0_22ck1830 FIND v(dout0_22) AT=1840.05n

.meas tran vdout0_23ck1830 FIND v(dout0_23) AT=1840.05n

.meas tran vdout0_24ck1830 FIND v(dout0_24) AT=1840.05n

.meas tran vdout0_25ck1830 FIND v(dout0_25) AT=1840.05n

.meas tran vdout0_26ck1830 FIND v(dout0_26) AT=1840.05n

.meas tran vdout0_27ck1830 FIND v(dout0_27) AT=1840.05n

.meas tran vdout0_28ck1830 FIND v(dout0_28) AT=1840.05n

.meas tran vdout0_29ck1830 FIND v(dout0_29) AT=1840.05n

.meas tran vdout0_30ck1830 FIND v(dout0_30) AT=1840.05n

.meas tran vdout0_31ck1830 FIND v(dout0_31) AT=1840.05n

.meas tran vdout0_0ck1840 FIND v(dout0_0) AT=1850.05n

.meas tran vdout0_1ck1840 FIND v(dout0_1) AT=1850.05n

.meas tran vdout0_2ck1840 FIND v(dout0_2) AT=1850.05n

.meas tran vdout0_3ck1840 FIND v(dout0_3) AT=1850.05n

.meas tran vdout0_4ck1840 FIND v(dout0_4) AT=1850.05n

.meas tran vdout0_5ck1840 FIND v(dout0_5) AT=1850.05n

.meas tran vdout0_6ck1840 FIND v(dout0_6) AT=1850.05n

.meas tran vdout0_7ck1840 FIND v(dout0_7) AT=1850.05n

.meas tran vdout0_8ck1840 FIND v(dout0_8) AT=1850.05n

.meas tran vdout0_9ck1840 FIND v(dout0_9) AT=1850.05n

.meas tran vdout0_10ck1840 FIND v(dout0_10) AT=1850.05n

.meas tran vdout0_11ck1840 FIND v(dout0_11) AT=1850.05n

.meas tran vdout0_12ck1840 FIND v(dout0_12) AT=1850.05n

.meas tran vdout0_13ck1840 FIND v(dout0_13) AT=1850.05n

.meas tran vdout0_14ck1840 FIND v(dout0_14) AT=1850.05n

.meas tran vdout0_15ck1840 FIND v(dout0_15) AT=1850.05n

.meas tran vdout0_16ck1840 FIND v(dout0_16) AT=1850.05n

.meas tran vdout0_17ck1840 FIND v(dout0_17) AT=1850.05n

.meas tran vdout0_18ck1840 FIND v(dout0_18) AT=1850.05n

.meas tran vdout0_19ck1840 FIND v(dout0_19) AT=1850.05n

.meas tran vdout0_20ck1840 FIND v(dout0_20) AT=1850.05n

.meas tran vdout0_21ck1840 FIND v(dout0_21) AT=1850.05n

.meas tran vdout0_22ck1840 FIND v(dout0_22) AT=1850.05n

.meas tran vdout0_23ck1840 FIND v(dout0_23) AT=1850.05n

.meas tran vdout0_24ck1840 FIND v(dout0_24) AT=1850.05n

.meas tran vdout0_25ck1840 FIND v(dout0_25) AT=1850.05n

.meas tran vdout0_26ck1840 FIND v(dout0_26) AT=1850.05n

.meas tran vdout0_27ck1840 FIND v(dout0_27) AT=1850.05n

.meas tran vdout0_28ck1840 FIND v(dout0_28) AT=1850.05n

.meas tran vdout0_29ck1840 FIND v(dout0_29) AT=1850.05n

.meas tran vdout0_30ck1840 FIND v(dout0_30) AT=1850.05n

.meas tran vdout0_31ck1840 FIND v(dout0_31) AT=1850.05n

.meas tran vdout1_0ck1840 FIND v(dout1_0) AT=1850.05n

.meas tran vdout1_1ck1840 FIND v(dout1_1) AT=1850.05n

.meas tran vdout1_2ck1840 FIND v(dout1_2) AT=1850.05n

.meas tran vdout1_3ck1840 FIND v(dout1_3) AT=1850.05n

.meas tran vdout1_4ck1840 FIND v(dout1_4) AT=1850.05n

.meas tran vdout1_5ck1840 FIND v(dout1_5) AT=1850.05n

.meas tran vdout1_6ck1840 FIND v(dout1_6) AT=1850.05n

.meas tran vdout1_7ck1840 FIND v(dout1_7) AT=1850.05n

.meas tran vdout1_8ck1840 FIND v(dout1_8) AT=1850.05n

.meas tran vdout1_9ck1840 FIND v(dout1_9) AT=1850.05n

.meas tran vdout1_10ck1840 FIND v(dout1_10) AT=1850.05n

.meas tran vdout1_11ck1840 FIND v(dout1_11) AT=1850.05n

.meas tran vdout1_12ck1840 FIND v(dout1_12) AT=1850.05n

.meas tran vdout1_13ck1840 FIND v(dout1_13) AT=1850.05n

.meas tran vdout1_14ck1840 FIND v(dout1_14) AT=1850.05n

.meas tran vdout1_15ck1840 FIND v(dout1_15) AT=1850.05n

.meas tran vdout1_16ck1840 FIND v(dout1_16) AT=1850.05n

.meas tran vdout1_17ck1840 FIND v(dout1_17) AT=1850.05n

.meas tran vdout1_18ck1840 FIND v(dout1_18) AT=1850.05n

.meas tran vdout1_19ck1840 FIND v(dout1_19) AT=1850.05n

.meas tran vdout1_20ck1840 FIND v(dout1_20) AT=1850.05n

.meas tran vdout1_21ck1840 FIND v(dout1_21) AT=1850.05n

.meas tran vdout1_22ck1840 FIND v(dout1_22) AT=1850.05n

.meas tran vdout1_23ck1840 FIND v(dout1_23) AT=1850.05n

.meas tran vdout1_24ck1840 FIND v(dout1_24) AT=1850.05n

.meas tran vdout1_25ck1840 FIND v(dout1_25) AT=1850.05n

.meas tran vdout1_26ck1840 FIND v(dout1_26) AT=1850.05n

.meas tran vdout1_27ck1840 FIND v(dout1_27) AT=1850.05n

.meas tran vdout1_28ck1840 FIND v(dout1_28) AT=1850.05n

.meas tran vdout1_29ck1840 FIND v(dout1_29) AT=1850.05n

.meas tran vdout1_30ck1840 FIND v(dout1_30) AT=1850.05n

.meas tran vdout1_31ck1840 FIND v(dout1_31) AT=1850.05n

.meas tran vdout0_0ck1860 FIND v(dout0_0) AT=1870.05n

.meas tran vdout0_1ck1860 FIND v(dout0_1) AT=1870.05n

.meas tran vdout0_2ck1860 FIND v(dout0_2) AT=1870.05n

.meas tran vdout0_3ck1860 FIND v(dout0_3) AT=1870.05n

.meas tran vdout0_4ck1860 FIND v(dout0_4) AT=1870.05n

.meas tran vdout0_5ck1860 FIND v(dout0_5) AT=1870.05n

.meas tran vdout0_6ck1860 FIND v(dout0_6) AT=1870.05n

.meas tran vdout0_7ck1860 FIND v(dout0_7) AT=1870.05n

.meas tran vdout0_8ck1860 FIND v(dout0_8) AT=1870.05n

.meas tran vdout0_9ck1860 FIND v(dout0_9) AT=1870.05n

.meas tran vdout0_10ck1860 FIND v(dout0_10) AT=1870.05n

.meas tran vdout0_11ck1860 FIND v(dout0_11) AT=1870.05n

.meas tran vdout0_12ck1860 FIND v(dout0_12) AT=1870.05n

.meas tran vdout0_13ck1860 FIND v(dout0_13) AT=1870.05n

.meas tran vdout0_14ck1860 FIND v(dout0_14) AT=1870.05n

.meas tran vdout0_15ck1860 FIND v(dout0_15) AT=1870.05n

.meas tran vdout0_16ck1860 FIND v(dout0_16) AT=1870.05n

.meas tran vdout0_17ck1860 FIND v(dout0_17) AT=1870.05n

.meas tran vdout0_18ck1860 FIND v(dout0_18) AT=1870.05n

.meas tran vdout0_19ck1860 FIND v(dout0_19) AT=1870.05n

.meas tran vdout0_20ck1860 FIND v(dout0_20) AT=1870.05n

.meas tran vdout0_21ck1860 FIND v(dout0_21) AT=1870.05n

.meas tran vdout0_22ck1860 FIND v(dout0_22) AT=1870.05n

.meas tran vdout0_23ck1860 FIND v(dout0_23) AT=1870.05n

.meas tran vdout0_24ck1860 FIND v(dout0_24) AT=1870.05n

.meas tran vdout0_25ck1860 FIND v(dout0_25) AT=1870.05n

.meas tran vdout0_26ck1860 FIND v(dout0_26) AT=1870.05n

.meas tran vdout0_27ck1860 FIND v(dout0_27) AT=1870.05n

.meas tran vdout0_28ck1860 FIND v(dout0_28) AT=1870.05n

.meas tran vdout0_29ck1860 FIND v(dout0_29) AT=1870.05n

.meas tran vdout0_30ck1860 FIND v(dout0_30) AT=1870.05n

.meas tran vdout0_31ck1860 FIND v(dout0_31) AT=1870.05n

.meas tran vdout1_0ck1860 FIND v(dout1_0) AT=1870.05n

.meas tran vdout1_1ck1860 FIND v(dout1_1) AT=1870.05n

.meas tran vdout1_2ck1860 FIND v(dout1_2) AT=1870.05n

.meas tran vdout1_3ck1860 FIND v(dout1_3) AT=1870.05n

.meas tran vdout1_4ck1860 FIND v(dout1_4) AT=1870.05n

.meas tran vdout1_5ck1860 FIND v(dout1_5) AT=1870.05n

.meas tran vdout1_6ck1860 FIND v(dout1_6) AT=1870.05n

.meas tran vdout1_7ck1860 FIND v(dout1_7) AT=1870.05n

.meas tran vdout1_8ck1860 FIND v(dout1_8) AT=1870.05n

.meas tran vdout1_9ck1860 FIND v(dout1_9) AT=1870.05n

.meas tran vdout1_10ck1860 FIND v(dout1_10) AT=1870.05n

.meas tran vdout1_11ck1860 FIND v(dout1_11) AT=1870.05n

.meas tran vdout1_12ck1860 FIND v(dout1_12) AT=1870.05n

.meas tran vdout1_13ck1860 FIND v(dout1_13) AT=1870.05n

.meas tran vdout1_14ck1860 FIND v(dout1_14) AT=1870.05n

.meas tran vdout1_15ck1860 FIND v(dout1_15) AT=1870.05n

.meas tran vdout1_16ck1860 FIND v(dout1_16) AT=1870.05n

.meas tran vdout1_17ck1860 FIND v(dout1_17) AT=1870.05n

.meas tran vdout1_18ck1860 FIND v(dout1_18) AT=1870.05n

.meas tran vdout1_19ck1860 FIND v(dout1_19) AT=1870.05n

.meas tran vdout1_20ck1860 FIND v(dout1_20) AT=1870.05n

.meas tran vdout1_21ck1860 FIND v(dout1_21) AT=1870.05n

.meas tran vdout1_22ck1860 FIND v(dout1_22) AT=1870.05n

.meas tran vdout1_23ck1860 FIND v(dout1_23) AT=1870.05n

.meas tran vdout1_24ck1860 FIND v(dout1_24) AT=1870.05n

.meas tran vdout1_25ck1860 FIND v(dout1_25) AT=1870.05n

.meas tran vdout1_26ck1860 FIND v(dout1_26) AT=1870.05n

.meas tran vdout1_27ck1860 FIND v(dout1_27) AT=1870.05n

.meas tran vdout1_28ck1860 FIND v(dout1_28) AT=1870.05n

.meas tran vdout1_29ck1860 FIND v(dout1_29) AT=1870.05n

.meas tran vdout1_30ck1860 FIND v(dout1_30) AT=1870.05n

.meas tran vdout1_31ck1860 FIND v(dout1_31) AT=1870.05n

.meas tran vdout0_0ck1870 FIND v(dout0_0) AT=1880.05n

.meas tran vdout0_1ck1870 FIND v(dout0_1) AT=1880.05n

.meas tran vdout0_2ck1870 FIND v(dout0_2) AT=1880.05n

.meas tran vdout0_3ck1870 FIND v(dout0_3) AT=1880.05n

.meas tran vdout0_4ck1870 FIND v(dout0_4) AT=1880.05n

.meas tran vdout0_5ck1870 FIND v(dout0_5) AT=1880.05n

.meas tran vdout0_6ck1870 FIND v(dout0_6) AT=1880.05n

.meas tran vdout0_7ck1870 FIND v(dout0_7) AT=1880.05n

.meas tran vdout0_8ck1870 FIND v(dout0_8) AT=1880.05n

.meas tran vdout0_9ck1870 FIND v(dout0_9) AT=1880.05n

.meas tran vdout0_10ck1870 FIND v(dout0_10) AT=1880.05n

.meas tran vdout0_11ck1870 FIND v(dout0_11) AT=1880.05n

.meas tran vdout0_12ck1870 FIND v(dout0_12) AT=1880.05n

.meas tran vdout0_13ck1870 FIND v(dout0_13) AT=1880.05n

.meas tran vdout0_14ck1870 FIND v(dout0_14) AT=1880.05n

.meas tran vdout0_15ck1870 FIND v(dout0_15) AT=1880.05n

.meas tran vdout0_16ck1870 FIND v(dout0_16) AT=1880.05n

.meas tran vdout0_17ck1870 FIND v(dout0_17) AT=1880.05n

.meas tran vdout0_18ck1870 FIND v(dout0_18) AT=1880.05n

.meas tran vdout0_19ck1870 FIND v(dout0_19) AT=1880.05n

.meas tran vdout0_20ck1870 FIND v(dout0_20) AT=1880.05n

.meas tran vdout0_21ck1870 FIND v(dout0_21) AT=1880.05n

.meas tran vdout0_22ck1870 FIND v(dout0_22) AT=1880.05n

.meas tran vdout0_23ck1870 FIND v(dout0_23) AT=1880.05n

.meas tran vdout0_24ck1870 FIND v(dout0_24) AT=1880.05n

.meas tran vdout0_25ck1870 FIND v(dout0_25) AT=1880.05n

.meas tran vdout0_26ck1870 FIND v(dout0_26) AT=1880.05n

.meas tran vdout0_27ck1870 FIND v(dout0_27) AT=1880.05n

.meas tran vdout0_28ck1870 FIND v(dout0_28) AT=1880.05n

.meas tran vdout0_29ck1870 FIND v(dout0_29) AT=1880.05n

.meas tran vdout0_30ck1870 FIND v(dout0_30) AT=1880.05n

.meas tran vdout0_31ck1870 FIND v(dout0_31) AT=1880.05n

.meas tran vdout0_0ck1880 FIND v(dout0_0) AT=1890.05n

.meas tran vdout0_1ck1880 FIND v(dout0_1) AT=1890.05n

.meas tran vdout0_2ck1880 FIND v(dout0_2) AT=1890.05n

.meas tran vdout0_3ck1880 FIND v(dout0_3) AT=1890.05n

.meas tran vdout0_4ck1880 FIND v(dout0_4) AT=1890.05n

.meas tran vdout0_5ck1880 FIND v(dout0_5) AT=1890.05n

.meas tran vdout0_6ck1880 FIND v(dout0_6) AT=1890.05n

.meas tran vdout0_7ck1880 FIND v(dout0_7) AT=1890.05n

.meas tran vdout0_8ck1880 FIND v(dout0_8) AT=1890.05n

.meas tran vdout0_9ck1880 FIND v(dout0_9) AT=1890.05n

.meas tran vdout0_10ck1880 FIND v(dout0_10) AT=1890.05n

.meas tran vdout0_11ck1880 FIND v(dout0_11) AT=1890.05n

.meas tran vdout0_12ck1880 FIND v(dout0_12) AT=1890.05n

.meas tran vdout0_13ck1880 FIND v(dout0_13) AT=1890.05n

.meas tran vdout0_14ck1880 FIND v(dout0_14) AT=1890.05n

.meas tran vdout0_15ck1880 FIND v(dout0_15) AT=1890.05n

.meas tran vdout0_16ck1880 FIND v(dout0_16) AT=1890.05n

.meas tran vdout0_17ck1880 FIND v(dout0_17) AT=1890.05n

.meas tran vdout0_18ck1880 FIND v(dout0_18) AT=1890.05n

.meas tran vdout0_19ck1880 FIND v(dout0_19) AT=1890.05n

.meas tran vdout0_20ck1880 FIND v(dout0_20) AT=1890.05n

.meas tran vdout0_21ck1880 FIND v(dout0_21) AT=1890.05n

.meas tran vdout0_22ck1880 FIND v(dout0_22) AT=1890.05n

.meas tran vdout0_23ck1880 FIND v(dout0_23) AT=1890.05n

.meas tran vdout0_24ck1880 FIND v(dout0_24) AT=1890.05n

.meas tran vdout0_25ck1880 FIND v(dout0_25) AT=1890.05n

.meas tran vdout0_26ck1880 FIND v(dout0_26) AT=1890.05n

.meas tran vdout0_27ck1880 FIND v(dout0_27) AT=1890.05n

.meas tran vdout0_28ck1880 FIND v(dout0_28) AT=1890.05n

.meas tran vdout0_29ck1880 FIND v(dout0_29) AT=1890.05n

.meas tran vdout0_30ck1880 FIND v(dout0_30) AT=1890.05n

.meas tran vdout0_31ck1880 FIND v(dout0_31) AT=1890.05n

.meas tran vdout1_0ck1880 FIND v(dout1_0) AT=1890.05n

.meas tran vdout1_1ck1880 FIND v(dout1_1) AT=1890.05n

.meas tran vdout1_2ck1880 FIND v(dout1_2) AT=1890.05n

.meas tran vdout1_3ck1880 FIND v(dout1_3) AT=1890.05n

.meas tran vdout1_4ck1880 FIND v(dout1_4) AT=1890.05n

.meas tran vdout1_5ck1880 FIND v(dout1_5) AT=1890.05n

.meas tran vdout1_6ck1880 FIND v(dout1_6) AT=1890.05n

.meas tran vdout1_7ck1880 FIND v(dout1_7) AT=1890.05n

.meas tran vdout1_8ck1880 FIND v(dout1_8) AT=1890.05n

.meas tran vdout1_9ck1880 FIND v(dout1_9) AT=1890.05n

.meas tran vdout1_10ck1880 FIND v(dout1_10) AT=1890.05n

.meas tran vdout1_11ck1880 FIND v(dout1_11) AT=1890.05n

.meas tran vdout1_12ck1880 FIND v(dout1_12) AT=1890.05n

.meas tran vdout1_13ck1880 FIND v(dout1_13) AT=1890.05n

.meas tran vdout1_14ck1880 FIND v(dout1_14) AT=1890.05n

.meas tran vdout1_15ck1880 FIND v(dout1_15) AT=1890.05n

.meas tran vdout1_16ck1880 FIND v(dout1_16) AT=1890.05n

.meas tran vdout1_17ck1880 FIND v(dout1_17) AT=1890.05n

.meas tran vdout1_18ck1880 FIND v(dout1_18) AT=1890.05n

.meas tran vdout1_19ck1880 FIND v(dout1_19) AT=1890.05n

.meas tran vdout1_20ck1880 FIND v(dout1_20) AT=1890.05n

.meas tran vdout1_21ck1880 FIND v(dout1_21) AT=1890.05n

.meas tran vdout1_22ck1880 FIND v(dout1_22) AT=1890.05n

.meas tran vdout1_23ck1880 FIND v(dout1_23) AT=1890.05n

.meas tran vdout1_24ck1880 FIND v(dout1_24) AT=1890.05n

.meas tran vdout1_25ck1880 FIND v(dout1_25) AT=1890.05n

.meas tran vdout1_26ck1880 FIND v(dout1_26) AT=1890.05n

.meas tran vdout1_27ck1880 FIND v(dout1_27) AT=1890.05n

.meas tran vdout1_28ck1880 FIND v(dout1_28) AT=1890.05n

.meas tran vdout1_29ck1880 FIND v(dout1_29) AT=1890.05n

.meas tran vdout1_30ck1880 FIND v(dout1_30) AT=1890.05n

.meas tran vdout1_31ck1880 FIND v(dout1_31) AT=1890.05n

.meas tran vdout1_0ck1890 FIND v(dout1_0) AT=1900.05n

.meas tran vdout1_1ck1890 FIND v(dout1_1) AT=1900.05n

.meas tran vdout1_2ck1890 FIND v(dout1_2) AT=1900.05n

.meas tran vdout1_3ck1890 FIND v(dout1_3) AT=1900.05n

.meas tran vdout1_4ck1890 FIND v(dout1_4) AT=1900.05n

.meas tran vdout1_5ck1890 FIND v(dout1_5) AT=1900.05n

.meas tran vdout1_6ck1890 FIND v(dout1_6) AT=1900.05n

.meas tran vdout1_7ck1890 FIND v(dout1_7) AT=1900.05n

.meas tran vdout1_8ck1890 FIND v(dout1_8) AT=1900.05n

.meas tran vdout1_9ck1890 FIND v(dout1_9) AT=1900.05n

.meas tran vdout1_10ck1890 FIND v(dout1_10) AT=1900.05n

.meas tran vdout1_11ck1890 FIND v(dout1_11) AT=1900.05n

.meas tran vdout1_12ck1890 FIND v(dout1_12) AT=1900.05n

.meas tran vdout1_13ck1890 FIND v(dout1_13) AT=1900.05n

.meas tran vdout1_14ck1890 FIND v(dout1_14) AT=1900.05n

.meas tran vdout1_15ck1890 FIND v(dout1_15) AT=1900.05n

.meas tran vdout1_16ck1890 FIND v(dout1_16) AT=1900.05n

.meas tran vdout1_17ck1890 FIND v(dout1_17) AT=1900.05n

.meas tran vdout1_18ck1890 FIND v(dout1_18) AT=1900.05n

.meas tran vdout1_19ck1890 FIND v(dout1_19) AT=1900.05n

.meas tran vdout1_20ck1890 FIND v(dout1_20) AT=1900.05n

.meas tran vdout1_21ck1890 FIND v(dout1_21) AT=1900.05n

.meas tran vdout1_22ck1890 FIND v(dout1_22) AT=1900.05n

.meas tran vdout1_23ck1890 FIND v(dout1_23) AT=1900.05n

.meas tran vdout1_24ck1890 FIND v(dout1_24) AT=1900.05n

.meas tran vdout1_25ck1890 FIND v(dout1_25) AT=1900.05n

.meas tran vdout1_26ck1890 FIND v(dout1_26) AT=1900.05n

.meas tran vdout1_27ck1890 FIND v(dout1_27) AT=1900.05n

.meas tran vdout1_28ck1890 FIND v(dout1_28) AT=1900.05n

.meas tran vdout1_29ck1890 FIND v(dout1_29) AT=1900.05n

.meas tran vdout1_30ck1890 FIND v(dout1_30) AT=1900.05n

.meas tran vdout1_31ck1890 FIND v(dout1_31) AT=1900.05n

.meas tran vdout0_0ck1920 FIND v(dout0_0) AT=1930.05n

.meas tran vdout0_1ck1920 FIND v(dout0_1) AT=1930.05n

.meas tran vdout0_2ck1920 FIND v(dout0_2) AT=1930.05n

.meas tran vdout0_3ck1920 FIND v(dout0_3) AT=1930.05n

.meas tran vdout0_4ck1920 FIND v(dout0_4) AT=1930.05n

.meas tran vdout0_5ck1920 FIND v(dout0_5) AT=1930.05n

.meas tran vdout0_6ck1920 FIND v(dout0_6) AT=1930.05n

.meas tran vdout0_7ck1920 FIND v(dout0_7) AT=1930.05n

.meas tran vdout0_8ck1920 FIND v(dout0_8) AT=1930.05n

.meas tran vdout0_9ck1920 FIND v(dout0_9) AT=1930.05n

.meas tran vdout0_10ck1920 FIND v(dout0_10) AT=1930.05n

.meas tran vdout0_11ck1920 FIND v(dout0_11) AT=1930.05n

.meas tran vdout0_12ck1920 FIND v(dout0_12) AT=1930.05n

.meas tran vdout0_13ck1920 FIND v(dout0_13) AT=1930.05n

.meas tran vdout0_14ck1920 FIND v(dout0_14) AT=1930.05n

.meas tran vdout0_15ck1920 FIND v(dout0_15) AT=1930.05n

.meas tran vdout0_16ck1920 FIND v(dout0_16) AT=1930.05n

.meas tran vdout0_17ck1920 FIND v(dout0_17) AT=1930.05n

.meas tran vdout0_18ck1920 FIND v(dout0_18) AT=1930.05n

.meas tran vdout0_19ck1920 FIND v(dout0_19) AT=1930.05n

.meas tran vdout0_20ck1920 FIND v(dout0_20) AT=1930.05n

.meas tran vdout0_21ck1920 FIND v(dout0_21) AT=1930.05n

.meas tran vdout0_22ck1920 FIND v(dout0_22) AT=1930.05n

.meas tran vdout0_23ck1920 FIND v(dout0_23) AT=1930.05n

.meas tran vdout0_24ck1920 FIND v(dout0_24) AT=1930.05n

.meas tran vdout0_25ck1920 FIND v(dout0_25) AT=1930.05n

.meas tran vdout0_26ck1920 FIND v(dout0_26) AT=1930.05n

.meas tran vdout0_27ck1920 FIND v(dout0_27) AT=1930.05n

.meas tran vdout0_28ck1920 FIND v(dout0_28) AT=1930.05n

.meas tran vdout0_29ck1920 FIND v(dout0_29) AT=1930.05n

.meas tran vdout0_30ck1920 FIND v(dout0_30) AT=1930.05n

.meas tran vdout0_31ck1920 FIND v(dout0_31) AT=1930.05n

.meas tran vdout1_0ck1920 FIND v(dout1_0) AT=1930.05n

.meas tran vdout1_1ck1920 FIND v(dout1_1) AT=1930.05n

.meas tran vdout1_2ck1920 FIND v(dout1_2) AT=1930.05n

.meas tran vdout1_3ck1920 FIND v(dout1_3) AT=1930.05n

.meas tran vdout1_4ck1920 FIND v(dout1_4) AT=1930.05n

.meas tran vdout1_5ck1920 FIND v(dout1_5) AT=1930.05n

.meas tran vdout1_6ck1920 FIND v(dout1_6) AT=1930.05n

.meas tran vdout1_7ck1920 FIND v(dout1_7) AT=1930.05n

.meas tran vdout1_8ck1920 FIND v(dout1_8) AT=1930.05n

.meas tran vdout1_9ck1920 FIND v(dout1_9) AT=1930.05n

.meas tran vdout1_10ck1920 FIND v(dout1_10) AT=1930.05n

.meas tran vdout1_11ck1920 FIND v(dout1_11) AT=1930.05n

.meas tran vdout1_12ck1920 FIND v(dout1_12) AT=1930.05n

.meas tran vdout1_13ck1920 FIND v(dout1_13) AT=1930.05n

.meas tran vdout1_14ck1920 FIND v(dout1_14) AT=1930.05n

.meas tran vdout1_15ck1920 FIND v(dout1_15) AT=1930.05n

.meas tran vdout1_16ck1920 FIND v(dout1_16) AT=1930.05n

.meas tran vdout1_17ck1920 FIND v(dout1_17) AT=1930.05n

.meas tran vdout1_18ck1920 FIND v(dout1_18) AT=1930.05n

.meas tran vdout1_19ck1920 FIND v(dout1_19) AT=1930.05n

.meas tran vdout1_20ck1920 FIND v(dout1_20) AT=1930.05n

.meas tran vdout1_21ck1920 FIND v(dout1_21) AT=1930.05n

.meas tran vdout1_22ck1920 FIND v(dout1_22) AT=1930.05n

.meas tran vdout1_23ck1920 FIND v(dout1_23) AT=1930.05n

.meas tran vdout1_24ck1920 FIND v(dout1_24) AT=1930.05n

.meas tran vdout1_25ck1920 FIND v(dout1_25) AT=1930.05n

.meas tran vdout1_26ck1920 FIND v(dout1_26) AT=1930.05n

.meas tran vdout1_27ck1920 FIND v(dout1_27) AT=1930.05n

.meas tran vdout1_28ck1920 FIND v(dout1_28) AT=1930.05n

.meas tran vdout1_29ck1920 FIND v(dout1_29) AT=1930.05n

.meas tran vdout1_30ck1920 FIND v(dout1_30) AT=1930.05n

.meas tran vdout1_31ck1920 FIND v(dout1_31) AT=1930.05n

.meas tran vdout1_0ck1930 FIND v(dout1_0) AT=1940.05n

.meas tran vdout1_1ck1930 FIND v(dout1_1) AT=1940.05n

.meas tran vdout1_2ck1930 FIND v(dout1_2) AT=1940.05n

.meas tran vdout1_3ck1930 FIND v(dout1_3) AT=1940.05n

.meas tran vdout1_4ck1930 FIND v(dout1_4) AT=1940.05n

.meas tran vdout1_5ck1930 FIND v(dout1_5) AT=1940.05n

.meas tran vdout1_6ck1930 FIND v(dout1_6) AT=1940.05n

.meas tran vdout1_7ck1930 FIND v(dout1_7) AT=1940.05n

.meas tran vdout1_8ck1930 FIND v(dout1_8) AT=1940.05n

.meas tran vdout1_9ck1930 FIND v(dout1_9) AT=1940.05n

.meas tran vdout1_10ck1930 FIND v(dout1_10) AT=1940.05n

.meas tran vdout1_11ck1930 FIND v(dout1_11) AT=1940.05n

.meas tran vdout1_12ck1930 FIND v(dout1_12) AT=1940.05n

.meas tran vdout1_13ck1930 FIND v(dout1_13) AT=1940.05n

.meas tran vdout1_14ck1930 FIND v(dout1_14) AT=1940.05n

.meas tran vdout1_15ck1930 FIND v(dout1_15) AT=1940.05n

.meas tran vdout1_16ck1930 FIND v(dout1_16) AT=1940.05n

.meas tran vdout1_17ck1930 FIND v(dout1_17) AT=1940.05n

.meas tran vdout1_18ck1930 FIND v(dout1_18) AT=1940.05n

.meas tran vdout1_19ck1930 FIND v(dout1_19) AT=1940.05n

.meas tran vdout1_20ck1930 FIND v(dout1_20) AT=1940.05n

.meas tran vdout1_21ck1930 FIND v(dout1_21) AT=1940.05n

.meas tran vdout1_22ck1930 FIND v(dout1_22) AT=1940.05n

.meas tran vdout1_23ck1930 FIND v(dout1_23) AT=1940.05n

.meas tran vdout1_24ck1930 FIND v(dout1_24) AT=1940.05n

.meas tran vdout1_25ck1930 FIND v(dout1_25) AT=1940.05n

.meas tran vdout1_26ck1930 FIND v(dout1_26) AT=1940.05n

.meas tran vdout1_27ck1930 FIND v(dout1_27) AT=1940.05n

.meas tran vdout1_28ck1930 FIND v(dout1_28) AT=1940.05n

.meas tran vdout1_29ck1930 FIND v(dout1_29) AT=1940.05n

.meas tran vdout1_30ck1930 FIND v(dout1_30) AT=1940.05n

.meas tran vdout1_31ck1930 FIND v(dout1_31) AT=1940.05n

.meas tran vdout0_0ck1950 FIND v(dout0_0) AT=1960.05n

.meas tran vdout0_1ck1950 FIND v(dout0_1) AT=1960.05n

.meas tran vdout0_2ck1950 FIND v(dout0_2) AT=1960.05n

.meas tran vdout0_3ck1950 FIND v(dout0_3) AT=1960.05n

.meas tran vdout0_4ck1950 FIND v(dout0_4) AT=1960.05n

.meas tran vdout0_5ck1950 FIND v(dout0_5) AT=1960.05n

.meas tran vdout0_6ck1950 FIND v(dout0_6) AT=1960.05n

.meas tran vdout0_7ck1950 FIND v(dout0_7) AT=1960.05n

.meas tran vdout0_8ck1950 FIND v(dout0_8) AT=1960.05n

.meas tran vdout0_9ck1950 FIND v(dout0_9) AT=1960.05n

.meas tran vdout0_10ck1950 FIND v(dout0_10) AT=1960.05n

.meas tran vdout0_11ck1950 FIND v(dout0_11) AT=1960.05n

.meas tran vdout0_12ck1950 FIND v(dout0_12) AT=1960.05n

.meas tran vdout0_13ck1950 FIND v(dout0_13) AT=1960.05n

.meas tran vdout0_14ck1950 FIND v(dout0_14) AT=1960.05n

.meas tran vdout0_15ck1950 FIND v(dout0_15) AT=1960.05n

.meas tran vdout0_16ck1950 FIND v(dout0_16) AT=1960.05n

.meas tran vdout0_17ck1950 FIND v(dout0_17) AT=1960.05n

.meas tran vdout0_18ck1950 FIND v(dout0_18) AT=1960.05n

.meas tran vdout0_19ck1950 FIND v(dout0_19) AT=1960.05n

.meas tran vdout0_20ck1950 FIND v(dout0_20) AT=1960.05n

.meas tran vdout0_21ck1950 FIND v(dout0_21) AT=1960.05n

.meas tran vdout0_22ck1950 FIND v(dout0_22) AT=1960.05n

.meas tran vdout0_23ck1950 FIND v(dout0_23) AT=1960.05n

.meas tran vdout0_24ck1950 FIND v(dout0_24) AT=1960.05n

.meas tran vdout0_25ck1950 FIND v(dout0_25) AT=1960.05n

.meas tran vdout0_26ck1950 FIND v(dout0_26) AT=1960.05n

.meas tran vdout0_27ck1950 FIND v(dout0_27) AT=1960.05n

.meas tran vdout0_28ck1950 FIND v(dout0_28) AT=1960.05n

.meas tran vdout0_29ck1950 FIND v(dout0_29) AT=1960.05n

.meas tran vdout0_30ck1950 FIND v(dout0_30) AT=1960.05n

.meas tran vdout0_31ck1950 FIND v(dout0_31) AT=1960.05n

.meas tran vdout0_0ck1960 FIND v(dout0_0) AT=1970.05n

.meas tran vdout0_1ck1960 FIND v(dout0_1) AT=1970.05n

.meas tran vdout0_2ck1960 FIND v(dout0_2) AT=1970.05n

.meas tran vdout0_3ck1960 FIND v(dout0_3) AT=1970.05n

.meas tran vdout0_4ck1960 FIND v(dout0_4) AT=1970.05n

.meas tran vdout0_5ck1960 FIND v(dout0_5) AT=1970.05n

.meas tran vdout0_6ck1960 FIND v(dout0_6) AT=1970.05n

.meas tran vdout0_7ck1960 FIND v(dout0_7) AT=1970.05n

.meas tran vdout0_8ck1960 FIND v(dout0_8) AT=1970.05n

.meas tran vdout0_9ck1960 FIND v(dout0_9) AT=1970.05n

.meas tran vdout0_10ck1960 FIND v(dout0_10) AT=1970.05n

.meas tran vdout0_11ck1960 FIND v(dout0_11) AT=1970.05n

.meas tran vdout0_12ck1960 FIND v(dout0_12) AT=1970.05n

.meas tran vdout0_13ck1960 FIND v(dout0_13) AT=1970.05n

.meas tran vdout0_14ck1960 FIND v(dout0_14) AT=1970.05n

.meas tran vdout0_15ck1960 FIND v(dout0_15) AT=1970.05n

.meas tran vdout0_16ck1960 FIND v(dout0_16) AT=1970.05n

.meas tran vdout0_17ck1960 FIND v(dout0_17) AT=1970.05n

.meas tran vdout0_18ck1960 FIND v(dout0_18) AT=1970.05n

.meas tran vdout0_19ck1960 FIND v(dout0_19) AT=1970.05n

.meas tran vdout0_20ck1960 FIND v(dout0_20) AT=1970.05n

.meas tran vdout0_21ck1960 FIND v(dout0_21) AT=1970.05n

.meas tran vdout0_22ck1960 FIND v(dout0_22) AT=1970.05n

.meas tran vdout0_23ck1960 FIND v(dout0_23) AT=1970.05n

.meas tran vdout0_24ck1960 FIND v(dout0_24) AT=1970.05n

.meas tran vdout0_25ck1960 FIND v(dout0_25) AT=1970.05n

.meas tran vdout0_26ck1960 FIND v(dout0_26) AT=1970.05n

.meas tran vdout0_27ck1960 FIND v(dout0_27) AT=1970.05n

.meas tran vdout0_28ck1960 FIND v(dout0_28) AT=1970.05n

.meas tran vdout0_29ck1960 FIND v(dout0_29) AT=1970.05n

.meas tran vdout0_30ck1960 FIND v(dout0_30) AT=1970.05n

.meas tran vdout0_31ck1960 FIND v(dout0_31) AT=1970.05n

.meas tran vdout0_0ck1980 FIND v(dout0_0) AT=1990.05n

.meas tran vdout0_1ck1980 FIND v(dout0_1) AT=1990.05n

.meas tran vdout0_2ck1980 FIND v(dout0_2) AT=1990.05n

.meas tran vdout0_3ck1980 FIND v(dout0_3) AT=1990.05n

.meas tran vdout0_4ck1980 FIND v(dout0_4) AT=1990.05n

.meas tran vdout0_5ck1980 FIND v(dout0_5) AT=1990.05n

.meas tran vdout0_6ck1980 FIND v(dout0_6) AT=1990.05n

.meas tran vdout0_7ck1980 FIND v(dout0_7) AT=1990.05n

.meas tran vdout0_8ck1980 FIND v(dout0_8) AT=1990.05n

.meas tran vdout0_9ck1980 FIND v(dout0_9) AT=1990.05n

.meas tran vdout0_10ck1980 FIND v(dout0_10) AT=1990.05n

.meas tran vdout0_11ck1980 FIND v(dout0_11) AT=1990.05n

.meas tran vdout0_12ck1980 FIND v(dout0_12) AT=1990.05n

.meas tran vdout0_13ck1980 FIND v(dout0_13) AT=1990.05n

.meas tran vdout0_14ck1980 FIND v(dout0_14) AT=1990.05n

.meas tran vdout0_15ck1980 FIND v(dout0_15) AT=1990.05n

.meas tran vdout0_16ck1980 FIND v(dout0_16) AT=1990.05n

.meas tran vdout0_17ck1980 FIND v(dout0_17) AT=1990.05n

.meas tran vdout0_18ck1980 FIND v(dout0_18) AT=1990.05n

.meas tran vdout0_19ck1980 FIND v(dout0_19) AT=1990.05n

.meas tran vdout0_20ck1980 FIND v(dout0_20) AT=1990.05n

.meas tran vdout0_21ck1980 FIND v(dout0_21) AT=1990.05n

.meas tran vdout0_22ck1980 FIND v(dout0_22) AT=1990.05n

.meas tran vdout0_23ck1980 FIND v(dout0_23) AT=1990.05n

.meas tran vdout0_24ck1980 FIND v(dout0_24) AT=1990.05n

.meas tran vdout0_25ck1980 FIND v(dout0_25) AT=1990.05n

.meas tran vdout0_26ck1980 FIND v(dout0_26) AT=1990.05n

.meas tran vdout0_27ck1980 FIND v(dout0_27) AT=1990.05n

.meas tran vdout0_28ck1980 FIND v(dout0_28) AT=1990.05n

.meas tran vdout0_29ck1980 FIND v(dout0_29) AT=1990.05n

.meas tran vdout0_30ck1980 FIND v(dout0_30) AT=1990.05n

.meas tran vdout0_31ck1980 FIND v(dout0_31) AT=1990.05n

.meas tran vdout1_0ck1980 FIND v(dout1_0) AT=1990.05n

.meas tran vdout1_1ck1980 FIND v(dout1_1) AT=1990.05n

.meas tran vdout1_2ck1980 FIND v(dout1_2) AT=1990.05n

.meas tran vdout1_3ck1980 FIND v(dout1_3) AT=1990.05n

.meas tran vdout1_4ck1980 FIND v(dout1_4) AT=1990.05n

.meas tran vdout1_5ck1980 FIND v(dout1_5) AT=1990.05n

.meas tran vdout1_6ck1980 FIND v(dout1_6) AT=1990.05n

.meas tran vdout1_7ck1980 FIND v(dout1_7) AT=1990.05n

.meas tran vdout1_8ck1980 FIND v(dout1_8) AT=1990.05n

.meas tran vdout1_9ck1980 FIND v(dout1_9) AT=1990.05n

.meas tran vdout1_10ck1980 FIND v(dout1_10) AT=1990.05n

.meas tran vdout1_11ck1980 FIND v(dout1_11) AT=1990.05n

.meas tran vdout1_12ck1980 FIND v(dout1_12) AT=1990.05n

.meas tran vdout1_13ck1980 FIND v(dout1_13) AT=1990.05n

.meas tran vdout1_14ck1980 FIND v(dout1_14) AT=1990.05n

.meas tran vdout1_15ck1980 FIND v(dout1_15) AT=1990.05n

.meas tran vdout1_16ck1980 FIND v(dout1_16) AT=1990.05n

.meas tran vdout1_17ck1980 FIND v(dout1_17) AT=1990.05n

.meas tran vdout1_18ck1980 FIND v(dout1_18) AT=1990.05n

.meas tran vdout1_19ck1980 FIND v(dout1_19) AT=1990.05n

.meas tran vdout1_20ck1980 FIND v(dout1_20) AT=1990.05n

.meas tran vdout1_21ck1980 FIND v(dout1_21) AT=1990.05n

.meas tran vdout1_22ck1980 FIND v(dout1_22) AT=1990.05n

.meas tran vdout1_23ck1980 FIND v(dout1_23) AT=1990.05n

.meas tran vdout1_24ck1980 FIND v(dout1_24) AT=1990.05n

.meas tran vdout1_25ck1980 FIND v(dout1_25) AT=1990.05n

.meas tran vdout1_26ck1980 FIND v(dout1_26) AT=1990.05n

.meas tran vdout1_27ck1980 FIND v(dout1_27) AT=1990.05n

.meas tran vdout1_28ck1980 FIND v(dout1_28) AT=1990.05n

.meas tran vdout1_29ck1980 FIND v(dout1_29) AT=1990.05n

.meas tran vdout1_30ck1980 FIND v(dout1_30) AT=1990.05n

.meas tran vdout1_31ck1980 FIND v(dout1_31) AT=1990.05n

.meas tran vdout0_0ck1990 FIND v(dout0_0) AT=2000.05n

.meas tran vdout0_1ck1990 FIND v(dout0_1) AT=2000.05n

.meas tran vdout0_2ck1990 FIND v(dout0_2) AT=2000.05n

.meas tran vdout0_3ck1990 FIND v(dout0_3) AT=2000.05n

.meas tran vdout0_4ck1990 FIND v(dout0_4) AT=2000.05n

.meas tran vdout0_5ck1990 FIND v(dout0_5) AT=2000.05n

.meas tran vdout0_6ck1990 FIND v(dout0_6) AT=2000.05n

.meas tran vdout0_7ck1990 FIND v(dout0_7) AT=2000.05n

.meas tran vdout0_8ck1990 FIND v(dout0_8) AT=2000.05n

.meas tran vdout0_9ck1990 FIND v(dout0_9) AT=2000.05n

.meas tran vdout0_10ck1990 FIND v(dout0_10) AT=2000.05n

.meas tran vdout0_11ck1990 FIND v(dout0_11) AT=2000.05n

.meas tran vdout0_12ck1990 FIND v(dout0_12) AT=2000.05n

.meas tran vdout0_13ck1990 FIND v(dout0_13) AT=2000.05n

.meas tran vdout0_14ck1990 FIND v(dout0_14) AT=2000.05n

.meas tran vdout0_15ck1990 FIND v(dout0_15) AT=2000.05n

.meas tran vdout0_16ck1990 FIND v(dout0_16) AT=2000.05n

.meas tran vdout0_17ck1990 FIND v(dout0_17) AT=2000.05n

.meas tran vdout0_18ck1990 FIND v(dout0_18) AT=2000.05n

.meas tran vdout0_19ck1990 FIND v(dout0_19) AT=2000.05n

.meas tran vdout0_20ck1990 FIND v(dout0_20) AT=2000.05n

.meas tran vdout0_21ck1990 FIND v(dout0_21) AT=2000.05n

.meas tran vdout0_22ck1990 FIND v(dout0_22) AT=2000.05n

.meas tran vdout0_23ck1990 FIND v(dout0_23) AT=2000.05n

.meas tran vdout0_24ck1990 FIND v(dout0_24) AT=2000.05n

.meas tran vdout0_25ck1990 FIND v(dout0_25) AT=2000.05n

.meas tran vdout0_26ck1990 FIND v(dout0_26) AT=2000.05n

.meas tran vdout0_27ck1990 FIND v(dout0_27) AT=2000.05n

.meas tran vdout0_28ck1990 FIND v(dout0_28) AT=2000.05n

.meas tran vdout0_29ck1990 FIND v(dout0_29) AT=2000.05n

.meas tran vdout0_30ck1990 FIND v(dout0_30) AT=2000.05n

.meas tran vdout0_31ck1990 FIND v(dout0_31) AT=2000.05n

.meas tran vdout1_0ck1990 FIND v(dout1_0) AT=2000.05n

.meas tran vdout1_1ck1990 FIND v(dout1_1) AT=2000.05n

.meas tran vdout1_2ck1990 FIND v(dout1_2) AT=2000.05n

.meas tran vdout1_3ck1990 FIND v(dout1_3) AT=2000.05n

.meas tran vdout1_4ck1990 FIND v(dout1_4) AT=2000.05n

.meas tran vdout1_5ck1990 FIND v(dout1_5) AT=2000.05n

.meas tran vdout1_6ck1990 FIND v(dout1_6) AT=2000.05n

.meas tran vdout1_7ck1990 FIND v(dout1_7) AT=2000.05n

.meas tran vdout1_8ck1990 FIND v(dout1_8) AT=2000.05n

.meas tran vdout1_9ck1990 FIND v(dout1_9) AT=2000.05n

.meas tran vdout1_10ck1990 FIND v(dout1_10) AT=2000.05n

.meas tran vdout1_11ck1990 FIND v(dout1_11) AT=2000.05n

.meas tran vdout1_12ck1990 FIND v(dout1_12) AT=2000.05n

.meas tran vdout1_13ck1990 FIND v(dout1_13) AT=2000.05n

.meas tran vdout1_14ck1990 FIND v(dout1_14) AT=2000.05n

.meas tran vdout1_15ck1990 FIND v(dout1_15) AT=2000.05n

.meas tran vdout1_16ck1990 FIND v(dout1_16) AT=2000.05n

.meas tran vdout1_17ck1990 FIND v(dout1_17) AT=2000.05n

.meas tran vdout1_18ck1990 FIND v(dout1_18) AT=2000.05n

.meas tran vdout1_19ck1990 FIND v(dout1_19) AT=2000.05n

.meas tran vdout1_20ck1990 FIND v(dout1_20) AT=2000.05n

.meas tran vdout1_21ck1990 FIND v(dout1_21) AT=2000.05n

.meas tran vdout1_22ck1990 FIND v(dout1_22) AT=2000.05n

.meas tran vdout1_23ck1990 FIND v(dout1_23) AT=2000.05n

.meas tran vdout1_24ck1990 FIND v(dout1_24) AT=2000.05n

.meas tran vdout1_25ck1990 FIND v(dout1_25) AT=2000.05n

.meas tran vdout1_26ck1990 FIND v(dout1_26) AT=2000.05n

.meas tran vdout1_27ck1990 FIND v(dout1_27) AT=2000.05n

.meas tran vdout1_28ck1990 FIND v(dout1_28) AT=2000.05n

.meas tran vdout1_29ck1990 FIND v(dout1_29) AT=2000.05n

.meas tran vdout1_30ck1990 FIND v(dout1_30) AT=2000.05n

.meas tran vdout1_31ck1990 FIND v(dout1_31) AT=2000.05n

.meas tran vdout1_0ck2000 FIND v(dout1_0) AT=2010.05n

.meas tran vdout1_1ck2000 FIND v(dout1_1) AT=2010.05n

.meas tran vdout1_2ck2000 FIND v(dout1_2) AT=2010.05n

.meas tran vdout1_3ck2000 FIND v(dout1_3) AT=2010.05n

.meas tran vdout1_4ck2000 FIND v(dout1_4) AT=2010.05n

.meas tran vdout1_5ck2000 FIND v(dout1_5) AT=2010.05n

.meas tran vdout1_6ck2000 FIND v(dout1_6) AT=2010.05n

.meas tran vdout1_7ck2000 FIND v(dout1_7) AT=2010.05n

.meas tran vdout1_8ck2000 FIND v(dout1_8) AT=2010.05n

.meas tran vdout1_9ck2000 FIND v(dout1_9) AT=2010.05n

.meas tran vdout1_10ck2000 FIND v(dout1_10) AT=2010.05n

.meas tran vdout1_11ck2000 FIND v(dout1_11) AT=2010.05n

.meas tran vdout1_12ck2000 FIND v(dout1_12) AT=2010.05n

.meas tran vdout1_13ck2000 FIND v(dout1_13) AT=2010.05n

.meas tran vdout1_14ck2000 FIND v(dout1_14) AT=2010.05n

.meas tran vdout1_15ck2000 FIND v(dout1_15) AT=2010.05n

.meas tran vdout1_16ck2000 FIND v(dout1_16) AT=2010.05n

.meas tran vdout1_17ck2000 FIND v(dout1_17) AT=2010.05n

.meas tran vdout1_18ck2000 FIND v(dout1_18) AT=2010.05n

.meas tran vdout1_19ck2000 FIND v(dout1_19) AT=2010.05n

.meas tran vdout1_20ck2000 FIND v(dout1_20) AT=2010.05n

.meas tran vdout1_21ck2000 FIND v(dout1_21) AT=2010.05n

.meas tran vdout1_22ck2000 FIND v(dout1_22) AT=2010.05n

.meas tran vdout1_23ck2000 FIND v(dout1_23) AT=2010.05n

.meas tran vdout1_24ck2000 FIND v(dout1_24) AT=2010.05n

.meas tran vdout1_25ck2000 FIND v(dout1_25) AT=2010.05n

.meas tran vdout1_26ck2000 FIND v(dout1_26) AT=2010.05n

.meas tran vdout1_27ck2000 FIND v(dout1_27) AT=2010.05n

.meas tran vdout1_28ck2000 FIND v(dout1_28) AT=2010.05n

.meas tran vdout1_29ck2000 FIND v(dout1_29) AT=2010.05n

.meas tran vdout1_30ck2000 FIND v(dout1_30) AT=2010.05n

.meas tran vdout1_31ck2000 FIND v(dout1_31) AT=2010.05n

.meas tran vdout0_0ck2010 FIND v(dout0_0) AT=2020.05n

.meas tran vdout0_1ck2010 FIND v(dout0_1) AT=2020.05n

.meas tran vdout0_2ck2010 FIND v(dout0_2) AT=2020.05n

.meas tran vdout0_3ck2010 FIND v(dout0_3) AT=2020.05n

.meas tran vdout0_4ck2010 FIND v(dout0_4) AT=2020.05n

.meas tran vdout0_5ck2010 FIND v(dout0_5) AT=2020.05n

.meas tran vdout0_6ck2010 FIND v(dout0_6) AT=2020.05n

.meas tran vdout0_7ck2010 FIND v(dout0_7) AT=2020.05n

.meas tran vdout0_8ck2010 FIND v(dout0_8) AT=2020.05n

.meas tran vdout0_9ck2010 FIND v(dout0_9) AT=2020.05n

.meas tran vdout0_10ck2010 FIND v(dout0_10) AT=2020.05n

.meas tran vdout0_11ck2010 FIND v(dout0_11) AT=2020.05n

.meas tran vdout0_12ck2010 FIND v(dout0_12) AT=2020.05n

.meas tran vdout0_13ck2010 FIND v(dout0_13) AT=2020.05n

.meas tran vdout0_14ck2010 FIND v(dout0_14) AT=2020.05n

.meas tran vdout0_15ck2010 FIND v(dout0_15) AT=2020.05n

.meas tran vdout0_16ck2010 FIND v(dout0_16) AT=2020.05n

.meas tran vdout0_17ck2010 FIND v(dout0_17) AT=2020.05n

.meas tran vdout0_18ck2010 FIND v(dout0_18) AT=2020.05n

.meas tran vdout0_19ck2010 FIND v(dout0_19) AT=2020.05n

.meas tran vdout0_20ck2010 FIND v(dout0_20) AT=2020.05n

.meas tran vdout0_21ck2010 FIND v(dout0_21) AT=2020.05n

.meas tran vdout0_22ck2010 FIND v(dout0_22) AT=2020.05n

.meas tran vdout0_23ck2010 FIND v(dout0_23) AT=2020.05n

.meas tran vdout0_24ck2010 FIND v(dout0_24) AT=2020.05n

.meas tran vdout0_25ck2010 FIND v(dout0_25) AT=2020.05n

.meas tran vdout0_26ck2010 FIND v(dout0_26) AT=2020.05n

.meas tran vdout0_27ck2010 FIND v(dout0_27) AT=2020.05n

.meas tran vdout0_28ck2010 FIND v(dout0_28) AT=2020.05n

.meas tran vdout0_29ck2010 FIND v(dout0_29) AT=2020.05n

.meas tran vdout0_30ck2010 FIND v(dout0_30) AT=2020.05n

.meas tran vdout0_31ck2010 FIND v(dout0_31) AT=2020.05n

.meas tran vdout1_0ck2010 FIND v(dout1_0) AT=2020.05n

.meas tran vdout1_1ck2010 FIND v(dout1_1) AT=2020.05n

.meas tran vdout1_2ck2010 FIND v(dout1_2) AT=2020.05n

.meas tran vdout1_3ck2010 FIND v(dout1_3) AT=2020.05n

.meas tran vdout1_4ck2010 FIND v(dout1_4) AT=2020.05n

.meas tran vdout1_5ck2010 FIND v(dout1_5) AT=2020.05n

.meas tran vdout1_6ck2010 FIND v(dout1_6) AT=2020.05n

.meas tran vdout1_7ck2010 FIND v(dout1_7) AT=2020.05n

.meas tran vdout1_8ck2010 FIND v(dout1_8) AT=2020.05n

.meas tran vdout1_9ck2010 FIND v(dout1_9) AT=2020.05n

.meas tran vdout1_10ck2010 FIND v(dout1_10) AT=2020.05n

.meas tran vdout1_11ck2010 FIND v(dout1_11) AT=2020.05n

.meas tran vdout1_12ck2010 FIND v(dout1_12) AT=2020.05n

.meas tran vdout1_13ck2010 FIND v(dout1_13) AT=2020.05n

.meas tran vdout1_14ck2010 FIND v(dout1_14) AT=2020.05n

.meas tran vdout1_15ck2010 FIND v(dout1_15) AT=2020.05n

.meas tran vdout1_16ck2010 FIND v(dout1_16) AT=2020.05n

.meas tran vdout1_17ck2010 FIND v(dout1_17) AT=2020.05n

.meas tran vdout1_18ck2010 FIND v(dout1_18) AT=2020.05n

.meas tran vdout1_19ck2010 FIND v(dout1_19) AT=2020.05n

.meas tran vdout1_20ck2010 FIND v(dout1_20) AT=2020.05n

.meas tran vdout1_21ck2010 FIND v(dout1_21) AT=2020.05n

.meas tran vdout1_22ck2010 FIND v(dout1_22) AT=2020.05n

.meas tran vdout1_23ck2010 FIND v(dout1_23) AT=2020.05n

.meas tran vdout1_24ck2010 FIND v(dout1_24) AT=2020.05n

.meas tran vdout1_25ck2010 FIND v(dout1_25) AT=2020.05n

.meas tran vdout1_26ck2010 FIND v(dout1_26) AT=2020.05n

.meas tran vdout1_27ck2010 FIND v(dout1_27) AT=2020.05n

.meas tran vdout1_28ck2010 FIND v(dout1_28) AT=2020.05n

.meas tran vdout1_29ck2010 FIND v(dout1_29) AT=2020.05n

.meas tran vdout1_30ck2010 FIND v(dout1_30) AT=2020.05n

.meas tran vdout1_31ck2010 FIND v(dout1_31) AT=2020.05n

.meas tran vdout0_0ck2020 FIND v(dout0_0) AT=2030.05n

.meas tran vdout0_1ck2020 FIND v(dout0_1) AT=2030.05n

.meas tran vdout0_2ck2020 FIND v(dout0_2) AT=2030.05n

.meas tran vdout0_3ck2020 FIND v(dout0_3) AT=2030.05n

.meas tran vdout0_4ck2020 FIND v(dout0_4) AT=2030.05n

.meas tran vdout0_5ck2020 FIND v(dout0_5) AT=2030.05n

.meas tran vdout0_6ck2020 FIND v(dout0_6) AT=2030.05n

.meas tran vdout0_7ck2020 FIND v(dout0_7) AT=2030.05n

.meas tran vdout0_8ck2020 FIND v(dout0_8) AT=2030.05n

.meas tran vdout0_9ck2020 FIND v(dout0_9) AT=2030.05n

.meas tran vdout0_10ck2020 FIND v(dout0_10) AT=2030.05n

.meas tran vdout0_11ck2020 FIND v(dout0_11) AT=2030.05n

.meas tran vdout0_12ck2020 FIND v(dout0_12) AT=2030.05n

.meas tran vdout0_13ck2020 FIND v(dout0_13) AT=2030.05n

.meas tran vdout0_14ck2020 FIND v(dout0_14) AT=2030.05n

.meas tran vdout0_15ck2020 FIND v(dout0_15) AT=2030.05n

.meas tran vdout0_16ck2020 FIND v(dout0_16) AT=2030.05n

.meas tran vdout0_17ck2020 FIND v(dout0_17) AT=2030.05n

.meas tran vdout0_18ck2020 FIND v(dout0_18) AT=2030.05n

.meas tran vdout0_19ck2020 FIND v(dout0_19) AT=2030.05n

.meas tran vdout0_20ck2020 FIND v(dout0_20) AT=2030.05n

.meas tran vdout0_21ck2020 FIND v(dout0_21) AT=2030.05n

.meas tran vdout0_22ck2020 FIND v(dout0_22) AT=2030.05n

.meas tran vdout0_23ck2020 FIND v(dout0_23) AT=2030.05n

.meas tran vdout0_24ck2020 FIND v(dout0_24) AT=2030.05n

.meas tran vdout0_25ck2020 FIND v(dout0_25) AT=2030.05n

.meas tran vdout0_26ck2020 FIND v(dout0_26) AT=2030.05n

.meas tran vdout0_27ck2020 FIND v(dout0_27) AT=2030.05n

.meas tran vdout0_28ck2020 FIND v(dout0_28) AT=2030.05n

.meas tran vdout0_29ck2020 FIND v(dout0_29) AT=2030.05n

.meas tran vdout0_30ck2020 FIND v(dout0_30) AT=2030.05n

.meas tran vdout0_31ck2020 FIND v(dout0_31) AT=2030.05n

.meas tran vdout1_0ck2020 FIND v(dout1_0) AT=2030.05n

.meas tran vdout1_1ck2020 FIND v(dout1_1) AT=2030.05n

.meas tran vdout1_2ck2020 FIND v(dout1_2) AT=2030.05n

.meas tran vdout1_3ck2020 FIND v(dout1_3) AT=2030.05n

.meas tran vdout1_4ck2020 FIND v(dout1_4) AT=2030.05n

.meas tran vdout1_5ck2020 FIND v(dout1_5) AT=2030.05n

.meas tran vdout1_6ck2020 FIND v(dout1_6) AT=2030.05n

.meas tran vdout1_7ck2020 FIND v(dout1_7) AT=2030.05n

.meas tran vdout1_8ck2020 FIND v(dout1_8) AT=2030.05n

.meas tran vdout1_9ck2020 FIND v(dout1_9) AT=2030.05n

.meas tran vdout1_10ck2020 FIND v(dout1_10) AT=2030.05n

.meas tran vdout1_11ck2020 FIND v(dout1_11) AT=2030.05n

.meas tran vdout1_12ck2020 FIND v(dout1_12) AT=2030.05n

.meas tran vdout1_13ck2020 FIND v(dout1_13) AT=2030.05n

.meas tran vdout1_14ck2020 FIND v(dout1_14) AT=2030.05n

.meas tran vdout1_15ck2020 FIND v(dout1_15) AT=2030.05n

.meas tran vdout1_16ck2020 FIND v(dout1_16) AT=2030.05n

.meas tran vdout1_17ck2020 FIND v(dout1_17) AT=2030.05n

.meas tran vdout1_18ck2020 FIND v(dout1_18) AT=2030.05n

.meas tran vdout1_19ck2020 FIND v(dout1_19) AT=2030.05n

.meas tran vdout1_20ck2020 FIND v(dout1_20) AT=2030.05n

.meas tran vdout1_21ck2020 FIND v(dout1_21) AT=2030.05n

.meas tran vdout1_22ck2020 FIND v(dout1_22) AT=2030.05n

.meas tran vdout1_23ck2020 FIND v(dout1_23) AT=2030.05n

.meas tran vdout1_24ck2020 FIND v(dout1_24) AT=2030.05n

.meas tran vdout1_25ck2020 FIND v(dout1_25) AT=2030.05n

.meas tran vdout1_26ck2020 FIND v(dout1_26) AT=2030.05n

.meas tran vdout1_27ck2020 FIND v(dout1_27) AT=2030.05n

.meas tran vdout1_28ck2020 FIND v(dout1_28) AT=2030.05n

.meas tran vdout1_29ck2020 FIND v(dout1_29) AT=2030.05n

.meas tran vdout1_30ck2020 FIND v(dout1_30) AT=2030.05n

.meas tran vdout1_31ck2020 FIND v(dout1_31) AT=2030.05n

.meas tran vdout0_0ck2030 FIND v(dout0_0) AT=2040.05n

.meas tran vdout0_1ck2030 FIND v(dout0_1) AT=2040.05n

.meas tran vdout0_2ck2030 FIND v(dout0_2) AT=2040.05n

.meas tran vdout0_3ck2030 FIND v(dout0_3) AT=2040.05n

.meas tran vdout0_4ck2030 FIND v(dout0_4) AT=2040.05n

.meas tran vdout0_5ck2030 FIND v(dout0_5) AT=2040.05n

.meas tran vdout0_6ck2030 FIND v(dout0_6) AT=2040.05n

.meas tran vdout0_7ck2030 FIND v(dout0_7) AT=2040.05n

.meas tran vdout0_8ck2030 FIND v(dout0_8) AT=2040.05n

.meas tran vdout0_9ck2030 FIND v(dout0_9) AT=2040.05n

.meas tran vdout0_10ck2030 FIND v(dout0_10) AT=2040.05n

.meas tran vdout0_11ck2030 FIND v(dout0_11) AT=2040.05n

.meas tran vdout0_12ck2030 FIND v(dout0_12) AT=2040.05n

.meas tran vdout0_13ck2030 FIND v(dout0_13) AT=2040.05n

.meas tran vdout0_14ck2030 FIND v(dout0_14) AT=2040.05n

.meas tran vdout0_15ck2030 FIND v(dout0_15) AT=2040.05n

.meas tran vdout0_16ck2030 FIND v(dout0_16) AT=2040.05n

.meas tran vdout0_17ck2030 FIND v(dout0_17) AT=2040.05n

.meas tran vdout0_18ck2030 FIND v(dout0_18) AT=2040.05n

.meas tran vdout0_19ck2030 FIND v(dout0_19) AT=2040.05n

.meas tran vdout0_20ck2030 FIND v(dout0_20) AT=2040.05n

.meas tran vdout0_21ck2030 FIND v(dout0_21) AT=2040.05n

.meas tran vdout0_22ck2030 FIND v(dout0_22) AT=2040.05n

.meas tran vdout0_23ck2030 FIND v(dout0_23) AT=2040.05n

.meas tran vdout0_24ck2030 FIND v(dout0_24) AT=2040.05n

.meas tran vdout0_25ck2030 FIND v(dout0_25) AT=2040.05n

.meas tran vdout0_26ck2030 FIND v(dout0_26) AT=2040.05n

.meas tran vdout0_27ck2030 FIND v(dout0_27) AT=2040.05n

.meas tran vdout0_28ck2030 FIND v(dout0_28) AT=2040.05n

.meas tran vdout0_29ck2030 FIND v(dout0_29) AT=2040.05n

.meas tran vdout0_30ck2030 FIND v(dout0_30) AT=2040.05n

.meas tran vdout0_31ck2030 FIND v(dout0_31) AT=2040.05n

.meas tran vdout0_0ck2040 FIND v(dout0_0) AT=2050.05n

.meas tran vdout0_1ck2040 FIND v(dout0_1) AT=2050.05n

.meas tran vdout0_2ck2040 FIND v(dout0_2) AT=2050.05n

.meas tran vdout0_3ck2040 FIND v(dout0_3) AT=2050.05n

.meas tran vdout0_4ck2040 FIND v(dout0_4) AT=2050.05n

.meas tran vdout0_5ck2040 FIND v(dout0_5) AT=2050.05n

.meas tran vdout0_6ck2040 FIND v(dout0_6) AT=2050.05n

.meas tran vdout0_7ck2040 FIND v(dout0_7) AT=2050.05n

.meas tran vdout0_8ck2040 FIND v(dout0_8) AT=2050.05n

.meas tran vdout0_9ck2040 FIND v(dout0_9) AT=2050.05n

.meas tran vdout0_10ck2040 FIND v(dout0_10) AT=2050.05n

.meas tran vdout0_11ck2040 FIND v(dout0_11) AT=2050.05n

.meas tran vdout0_12ck2040 FIND v(dout0_12) AT=2050.05n

.meas tran vdout0_13ck2040 FIND v(dout0_13) AT=2050.05n

.meas tran vdout0_14ck2040 FIND v(dout0_14) AT=2050.05n

.meas tran vdout0_15ck2040 FIND v(dout0_15) AT=2050.05n

.meas tran vdout0_16ck2040 FIND v(dout0_16) AT=2050.05n

.meas tran vdout0_17ck2040 FIND v(dout0_17) AT=2050.05n

.meas tran vdout0_18ck2040 FIND v(dout0_18) AT=2050.05n

.meas tran vdout0_19ck2040 FIND v(dout0_19) AT=2050.05n

.meas tran vdout0_20ck2040 FIND v(dout0_20) AT=2050.05n

.meas tran vdout0_21ck2040 FIND v(dout0_21) AT=2050.05n

.meas tran vdout0_22ck2040 FIND v(dout0_22) AT=2050.05n

.meas tran vdout0_23ck2040 FIND v(dout0_23) AT=2050.05n

.meas tran vdout0_24ck2040 FIND v(dout0_24) AT=2050.05n

.meas tran vdout0_25ck2040 FIND v(dout0_25) AT=2050.05n

.meas tran vdout0_26ck2040 FIND v(dout0_26) AT=2050.05n

.meas tran vdout0_27ck2040 FIND v(dout0_27) AT=2050.05n

.meas tran vdout0_28ck2040 FIND v(dout0_28) AT=2050.05n

.meas tran vdout0_29ck2040 FIND v(dout0_29) AT=2050.05n

.meas tran vdout0_30ck2040 FIND v(dout0_30) AT=2050.05n

.meas tran vdout0_31ck2040 FIND v(dout0_31) AT=2050.05n
