* Functional test stimulus file for 10ns period

* TT process corner
.lib "/home/lukas/Projects/pdks/sky130A/libs.tech/ngspice/sky130.lib.spice" tt
.include "/tmp/openram_lukas_91067_temp/sram.sp"

* Global Power Supplies
Vvdd vdd 0 1.8

*Nodes gnd and 0 are the same global ground node in ngspice/hspice/xa. Otherwise, this source may be needed.
*Vgnd gnd 0 0.0

* Instantiation of the SRAM
Xsram_1rw1r_32x16 din0_0 din0_1 din0_2 din0_3 din0_4 din0_5 din0_6 din0_7 din0_8 din0_9 din0_10 din0_11 din0_12 din0_13 din0_14 din0_15 din0_16 din0_17 din0_18 din0_19 din0_20 din0_21 din0_22 din0_23 din0_24 din0_25 din0_26 din0_27 din0_28 din0_29 din0_30 din0_31 a0_0 a0_1 a0_2 a0_3 a1_0 a1_1 a1_2 a1_3 CSB0 CSB1 WEB0 clk0 clk1 dout0_0 dout0_1 dout0_2 dout0_3 dout0_4 dout0_5 dout0_6 dout0_7 dout0_8 dout0_9 dout0_10 dout0_11 dout0_12 dout0_13 dout0_14 dout0_15 dout0_16 dout0_17 dout0_18 dout0_19 dout0_20 dout0_21 dout0_22 dout0_23 dout0_24 dout0_25 dout0_26 dout0_27 dout0_28 dout0_29 dout0_30 dout0_31 dout1_0 dout1_1 dout1_2 dout1_3 dout1_4 dout1_5 dout1_6 dout1_7 dout1_8 dout1_9 dout1_10 dout1_11 dout1_12 dout1_13 dout1_14 dout1_15 dout1_16 dout1_17 dout1_18 dout1_19 dout1_20 dout1_21 dout1_22 dout1_23 dout1_24 dout1_25 dout1_26 dout1_27 dout1_28 dout1_29 dout1_30 dout1_31 vdd gnd sram_1rw1r_32x16

* SRAM output loads
CD00 dout0_0  0 27.56f
CD01 dout0_1  0 27.56f
CD02 dout0_2  0 27.56f
CD03 dout0_3  0 27.56f
CD04 dout0_4  0 27.56f
CD05 dout0_5  0 27.56f
CD06 dout0_6  0 27.56f
CD07 dout0_7  0 27.56f
CD08 dout0_8  0 27.56f
CD09 dout0_9  0 27.56f
CD010 dout0_10  0 27.56f
CD011 dout0_11  0 27.56f
CD012 dout0_12  0 27.56f
CD013 dout0_13  0 27.56f
CD014 dout0_14  0 27.56f
CD015 dout0_15  0 27.56f
CD016 dout0_16  0 27.56f
CD017 dout0_17  0 27.56f
CD018 dout0_18  0 27.56f
CD019 dout0_19  0 27.56f
CD020 dout0_20  0 27.56f
CD021 dout0_21  0 27.56f
CD022 dout0_22  0 27.56f
CD023 dout0_23  0 27.56f
CD024 dout0_24  0 27.56f
CD025 dout0_25  0 27.56f
CD026 dout0_26  0 27.56f
CD027 dout0_27  0 27.56f
CD028 dout0_28  0 27.56f
CD029 dout0_29  0 27.56f
CD030 dout0_30  0 27.56f
CD031 dout0_31  0 27.56f
CD10 dout1_0  0 27.56f
CD11 dout1_1  0 27.56f
CD12 dout1_2  0 27.56f
CD13 dout1_3  0 27.56f
CD14 dout1_4  0 27.56f
CD15 dout1_5  0 27.56f
CD16 dout1_6  0 27.56f
CD17 dout1_7  0 27.56f
CD18 dout1_8  0 27.56f
CD19 dout1_9  0 27.56f
CD110 dout1_10  0 27.56f
CD111 dout1_11  0 27.56f
CD112 dout1_12  0 27.56f
CD113 dout1_13  0 27.56f
CD114 dout1_14  0 27.56f
CD115 dout1_15  0 27.56f
CD116 dout1_16  0 27.56f
CD117 dout1_17  0 27.56f
CD118 dout1_18  0 27.56f
CD119 dout1_19  0 27.56f
CD120 dout1_20  0 27.56f
CD121 dout1_21  0 27.56f
CD122 dout1_22  0 27.56f
CD123 dout1_23  0 27.56f
CD124 dout1_24  0 27.56f
CD125 dout1_25  0 27.56f
CD126 dout1_26  0 27.56f
CD127 dout1_27  0 27.56f
CD128 dout1_28  0 27.56f
CD129 dout1_29  0 27.56f
CD130 dout1_30  0 27.56f
CD131 dout1_31  0 27.56f

* Important signals for debug
* bl:	xsram:xbank0:bl_0_1
* br:	xsram:xbank0:br_0_1
* s_en:	xsram:s_en
* q:	xsram:xbank0:xbitcell_array:xbitcell_array:xbit_r0_c0.Q
* qbar:	xsram:xbank0:xbitcell_array:xbitcell_array:xbit_r0_c0.Q_bar

* Sequence of operations
*	Idle during cycle 0 (0ns - 10ns)
*	Writing 00101111100111111011010010001000  to  address 0000 (from port 0) during cycle 1 (10ns - 20ns)
*	Writing 00010001011010010000111110000000  to  address 0000 (from port 0) during cycle 2 (20ns - 30ns)
*	Writing 00110101101101110010111010110100  to  address 0000 (from port 0) during cycle 3 (30ns - 40ns)
*	Reading 00110101101101110010111010110100 from address 0000 (from port 0) during cycle 4 (40ns - 50ns)
*	Reading 00110101101101110010111010110100 from address 0000 (from port 1) during cycle 4 (40ns - 50ns)
*	Reading 00110101101101110010111010110100 from address 0000 (from port 1) during cycle 5 (50ns - 60ns)
*	Reading 00110101101101110010111010110100 from address 0000 (from port 0) during cycle 6 (60ns - 70ns)
*	Reading 00110101101101110010111010110100 from address 0000 (from port 1) during cycle 6 (60ns - 70ns)
*	Reading 00110101101101110010111010110100 from address 0000 (from port 1) during cycle 7 (70ns - 80ns)
*	Writing 01011101001110110110000101101101  to  address 1110 (from port 0) during cycle 9 (90ns - 100ns)
*	Writing 10101010110010000101101101111110  to  address 1110 (from port 0) during cycle 10 (100ns - 110ns)
*	Reading 10101010110010000101101101111110 from address 1110 (from port 0) during cycle 11 (110ns - 120ns)
*	Reading 00110101101101110010111010110100 from address 0000 (from port 1) during cycle 11 (110ns - 120ns)
*	Writing 10010010101111001110100011010110  to  address 0000 (from port 0) during cycle 12 (120ns - 130ns)
*	Reading 10010010101111001110100011010110 from address 0000 (from port 0) during cycle 13 (130ns - 140ns)
*	Reading 10101010110010000101101101111110 from address 1110 (from port 0) during cycle 15 (150ns - 160ns)
*	Reading 10101010110010000101101101111110 from address 1110 (from port 0) during cycle 16 (160ns - 170ns)
*	Reading 10101010110010000101101101111110 from address 1110 (from port 1) during cycle 16 (160ns - 170ns)
*	Reading 10010010101111001110100011010110 from address 0000 (from port 1) during cycle 17 (170ns - 180ns)
*	Writing 01000001000101010011110011011001  to  address 0000 (from port 0) during cycle 18 (180ns - 190ns)
*	Writing 11000001101100101101000010100101  to  address 1110 (from port 0) during cycle 20 (200ns - 210ns)
*	Reading 01000001000101010011110011011001 from address 0000 (from port 1) during cycle 22 (220ns - 230ns)
*	Writing 00100111001000001111001001010110  to  address 1110 (from port 0) during cycle 23 (230ns - 240ns)
*	Writing 11110010101110100001011100000100  to  address 1110 (from port 0) during cycle 24 (240ns - 250ns)
*	Reading 01000001000101010011110011011001 from address 0000 (from port 1) during cycle 24 (240ns - 250ns)
*	Reading 11110010101110100001011100000100 from address 1110 (from port 0) during cycle 28 (280ns - 290ns)
*	Writing 11000111001000110011001001100101  to  address 1110 (from port 0) during cycle 29 (290ns - 300ns)
*	Writing 11110011101011011100010100101001  to  address 0000 (from port 0) during cycle 30 (300ns - 310ns)
*	Reading 11000111001000110011001001100101 from address 1110 (from port 1) during cycle 30 (300ns - 310ns)
*	Reading 11110011101011011100010100101001 from address 0000 (from port 1) during cycle 31 (310ns - 320ns)
*	Writing 00011101010101001011111111010011  to  address 1110 (from port 0) during cycle 33 (330ns - 340ns)
*	Reading 11110011101011011100010100101001 from address 0000 (from port 0) during cycle 34 (340ns - 350ns)
*	Reading 00011101010101001011111111010011 from address 1110 (from port 0) during cycle 35 (350ns - 360ns)
*	Reading 00011101010101001011111111010011 from address 1110 (from port 1) during cycle 35 (350ns - 360ns)
*	Writing 01111101100001000111111100100100  to  address 1110 (from port 0) during cycle 36 (360ns - 370ns)
*	Writing 11110001010011101100100100101000  to  address 1110 (from port 0) during cycle 37 (370ns - 380ns)
*	Reading 11110011101011011100010100101001 from address 0000 (from port 0) during cycle 38 (380ns - 390ns)
*	Reading 11110011101011011100010100101001 from address 0000 (from port 0) during cycle 39 (390ns - 400ns)
*	Reading 11110001010011101100100100101000 from address 1110 (from port 1) during cycle 39 (390ns - 400ns)
*	Reading 11110001010011101100100100101000 from address 1110 (from port 0) during cycle 40 (400ns - 410ns)
*	Reading 11110011101011011100010100101001 from address 0000 (from port 1) during cycle 40 (400ns - 410ns)
*	Reading 11110001010011101100100100101000 from address 1110 (from port 1) during cycle 41 (410ns - 420ns)
*	Reading 11110011101011011100010100101001 from address 0000 (from port 0) during cycle 42 (420ns - 430ns)
*	Reading 11110011101011011100010100101001 from address 0000 (from port 1) during cycle 42 (420ns - 430ns)
*	Reading 11110001010011101100100100101000 from address 1110 (from port 0) during cycle 43 (430ns - 440ns)
*	Reading 11110011101011011100010100101001 from address 0000 (from port 1) during cycle 44 (440ns - 450ns)
*	Writing 11011100000010010000011110000111  to  address 1110 (from port 0) during cycle 46 (460ns - 470ns)
*	Writing 10001110011010111111000110010001  to  address 0000 (from port 0) during cycle 47 (470ns - 480ns)
*	Reading 10001110011010111111000110010001 from address 0000 (from port 1) during cycle 48 (480ns - 490ns)
*	Reading 11011100000010010000011110000111 from address 1110 (from port 0) during cycle 49 (490ns - 500ns)
*	Reading 10001110011010111111000110010001 from address 0000 (from port 0) during cycle 50 (500ns - 510ns)
*	Reading 10001110011010111111000110010001 from address 0000 (from port 1) during cycle 50 (500ns - 510ns)
*	Reading 10001110011010111111000110010001 from address 0000 (from port 1) during cycle 51 (510ns - 520ns)
*	Reading 11011100000010010000011110000111 from address 1110 (from port 0) during cycle 53 (530ns - 540ns)
*	Reading 11011100000010010000011110000111 from address 1110 (from port 1) during cycle 53 (530ns - 540ns)
*	Reading 11011100000010010000011110000111 from address 1110 (from port 0) during cycle 54 (540ns - 550ns)
*	Reading 11011100000010010000011110000111 from address 1110 (from port 1) during cycle 54 (540ns - 550ns)
*	Reading 11011100000010010000011110000111 from address 1110 (from port 0) during cycle 55 (550ns - 560ns)
*	Reading 11011100000010010000011110000111 from address 1110 (from port 1) during cycle 55 (550ns - 560ns)
*	Writing 01111000011100100100011100100110  to  address 1110 (from port 0) during cycle 56 (560ns - 570ns)
*	Reading 10001110011010111111000110010001 from address 0000 (from port 1) during cycle 56 (560ns - 570ns)
*	Reading 10001110011010111111000110010001 from address 0000 (from port 0) during cycle 58 (580ns - 590ns)
*	Reading 01111000011100100100011100100110 from address 1110 (from port 0) during cycle 59 (590ns - 600ns)
*	Reading 10001110011010111111000110010001 from address 0000 (from port 1) during cycle 59 (590ns - 600ns)
*	Reading 10001110011010111111000110010001 from address 0000 (from port 0) during cycle 60 (600ns - 610ns)
*	Reading 01111000011100100100011100100110 from address 1110 (from port 0) during cycle 61 (610ns - 620ns)
*	Reading 01111000011100100100011100100110 from address 1110 (from port 0) during cycle 63 (630ns - 640ns)
*	Writing 10001110001010010111100110111010  to  address 0000 (from port 0) during cycle 64 (640ns - 650ns)
*	Reading 01111000011100100100011100100110 from address 1110 (from port 1) during cycle 65 (650ns - 660ns)
*	Writing 11101010111010000111110000010010  to  address 1110 (from port 0) during cycle 66 (660ns - 670ns)
*	Reading 10001110001010010111100110111010 from address 0000 (from port 0) during cycle 67 (670ns - 680ns)
*	Writing 00111100100000100001110011110011  to  address 0000 (from port 0) during cycle 68 (680ns - 690ns)
*	Reading 11101010111010000111110000010010 from address 1110 (from port 1) during cycle 68 (680ns - 690ns)
*	Reading 11101010111010000111110000010010 from address 1110 (from port 0) during cycle 69 (690ns - 700ns)
*	Writing 00111010110010100010001011000111  to  address 0000 (from port 0) during cycle 70 (700ns - 710ns)
*	Reading 00111010110010100010001011000111 from address 0000 (from port 0) during cycle 72 (720ns - 730ns)
*	Reading 00111010110010100010001011000111 from address 0000 (from port 1) during cycle 73 (730ns - 740ns)
*	Writing 11011110011111010010010110010010  to  address 1110 (from port 0) during cycle 74 (740ns - 750ns)
*	Reading 00111010110010100010001011000111 from address 0000 (from port 1) during cycle 75 (750ns - 760ns)
*	Writing 00010011011000011001000010010010  to  address 0000 (from port 0) during cycle 76 (760ns - 770ns)
*	Reading 00010011011000011001000010010010 from address 0000 (from port 1) during cycle 77 (770ns - 780ns)
*	Reading 00010011011000011001000010010010 from address 0000 (from port 0) during cycle 78 (780ns - 790ns)
*	Reading 11011110011111010010010110010010 from address 1110 (from port 1) during cycle 78 (780ns - 790ns)
*	Reading 11011110011111010010010110010010 from address 1110 (from port 0) during cycle 79 (790ns - 800ns)
*	Reading 11011110011111010010010110010010 from address 1110 (from port 1) during cycle 79 (790ns - 800ns)
*	Writing 00111001111011001111011110000011  to  address 0000 (from port 0) during cycle 81 (810ns - 820ns)
*	Reading 11011110011111010010010110010010 from address 1110 (from port 0) during cycle 82 (820ns - 830ns)
*	Reading 00111001111011001111011110000011 from address 0000 (from port 1) during cycle 82 (820ns - 830ns)
*	Reading 00111001111011001111011110000011 from address 0000 (from port 0) during cycle 84 (840ns - 850ns)
*	Reading 11011110011111010010010110010010 from address 1110 (from port 1) during cycle 84 (840ns - 850ns)
*	Reading 11011110011111010010010110010010 from address 1110 (from port 0) during cycle 85 (850ns - 860ns)
*	Reading 11011110011111010010010110010010 from address 1110 (from port 1) during cycle 85 (850ns - 860ns)
*	Writing 00011110101001100100111101111010  to  address 0000 (from port 0) during cycle 86 (860ns - 870ns)
*	Writing 10011000001110011011101011011101  to  address 0000 (from port 0) during cycle 87 (870ns - 880ns)
*	Reading 11011110011111010010010110010010 from address 1110 (from port 0) during cycle 88 (880ns - 890ns)
*	Reading 11011110011111010010010110010010 from address 1110 (from port 1) during cycle 88 (880ns - 890ns)
*	Reading 10011000001110011011101011011101 from address 0000 (from port 0) during cycle 89 (890ns - 900ns)
*	Reading 10011000001110011011101011011101 from address 0000 (from port 1) during cycle 90 (900ns - 910ns)
*	Reading 11011110011111010010010110010010 from address 1110 (from port 0) during cycle 92 (920ns - 930ns)
*	Reading 11011110011111010010010110010010 from address 1110 (from port 1) during cycle 92 (920ns - 930ns)
*	Writing 01000001111010001101001000011101  to  address 1110 (from port 0) during cycle 93 (930ns - 940ns)
*	Writing 01110000110011001111100100011000  to  address 1110 (from port 0) during cycle 94 (940ns - 950ns)
*	Writing 00101001001101111001111000000011  to  address 1110 (from port 0) during cycle 96 (960ns - 970ns)
*	Reading 10011000001110011011101011011101 from address 0000 (from port 0) during cycle 97 (970ns - 980ns)
*	Reading 00101001001101111001111000000011 from address 1110 (from port 0) during cycle 98 (980ns - 990ns)
*	Reading 00101001001101111001111000000011 from address 1110 (from port 0) during cycle 99 (990ns - 1000ns)
*	Reading 10011000001110011011101011011101 from address 0000 (from port 1) during cycle 99 (990ns - 1000ns)
*	Reading 10011000001110011011101011011101 from address 0000 (from port 1) during cycle 101 (1010ns - 1020ns)
*	Reading 00101001001101111001111000000011 from address 1110 (from port 0) during cycle 102 (1020ns - 1030ns)
*	Reading 00101001001101111001111000000011 from address 1110 (from port 1) during cycle 102 (1020ns - 1030ns)
*	Reading 00101001001101111001111000000011 from address 1110 (from port 1) during cycle 104 (1040ns - 1050ns)
*	Writing 11010111110101010110000010000011  to  address 0000 (from port 0) during cycle 105 (1050ns - 1060ns)
*	Writing 01111100110000100101010101101000  to  address 0000 (from port 0) during cycle 106 (1060ns - 1070ns)
*	Reading 00101001001101111001111000000011 from address 1110 (from port 0) during cycle 108 (1080ns - 1090ns)
*	Writing 10110101100010110100110111100001  to  address 1110 (from port 0) during cycle 109 (1090ns - 1100ns)
*	Reading 01111100110000100101010101101000 from address 0000 (from port 0) during cycle 110 (1100ns - 1110ns)
*	Reading 01111100110000100101010101101000 from address 0000 (from port 0) during cycle 111 (1110ns - 1120ns)
*	Reading 01111100110000100101010101101000 from address 0000 (from port 1) during cycle 111 (1110ns - 1120ns)
*	Reading 10110101100010110100110111100001 from address 1110 (from port 0) during cycle 112 (1120ns - 1130ns)
*	Reading 01111100110000100101010101101000 from address 0000 (from port 0) during cycle 113 (1130ns - 1140ns)
*	Reading 01111100110000100101010101101000 from address 0000 (from port 1) during cycle 113 (1130ns - 1140ns)
*	Writing 01110010000000001100001111000011  to  address 0000 (from port 0) during cycle 114 (1140ns - 1150ns)
*	Writing 01011010110011010010111011100110  to  address 0000 (from port 0) during cycle 116 (1160ns - 1170ns)
*	Reading 10110101100010110100110111100001 from address 1110 (from port 0) during cycle 117 (1170ns - 1180ns)
*	Reading 01011010110011010010111011100110 from address 0000 (from port 1) during cycle 117 (1170ns - 1180ns)
*	Reading 01011010110011010010111011100110 from address 0000 (from port 0) during cycle 118 (1180ns - 1190ns)
*	Reading 10110101100010110100110111100001 from address 1110 (from port 1) during cycle 118 (1180ns - 1190ns)
*	Reading 10110101100010110100110111100001 from address 1110 (from port 0) during cycle 119 (1190ns - 1200ns)
*	Reading 10110101100010110100110111100001 from address 1110 (from port 1) during cycle 119 (1190ns - 1200ns)
*	Reading 10110101100010110100110111100001 from address 1110 (from port 0) during cycle 120 (1200ns - 1210ns)
*	Reading 10110101100010110100110111100001 from address 1110 (from port 1) during cycle 120 (1200ns - 1210ns)
*	Reading 10110101100010110100110111100001 from address 1110 (from port 0) during cycle 121 (1210ns - 1220ns)
*	Reading 01011010110011010010111011100110 from address 0000 (from port 1) during cycle 122 (1220ns - 1230ns)
*	Reading 01011010110011010010111011100110 from address 0000 (from port 0) during cycle 123 (1230ns - 1240ns)
*	Reading 01011010110011010010111011100110 from address 0000 (from port 1) during cycle 123 (1230ns - 1240ns)
*	Reading 01011010110011010010111011100110 from address 0000 (from port 0) during cycle 124 (1240ns - 1250ns)
*	Reading 10110101100010110100110111100001 from address 1110 (from port 1) during cycle 124 (1240ns - 1250ns)
*	Writing 01100110110100101100010111010011  to  address 0000 (from port 0) during cycle 125 (1250ns - 1260ns)
*	Reading 10110101100010110100110111100001 from address 1110 (from port 1) during cycle 125 (1250ns - 1260ns)
*	Writing 01010100011111000100111000101111  to  address 0000 (from port 0) during cycle 126 (1260ns - 1270ns)
*	Reading 01010100011111000100111000101111 from address 0000 (from port 0) during cycle 127 (1270ns - 1280ns)
*	Writing 01000100000110011011110111010101  to  address 1110 (from port 0) during cycle 128 (1280ns - 1290ns)
*	Reading 01010100011111000100111000101111 from address 0000 (from port 0) during cycle 129 (1290ns - 1300ns)
*	Reading 01000100000110011011110111010101 from address 1110 (from port 1) during cycle 129 (1290ns - 1300ns)
*	Reading 01010100011111000100111000101111 from address 0000 (from port 0) during cycle 131 (1310ns - 1320ns)
*	Reading 01000100000110011011110111010101 from address 1110 (from port 0) during cycle 132 (1320ns - 1330ns)
*	Writing 00101010000001001011010111010000  to  address 0000 (from port 0) during cycle 133 (1330ns - 1340ns)
*	Reading 00101010000001001011010111010000 from address 0000 (from port 1) during cycle 134 (1340ns - 1350ns)
*	Reading 01000100000110011011110111010101 from address 1110 (from port 0) during cycle 135 (1350ns - 1360ns)
*	Reading 01000100000110011011110111010101 from address 1110 (from port 1) during cycle 135 (1350ns - 1360ns)
*	Reading 01000100000110011011110111010101 from address 1110 (from port 0) during cycle 136 (1360ns - 1370ns)
*	Writing 01110011101111010000100100100101  to  address 1110 (from port 0) during cycle 137 (1370ns - 1380ns)
*	Reading 01110011101111010000100100100101 from address 1110 (from port 0) during cycle 138 (1380ns - 1390ns)
*	Reading 01110011101111010000100100100101 from address 1110 (from port 1) during cycle 139 (1390ns - 1400ns)
*	Writing 10000000100100100110110111111100  to  address 0000 (from port 0) during cycle 140 (1400ns - 1410ns)
*	Reading 01110011101111010000100100100101 from address 1110 (from port 1) during cycle 140 (1400ns - 1410ns)
*	Writing 01101010010010000111010000001100  to  address 0000 (from port 0) during cycle 142 (1420ns - 1430ns)
*	Writing 10000111100101100010000100000001  to  address 1110 (from port 0) during cycle 143 (1430ns - 1440ns)
*	Reading 01101010010010000111010000001100 from address 0000 (from port 1) during cycle 143 (1430ns - 1440ns)
*	Reading 10000111100101100010000100000001 from address 1110 (from port 0) during cycle 144 (1440ns - 1450ns)
*	Reading 01101010010010000111010000001100 from address 0000 (from port 1) during cycle 144 (1440ns - 1450ns)
*	Reading 10000111100101100010000100000001 from address 1110 (from port 0) during cycle 145 (1450ns - 1460ns)
*	Reading 01101010010010000111010000001100 from address 0000 (from port 1) during cycle 145 (1450ns - 1460ns)
*	Reading 10000111100101100010000100000001 from address 1110 (from port 0) during cycle 146 (1460ns - 1470ns)
*	Writing 01100011110111110100011001000100  to  address 1110 (from port 0) during cycle 149 (1490ns - 1500ns)
*	Reading 01101010010010000111010000001100 from address 0000 (from port 1) during cycle 149 (1490ns - 1500ns)
*	Reading 01101010010010000111010000001100 from address 0000 (from port 0) during cycle 151 (1510ns - 1520ns)
*	Reading 01101010010010000111010000001100 from address 0000 (from port 1) during cycle 151 (1510ns - 1520ns)
*	Reading 01100011110111110100011001000100 from address 1110 (from port 0) during cycle 152 (1520ns - 1530ns)
*	Reading 01101010010010000111010000001100 from address 0000 (from port 1) during cycle 152 (1520ns - 1530ns)
*	Reading 01100011110111110100011001000100 from address 1110 (from port 0) during cycle 153 (1530ns - 1540ns)
*	Reading 01101010010010000111010000001100 from address 0000 (from port 1) during cycle 153 (1530ns - 1540ns)
*	Reading 01100011110111110100011001000100 from address 1110 (from port 0) during cycle 154 (1540ns - 1550ns)
*	Writing 11001100010000111100111110110101  to  address 0000 (from port 0) during cycle 155 (1550ns - 1560ns)
*	Reading 11001100010000111100111110110101 from address 0000 (from port 0) during cycle 156 (1560ns - 1570ns)
*	Reading 01100011110111110100011001000100 from address 1110 (from port 1) during cycle 156 (1560ns - 1570ns)
*	Writing 01001011010010111100111110110100  to  address 0000 (from port 0) during cycle 157 (1570ns - 1580ns)
*	Reading 01001011010010111100111110110100 from address 0000 (from port 0) during cycle 160 (1600ns - 1610ns)
*	Reading 01001011010010111100111110110100 from address 0000 (from port 1) during cycle 161 (1610ns - 1620ns)
*	Reading 01100011110111110100011001000100 from address 1110 (from port 0) during cycle 162 (1620ns - 1630ns)
*	Reading 01001011010010111100111110110100 from address 0000 (from port 0) during cycle 163 (1630ns - 1640ns)
*	Reading 01001011010010111100111110110100 from address 0000 (from port 0) during cycle 164 (1640ns - 1650ns)
*	Reading 01100011110111110100011001000100 from address 1110 (from port 1) during cycle 164 (1640ns - 1650ns)
*	Writing 01111011010110000001001010100000  to  address 1110 (from port 0) during cycle 165 (1650ns - 1660ns)
*	Reading 01111011010110000001001010100000 from address 1110 (from port 1) during cycle 166 (1660ns - 1670ns)
*	Reading 01001011010010111100111110110100 from address 0000 (from port 0) during cycle 167 (1670ns - 1680ns)
*	Reading 01001011010010111100111110110100 from address 0000 (from port 1) during cycle 167 (1670ns - 1680ns)
*	Reading 01111011010110000001001010100000 from address 1110 (from port 0) during cycle 168 (1680ns - 1690ns)
*	Reading 01111011010110000001001010100000 from address 1110 (from port 1) during cycle 168 (1680ns - 1690ns)
*	Reading 01111011010110000001001010100000 from address 1110 (from port 1) during cycle 169 (1690ns - 1700ns)
*	Reading 01111011010110000001001010100000 from address 1110 (from port 0) during cycle 171 (1710ns - 1720ns)
*	Reading 01001011010010111100111110110100 from address 0000 (from port 1) during cycle 172 (1720ns - 1730ns)
*	Reading 01001011010010111100111110110100 from address 0000 (from port 0) during cycle 173 (1730ns - 1740ns)
*	Reading 01111011010110000001001010100000 from address 1110 (from port 1) during cycle 173 (1730ns - 1740ns)
*	Reading 01111011010110000001001010100000 from address 1110 (from port 1) during cycle 174 (1740ns - 1750ns)
*	Reading 01001011010010111100111110110100 from address 0000 (from port 1) during cycle 175 (1750ns - 1760ns)
*	Writing 00010011110011101111101000101000  to  address 0000 (from port 0) during cycle 176 (1760ns - 1770ns)
*	Reading 01111011010110000001001010100000 from address 1110 (from port 1) during cycle 176 (1760ns - 1770ns)
*	Reading 01111011010110000001001010100000 from address 1110 (from port 0) during cycle 177 (1770ns - 1780ns)
*	Reading 01111011010110000001001010100000 from address 1110 (from port 1) during cycle 177 (1770ns - 1780ns)
*	Reading 01111011010110000001001010100000 from address 1110 (from port 0) during cycle 178 (1780ns - 1790ns)
*	Writing 00010010111111111100001010010110  to  address 0000 (from port 0) during cycle 179 (1790ns - 1800ns)
*	Reading 00010010111111111100001010010110 from address 0000 (from port 0) during cycle 180 (1800ns - 1810ns)
*	Reading 01111011010110000001001010100000 from address 1110 (from port 1) during cycle 180 (1800ns - 1810ns)
*	Reading 00010010111111111100001010010110 from address 0000 (from port 0) during cycle 181 (1810ns - 1820ns)
*	Writing 11100011011010100001110101111000  to  address 1110 (from port 0) during cycle 182 (1820ns - 1830ns)
*	Reading 00010010111111111100001010010110 from address 0000 (from port 0) during cycle 183 (1830ns - 1840ns)
*	Reading 00010010111111111100001010010110 from address 0000 (from port 0) during cycle 184 (1840ns - 1850ns)
*	Reading 00010010111111111100001010010110 from address 0000 (from port 1) during cycle 184 (1840ns - 1850ns)
*	Writing 10101110101111101100000111101011  to  address 1110 (from port 0) during cycle 185 (1850ns - 1860ns)
*	Reading 00010010111111111100001010010110 from address 0000 (from port 0) during cycle 186 (1860ns - 1870ns)
*	Reading 10101110101111101100000111101011 from address 1110 (from port 1) during cycle 186 (1860ns - 1870ns)
*	Reading 00010010111111111100001010010110 from address 0000 (from port 0) during cycle 187 (1870ns - 1880ns)
*	Reading 00010010111111111100001010010110 from address 0000 (from port 0) during cycle 188 (1880ns - 1890ns)
*	Reading 10101110101111101100000111101011 from address 1110 (from port 1) during cycle 188 (1880ns - 1890ns)
*	Reading 10101110101111101100000111101011 from address 1110 (from port 1) during cycle 189 (1890ns - 1900ns)
*	Writing 10100111111000011011000001111100  to  address 1110 (from port 0) during cycle 191 (1910ns - 1920ns)
*	Reading 10100111111000011011000001111100 from address 1110 (from port 0) during cycle 192 (1920ns - 1930ns)
*	Reading 10100111111000011011000001111100 from address 1110 (from port 1) during cycle 192 (1920ns - 1930ns)
*	Reading 10100111111000011011000001111100 from address 1110 (from port 1) during cycle 193 (1930ns - 1940ns)
*	Reading 00010010111111111100001010010110 from address 0000 (from port 0) during cycle 195 (1950ns - 1960ns)
*	Reading 00010010111111111100001010010110 from address 0000 (from port 0) during cycle 196 (1960ns - 1970ns)
*	Reading 10100111111000011011000001111100 from address 1110 (from port 0) during cycle 198 (1980ns - 1990ns)
*	Reading 10100111111000011011000001111100 from address 1110 (from port 1) during cycle 198 (1980ns - 1990ns)
*	Reading 00010010111111111100001010010110 from address 0000 (from port 0) during cycle 199 (1990ns - 2000ns)
*	Reading 10100111111000011011000001111100 from address 1110 (from port 1) during cycle 199 (1990ns - 2000ns)
*	Reading 00010010111111111100001010010110 from address 0000 (from port 1) during cycle 200 (2000ns - 2010ns)
*	Reading 10100111111000011011000001111100 from address 1110 (from port 0) during cycle 201 (2010ns - 2020ns)
*	Reading 10100111111000011011000001111100 from address 1110 (from port 1) during cycle 201 (2010ns - 2020ns)
*	Reading 00010010111111111100001010010110 from address 0000 (from port 0) during cycle 202 (2020ns - 2030ns)
*	Reading 00010010111111111100001010010110 from address 0000 (from port 1) during cycle 202 (2020ns - 2030ns)
*	Reading 00010010111111111100001010010110 from address 0000 (from port 0) during cycle 203 (2030ns - 2040ns)
*	Reading 00010010111111111100001010010110 from address 0000 (from port 0) during cycle 204 (2040ns - 2050ns)
*	Idle during cycle 205 (2050ns - 2060ns)

* Generation of data and address signals
* (time, data): [(0, 0), (10, 0), (20, 0), (30, 0), (40, 0), (50, 0), (60, 0), (70, 0), (80, 0), (90, 1), (100, 0), (110, 0), (120, 0), (130, 0), (140, 0), (150, 0), (160, 0), (170, 0), (180, 1), (190, 1), (200, 1), (210, 1), (220, 1), (230, 0), (240, 0), (250, 0), (260, 0), (270, 0), (280, 0), (290, 1), (300, 1), (310, 1), (320, 1), (330, 1), (340, 1), (350, 1), (360, 0), (370, 0), (380, 0), (390, 0), (400, 0), (410, 0), (420, 0), (430, 0), (440, 0), (450, 0), (460, 1), (470, 1), (480, 1), (490, 1), (500, 1), (510, 1), (520, 1), (530, 1), (540, 1), (550, 1), (560, 0), (570, 0), (580, 0), (590, 0), (600, 0), (610, 0), (620, 0), (630, 0), (640, 0), (650, 0), (660, 0), (670, 0), (680, 1), (690, 1), (700, 1), (710, 1), (720, 1), (730, 1), (740, 0), (750, 0), (760, 0), (770, 0), (780, 0), (790, 0), (800, 0), (810, 1), (820, 1), (830, 1), (840, 1), (850, 1), (860, 0), (870, 1), (880, 1), (890, 1), (900, 1), (910, 1), (920, 1), (930, 1), (940, 0), (950, 0), (960, 1), (970, 1), (980, 1), (990, 1), (1000, 1), (1010, 1), (1020, 1), (1030, 1), (1040, 1), (1050, 1), (1060, 0), (1070, 0), (1080, 0), (1090, 1), (1100, 1), (1110, 1), (1120, 1), (1130, 1), (1140, 1), (1150, 1), (1160, 0), (1170, 0), (1180, 0), (1190, 0), (1200, 0), (1210, 0), (1220, 0), (1230, 0), (1240, 0), (1250, 1), (1260, 1), (1270, 1), (1280, 1), (1290, 1), (1300, 1), (1310, 1), (1320, 1), (1330, 0), (1340, 0), (1350, 0), (1360, 0), (1370, 1), (1380, 1), (1390, 1), (1400, 0), (1410, 0), (1420, 0), (1430, 1), (1440, 1), (1450, 1), (1460, 1), (1470, 1), (1480, 1), (1490, 0), (1500, 0), (1510, 0), (1520, 0), (1530, 0), (1540, 0), (1550, 1), (1560, 1), (1570, 0), (1580, 0), (1590, 0), (1600, 0), (1610, 0), (1620, 0), (1630, 0), (1640, 0), (1650, 0), (1660, 0), (1670, 0), (1680, 0), (1690, 0), (1700, 0), (1710, 0), (1720, 0), (1730, 0), (1740, 0), (1750, 0), (1760, 0), (1770, 0), (1780, 0), (1790, 0), (1800, 0), (1810, 0), (1820, 0), (1830, 0), (1840, 0), (1850, 1), (1860, 1), (1870, 1), (1880, 1), (1890, 1), (1900, 1), (1910, 0), (1920, 0), (1930, 0), (1940, 0), (1950, 0), (1960, 0), (1970, 0), (1980, 0), (1990, 0), (2000, 0), (2010, 0), (2020, 0), (2030, 0), (2040, 0), (2050, 0)]
Vdin0_0  din0_0  0 PWL (0n 0.0v 9.495n 0.0v 9.505n 0.0v 19.495n 0.0v 19.505n 0.0v 29.495n 0.0v 29.505n 0.0v 39.495n 0.0v 39.505n 0.0v 49.495n 0.0v 49.505n 0.0v 59.495n 0.0v 59.505n 0.0v 69.495n 0.0v 69.505n 0.0v 79.495n 0.0v 79.505n 0.0v 89.495n 0.0v 89.505n 1.8v 99.495n 1.8v 99.505n 0.0v 109.495n 0.0v 109.505n 0.0v 119.495n 0.0v 119.505n 0.0v 129.495n 0.0v 129.505n 0.0v 139.495n 0.0v 139.505n 0.0v 149.495n 0.0v 149.505n 0.0v 159.495n 0.0v 159.505n 0.0v 169.495n 0.0v 169.505n 0.0v 179.495n 0.0v 179.505n 1.8v 189.495n 1.8v 189.505n 1.8v 199.495n 1.8v 199.505n 1.8v 209.495n 1.8v 209.505n 1.8v 219.495n 1.8v 219.505n 1.8v 229.495n 1.8v 229.505n 0.0v 239.495n 0.0v 239.505n 0.0v 249.495n 0.0v 249.505n 0.0v 259.495n 0.0v 259.505n 0.0v 269.495n 0.0v 269.505n 0.0v 279.495n 0.0v 279.505n 0.0v 289.495n 0.0v 289.505n 1.8v 299.495n 1.8v 299.505n 1.8v 309.495n 1.8v 309.505n 1.8v 319.495n 1.8v 319.505n 1.8v 329.495n 1.8v 329.505n 1.8v 339.495n 1.8v 339.505n 1.8v 349.495n 1.8v 349.505n 1.8v 359.495n 1.8v 359.505n 0.0v 369.495n 0.0v 369.505n 0.0v 379.495n 0.0v 379.505n 0.0v 389.495n 0.0v 389.505n 0.0v 399.495n 0.0v 399.505n 0.0v 409.495n 0.0v 409.505n 0.0v 419.495n 0.0v 419.505n 0.0v 429.495n 0.0v 429.505n 0.0v 439.495n 0.0v 439.505n 0.0v 449.495n 0.0v 449.505n 0.0v 459.495n 0.0v 459.505n 1.8v 469.495n 1.8v 469.505n 1.8v 479.495n 1.8v 479.505n 1.8v 489.495n 1.8v 489.505n 1.8v 499.495n 1.8v 499.505n 1.8v 509.495n 1.8v 509.505n 1.8v 519.495n 1.8v 519.505n 1.8v 529.495n 1.8v 529.505n 1.8v 539.495n 1.8v 539.505n 1.8v 549.495n 1.8v 549.505n 1.8v 559.495n 1.8v 559.505n 0.0v 569.495n 0.0v 569.505n 0.0v 579.495n 0.0v 579.505n 0.0v 589.495n 0.0v 589.505n 0.0v 599.495n 0.0v 599.505n 0.0v 609.495n 0.0v 609.505n 0.0v 619.495n 0.0v 619.505n 0.0v 629.495n 0.0v 629.505n 0.0v 639.495n 0.0v 639.505n 0.0v 649.495n 0.0v 649.505n 0.0v 659.495n 0.0v 659.505n 0.0v 669.495n 0.0v 669.505n 0.0v 679.495n 0.0v 679.505n 1.8v 689.495n 1.8v 689.505n 1.8v 699.495n 1.8v 699.505n 1.8v 709.495n 1.8v 709.505n 1.8v 719.495n 1.8v 719.505n 1.8v 729.495n 1.8v 729.505n 1.8v 739.495n 1.8v 739.505n 0.0v 749.495n 0.0v 749.505n 0.0v 759.495n 0.0v 759.505n 0.0v 769.495n 0.0v 769.505n 0.0v 779.495n 0.0v 779.505n 0.0v 789.495n 0.0v 789.505n 0.0v 799.495n 0.0v 799.505n 0.0v 809.495n 0.0v 809.505n 1.8v 819.495n 1.8v 819.505n 1.8v 829.495n 1.8v 829.505n 1.8v 839.495n 1.8v 839.505n 1.8v 849.495n 1.8v 849.505n 1.8v 859.495n 1.8v 859.505n 0.0v 869.495n 0.0v 869.505n 1.8v 879.495n 1.8v 879.505n 1.8v 889.495n 1.8v 889.505n 1.8v 899.495n 1.8v 899.505n 1.8v 909.495n 1.8v 909.505n 1.8v 919.495n 1.8v 919.505n 1.8v 929.495n 1.8v 929.505n 1.8v 939.495n 1.8v 939.505n 0.0v 949.495n 0.0v 949.505n 0.0v 959.495n 0.0v 959.505n 1.8v 969.495n 1.8v 969.505n 1.8v 979.495n 1.8v 979.505n 1.8v 989.495n 1.8v 989.505n 1.8v 999.495n 1.8v 999.505n 1.8v 1009.495n 1.8v 1009.505n 1.8v 1019.495n 1.8v 1019.505n 1.8v 1029.495n 1.8v 1029.505n 1.8v 1039.495n 1.8v 1039.505n 1.8v 1049.495n 1.8v 1049.505n 1.8v 1059.495n 1.8v 1059.505n 0.0v 1069.495n 0.0v 1069.505n 0.0v 1079.495n 0.0v 1079.505n 0.0v 1089.495n 0.0v 1089.505n 1.8v 1099.495n 1.8v 1099.505n 1.8v 1109.495n 1.8v 1109.505n 1.8v 1119.495n 1.8v 1119.505n 1.8v 1129.495n 1.8v 1129.505n 1.8v 1139.495n 1.8v 1139.505n 1.8v 1149.495n 1.8v 1149.505n 1.8v 1159.495n 1.8v 1159.505n 0.0v 1169.495n 0.0v 1169.505n 0.0v 1179.495n 0.0v 1179.505n 0.0v 1189.495n 0.0v 1189.505n 0.0v 1199.495n 0.0v 1199.505n 0.0v 1209.495n 0.0v 1209.505n 0.0v 1219.495n 0.0v 1219.505n 0.0v 1229.495n 0.0v 1229.505n 0.0v 1239.495n 0.0v 1239.505n 0.0v 1249.495n 0.0v 1249.505n 1.8v 1259.495n 1.8v 1259.505n 1.8v 1269.495n 1.8v 1269.505n 1.8v 1279.495n 1.8v 1279.505n 1.8v 1289.495n 1.8v 1289.505n 1.8v 1299.495n 1.8v 1299.505n 1.8v 1309.495n 1.8v 1309.505n 1.8v 1319.495n 1.8v 1319.505n 1.8v 1329.495n 1.8v 1329.505n 0.0v 1339.495n 0.0v 1339.505n 0.0v 1349.495n 0.0v 1349.505n 0.0v 1359.495n 0.0v 1359.505n 0.0v 1369.495n 0.0v 1369.505n 1.8v 1379.495n 1.8v 1379.505n 1.8v 1389.495n 1.8v 1389.505n 1.8v 1399.495n 1.8v 1399.505n 0.0v 1409.495n 0.0v 1409.505n 0.0v 1419.495n 0.0v 1419.505n 0.0v 1429.495n 0.0v 1429.505n 1.8v 1439.495n 1.8v 1439.505n 1.8v 1449.495n 1.8v 1449.505n 1.8v 1459.495n 1.8v 1459.505n 1.8v 1469.495n 1.8v 1469.505n 1.8v 1479.495n 1.8v 1479.505n 1.8v 1489.495n 1.8v 1489.505n 0.0v 1499.495n 0.0v 1499.505n 0.0v 1509.495n 0.0v 1509.505n 0.0v 1519.495n 0.0v 1519.505n 0.0v 1529.495n 0.0v 1529.505n 0.0v 1539.495n 0.0v 1539.505n 0.0v 1549.495n 0.0v 1549.505n 1.8v 1559.495n 1.8v 1559.505n 1.8v 1569.495n 1.8v 1569.505n 0.0v 1579.495n 0.0v 1579.505n 0.0v 1589.495n 0.0v 1589.505n 0.0v 1599.495n 0.0v 1599.505n 0.0v 1609.495n 0.0v 1609.505n 0.0v 1619.495n 0.0v 1619.505n 0.0v 1629.495n 0.0v 1629.505n 0.0v 1639.495n 0.0v 1639.505n 0.0v 1649.495n 0.0v 1649.505n 0.0v 1659.495n 0.0v 1659.505n 0.0v 1669.495n 0.0v 1669.505n 0.0v 1679.495n 0.0v 1679.505n 0.0v 1689.495n 0.0v 1689.505n 0.0v 1699.495n 0.0v 1699.505n 0.0v 1709.495n 0.0v 1709.505n 0.0v 1719.495n 0.0v 1719.505n 0.0v 1729.495n 0.0v 1729.505n 0.0v 1739.495n 0.0v 1739.505n 0.0v 1749.495n 0.0v 1749.505n 0.0v 1759.495n 0.0v 1759.505n 0.0v 1769.495n 0.0v 1769.505n 0.0v 1779.495n 0.0v 1779.505n 0.0v 1789.495n 0.0v 1789.505n 0.0v 1799.495n 0.0v 1799.505n 0.0v 1809.495n 0.0v 1809.505n 0.0v 1819.495n 0.0v 1819.505n 0.0v 1829.495n 0.0v 1829.505n 0.0v 1839.495n 0.0v 1839.505n 0.0v 1849.495n 0.0v 1849.505n 1.8v 1859.495n 1.8v 1859.505n 1.8v 1869.495n 1.8v 1869.505n 1.8v 1879.495n 1.8v 1879.505n 1.8v 1889.495n 1.8v 1889.505n 1.8v 1899.495n 1.8v 1899.505n 1.8v 1909.495n 1.8v 1909.505n 0.0v 1919.495n 0.0v 1919.505n 0.0v 1929.495n 0.0v 1929.505n 0.0v 1939.495n 0.0v 1939.505n 0.0v 1949.495n 0.0v 1949.505n 0.0v 1959.495n 0.0v 1959.505n 0.0v 1969.495n 0.0v 1969.505n 0.0v 1979.495n 0.0v 1979.505n 0.0v 1989.495n 0.0v 1989.505n 0.0v 1999.495n 0.0v 1999.505n 0.0v 2009.495n 0.0v 2009.505n 0.0v 2019.495n 0.0v 2019.505n 0.0v 2029.495n 0.0v 2029.505n 0.0v 2039.495n 0.0v 2039.505n 0.0v 2049.495n 0.0v 2049.505n 0.0v )
* (time, data): [(0, 0), (10, 0), (20, 0), (30, 0), (40, 0), (50, 0), (60, 0), (70, 0), (80, 0), (90, 0), (100, 1), (110, 1), (120, 1), (130, 1), (140, 1), (150, 1), (160, 1), (170, 1), (180, 0), (190, 0), (200, 0), (210, 0), (220, 0), (230, 1), (240, 0), (250, 0), (260, 0), (270, 0), (280, 0), (290, 0), (300, 0), (310, 0), (320, 0), (330, 1), (340, 1), (350, 1), (360, 0), (370, 0), (380, 0), (390, 0), (400, 0), (410, 0), (420, 0), (430, 0), (440, 0), (450, 0), (460, 1), (470, 0), (480, 0), (490, 0), (500, 0), (510, 0), (520, 0), (530, 0), (540, 0), (550, 0), (560, 1), (570, 1), (580, 1), (590, 1), (600, 1), (610, 1), (620, 1), (630, 1), (640, 1), (650, 1), (660, 1), (670, 1), (680, 1), (690, 1), (700, 1), (710, 1), (720, 1), (730, 1), (740, 1), (750, 1), (760, 1), (770, 1), (780, 1), (790, 1), (800, 1), (810, 1), (820, 1), (830, 1), (840, 1), (850, 1), (860, 1), (870, 0), (880, 0), (890, 0), (900, 0), (910, 0), (920, 0), (930, 0), (940, 0), (950, 0), (960, 1), (970, 1), (980, 1), (990, 1), (1000, 1), (1010, 1), (1020, 1), (1030, 1), (1040, 1), (1050, 1), (1060, 0), (1070, 0), (1080, 0), (1090, 0), (1100, 0), (1110, 0), (1120, 0), (1130, 0), (1140, 1), (1150, 1), (1160, 1), (1170, 1), (1180, 1), (1190, 1), (1200, 1), (1210, 1), (1220, 1), (1230, 1), (1240, 1), (1250, 1), (1260, 1), (1270, 1), (1280, 0), (1290, 0), (1300, 0), (1310, 0), (1320, 0), (1330, 0), (1340, 0), (1350, 0), (1360, 0), (1370, 0), (1380, 0), (1390, 0), (1400, 0), (1410, 0), (1420, 0), (1430, 0), (1440, 0), (1450, 0), (1460, 0), (1470, 0), (1480, 0), (1490, 0), (1500, 0), (1510, 0), (1520, 0), (1530, 0), (1540, 0), (1550, 0), (1560, 0), (1570, 0), (1580, 0), (1590, 0), (1600, 0), (1610, 0), (1620, 0), (1630, 0), (1640, 0), (1650, 0), (1660, 0), (1670, 0), (1680, 0), (1690, 0), (1700, 0), (1710, 0), (1720, 0), (1730, 0), (1740, 0), (1750, 0), (1760, 0), (1770, 0), (1780, 0), (1790, 1), (1800, 1), (1810, 1), (1820, 0), (1830, 0), (1840, 0), (1850, 1), (1860, 1), (1870, 1), (1880, 1), (1890, 1), (1900, 1), (1910, 0), (1920, 0), (1930, 0), (1940, 0), (1950, 0), (1960, 0), (1970, 0), (1980, 0), (1990, 0), (2000, 0), (2010, 0), (2020, 0), (2030, 0), (2040, 0), (2050, 0)]
Vdin0_1  din0_1  0 PWL (0n 0.0v 9.495n 0.0v 9.505n 0.0v 19.495n 0.0v 19.505n 0.0v 29.495n 0.0v 29.505n 0.0v 39.495n 0.0v 39.505n 0.0v 49.495n 0.0v 49.505n 0.0v 59.495n 0.0v 59.505n 0.0v 69.495n 0.0v 69.505n 0.0v 79.495n 0.0v 79.505n 0.0v 89.495n 0.0v 89.505n 0.0v 99.495n 0.0v 99.505n 1.8v 109.495n 1.8v 109.505n 1.8v 119.495n 1.8v 119.505n 1.8v 129.495n 1.8v 129.505n 1.8v 139.495n 1.8v 139.505n 1.8v 149.495n 1.8v 149.505n 1.8v 159.495n 1.8v 159.505n 1.8v 169.495n 1.8v 169.505n 1.8v 179.495n 1.8v 179.505n 0.0v 189.495n 0.0v 189.505n 0.0v 199.495n 0.0v 199.505n 0.0v 209.495n 0.0v 209.505n 0.0v 219.495n 0.0v 219.505n 0.0v 229.495n 0.0v 229.505n 1.8v 239.495n 1.8v 239.505n 0.0v 249.495n 0.0v 249.505n 0.0v 259.495n 0.0v 259.505n 0.0v 269.495n 0.0v 269.505n 0.0v 279.495n 0.0v 279.505n 0.0v 289.495n 0.0v 289.505n 0.0v 299.495n 0.0v 299.505n 0.0v 309.495n 0.0v 309.505n 0.0v 319.495n 0.0v 319.505n 0.0v 329.495n 0.0v 329.505n 1.8v 339.495n 1.8v 339.505n 1.8v 349.495n 1.8v 349.505n 1.8v 359.495n 1.8v 359.505n 0.0v 369.495n 0.0v 369.505n 0.0v 379.495n 0.0v 379.505n 0.0v 389.495n 0.0v 389.505n 0.0v 399.495n 0.0v 399.505n 0.0v 409.495n 0.0v 409.505n 0.0v 419.495n 0.0v 419.505n 0.0v 429.495n 0.0v 429.505n 0.0v 439.495n 0.0v 439.505n 0.0v 449.495n 0.0v 449.505n 0.0v 459.495n 0.0v 459.505n 1.8v 469.495n 1.8v 469.505n 0.0v 479.495n 0.0v 479.505n 0.0v 489.495n 0.0v 489.505n 0.0v 499.495n 0.0v 499.505n 0.0v 509.495n 0.0v 509.505n 0.0v 519.495n 0.0v 519.505n 0.0v 529.495n 0.0v 529.505n 0.0v 539.495n 0.0v 539.505n 0.0v 549.495n 0.0v 549.505n 0.0v 559.495n 0.0v 559.505n 1.8v 569.495n 1.8v 569.505n 1.8v 579.495n 1.8v 579.505n 1.8v 589.495n 1.8v 589.505n 1.8v 599.495n 1.8v 599.505n 1.8v 609.495n 1.8v 609.505n 1.8v 619.495n 1.8v 619.505n 1.8v 629.495n 1.8v 629.505n 1.8v 639.495n 1.8v 639.505n 1.8v 649.495n 1.8v 649.505n 1.8v 659.495n 1.8v 659.505n 1.8v 669.495n 1.8v 669.505n 1.8v 679.495n 1.8v 679.505n 1.8v 689.495n 1.8v 689.505n 1.8v 699.495n 1.8v 699.505n 1.8v 709.495n 1.8v 709.505n 1.8v 719.495n 1.8v 719.505n 1.8v 729.495n 1.8v 729.505n 1.8v 739.495n 1.8v 739.505n 1.8v 749.495n 1.8v 749.505n 1.8v 759.495n 1.8v 759.505n 1.8v 769.495n 1.8v 769.505n 1.8v 779.495n 1.8v 779.505n 1.8v 789.495n 1.8v 789.505n 1.8v 799.495n 1.8v 799.505n 1.8v 809.495n 1.8v 809.505n 1.8v 819.495n 1.8v 819.505n 1.8v 829.495n 1.8v 829.505n 1.8v 839.495n 1.8v 839.505n 1.8v 849.495n 1.8v 849.505n 1.8v 859.495n 1.8v 859.505n 1.8v 869.495n 1.8v 869.505n 0.0v 879.495n 0.0v 879.505n 0.0v 889.495n 0.0v 889.505n 0.0v 899.495n 0.0v 899.505n 0.0v 909.495n 0.0v 909.505n 0.0v 919.495n 0.0v 919.505n 0.0v 929.495n 0.0v 929.505n 0.0v 939.495n 0.0v 939.505n 0.0v 949.495n 0.0v 949.505n 0.0v 959.495n 0.0v 959.505n 1.8v 969.495n 1.8v 969.505n 1.8v 979.495n 1.8v 979.505n 1.8v 989.495n 1.8v 989.505n 1.8v 999.495n 1.8v 999.505n 1.8v 1009.495n 1.8v 1009.505n 1.8v 1019.495n 1.8v 1019.505n 1.8v 1029.495n 1.8v 1029.505n 1.8v 1039.495n 1.8v 1039.505n 1.8v 1049.495n 1.8v 1049.505n 1.8v 1059.495n 1.8v 1059.505n 0.0v 1069.495n 0.0v 1069.505n 0.0v 1079.495n 0.0v 1079.505n 0.0v 1089.495n 0.0v 1089.505n 0.0v 1099.495n 0.0v 1099.505n 0.0v 1109.495n 0.0v 1109.505n 0.0v 1119.495n 0.0v 1119.505n 0.0v 1129.495n 0.0v 1129.505n 0.0v 1139.495n 0.0v 1139.505n 1.8v 1149.495n 1.8v 1149.505n 1.8v 1159.495n 1.8v 1159.505n 1.8v 1169.495n 1.8v 1169.505n 1.8v 1179.495n 1.8v 1179.505n 1.8v 1189.495n 1.8v 1189.505n 1.8v 1199.495n 1.8v 1199.505n 1.8v 1209.495n 1.8v 1209.505n 1.8v 1219.495n 1.8v 1219.505n 1.8v 1229.495n 1.8v 1229.505n 1.8v 1239.495n 1.8v 1239.505n 1.8v 1249.495n 1.8v 1249.505n 1.8v 1259.495n 1.8v 1259.505n 1.8v 1269.495n 1.8v 1269.505n 1.8v 1279.495n 1.8v 1279.505n 0.0v 1289.495n 0.0v 1289.505n 0.0v 1299.495n 0.0v 1299.505n 0.0v 1309.495n 0.0v 1309.505n 0.0v 1319.495n 0.0v 1319.505n 0.0v 1329.495n 0.0v 1329.505n 0.0v 1339.495n 0.0v 1339.505n 0.0v 1349.495n 0.0v 1349.505n 0.0v 1359.495n 0.0v 1359.505n 0.0v 1369.495n 0.0v 1369.505n 0.0v 1379.495n 0.0v 1379.505n 0.0v 1389.495n 0.0v 1389.505n 0.0v 1399.495n 0.0v 1399.505n 0.0v 1409.495n 0.0v 1409.505n 0.0v 1419.495n 0.0v 1419.505n 0.0v 1429.495n 0.0v 1429.505n 0.0v 1439.495n 0.0v 1439.505n 0.0v 1449.495n 0.0v 1449.505n 0.0v 1459.495n 0.0v 1459.505n 0.0v 1469.495n 0.0v 1469.505n 0.0v 1479.495n 0.0v 1479.505n 0.0v 1489.495n 0.0v 1489.505n 0.0v 1499.495n 0.0v 1499.505n 0.0v 1509.495n 0.0v 1509.505n 0.0v 1519.495n 0.0v 1519.505n 0.0v 1529.495n 0.0v 1529.505n 0.0v 1539.495n 0.0v 1539.505n 0.0v 1549.495n 0.0v 1549.505n 0.0v 1559.495n 0.0v 1559.505n 0.0v 1569.495n 0.0v 1569.505n 0.0v 1579.495n 0.0v 1579.505n 0.0v 1589.495n 0.0v 1589.505n 0.0v 1599.495n 0.0v 1599.505n 0.0v 1609.495n 0.0v 1609.505n 0.0v 1619.495n 0.0v 1619.505n 0.0v 1629.495n 0.0v 1629.505n 0.0v 1639.495n 0.0v 1639.505n 0.0v 1649.495n 0.0v 1649.505n 0.0v 1659.495n 0.0v 1659.505n 0.0v 1669.495n 0.0v 1669.505n 0.0v 1679.495n 0.0v 1679.505n 0.0v 1689.495n 0.0v 1689.505n 0.0v 1699.495n 0.0v 1699.505n 0.0v 1709.495n 0.0v 1709.505n 0.0v 1719.495n 0.0v 1719.505n 0.0v 1729.495n 0.0v 1729.505n 0.0v 1739.495n 0.0v 1739.505n 0.0v 1749.495n 0.0v 1749.505n 0.0v 1759.495n 0.0v 1759.505n 0.0v 1769.495n 0.0v 1769.505n 0.0v 1779.495n 0.0v 1779.505n 0.0v 1789.495n 0.0v 1789.505n 1.8v 1799.495n 1.8v 1799.505n 1.8v 1809.495n 1.8v 1809.505n 1.8v 1819.495n 1.8v 1819.505n 0.0v 1829.495n 0.0v 1829.505n 0.0v 1839.495n 0.0v 1839.505n 0.0v 1849.495n 0.0v 1849.505n 1.8v 1859.495n 1.8v 1859.505n 1.8v 1869.495n 1.8v 1869.505n 1.8v 1879.495n 1.8v 1879.505n 1.8v 1889.495n 1.8v 1889.505n 1.8v 1899.495n 1.8v 1899.505n 1.8v 1909.495n 1.8v 1909.505n 0.0v 1919.495n 0.0v 1919.505n 0.0v 1929.495n 0.0v 1929.505n 0.0v 1939.495n 0.0v 1939.505n 0.0v 1949.495n 0.0v 1949.505n 0.0v 1959.495n 0.0v 1959.505n 0.0v 1969.495n 0.0v 1969.505n 0.0v 1979.495n 0.0v 1979.505n 0.0v 1989.495n 0.0v 1989.505n 0.0v 1999.495n 0.0v 1999.505n 0.0v 2009.495n 0.0v 2009.505n 0.0v 2019.495n 0.0v 2019.505n 0.0v 2029.495n 0.0v 2029.505n 0.0v 2039.495n 0.0v 2039.505n 0.0v 2049.495n 0.0v 2049.505n 0.0v )
* (time, data): [(0, 0), (10, 0), (20, 0), (30, 1), (40, 1), (50, 1), (60, 1), (70, 1), (80, 1), (90, 1), (100, 1), (110, 1), (120, 1), (130, 1), (140, 1), (150, 1), (160, 1), (170, 1), (180, 0), (190, 0), (200, 1), (210, 1), (220, 1), (230, 1), (240, 1), (250, 1), (260, 1), (270, 1), (280, 1), (290, 1), (300, 0), (310, 0), (320, 0), (330, 0), (340, 0), (350, 0), (360, 1), (370, 0), (380, 0), (390, 0), (400, 0), (410, 0), (420, 0), (430, 0), (440, 0), (450, 0), (460, 1), (470, 0), (480, 0), (490, 0), (500, 0), (510, 0), (520, 0), (530, 0), (540, 0), (550, 0), (560, 1), (570, 1), (580, 1), (590, 1), (600, 1), (610, 1), (620, 1), (630, 1), (640, 0), (650, 0), (660, 0), (670, 0), (680, 0), (690, 0), (700, 1), (710, 1), (720, 1), (730, 1), (740, 0), (750, 0), (760, 0), (770, 0), (780, 0), (790, 0), (800, 0), (810, 0), (820, 0), (830, 0), (840, 0), (850, 0), (860, 0), (870, 1), (880, 1), (890, 1), (900, 1), (910, 1), (920, 1), (930, 1), (940, 0), (950, 0), (960, 0), (970, 0), (980, 0), (990, 0), (1000, 0), (1010, 0), (1020, 0), (1030, 0), (1040, 0), (1050, 0), (1060, 0), (1070, 0), (1080, 0), (1090, 0), (1100, 0), (1110, 0), (1120, 0), (1130, 0), (1140, 0), (1150, 0), (1160, 1), (1170, 1), (1180, 1), (1190, 1), (1200, 1), (1210, 1), (1220, 1), (1230, 1), (1240, 1), (1250, 0), (1260, 1), (1270, 1), (1280, 1), (1290, 1), (1300, 1), (1310, 1), (1320, 1), (1330, 0), (1340, 0), (1350, 0), (1360, 0), (1370, 1), (1380, 1), (1390, 1), (1400, 1), (1410, 1), (1420, 1), (1430, 0), (1440, 0), (1450, 0), (1460, 0), (1470, 0), (1480, 0), (1490, 1), (1500, 1), (1510, 1), (1520, 1), (1530, 1), (1540, 1), (1550, 1), (1560, 1), (1570, 1), (1580, 1), (1590, 1), (1600, 1), (1610, 1), (1620, 1), (1630, 1), (1640, 1), (1650, 0), (1660, 0), (1670, 0), (1680, 0), (1690, 0), (1700, 0), (1710, 0), (1720, 0), (1730, 0), (1740, 0), (1750, 0), (1760, 0), (1770, 0), (1780, 0), (1790, 1), (1800, 1), (1810, 1), (1820, 0), (1830, 0), (1840, 0), (1850, 0), (1860, 0), (1870, 0), (1880, 0), (1890, 0), (1900, 0), (1910, 1), (1920, 1), (1930, 1), (1940, 1), (1950, 1), (1960, 1), (1970, 1), (1980, 1), (1990, 1), (2000, 1), (2010, 1), (2020, 1), (2030, 1), (2040, 1), (2050, 1)]
Vdin0_2  din0_2  0 PWL (0n 0.0v 9.495n 0.0v 9.505n 0.0v 19.495n 0.0v 19.505n 0.0v 29.495n 0.0v 29.505n 1.8v 39.495n 1.8v 39.505n 1.8v 49.495n 1.8v 49.505n 1.8v 59.495n 1.8v 59.505n 1.8v 69.495n 1.8v 69.505n 1.8v 79.495n 1.8v 79.505n 1.8v 89.495n 1.8v 89.505n 1.8v 99.495n 1.8v 99.505n 1.8v 109.495n 1.8v 109.505n 1.8v 119.495n 1.8v 119.505n 1.8v 129.495n 1.8v 129.505n 1.8v 139.495n 1.8v 139.505n 1.8v 149.495n 1.8v 149.505n 1.8v 159.495n 1.8v 159.505n 1.8v 169.495n 1.8v 169.505n 1.8v 179.495n 1.8v 179.505n 0.0v 189.495n 0.0v 189.505n 0.0v 199.495n 0.0v 199.505n 1.8v 209.495n 1.8v 209.505n 1.8v 219.495n 1.8v 219.505n 1.8v 229.495n 1.8v 229.505n 1.8v 239.495n 1.8v 239.505n 1.8v 249.495n 1.8v 249.505n 1.8v 259.495n 1.8v 259.505n 1.8v 269.495n 1.8v 269.505n 1.8v 279.495n 1.8v 279.505n 1.8v 289.495n 1.8v 289.505n 1.8v 299.495n 1.8v 299.505n 0.0v 309.495n 0.0v 309.505n 0.0v 319.495n 0.0v 319.505n 0.0v 329.495n 0.0v 329.505n 0.0v 339.495n 0.0v 339.505n 0.0v 349.495n 0.0v 349.505n 0.0v 359.495n 0.0v 359.505n 1.8v 369.495n 1.8v 369.505n 0.0v 379.495n 0.0v 379.505n 0.0v 389.495n 0.0v 389.505n 0.0v 399.495n 0.0v 399.505n 0.0v 409.495n 0.0v 409.505n 0.0v 419.495n 0.0v 419.505n 0.0v 429.495n 0.0v 429.505n 0.0v 439.495n 0.0v 439.505n 0.0v 449.495n 0.0v 449.505n 0.0v 459.495n 0.0v 459.505n 1.8v 469.495n 1.8v 469.505n 0.0v 479.495n 0.0v 479.505n 0.0v 489.495n 0.0v 489.505n 0.0v 499.495n 0.0v 499.505n 0.0v 509.495n 0.0v 509.505n 0.0v 519.495n 0.0v 519.505n 0.0v 529.495n 0.0v 529.505n 0.0v 539.495n 0.0v 539.505n 0.0v 549.495n 0.0v 549.505n 0.0v 559.495n 0.0v 559.505n 1.8v 569.495n 1.8v 569.505n 1.8v 579.495n 1.8v 579.505n 1.8v 589.495n 1.8v 589.505n 1.8v 599.495n 1.8v 599.505n 1.8v 609.495n 1.8v 609.505n 1.8v 619.495n 1.8v 619.505n 1.8v 629.495n 1.8v 629.505n 1.8v 639.495n 1.8v 639.505n 0.0v 649.495n 0.0v 649.505n 0.0v 659.495n 0.0v 659.505n 0.0v 669.495n 0.0v 669.505n 0.0v 679.495n 0.0v 679.505n 0.0v 689.495n 0.0v 689.505n 0.0v 699.495n 0.0v 699.505n 1.8v 709.495n 1.8v 709.505n 1.8v 719.495n 1.8v 719.505n 1.8v 729.495n 1.8v 729.505n 1.8v 739.495n 1.8v 739.505n 0.0v 749.495n 0.0v 749.505n 0.0v 759.495n 0.0v 759.505n 0.0v 769.495n 0.0v 769.505n 0.0v 779.495n 0.0v 779.505n 0.0v 789.495n 0.0v 789.505n 0.0v 799.495n 0.0v 799.505n 0.0v 809.495n 0.0v 809.505n 0.0v 819.495n 0.0v 819.505n 0.0v 829.495n 0.0v 829.505n 0.0v 839.495n 0.0v 839.505n 0.0v 849.495n 0.0v 849.505n 0.0v 859.495n 0.0v 859.505n 0.0v 869.495n 0.0v 869.505n 1.8v 879.495n 1.8v 879.505n 1.8v 889.495n 1.8v 889.505n 1.8v 899.495n 1.8v 899.505n 1.8v 909.495n 1.8v 909.505n 1.8v 919.495n 1.8v 919.505n 1.8v 929.495n 1.8v 929.505n 1.8v 939.495n 1.8v 939.505n 0.0v 949.495n 0.0v 949.505n 0.0v 959.495n 0.0v 959.505n 0.0v 969.495n 0.0v 969.505n 0.0v 979.495n 0.0v 979.505n 0.0v 989.495n 0.0v 989.505n 0.0v 999.495n 0.0v 999.505n 0.0v 1009.495n 0.0v 1009.505n 0.0v 1019.495n 0.0v 1019.505n 0.0v 1029.495n 0.0v 1029.505n 0.0v 1039.495n 0.0v 1039.505n 0.0v 1049.495n 0.0v 1049.505n 0.0v 1059.495n 0.0v 1059.505n 0.0v 1069.495n 0.0v 1069.505n 0.0v 1079.495n 0.0v 1079.505n 0.0v 1089.495n 0.0v 1089.505n 0.0v 1099.495n 0.0v 1099.505n 0.0v 1109.495n 0.0v 1109.505n 0.0v 1119.495n 0.0v 1119.505n 0.0v 1129.495n 0.0v 1129.505n 0.0v 1139.495n 0.0v 1139.505n 0.0v 1149.495n 0.0v 1149.505n 0.0v 1159.495n 0.0v 1159.505n 1.8v 1169.495n 1.8v 1169.505n 1.8v 1179.495n 1.8v 1179.505n 1.8v 1189.495n 1.8v 1189.505n 1.8v 1199.495n 1.8v 1199.505n 1.8v 1209.495n 1.8v 1209.505n 1.8v 1219.495n 1.8v 1219.505n 1.8v 1229.495n 1.8v 1229.505n 1.8v 1239.495n 1.8v 1239.505n 1.8v 1249.495n 1.8v 1249.505n 0.0v 1259.495n 0.0v 1259.505n 1.8v 1269.495n 1.8v 1269.505n 1.8v 1279.495n 1.8v 1279.505n 1.8v 1289.495n 1.8v 1289.505n 1.8v 1299.495n 1.8v 1299.505n 1.8v 1309.495n 1.8v 1309.505n 1.8v 1319.495n 1.8v 1319.505n 1.8v 1329.495n 1.8v 1329.505n 0.0v 1339.495n 0.0v 1339.505n 0.0v 1349.495n 0.0v 1349.505n 0.0v 1359.495n 0.0v 1359.505n 0.0v 1369.495n 0.0v 1369.505n 1.8v 1379.495n 1.8v 1379.505n 1.8v 1389.495n 1.8v 1389.505n 1.8v 1399.495n 1.8v 1399.505n 1.8v 1409.495n 1.8v 1409.505n 1.8v 1419.495n 1.8v 1419.505n 1.8v 1429.495n 1.8v 1429.505n 0.0v 1439.495n 0.0v 1439.505n 0.0v 1449.495n 0.0v 1449.505n 0.0v 1459.495n 0.0v 1459.505n 0.0v 1469.495n 0.0v 1469.505n 0.0v 1479.495n 0.0v 1479.505n 0.0v 1489.495n 0.0v 1489.505n 1.8v 1499.495n 1.8v 1499.505n 1.8v 1509.495n 1.8v 1509.505n 1.8v 1519.495n 1.8v 1519.505n 1.8v 1529.495n 1.8v 1529.505n 1.8v 1539.495n 1.8v 1539.505n 1.8v 1549.495n 1.8v 1549.505n 1.8v 1559.495n 1.8v 1559.505n 1.8v 1569.495n 1.8v 1569.505n 1.8v 1579.495n 1.8v 1579.505n 1.8v 1589.495n 1.8v 1589.505n 1.8v 1599.495n 1.8v 1599.505n 1.8v 1609.495n 1.8v 1609.505n 1.8v 1619.495n 1.8v 1619.505n 1.8v 1629.495n 1.8v 1629.505n 1.8v 1639.495n 1.8v 1639.505n 1.8v 1649.495n 1.8v 1649.505n 0.0v 1659.495n 0.0v 1659.505n 0.0v 1669.495n 0.0v 1669.505n 0.0v 1679.495n 0.0v 1679.505n 0.0v 1689.495n 0.0v 1689.505n 0.0v 1699.495n 0.0v 1699.505n 0.0v 1709.495n 0.0v 1709.505n 0.0v 1719.495n 0.0v 1719.505n 0.0v 1729.495n 0.0v 1729.505n 0.0v 1739.495n 0.0v 1739.505n 0.0v 1749.495n 0.0v 1749.505n 0.0v 1759.495n 0.0v 1759.505n 0.0v 1769.495n 0.0v 1769.505n 0.0v 1779.495n 0.0v 1779.505n 0.0v 1789.495n 0.0v 1789.505n 1.8v 1799.495n 1.8v 1799.505n 1.8v 1809.495n 1.8v 1809.505n 1.8v 1819.495n 1.8v 1819.505n 0.0v 1829.495n 0.0v 1829.505n 0.0v 1839.495n 0.0v 1839.505n 0.0v 1849.495n 0.0v 1849.505n 0.0v 1859.495n 0.0v 1859.505n 0.0v 1869.495n 0.0v 1869.505n 0.0v 1879.495n 0.0v 1879.505n 0.0v 1889.495n 0.0v 1889.505n 0.0v 1899.495n 0.0v 1899.505n 0.0v 1909.495n 0.0v 1909.505n 1.8v 1919.495n 1.8v 1919.505n 1.8v 1929.495n 1.8v 1929.505n 1.8v 1939.495n 1.8v 1939.505n 1.8v 1949.495n 1.8v 1949.505n 1.8v 1959.495n 1.8v 1959.505n 1.8v 1969.495n 1.8v 1969.505n 1.8v 1979.495n 1.8v 1979.505n 1.8v 1989.495n 1.8v 1989.505n 1.8v 1999.495n 1.8v 1999.505n 1.8v 2009.495n 1.8v 2009.505n 1.8v 2019.495n 1.8v 2019.505n 1.8v 2029.495n 1.8v 2029.505n 1.8v 2039.495n 1.8v 2039.505n 1.8v 2049.495n 1.8v 2049.505n 1.8v )
* (time, data): [(0, 0), (10, 1), (20, 0), (30, 0), (40, 0), (50, 0), (60, 0), (70, 0), (80, 0), (90, 1), (100, 1), (110, 1), (120, 0), (130, 0), (140, 0), (150, 0), (160, 0), (170, 0), (180, 1), (190, 1), (200, 0), (210, 0), (220, 0), (230, 0), (240, 0), (250, 0), (260, 0), (270, 0), (280, 0), (290, 0), (300, 1), (310, 1), (320, 1), (330, 0), (340, 0), (350, 0), (360, 0), (370, 1), (380, 1), (390, 1), (400, 1), (410, 1), (420, 1), (430, 1), (440, 1), (450, 1), (460, 0), (470, 0), (480, 0), (490, 0), (500, 0), (510, 0), (520, 0), (530, 0), (540, 0), (550, 0), (560, 0), (570, 0), (580, 0), (590, 0), (600, 0), (610, 0), (620, 0), (630, 0), (640, 1), (650, 1), (660, 0), (670, 0), (680, 0), (690, 0), (700, 0), (710, 0), (720, 0), (730, 0), (740, 0), (750, 0), (760, 0), (770, 0), (780, 0), (790, 0), (800, 0), (810, 0), (820, 0), (830, 0), (840, 0), (850, 0), (860, 1), (870, 1), (880, 1), (890, 1), (900, 1), (910, 1), (920, 1), (930, 1), (940, 1), (950, 1), (960, 0), (970, 0), (980, 0), (990, 0), (1000, 0), (1010, 0), (1020, 0), (1030, 0), (1040, 0), (1050, 0), (1060, 1), (1070, 1), (1080, 1), (1090, 0), (1100, 0), (1110, 0), (1120, 0), (1130, 0), (1140, 0), (1150, 0), (1160, 0), (1170, 0), (1180, 0), (1190, 0), (1200, 0), (1210, 0), (1220, 0), (1230, 0), (1240, 0), (1250, 0), (1260, 1), (1270, 1), (1280, 0), (1290, 0), (1300, 0), (1310, 0), (1320, 0), (1330, 0), (1340, 0), (1350, 0), (1360, 0), (1370, 0), (1380, 0), (1390, 0), (1400, 1), (1410, 1), (1420, 1), (1430, 0), (1440, 0), (1450, 0), (1460, 0), (1470, 0), (1480, 0), (1490, 0), (1500, 0), (1510, 0), (1520, 0), (1530, 0), (1540, 0), (1550, 0), (1560, 0), (1570, 0), (1580, 0), (1590, 0), (1600, 0), (1610, 0), (1620, 0), (1630, 0), (1640, 0), (1650, 0), (1660, 0), (1670, 0), (1680, 0), (1690, 0), (1700, 0), (1710, 0), (1720, 0), (1730, 0), (1740, 0), (1750, 0), (1760, 1), (1770, 1), (1780, 1), (1790, 0), (1800, 0), (1810, 0), (1820, 1), (1830, 1), (1840, 1), (1850, 1), (1860, 1), (1870, 1), (1880, 1), (1890, 1), (1900, 1), (1910, 1), (1920, 1), (1930, 1), (1940, 1), (1950, 1), (1960, 1), (1970, 1), (1980, 1), (1990, 1), (2000, 1), (2010, 1), (2020, 1), (2030, 1), (2040, 1), (2050, 1)]
Vdin0_3  din0_3  0 PWL (0n 0.0v 9.495n 0.0v 9.505n 1.8v 19.495n 1.8v 19.505n 0.0v 29.495n 0.0v 29.505n 0.0v 39.495n 0.0v 39.505n 0.0v 49.495n 0.0v 49.505n 0.0v 59.495n 0.0v 59.505n 0.0v 69.495n 0.0v 69.505n 0.0v 79.495n 0.0v 79.505n 0.0v 89.495n 0.0v 89.505n 1.8v 99.495n 1.8v 99.505n 1.8v 109.495n 1.8v 109.505n 1.8v 119.495n 1.8v 119.505n 0.0v 129.495n 0.0v 129.505n 0.0v 139.495n 0.0v 139.505n 0.0v 149.495n 0.0v 149.505n 0.0v 159.495n 0.0v 159.505n 0.0v 169.495n 0.0v 169.505n 0.0v 179.495n 0.0v 179.505n 1.8v 189.495n 1.8v 189.505n 1.8v 199.495n 1.8v 199.505n 0.0v 209.495n 0.0v 209.505n 0.0v 219.495n 0.0v 219.505n 0.0v 229.495n 0.0v 229.505n 0.0v 239.495n 0.0v 239.505n 0.0v 249.495n 0.0v 249.505n 0.0v 259.495n 0.0v 259.505n 0.0v 269.495n 0.0v 269.505n 0.0v 279.495n 0.0v 279.505n 0.0v 289.495n 0.0v 289.505n 0.0v 299.495n 0.0v 299.505n 1.8v 309.495n 1.8v 309.505n 1.8v 319.495n 1.8v 319.505n 1.8v 329.495n 1.8v 329.505n 0.0v 339.495n 0.0v 339.505n 0.0v 349.495n 0.0v 349.505n 0.0v 359.495n 0.0v 359.505n 0.0v 369.495n 0.0v 369.505n 1.8v 379.495n 1.8v 379.505n 1.8v 389.495n 1.8v 389.505n 1.8v 399.495n 1.8v 399.505n 1.8v 409.495n 1.8v 409.505n 1.8v 419.495n 1.8v 419.505n 1.8v 429.495n 1.8v 429.505n 1.8v 439.495n 1.8v 439.505n 1.8v 449.495n 1.8v 449.505n 1.8v 459.495n 1.8v 459.505n 0.0v 469.495n 0.0v 469.505n 0.0v 479.495n 0.0v 479.505n 0.0v 489.495n 0.0v 489.505n 0.0v 499.495n 0.0v 499.505n 0.0v 509.495n 0.0v 509.505n 0.0v 519.495n 0.0v 519.505n 0.0v 529.495n 0.0v 529.505n 0.0v 539.495n 0.0v 539.505n 0.0v 549.495n 0.0v 549.505n 0.0v 559.495n 0.0v 559.505n 0.0v 569.495n 0.0v 569.505n 0.0v 579.495n 0.0v 579.505n 0.0v 589.495n 0.0v 589.505n 0.0v 599.495n 0.0v 599.505n 0.0v 609.495n 0.0v 609.505n 0.0v 619.495n 0.0v 619.505n 0.0v 629.495n 0.0v 629.505n 0.0v 639.495n 0.0v 639.505n 1.8v 649.495n 1.8v 649.505n 1.8v 659.495n 1.8v 659.505n 0.0v 669.495n 0.0v 669.505n 0.0v 679.495n 0.0v 679.505n 0.0v 689.495n 0.0v 689.505n 0.0v 699.495n 0.0v 699.505n 0.0v 709.495n 0.0v 709.505n 0.0v 719.495n 0.0v 719.505n 0.0v 729.495n 0.0v 729.505n 0.0v 739.495n 0.0v 739.505n 0.0v 749.495n 0.0v 749.505n 0.0v 759.495n 0.0v 759.505n 0.0v 769.495n 0.0v 769.505n 0.0v 779.495n 0.0v 779.505n 0.0v 789.495n 0.0v 789.505n 0.0v 799.495n 0.0v 799.505n 0.0v 809.495n 0.0v 809.505n 0.0v 819.495n 0.0v 819.505n 0.0v 829.495n 0.0v 829.505n 0.0v 839.495n 0.0v 839.505n 0.0v 849.495n 0.0v 849.505n 0.0v 859.495n 0.0v 859.505n 1.8v 869.495n 1.8v 869.505n 1.8v 879.495n 1.8v 879.505n 1.8v 889.495n 1.8v 889.505n 1.8v 899.495n 1.8v 899.505n 1.8v 909.495n 1.8v 909.505n 1.8v 919.495n 1.8v 919.505n 1.8v 929.495n 1.8v 929.505n 1.8v 939.495n 1.8v 939.505n 1.8v 949.495n 1.8v 949.505n 1.8v 959.495n 1.8v 959.505n 0.0v 969.495n 0.0v 969.505n 0.0v 979.495n 0.0v 979.505n 0.0v 989.495n 0.0v 989.505n 0.0v 999.495n 0.0v 999.505n 0.0v 1009.495n 0.0v 1009.505n 0.0v 1019.495n 0.0v 1019.505n 0.0v 1029.495n 0.0v 1029.505n 0.0v 1039.495n 0.0v 1039.505n 0.0v 1049.495n 0.0v 1049.505n 0.0v 1059.495n 0.0v 1059.505n 1.8v 1069.495n 1.8v 1069.505n 1.8v 1079.495n 1.8v 1079.505n 1.8v 1089.495n 1.8v 1089.505n 0.0v 1099.495n 0.0v 1099.505n 0.0v 1109.495n 0.0v 1109.505n 0.0v 1119.495n 0.0v 1119.505n 0.0v 1129.495n 0.0v 1129.505n 0.0v 1139.495n 0.0v 1139.505n 0.0v 1149.495n 0.0v 1149.505n 0.0v 1159.495n 0.0v 1159.505n 0.0v 1169.495n 0.0v 1169.505n 0.0v 1179.495n 0.0v 1179.505n 0.0v 1189.495n 0.0v 1189.505n 0.0v 1199.495n 0.0v 1199.505n 0.0v 1209.495n 0.0v 1209.505n 0.0v 1219.495n 0.0v 1219.505n 0.0v 1229.495n 0.0v 1229.505n 0.0v 1239.495n 0.0v 1239.505n 0.0v 1249.495n 0.0v 1249.505n 0.0v 1259.495n 0.0v 1259.505n 1.8v 1269.495n 1.8v 1269.505n 1.8v 1279.495n 1.8v 1279.505n 0.0v 1289.495n 0.0v 1289.505n 0.0v 1299.495n 0.0v 1299.505n 0.0v 1309.495n 0.0v 1309.505n 0.0v 1319.495n 0.0v 1319.505n 0.0v 1329.495n 0.0v 1329.505n 0.0v 1339.495n 0.0v 1339.505n 0.0v 1349.495n 0.0v 1349.505n 0.0v 1359.495n 0.0v 1359.505n 0.0v 1369.495n 0.0v 1369.505n 0.0v 1379.495n 0.0v 1379.505n 0.0v 1389.495n 0.0v 1389.505n 0.0v 1399.495n 0.0v 1399.505n 1.8v 1409.495n 1.8v 1409.505n 1.8v 1419.495n 1.8v 1419.505n 1.8v 1429.495n 1.8v 1429.505n 0.0v 1439.495n 0.0v 1439.505n 0.0v 1449.495n 0.0v 1449.505n 0.0v 1459.495n 0.0v 1459.505n 0.0v 1469.495n 0.0v 1469.505n 0.0v 1479.495n 0.0v 1479.505n 0.0v 1489.495n 0.0v 1489.505n 0.0v 1499.495n 0.0v 1499.505n 0.0v 1509.495n 0.0v 1509.505n 0.0v 1519.495n 0.0v 1519.505n 0.0v 1529.495n 0.0v 1529.505n 0.0v 1539.495n 0.0v 1539.505n 0.0v 1549.495n 0.0v 1549.505n 0.0v 1559.495n 0.0v 1559.505n 0.0v 1569.495n 0.0v 1569.505n 0.0v 1579.495n 0.0v 1579.505n 0.0v 1589.495n 0.0v 1589.505n 0.0v 1599.495n 0.0v 1599.505n 0.0v 1609.495n 0.0v 1609.505n 0.0v 1619.495n 0.0v 1619.505n 0.0v 1629.495n 0.0v 1629.505n 0.0v 1639.495n 0.0v 1639.505n 0.0v 1649.495n 0.0v 1649.505n 0.0v 1659.495n 0.0v 1659.505n 0.0v 1669.495n 0.0v 1669.505n 0.0v 1679.495n 0.0v 1679.505n 0.0v 1689.495n 0.0v 1689.505n 0.0v 1699.495n 0.0v 1699.505n 0.0v 1709.495n 0.0v 1709.505n 0.0v 1719.495n 0.0v 1719.505n 0.0v 1729.495n 0.0v 1729.505n 0.0v 1739.495n 0.0v 1739.505n 0.0v 1749.495n 0.0v 1749.505n 0.0v 1759.495n 0.0v 1759.505n 1.8v 1769.495n 1.8v 1769.505n 1.8v 1779.495n 1.8v 1779.505n 1.8v 1789.495n 1.8v 1789.505n 0.0v 1799.495n 0.0v 1799.505n 0.0v 1809.495n 0.0v 1809.505n 0.0v 1819.495n 0.0v 1819.505n 1.8v 1829.495n 1.8v 1829.505n 1.8v 1839.495n 1.8v 1839.505n 1.8v 1849.495n 1.8v 1849.505n 1.8v 1859.495n 1.8v 1859.505n 1.8v 1869.495n 1.8v 1869.505n 1.8v 1879.495n 1.8v 1879.505n 1.8v 1889.495n 1.8v 1889.505n 1.8v 1899.495n 1.8v 1899.505n 1.8v 1909.495n 1.8v 1909.505n 1.8v 1919.495n 1.8v 1919.505n 1.8v 1929.495n 1.8v 1929.505n 1.8v 1939.495n 1.8v 1939.505n 1.8v 1949.495n 1.8v 1949.505n 1.8v 1959.495n 1.8v 1959.505n 1.8v 1969.495n 1.8v 1969.505n 1.8v 1979.495n 1.8v 1979.505n 1.8v 1989.495n 1.8v 1989.505n 1.8v 1999.495n 1.8v 1999.505n 1.8v 2009.495n 1.8v 2009.505n 1.8v 2019.495n 1.8v 2019.505n 1.8v 2029.495n 1.8v 2029.505n 1.8v 2039.495n 1.8v 2039.505n 1.8v 2049.495n 1.8v 2049.505n 1.8v )
* (time, data): [(0, 0), (10, 0), (20, 0), (30, 1), (40, 1), (50, 1), (60, 1), (70, 1), (80, 1), (90, 0), (100, 1), (110, 1), (120, 1), (130, 1), (140, 1), (150, 1), (160, 1), (170, 1), (180, 1), (190, 1), (200, 0), (210, 0), (220, 0), (230, 1), (240, 0), (250, 0), (260, 0), (270, 0), (280, 0), (290, 0), (300, 0), (310, 0), (320, 0), (330, 1), (340, 1), (350, 1), (360, 0), (370, 0), (380, 0), (390, 0), (400, 0), (410, 0), (420, 0), (430, 0), (440, 0), (450, 0), (460, 0), (470, 1), (480, 1), (490, 1), (500, 1), (510, 1), (520, 1), (530, 1), (540, 1), (550, 1), (560, 0), (570, 0), (580, 0), (590, 0), (600, 0), (610, 0), (620, 0), (630, 0), (640, 1), (650, 1), (660, 1), (670, 1), (680, 1), (690, 1), (700, 0), (710, 0), (720, 0), (730, 0), (740, 1), (750, 1), (760, 1), (770, 1), (780, 1), (790, 1), (800, 1), (810, 0), (820, 0), (830, 0), (840, 0), (850, 0), (860, 1), (870, 1), (880, 1), (890, 1), (900, 1), (910, 1), (920, 1), (930, 1), (940, 1), (950, 1), (960, 0), (970, 0), (980, 0), (990, 0), (1000, 0), (1010, 0), (1020, 0), (1030, 0), (1040, 0), (1050, 0), (1060, 0), (1070, 0), (1080, 0), (1090, 0), (1100, 0), (1110, 0), (1120, 0), (1130, 0), (1140, 0), (1150, 0), (1160, 0), (1170, 0), (1180, 0), (1190, 0), (1200, 0), (1210, 0), (1220, 0), (1230, 0), (1240, 0), (1250, 1), (1260, 0), (1270, 0), (1280, 1), (1290, 1), (1300, 1), (1310, 1), (1320, 1), (1330, 1), (1340, 1), (1350, 1), (1360, 1), (1370, 0), (1380, 0), (1390, 0), (1400, 1), (1410, 1), (1420, 0), (1430, 0), (1440, 0), (1450, 0), (1460, 0), (1470, 0), (1480, 0), (1490, 0), (1500, 0), (1510, 0), (1520, 0), (1530, 0), (1540, 0), (1550, 1), (1560, 1), (1570, 1), (1580, 1), (1590, 1), (1600, 1), (1610, 1), (1620, 1), (1630, 1), (1640, 1), (1650, 0), (1660, 0), (1670, 0), (1680, 0), (1690, 0), (1700, 0), (1710, 0), (1720, 0), (1730, 0), (1740, 0), (1750, 0), (1760, 0), (1770, 0), (1780, 0), (1790, 1), (1800, 1), (1810, 1), (1820, 1), (1830, 1), (1840, 1), (1850, 0), (1860, 0), (1870, 0), (1880, 0), (1890, 0), (1900, 0), (1910, 1), (1920, 1), (1930, 1), (1940, 1), (1950, 1), (1960, 1), (1970, 1), (1980, 1), (1990, 1), (2000, 1), (2010, 1), (2020, 1), (2030, 1), (2040, 1), (2050, 1)]
Vdin0_4  din0_4  0 PWL (0n 0.0v 9.495n 0.0v 9.505n 0.0v 19.495n 0.0v 19.505n 0.0v 29.495n 0.0v 29.505n 1.8v 39.495n 1.8v 39.505n 1.8v 49.495n 1.8v 49.505n 1.8v 59.495n 1.8v 59.505n 1.8v 69.495n 1.8v 69.505n 1.8v 79.495n 1.8v 79.505n 1.8v 89.495n 1.8v 89.505n 0.0v 99.495n 0.0v 99.505n 1.8v 109.495n 1.8v 109.505n 1.8v 119.495n 1.8v 119.505n 1.8v 129.495n 1.8v 129.505n 1.8v 139.495n 1.8v 139.505n 1.8v 149.495n 1.8v 149.505n 1.8v 159.495n 1.8v 159.505n 1.8v 169.495n 1.8v 169.505n 1.8v 179.495n 1.8v 179.505n 1.8v 189.495n 1.8v 189.505n 1.8v 199.495n 1.8v 199.505n 0.0v 209.495n 0.0v 209.505n 0.0v 219.495n 0.0v 219.505n 0.0v 229.495n 0.0v 229.505n 1.8v 239.495n 1.8v 239.505n 0.0v 249.495n 0.0v 249.505n 0.0v 259.495n 0.0v 259.505n 0.0v 269.495n 0.0v 269.505n 0.0v 279.495n 0.0v 279.505n 0.0v 289.495n 0.0v 289.505n 0.0v 299.495n 0.0v 299.505n 0.0v 309.495n 0.0v 309.505n 0.0v 319.495n 0.0v 319.505n 0.0v 329.495n 0.0v 329.505n 1.8v 339.495n 1.8v 339.505n 1.8v 349.495n 1.8v 349.505n 1.8v 359.495n 1.8v 359.505n 0.0v 369.495n 0.0v 369.505n 0.0v 379.495n 0.0v 379.505n 0.0v 389.495n 0.0v 389.505n 0.0v 399.495n 0.0v 399.505n 0.0v 409.495n 0.0v 409.505n 0.0v 419.495n 0.0v 419.505n 0.0v 429.495n 0.0v 429.505n 0.0v 439.495n 0.0v 439.505n 0.0v 449.495n 0.0v 449.505n 0.0v 459.495n 0.0v 459.505n 0.0v 469.495n 0.0v 469.505n 1.8v 479.495n 1.8v 479.505n 1.8v 489.495n 1.8v 489.505n 1.8v 499.495n 1.8v 499.505n 1.8v 509.495n 1.8v 509.505n 1.8v 519.495n 1.8v 519.505n 1.8v 529.495n 1.8v 529.505n 1.8v 539.495n 1.8v 539.505n 1.8v 549.495n 1.8v 549.505n 1.8v 559.495n 1.8v 559.505n 0.0v 569.495n 0.0v 569.505n 0.0v 579.495n 0.0v 579.505n 0.0v 589.495n 0.0v 589.505n 0.0v 599.495n 0.0v 599.505n 0.0v 609.495n 0.0v 609.505n 0.0v 619.495n 0.0v 619.505n 0.0v 629.495n 0.0v 629.505n 0.0v 639.495n 0.0v 639.505n 1.8v 649.495n 1.8v 649.505n 1.8v 659.495n 1.8v 659.505n 1.8v 669.495n 1.8v 669.505n 1.8v 679.495n 1.8v 679.505n 1.8v 689.495n 1.8v 689.505n 1.8v 699.495n 1.8v 699.505n 0.0v 709.495n 0.0v 709.505n 0.0v 719.495n 0.0v 719.505n 0.0v 729.495n 0.0v 729.505n 0.0v 739.495n 0.0v 739.505n 1.8v 749.495n 1.8v 749.505n 1.8v 759.495n 1.8v 759.505n 1.8v 769.495n 1.8v 769.505n 1.8v 779.495n 1.8v 779.505n 1.8v 789.495n 1.8v 789.505n 1.8v 799.495n 1.8v 799.505n 1.8v 809.495n 1.8v 809.505n 0.0v 819.495n 0.0v 819.505n 0.0v 829.495n 0.0v 829.505n 0.0v 839.495n 0.0v 839.505n 0.0v 849.495n 0.0v 849.505n 0.0v 859.495n 0.0v 859.505n 1.8v 869.495n 1.8v 869.505n 1.8v 879.495n 1.8v 879.505n 1.8v 889.495n 1.8v 889.505n 1.8v 899.495n 1.8v 899.505n 1.8v 909.495n 1.8v 909.505n 1.8v 919.495n 1.8v 919.505n 1.8v 929.495n 1.8v 929.505n 1.8v 939.495n 1.8v 939.505n 1.8v 949.495n 1.8v 949.505n 1.8v 959.495n 1.8v 959.505n 0.0v 969.495n 0.0v 969.505n 0.0v 979.495n 0.0v 979.505n 0.0v 989.495n 0.0v 989.505n 0.0v 999.495n 0.0v 999.505n 0.0v 1009.495n 0.0v 1009.505n 0.0v 1019.495n 0.0v 1019.505n 0.0v 1029.495n 0.0v 1029.505n 0.0v 1039.495n 0.0v 1039.505n 0.0v 1049.495n 0.0v 1049.505n 0.0v 1059.495n 0.0v 1059.505n 0.0v 1069.495n 0.0v 1069.505n 0.0v 1079.495n 0.0v 1079.505n 0.0v 1089.495n 0.0v 1089.505n 0.0v 1099.495n 0.0v 1099.505n 0.0v 1109.495n 0.0v 1109.505n 0.0v 1119.495n 0.0v 1119.505n 0.0v 1129.495n 0.0v 1129.505n 0.0v 1139.495n 0.0v 1139.505n 0.0v 1149.495n 0.0v 1149.505n 0.0v 1159.495n 0.0v 1159.505n 0.0v 1169.495n 0.0v 1169.505n 0.0v 1179.495n 0.0v 1179.505n 0.0v 1189.495n 0.0v 1189.505n 0.0v 1199.495n 0.0v 1199.505n 0.0v 1209.495n 0.0v 1209.505n 0.0v 1219.495n 0.0v 1219.505n 0.0v 1229.495n 0.0v 1229.505n 0.0v 1239.495n 0.0v 1239.505n 0.0v 1249.495n 0.0v 1249.505n 1.8v 1259.495n 1.8v 1259.505n 0.0v 1269.495n 0.0v 1269.505n 0.0v 1279.495n 0.0v 1279.505n 1.8v 1289.495n 1.8v 1289.505n 1.8v 1299.495n 1.8v 1299.505n 1.8v 1309.495n 1.8v 1309.505n 1.8v 1319.495n 1.8v 1319.505n 1.8v 1329.495n 1.8v 1329.505n 1.8v 1339.495n 1.8v 1339.505n 1.8v 1349.495n 1.8v 1349.505n 1.8v 1359.495n 1.8v 1359.505n 1.8v 1369.495n 1.8v 1369.505n 0.0v 1379.495n 0.0v 1379.505n 0.0v 1389.495n 0.0v 1389.505n 0.0v 1399.495n 0.0v 1399.505n 1.8v 1409.495n 1.8v 1409.505n 1.8v 1419.495n 1.8v 1419.505n 0.0v 1429.495n 0.0v 1429.505n 0.0v 1439.495n 0.0v 1439.505n 0.0v 1449.495n 0.0v 1449.505n 0.0v 1459.495n 0.0v 1459.505n 0.0v 1469.495n 0.0v 1469.505n 0.0v 1479.495n 0.0v 1479.505n 0.0v 1489.495n 0.0v 1489.505n 0.0v 1499.495n 0.0v 1499.505n 0.0v 1509.495n 0.0v 1509.505n 0.0v 1519.495n 0.0v 1519.505n 0.0v 1529.495n 0.0v 1529.505n 0.0v 1539.495n 0.0v 1539.505n 0.0v 1549.495n 0.0v 1549.505n 1.8v 1559.495n 1.8v 1559.505n 1.8v 1569.495n 1.8v 1569.505n 1.8v 1579.495n 1.8v 1579.505n 1.8v 1589.495n 1.8v 1589.505n 1.8v 1599.495n 1.8v 1599.505n 1.8v 1609.495n 1.8v 1609.505n 1.8v 1619.495n 1.8v 1619.505n 1.8v 1629.495n 1.8v 1629.505n 1.8v 1639.495n 1.8v 1639.505n 1.8v 1649.495n 1.8v 1649.505n 0.0v 1659.495n 0.0v 1659.505n 0.0v 1669.495n 0.0v 1669.505n 0.0v 1679.495n 0.0v 1679.505n 0.0v 1689.495n 0.0v 1689.505n 0.0v 1699.495n 0.0v 1699.505n 0.0v 1709.495n 0.0v 1709.505n 0.0v 1719.495n 0.0v 1719.505n 0.0v 1729.495n 0.0v 1729.505n 0.0v 1739.495n 0.0v 1739.505n 0.0v 1749.495n 0.0v 1749.505n 0.0v 1759.495n 0.0v 1759.505n 0.0v 1769.495n 0.0v 1769.505n 0.0v 1779.495n 0.0v 1779.505n 0.0v 1789.495n 0.0v 1789.505n 1.8v 1799.495n 1.8v 1799.505n 1.8v 1809.495n 1.8v 1809.505n 1.8v 1819.495n 1.8v 1819.505n 1.8v 1829.495n 1.8v 1829.505n 1.8v 1839.495n 1.8v 1839.505n 1.8v 1849.495n 1.8v 1849.505n 0.0v 1859.495n 0.0v 1859.505n 0.0v 1869.495n 0.0v 1869.505n 0.0v 1879.495n 0.0v 1879.505n 0.0v 1889.495n 0.0v 1889.505n 0.0v 1899.495n 0.0v 1899.505n 0.0v 1909.495n 0.0v 1909.505n 1.8v 1919.495n 1.8v 1919.505n 1.8v 1929.495n 1.8v 1929.505n 1.8v 1939.495n 1.8v 1939.505n 1.8v 1949.495n 1.8v 1949.505n 1.8v 1959.495n 1.8v 1959.505n 1.8v 1969.495n 1.8v 1969.505n 1.8v 1979.495n 1.8v 1979.505n 1.8v 1989.495n 1.8v 1989.505n 1.8v 1999.495n 1.8v 1999.505n 1.8v 2009.495n 1.8v 2009.505n 1.8v 2019.495n 1.8v 2019.505n 1.8v 2029.495n 1.8v 2029.505n 1.8v 2039.495n 1.8v 2039.505n 1.8v 2049.495n 1.8v 2049.505n 1.8v )
* (time, data): [(0, 0), (10, 0), (20, 0), (30, 1), (40, 1), (50, 1), (60, 1), (70, 1), (80, 1), (90, 1), (100, 1), (110, 1), (120, 0), (130, 0), (140, 0), (150, 0), (160, 0), (170, 0), (180, 0), (190, 0), (200, 1), (210, 1), (220, 1), (230, 0), (240, 0), (250, 0), (260, 0), (270, 0), (280, 0), (290, 1), (300, 1), (310, 1), (320, 1), (330, 0), (340, 0), (350, 0), (360, 1), (370, 1), (380, 1), (390, 1), (400, 1), (410, 1), (420, 1), (430, 1), (440, 1), (450, 1), (460, 0), (470, 0), (480, 0), (490, 0), (500, 0), (510, 0), (520, 0), (530, 0), (540, 0), (550, 0), (560, 1), (570, 1), (580, 1), (590, 1), (600, 1), (610, 1), (620, 1), (630, 1), (640, 1), (650, 1), (660, 0), (670, 0), (680, 1), (690, 1), (700, 0), (710, 0), (720, 0), (730, 0), (740, 0), (750, 0), (760, 0), (770, 0), (780, 0), (790, 0), (800, 0), (810, 0), (820, 0), (830, 0), (840, 0), (850, 0), (860, 1), (870, 0), (880, 0), (890, 0), (900, 0), (910, 0), (920, 0), (930, 0), (940, 0), (950, 0), (960, 0), (970, 0), (980, 0), (990, 0), (1000, 0), (1010, 0), (1020, 0), (1030, 0), (1040, 0), (1050, 0), (1060, 1), (1070, 1), (1080, 1), (1090, 1), (1100, 1), (1110, 1), (1120, 1), (1130, 1), (1140, 0), (1150, 0), (1160, 1), (1170, 1), (1180, 1), (1190, 1), (1200, 1), (1210, 1), (1220, 1), (1230, 1), (1240, 1), (1250, 0), (1260, 1), (1270, 1), (1280, 0), (1290, 0), (1300, 0), (1310, 0), (1320, 0), (1330, 0), (1340, 0), (1350, 0), (1360, 0), (1370, 1), (1380, 1), (1390, 1), (1400, 1), (1410, 1), (1420, 0), (1430, 0), (1440, 0), (1450, 0), (1460, 0), (1470, 0), (1480, 0), (1490, 0), (1500, 0), (1510, 0), (1520, 0), (1530, 0), (1540, 0), (1550, 1), (1560, 1), (1570, 1), (1580, 1), (1590, 1), (1600, 1), (1610, 1), (1620, 1), (1630, 1), (1640, 1), (1650, 1), (1660, 1), (1670, 1), (1680, 1), (1690, 1), (1700, 1), (1710, 1), (1720, 1), (1730, 1), (1740, 1), (1750, 1), (1760, 1), (1770, 1), (1780, 1), (1790, 0), (1800, 0), (1810, 0), (1820, 1), (1830, 1), (1840, 1), (1850, 1), (1860, 1), (1870, 1), (1880, 1), (1890, 1), (1900, 1), (1910, 1), (1920, 1), (1930, 1), (1940, 1), (1950, 1), (1960, 1), (1970, 1), (1980, 1), (1990, 1), (2000, 1), (2010, 1), (2020, 1), (2030, 1), (2040, 1), (2050, 1)]
Vdin0_5  din0_5  0 PWL (0n 0.0v 9.495n 0.0v 9.505n 0.0v 19.495n 0.0v 19.505n 0.0v 29.495n 0.0v 29.505n 1.8v 39.495n 1.8v 39.505n 1.8v 49.495n 1.8v 49.505n 1.8v 59.495n 1.8v 59.505n 1.8v 69.495n 1.8v 69.505n 1.8v 79.495n 1.8v 79.505n 1.8v 89.495n 1.8v 89.505n 1.8v 99.495n 1.8v 99.505n 1.8v 109.495n 1.8v 109.505n 1.8v 119.495n 1.8v 119.505n 0.0v 129.495n 0.0v 129.505n 0.0v 139.495n 0.0v 139.505n 0.0v 149.495n 0.0v 149.505n 0.0v 159.495n 0.0v 159.505n 0.0v 169.495n 0.0v 169.505n 0.0v 179.495n 0.0v 179.505n 0.0v 189.495n 0.0v 189.505n 0.0v 199.495n 0.0v 199.505n 1.8v 209.495n 1.8v 209.505n 1.8v 219.495n 1.8v 219.505n 1.8v 229.495n 1.8v 229.505n 0.0v 239.495n 0.0v 239.505n 0.0v 249.495n 0.0v 249.505n 0.0v 259.495n 0.0v 259.505n 0.0v 269.495n 0.0v 269.505n 0.0v 279.495n 0.0v 279.505n 0.0v 289.495n 0.0v 289.505n 1.8v 299.495n 1.8v 299.505n 1.8v 309.495n 1.8v 309.505n 1.8v 319.495n 1.8v 319.505n 1.8v 329.495n 1.8v 329.505n 0.0v 339.495n 0.0v 339.505n 0.0v 349.495n 0.0v 349.505n 0.0v 359.495n 0.0v 359.505n 1.8v 369.495n 1.8v 369.505n 1.8v 379.495n 1.8v 379.505n 1.8v 389.495n 1.8v 389.505n 1.8v 399.495n 1.8v 399.505n 1.8v 409.495n 1.8v 409.505n 1.8v 419.495n 1.8v 419.505n 1.8v 429.495n 1.8v 429.505n 1.8v 439.495n 1.8v 439.505n 1.8v 449.495n 1.8v 449.505n 1.8v 459.495n 1.8v 459.505n 0.0v 469.495n 0.0v 469.505n 0.0v 479.495n 0.0v 479.505n 0.0v 489.495n 0.0v 489.505n 0.0v 499.495n 0.0v 499.505n 0.0v 509.495n 0.0v 509.505n 0.0v 519.495n 0.0v 519.505n 0.0v 529.495n 0.0v 529.505n 0.0v 539.495n 0.0v 539.505n 0.0v 549.495n 0.0v 549.505n 0.0v 559.495n 0.0v 559.505n 1.8v 569.495n 1.8v 569.505n 1.8v 579.495n 1.8v 579.505n 1.8v 589.495n 1.8v 589.505n 1.8v 599.495n 1.8v 599.505n 1.8v 609.495n 1.8v 609.505n 1.8v 619.495n 1.8v 619.505n 1.8v 629.495n 1.8v 629.505n 1.8v 639.495n 1.8v 639.505n 1.8v 649.495n 1.8v 649.505n 1.8v 659.495n 1.8v 659.505n 0.0v 669.495n 0.0v 669.505n 0.0v 679.495n 0.0v 679.505n 1.8v 689.495n 1.8v 689.505n 1.8v 699.495n 1.8v 699.505n 0.0v 709.495n 0.0v 709.505n 0.0v 719.495n 0.0v 719.505n 0.0v 729.495n 0.0v 729.505n 0.0v 739.495n 0.0v 739.505n 0.0v 749.495n 0.0v 749.505n 0.0v 759.495n 0.0v 759.505n 0.0v 769.495n 0.0v 769.505n 0.0v 779.495n 0.0v 779.505n 0.0v 789.495n 0.0v 789.505n 0.0v 799.495n 0.0v 799.505n 0.0v 809.495n 0.0v 809.505n 0.0v 819.495n 0.0v 819.505n 0.0v 829.495n 0.0v 829.505n 0.0v 839.495n 0.0v 839.505n 0.0v 849.495n 0.0v 849.505n 0.0v 859.495n 0.0v 859.505n 1.8v 869.495n 1.8v 869.505n 0.0v 879.495n 0.0v 879.505n 0.0v 889.495n 0.0v 889.505n 0.0v 899.495n 0.0v 899.505n 0.0v 909.495n 0.0v 909.505n 0.0v 919.495n 0.0v 919.505n 0.0v 929.495n 0.0v 929.505n 0.0v 939.495n 0.0v 939.505n 0.0v 949.495n 0.0v 949.505n 0.0v 959.495n 0.0v 959.505n 0.0v 969.495n 0.0v 969.505n 0.0v 979.495n 0.0v 979.505n 0.0v 989.495n 0.0v 989.505n 0.0v 999.495n 0.0v 999.505n 0.0v 1009.495n 0.0v 1009.505n 0.0v 1019.495n 0.0v 1019.505n 0.0v 1029.495n 0.0v 1029.505n 0.0v 1039.495n 0.0v 1039.505n 0.0v 1049.495n 0.0v 1049.505n 0.0v 1059.495n 0.0v 1059.505n 1.8v 1069.495n 1.8v 1069.505n 1.8v 1079.495n 1.8v 1079.505n 1.8v 1089.495n 1.8v 1089.505n 1.8v 1099.495n 1.8v 1099.505n 1.8v 1109.495n 1.8v 1109.505n 1.8v 1119.495n 1.8v 1119.505n 1.8v 1129.495n 1.8v 1129.505n 1.8v 1139.495n 1.8v 1139.505n 0.0v 1149.495n 0.0v 1149.505n 0.0v 1159.495n 0.0v 1159.505n 1.8v 1169.495n 1.8v 1169.505n 1.8v 1179.495n 1.8v 1179.505n 1.8v 1189.495n 1.8v 1189.505n 1.8v 1199.495n 1.8v 1199.505n 1.8v 1209.495n 1.8v 1209.505n 1.8v 1219.495n 1.8v 1219.505n 1.8v 1229.495n 1.8v 1229.505n 1.8v 1239.495n 1.8v 1239.505n 1.8v 1249.495n 1.8v 1249.505n 0.0v 1259.495n 0.0v 1259.505n 1.8v 1269.495n 1.8v 1269.505n 1.8v 1279.495n 1.8v 1279.505n 0.0v 1289.495n 0.0v 1289.505n 0.0v 1299.495n 0.0v 1299.505n 0.0v 1309.495n 0.0v 1309.505n 0.0v 1319.495n 0.0v 1319.505n 0.0v 1329.495n 0.0v 1329.505n 0.0v 1339.495n 0.0v 1339.505n 0.0v 1349.495n 0.0v 1349.505n 0.0v 1359.495n 0.0v 1359.505n 0.0v 1369.495n 0.0v 1369.505n 1.8v 1379.495n 1.8v 1379.505n 1.8v 1389.495n 1.8v 1389.505n 1.8v 1399.495n 1.8v 1399.505n 1.8v 1409.495n 1.8v 1409.505n 1.8v 1419.495n 1.8v 1419.505n 0.0v 1429.495n 0.0v 1429.505n 0.0v 1439.495n 0.0v 1439.505n 0.0v 1449.495n 0.0v 1449.505n 0.0v 1459.495n 0.0v 1459.505n 0.0v 1469.495n 0.0v 1469.505n 0.0v 1479.495n 0.0v 1479.505n 0.0v 1489.495n 0.0v 1489.505n 0.0v 1499.495n 0.0v 1499.505n 0.0v 1509.495n 0.0v 1509.505n 0.0v 1519.495n 0.0v 1519.505n 0.0v 1529.495n 0.0v 1529.505n 0.0v 1539.495n 0.0v 1539.505n 0.0v 1549.495n 0.0v 1549.505n 1.8v 1559.495n 1.8v 1559.505n 1.8v 1569.495n 1.8v 1569.505n 1.8v 1579.495n 1.8v 1579.505n 1.8v 1589.495n 1.8v 1589.505n 1.8v 1599.495n 1.8v 1599.505n 1.8v 1609.495n 1.8v 1609.505n 1.8v 1619.495n 1.8v 1619.505n 1.8v 1629.495n 1.8v 1629.505n 1.8v 1639.495n 1.8v 1639.505n 1.8v 1649.495n 1.8v 1649.505n 1.8v 1659.495n 1.8v 1659.505n 1.8v 1669.495n 1.8v 1669.505n 1.8v 1679.495n 1.8v 1679.505n 1.8v 1689.495n 1.8v 1689.505n 1.8v 1699.495n 1.8v 1699.505n 1.8v 1709.495n 1.8v 1709.505n 1.8v 1719.495n 1.8v 1719.505n 1.8v 1729.495n 1.8v 1729.505n 1.8v 1739.495n 1.8v 1739.505n 1.8v 1749.495n 1.8v 1749.505n 1.8v 1759.495n 1.8v 1759.505n 1.8v 1769.495n 1.8v 1769.505n 1.8v 1779.495n 1.8v 1779.505n 1.8v 1789.495n 1.8v 1789.505n 0.0v 1799.495n 0.0v 1799.505n 0.0v 1809.495n 0.0v 1809.505n 0.0v 1819.495n 0.0v 1819.505n 1.8v 1829.495n 1.8v 1829.505n 1.8v 1839.495n 1.8v 1839.505n 1.8v 1849.495n 1.8v 1849.505n 1.8v 1859.495n 1.8v 1859.505n 1.8v 1869.495n 1.8v 1869.505n 1.8v 1879.495n 1.8v 1879.505n 1.8v 1889.495n 1.8v 1889.505n 1.8v 1899.495n 1.8v 1899.505n 1.8v 1909.495n 1.8v 1909.505n 1.8v 1919.495n 1.8v 1919.505n 1.8v 1929.495n 1.8v 1929.505n 1.8v 1939.495n 1.8v 1939.505n 1.8v 1949.495n 1.8v 1949.505n 1.8v 1959.495n 1.8v 1959.505n 1.8v 1969.495n 1.8v 1969.505n 1.8v 1979.495n 1.8v 1979.505n 1.8v 1989.495n 1.8v 1989.505n 1.8v 1999.495n 1.8v 1999.505n 1.8v 2009.495n 1.8v 2009.505n 1.8v 2019.495n 1.8v 2019.505n 1.8v 2029.495n 1.8v 2029.505n 1.8v 2039.495n 1.8v 2039.505n 1.8v 2049.495n 1.8v 2049.505n 1.8v )
* (time, data): [(0, 0), (10, 0), (20, 0), (30, 0), (40, 0), (50, 0), (60, 0), (70, 0), (80, 0), (90, 1), (100, 1), (110, 1), (120, 1), (130, 1), (140, 1), (150, 1), (160, 1), (170, 1), (180, 1), (190, 1), (200, 0), (210, 0), (220, 0), (230, 1), (240, 0), (250, 0), (260, 0), (270, 0), (280, 0), (290, 1), (300, 0), (310, 0), (320, 0), (330, 1), (340, 1), (350, 1), (360, 0), (370, 0), (380, 0), (390, 0), (400, 0), (410, 0), (420, 0), (430, 0), (440, 0), (450, 0), (460, 0), (470, 0), (480, 0), (490, 0), (500, 0), (510, 0), (520, 0), (530, 0), (540, 0), (550, 0), (560, 0), (570, 0), (580, 0), (590, 0), (600, 0), (610, 0), (620, 0), (630, 0), (640, 0), (650, 0), (660, 0), (670, 0), (680, 1), (690, 1), (700, 1), (710, 1), (720, 1), (730, 1), (740, 0), (750, 0), (760, 0), (770, 0), (780, 0), (790, 0), (800, 0), (810, 0), (820, 0), (830, 0), (840, 0), (850, 0), (860, 1), (870, 1), (880, 1), (890, 1), (900, 1), (910, 1), (920, 1), (930, 0), (940, 0), (950, 0), (960, 0), (970, 0), (980, 0), (990, 0), (1000, 0), (1010, 0), (1020, 0), (1030, 0), (1040, 0), (1050, 0), (1060, 1), (1070, 1), (1080, 1), (1090, 1), (1100, 1), (1110, 1), (1120, 1), (1130, 1), (1140, 1), (1150, 1), (1160, 1), (1170, 1), (1180, 1), (1190, 1), (1200, 1), (1210, 1), (1220, 1), (1230, 1), (1240, 1), (1250, 1), (1260, 0), (1270, 0), (1280, 1), (1290, 1), (1300, 1), (1310, 1), (1320, 1), (1330, 1), (1340, 1), (1350, 1), (1360, 1), (1370, 0), (1380, 0), (1390, 0), (1400, 1), (1410, 1), (1420, 0), (1430, 0), (1440, 0), (1450, 0), (1460, 0), (1470, 0), (1480, 0), (1490, 1), (1500, 1), (1510, 1), (1520, 1), (1530, 1), (1540, 1), (1550, 0), (1560, 0), (1570, 0), (1580, 0), (1590, 0), (1600, 0), (1610, 0), (1620, 0), (1630, 0), (1640, 0), (1650, 0), (1660, 0), (1670, 0), (1680, 0), (1690, 0), (1700, 0), (1710, 0), (1720, 0), (1730, 0), (1740, 0), (1750, 0), (1760, 0), (1770, 0), (1780, 0), (1790, 0), (1800, 0), (1810, 0), (1820, 1), (1830, 1), (1840, 1), (1850, 1), (1860, 1), (1870, 1), (1880, 1), (1890, 1), (1900, 1), (1910, 1), (1920, 1), (1930, 1), (1940, 1), (1950, 1), (1960, 1), (1970, 1), (1980, 1), (1990, 1), (2000, 1), (2010, 1), (2020, 1), (2030, 1), (2040, 1), (2050, 1)]
Vdin0_6  din0_6  0 PWL (0n 0.0v 9.495n 0.0v 9.505n 0.0v 19.495n 0.0v 19.505n 0.0v 29.495n 0.0v 29.505n 0.0v 39.495n 0.0v 39.505n 0.0v 49.495n 0.0v 49.505n 0.0v 59.495n 0.0v 59.505n 0.0v 69.495n 0.0v 69.505n 0.0v 79.495n 0.0v 79.505n 0.0v 89.495n 0.0v 89.505n 1.8v 99.495n 1.8v 99.505n 1.8v 109.495n 1.8v 109.505n 1.8v 119.495n 1.8v 119.505n 1.8v 129.495n 1.8v 129.505n 1.8v 139.495n 1.8v 139.505n 1.8v 149.495n 1.8v 149.505n 1.8v 159.495n 1.8v 159.505n 1.8v 169.495n 1.8v 169.505n 1.8v 179.495n 1.8v 179.505n 1.8v 189.495n 1.8v 189.505n 1.8v 199.495n 1.8v 199.505n 0.0v 209.495n 0.0v 209.505n 0.0v 219.495n 0.0v 219.505n 0.0v 229.495n 0.0v 229.505n 1.8v 239.495n 1.8v 239.505n 0.0v 249.495n 0.0v 249.505n 0.0v 259.495n 0.0v 259.505n 0.0v 269.495n 0.0v 269.505n 0.0v 279.495n 0.0v 279.505n 0.0v 289.495n 0.0v 289.505n 1.8v 299.495n 1.8v 299.505n 0.0v 309.495n 0.0v 309.505n 0.0v 319.495n 0.0v 319.505n 0.0v 329.495n 0.0v 329.505n 1.8v 339.495n 1.8v 339.505n 1.8v 349.495n 1.8v 349.505n 1.8v 359.495n 1.8v 359.505n 0.0v 369.495n 0.0v 369.505n 0.0v 379.495n 0.0v 379.505n 0.0v 389.495n 0.0v 389.505n 0.0v 399.495n 0.0v 399.505n 0.0v 409.495n 0.0v 409.505n 0.0v 419.495n 0.0v 419.505n 0.0v 429.495n 0.0v 429.505n 0.0v 439.495n 0.0v 439.505n 0.0v 449.495n 0.0v 449.505n 0.0v 459.495n 0.0v 459.505n 0.0v 469.495n 0.0v 469.505n 0.0v 479.495n 0.0v 479.505n 0.0v 489.495n 0.0v 489.505n 0.0v 499.495n 0.0v 499.505n 0.0v 509.495n 0.0v 509.505n 0.0v 519.495n 0.0v 519.505n 0.0v 529.495n 0.0v 529.505n 0.0v 539.495n 0.0v 539.505n 0.0v 549.495n 0.0v 549.505n 0.0v 559.495n 0.0v 559.505n 0.0v 569.495n 0.0v 569.505n 0.0v 579.495n 0.0v 579.505n 0.0v 589.495n 0.0v 589.505n 0.0v 599.495n 0.0v 599.505n 0.0v 609.495n 0.0v 609.505n 0.0v 619.495n 0.0v 619.505n 0.0v 629.495n 0.0v 629.505n 0.0v 639.495n 0.0v 639.505n 0.0v 649.495n 0.0v 649.505n 0.0v 659.495n 0.0v 659.505n 0.0v 669.495n 0.0v 669.505n 0.0v 679.495n 0.0v 679.505n 1.8v 689.495n 1.8v 689.505n 1.8v 699.495n 1.8v 699.505n 1.8v 709.495n 1.8v 709.505n 1.8v 719.495n 1.8v 719.505n 1.8v 729.495n 1.8v 729.505n 1.8v 739.495n 1.8v 739.505n 0.0v 749.495n 0.0v 749.505n 0.0v 759.495n 0.0v 759.505n 0.0v 769.495n 0.0v 769.505n 0.0v 779.495n 0.0v 779.505n 0.0v 789.495n 0.0v 789.505n 0.0v 799.495n 0.0v 799.505n 0.0v 809.495n 0.0v 809.505n 0.0v 819.495n 0.0v 819.505n 0.0v 829.495n 0.0v 829.505n 0.0v 839.495n 0.0v 839.505n 0.0v 849.495n 0.0v 849.505n 0.0v 859.495n 0.0v 859.505n 1.8v 869.495n 1.8v 869.505n 1.8v 879.495n 1.8v 879.505n 1.8v 889.495n 1.8v 889.505n 1.8v 899.495n 1.8v 899.505n 1.8v 909.495n 1.8v 909.505n 1.8v 919.495n 1.8v 919.505n 1.8v 929.495n 1.8v 929.505n 0.0v 939.495n 0.0v 939.505n 0.0v 949.495n 0.0v 949.505n 0.0v 959.495n 0.0v 959.505n 0.0v 969.495n 0.0v 969.505n 0.0v 979.495n 0.0v 979.505n 0.0v 989.495n 0.0v 989.505n 0.0v 999.495n 0.0v 999.505n 0.0v 1009.495n 0.0v 1009.505n 0.0v 1019.495n 0.0v 1019.505n 0.0v 1029.495n 0.0v 1029.505n 0.0v 1039.495n 0.0v 1039.505n 0.0v 1049.495n 0.0v 1049.505n 0.0v 1059.495n 0.0v 1059.505n 1.8v 1069.495n 1.8v 1069.505n 1.8v 1079.495n 1.8v 1079.505n 1.8v 1089.495n 1.8v 1089.505n 1.8v 1099.495n 1.8v 1099.505n 1.8v 1109.495n 1.8v 1109.505n 1.8v 1119.495n 1.8v 1119.505n 1.8v 1129.495n 1.8v 1129.505n 1.8v 1139.495n 1.8v 1139.505n 1.8v 1149.495n 1.8v 1149.505n 1.8v 1159.495n 1.8v 1159.505n 1.8v 1169.495n 1.8v 1169.505n 1.8v 1179.495n 1.8v 1179.505n 1.8v 1189.495n 1.8v 1189.505n 1.8v 1199.495n 1.8v 1199.505n 1.8v 1209.495n 1.8v 1209.505n 1.8v 1219.495n 1.8v 1219.505n 1.8v 1229.495n 1.8v 1229.505n 1.8v 1239.495n 1.8v 1239.505n 1.8v 1249.495n 1.8v 1249.505n 1.8v 1259.495n 1.8v 1259.505n 0.0v 1269.495n 0.0v 1269.505n 0.0v 1279.495n 0.0v 1279.505n 1.8v 1289.495n 1.8v 1289.505n 1.8v 1299.495n 1.8v 1299.505n 1.8v 1309.495n 1.8v 1309.505n 1.8v 1319.495n 1.8v 1319.505n 1.8v 1329.495n 1.8v 1329.505n 1.8v 1339.495n 1.8v 1339.505n 1.8v 1349.495n 1.8v 1349.505n 1.8v 1359.495n 1.8v 1359.505n 1.8v 1369.495n 1.8v 1369.505n 0.0v 1379.495n 0.0v 1379.505n 0.0v 1389.495n 0.0v 1389.505n 0.0v 1399.495n 0.0v 1399.505n 1.8v 1409.495n 1.8v 1409.505n 1.8v 1419.495n 1.8v 1419.505n 0.0v 1429.495n 0.0v 1429.505n 0.0v 1439.495n 0.0v 1439.505n 0.0v 1449.495n 0.0v 1449.505n 0.0v 1459.495n 0.0v 1459.505n 0.0v 1469.495n 0.0v 1469.505n 0.0v 1479.495n 0.0v 1479.505n 0.0v 1489.495n 0.0v 1489.505n 1.8v 1499.495n 1.8v 1499.505n 1.8v 1509.495n 1.8v 1509.505n 1.8v 1519.495n 1.8v 1519.505n 1.8v 1529.495n 1.8v 1529.505n 1.8v 1539.495n 1.8v 1539.505n 1.8v 1549.495n 1.8v 1549.505n 0.0v 1559.495n 0.0v 1559.505n 0.0v 1569.495n 0.0v 1569.505n 0.0v 1579.495n 0.0v 1579.505n 0.0v 1589.495n 0.0v 1589.505n 0.0v 1599.495n 0.0v 1599.505n 0.0v 1609.495n 0.0v 1609.505n 0.0v 1619.495n 0.0v 1619.505n 0.0v 1629.495n 0.0v 1629.505n 0.0v 1639.495n 0.0v 1639.505n 0.0v 1649.495n 0.0v 1649.505n 0.0v 1659.495n 0.0v 1659.505n 0.0v 1669.495n 0.0v 1669.505n 0.0v 1679.495n 0.0v 1679.505n 0.0v 1689.495n 0.0v 1689.505n 0.0v 1699.495n 0.0v 1699.505n 0.0v 1709.495n 0.0v 1709.505n 0.0v 1719.495n 0.0v 1719.505n 0.0v 1729.495n 0.0v 1729.505n 0.0v 1739.495n 0.0v 1739.505n 0.0v 1749.495n 0.0v 1749.505n 0.0v 1759.495n 0.0v 1759.505n 0.0v 1769.495n 0.0v 1769.505n 0.0v 1779.495n 0.0v 1779.505n 0.0v 1789.495n 0.0v 1789.505n 0.0v 1799.495n 0.0v 1799.505n 0.0v 1809.495n 0.0v 1809.505n 0.0v 1819.495n 0.0v 1819.505n 1.8v 1829.495n 1.8v 1829.505n 1.8v 1839.495n 1.8v 1839.505n 1.8v 1849.495n 1.8v 1849.505n 1.8v 1859.495n 1.8v 1859.505n 1.8v 1869.495n 1.8v 1869.505n 1.8v 1879.495n 1.8v 1879.505n 1.8v 1889.495n 1.8v 1889.505n 1.8v 1899.495n 1.8v 1899.505n 1.8v 1909.495n 1.8v 1909.505n 1.8v 1919.495n 1.8v 1919.505n 1.8v 1929.495n 1.8v 1929.505n 1.8v 1939.495n 1.8v 1939.505n 1.8v 1949.495n 1.8v 1949.505n 1.8v 1959.495n 1.8v 1959.505n 1.8v 1969.495n 1.8v 1969.505n 1.8v 1979.495n 1.8v 1979.505n 1.8v 1989.495n 1.8v 1989.505n 1.8v 1999.495n 1.8v 1999.505n 1.8v 2009.495n 1.8v 2009.505n 1.8v 2019.495n 1.8v 2019.505n 1.8v 2029.495n 1.8v 2029.505n 1.8v 2039.495n 1.8v 2039.505n 1.8v 2049.495n 1.8v 2049.505n 1.8v )
* (time, data): [(0, 0), (10, 1), (20, 1), (30, 1), (40, 1), (50, 1), (60, 1), (70, 1), (80, 1), (90, 0), (100, 0), (110, 0), (120, 1), (130, 1), (140, 1), (150, 1), (160, 1), (170, 1), (180, 1), (190, 1), (200, 1), (210, 1), (220, 1), (230, 0), (240, 0), (250, 0), (260, 0), (270, 0), (280, 0), (290, 0), (300, 0), (310, 0), (320, 0), (330, 1), (340, 1), (350, 1), (360, 0), (370, 0), (380, 0), (390, 0), (400, 0), (410, 0), (420, 0), (430, 0), (440, 0), (450, 0), (460, 1), (470, 1), (480, 1), (490, 1), (500, 1), (510, 1), (520, 1), (530, 1), (540, 1), (550, 1), (560, 0), (570, 0), (580, 0), (590, 0), (600, 0), (610, 0), (620, 0), (630, 0), (640, 1), (650, 1), (660, 0), (670, 0), (680, 1), (690, 1), (700, 1), (710, 1), (720, 1), (730, 1), (740, 1), (750, 1), (760, 1), (770, 1), (780, 1), (790, 1), (800, 1), (810, 1), (820, 1), (830, 1), (840, 1), (850, 1), (860, 0), (870, 1), (880, 1), (890, 1), (900, 1), (910, 1), (920, 1), (930, 0), (940, 0), (950, 0), (960, 0), (970, 0), (980, 0), (990, 0), (1000, 0), (1010, 0), (1020, 0), (1030, 0), (1040, 0), (1050, 1), (1060, 0), (1070, 0), (1080, 0), (1090, 1), (1100, 1), (1110, 1), (1120, 1), (1130, 1), (1140, 1), (1150, 1), (1160, 1), (1170, 1), (1180, 1), (1190, 1), (1200, 1), (1210, 1), (1220, 1), (1230, 1), (1240, 1), (1250, 1), (1260, 0), (1270, 0), (1280, 1), (1290, 1), (1300, 1), (1310, 1), (1320, 1), (1330, 1), (1340, 1), (1350, 1), (1360, 1), (1370, 0), (1380, 0), (1390, 0), (1400, 1), (1410, 1), (1420, 0), (1430, 0), (1440, 0), (1450, 0), (1460, 0), (1470, 0), (1480, 0), (1490, 0), (1500, 0), (1510, 0), (1520, 0), (1530, 0), (1540, 0), (1550, 1), (1560, 1), (1570, 1), (1580, 1), (1590, 1), (1600, 1), (1610, 1), (1620, 1), (1630, 1), (1640, 1), (1650, 1), (1660, 1), (1670, 1), (1680, 1), (1690, 1), (1700, 1), (1710, 1), (1720, 1), (1730, 1), (1740, 1), (1750, 1), (1760, 0), (1770, 0), (1780, 0), (1790, 1), (1800, 1), (1810, 1), (1820, 0), (1830, 0), (1840, 0), (1850, 1), (1860, 1), (1870, 1), (1880, 1), (1890, 1), (1900, 1), (1910, 0), (1920, 0), (1930, 0), (1940, 0), (1950, 0), (1960, 0), (1970, 0), (1980, 0), (1990, 0), (2000, 0), (2010, 0), (2020, 0), (2030, 0), (2040, 0), (2050, 0)]
Vdin0_7  din0_7  0 PWL (0n 0.0v 9.495n 0.0v 9.505n 1.8v 19.495n 1.8v 19.505n 1.8v 29.495n 1.8v 29.505n 1.8v 39.495n 1.8v 39.505n 1.8v 49.495n 1.8v 49.505n 1.8v 59.495n 1.8v 59.505n 1.8v 69.495n 1.8v 69.505n 1.8v 79.495n 1.8v 79.505n 1.8v 89.495n 1.8v 89.505n 0.0v 99.495n 0.0v 99.505n 0.0v 109.495n 0.0v 109.505n 0.0v 119.495n 0.0v 119.505n 1.8v 129.495n 1.8v 129.505n 1.8v 139.495n 1.8v 139.505n 1.8v 149.495n 1.8v 149.505n 1.8v 159.495n 1.8v 159.505n 1.8v 169.495n 1.8v 169.505n 1.8v 179.495n 1.8v 179.505n 1.8v 189.495n 1.8v 189.505n 1.8v 199.495n 1.8v 199.505n 1.8v 209.495n 1.8v 209.505n 1.8v 219.495n 1.8v 219.505n 1.8v 229.495n 1.8v 229.505n 0.0v 239.495n 0.0v 239.505n 0.0v 249.495n 0.0v 249.505n 0.0v 259.495n 0.0v 259.505n 0.0v 269.495n 0.0v 269.505n 0.0v 279.495n 0.0v 279.505n 0.0v 289.495n 0.0v 289.505n 0.0v 299.495n 0.0v 299.505n 0.0v 309.495n 0.0v 309.505n 0.0v 319.495n 0.0v 319.505n 0.0v 329.495n 0.0v 329.505n 1.8v 339.495n 1.8v 339.505n 1.8v 349.495n 1.8v 349.505n 1.8v 359.495n 1.8v 359.505n 0.0v 369.495n 0.0v 369.505n 0.0v 379.495n 0.0v 379.505n 0.0v 389.495n 0.0v 389.505n 0.0v 399.495n 0.0v 399.505n 0.0v 409.495n 0.0v 409.505n 0.0v 419.495n 0.0v 419.505n 0.0v 429.495n 0.0v 429.505n 0.0v 439.495n 0.0v 439.505n 0.0v 449.495n 0.0v 449.505n 0.0v 459.495n 0.0v 459.505n 1.8v 469.495n 1.8v 469.505n 1.8v 479.495n 1.8v 479.505n 1.8v 489.495n 1.8v 489.505n 1.8v 499.495n 1.8v 499.505n 1.8v 509.495n 1.8v 509.505n 1.8v 519.495n 1.8v 519.505n 1.8v 529.495n 1.8v 529.505n 1.8v 539.495n 1.8v 539.505n 1.8v 549.495n 1.8v 549.505n 1.8v 559.495n 1.8v 559.505n 0.0v 569.495n 0.0v 569.505n 0.0v 579.495n 0.0v 579.505n 0.0v 589.495n 0.0v 589.505n 0.0v 599.495n 0.0v 599.505n 0.0v 609.495n 0.0v 609.505n 0.0v 619.495n 0.0v 619.505n 0.0v 629.495n 0.0v 629.505n 0.0v 639.495n 0.0v 639.505n 1.8v 649.495n 1.8v 649.505n 1.8v 659.495n 1.8v 659.505n 0.0v 669.495n 0.0v 669.505n 0.0v 679.495n 0.0v 679.505n 1.8v 689.495n 1.8v 689.505n 1.8v 699.495n 1.8v 699.505n 1.8v 709.495n 1.8v 709.505n 1.8v 719.495n 1.8v 719.505n 1.8v 729.495n 1.8v 729.505n 1.8v 739.495n 1.8v 739.505n 1.8v 749.495n 1.8v 749.505n 1.8v 759.495n 1.8v 759.505n 1.8v 769.495n 1.8v 769.505n 1.8v 779.495n 1.8v 779.505n 1.8v 789.495n 1.8v 789.505n 1.8v 799.495n 1.8v 799.505n 1.8v 809.495n 1.8v 809.505n 1.8v 819.495n 1.8v 819.505n 1.8v 829.495n 1.8v 829.505n 1.8v 839.495n 1.8v 839.505n 1.8v 849.495n 1.8v 849.505n 1.8v 859.495n 1.8v 859.505n 0.0v 869.495n 0.0v 869.505n 1.8v 879.495n 1.8v 879.505n 1.8v 889.495n 1.8v 889.505n 1.8v 899.495n 1.8v 899.505n 1.8v 909.495n 1.8v 909.505n 1.8v 919.495n 1.8v 919.505n 1.8v 929.495n 1.8v 929.505n 0.0v 939.495n 0.0v 939.505n 0.0v 949.495n 0.0v 949.505n 0.0v 959.495n 0.0v 959.505n 0.0v 969.495n 0.0v 969.505n 0.0v 979.495n 0.0v 979.505n 0.0v 989.495n 0.0v 989.505n 0.0v 999.495n 0.0v 999.505n 0.0v 1009.495n 0.0v 1009.505n 0.0v 1019.495n 0.0v 1019.505n 0.0v 1029.495n 0.0v 1029.505n 0.0v 1039.495n 0.0v 1039.505n 0.0v 1049.495n 0.0v 1049.505n 1.8v 1059.495n 1.8v 1059.505n 0.0v 1069.495n 0.0v 1069.505n 0.0v 1079.495n 0.0v 1079.505n 0.0v 1089.495n 0.0v 1089.505n 1.8v 1099.495n 1.8v 1099.505n 1.8v 1109.495n 1.8v 1109.505n 1.8v 1119.495n 1.8v 1119.505n 1.8v 1129.495n 1.8v 1129.505n 1.8v 1139.495n 1.8v 1139.505n 1.8v 1149.495n 1.8v 1149.505n 1.8v 1159.495n 1.8v 1159.505n 1.8v 1169.495n 1.8v 1169.505n 1.8v 1179.495n 1.8v 1179.505n 1.8v 1189.495n 1.8v 1189.505n 1.8v 1199.495n 1.8v 1199.505n 1.8v 1209.495n 1.8v 1209.505n 1.8v 1219.495n 1.8v 1219.505n 1.8v 1229.495n 1.8v 1229.505n 1.8v 1239.495n 1.8v 1239.505n 1.8v 1249.495n 1.8v 1249.505n 1.8v 1259.495n 1.8v 1259.505n 0.0v 1269.495n 0.0v 1269.505n 0.0v 1279.495n 0.0v 1279.505n 1.8v 1289.495n 1.8v 1289.505n 1.8v 1299.495n 1.8v 1299.505n 1.8v 1309.495n 1.8v 1309.505n 1.8v 1319.495n 1.8v 1319.505n 1.8v 1329.495n 1.8v 1329.505n 1.8v 1339.495n 1.8v 1339.505n 1.8v 1349.495n 1.8v 1349.505n 1.8v 1359.495n 1.8v 1359.505n 1.8v 1369.495n 1.8v 1369.505n 0.0v 1379.495n 0.0v 1379.505n 0.0v 1389.495n 0.0v 1389.505n 0.0v 1399.495n 0.0v 1399.505n 1.8v 1409.495n 1.8v 1409.505n 1.8v 1419.495n 1.8v 1419.505n 0.0v 1429.495n 0.0v 1429.505n 0.0v 1439.495n 0.0v 1439.505n 0.0v 1449.495n 0.0v 1449.505n 0.0v 1459.495n 0.0v 1459.505n 0.0v 1469.495n 0.0v 1469.505n 0.0v 1479.495n 0.0v 1479.505n 0.0v 1489.495n 0.0v 1489.505n 0.0v 1499.495n 0.0v 1499.505n 0.0v 1509.495n 0.0v 1509.505n 0.0v 1519.495n 0.0v 1519.505n 0.0v 1529.495n 0.0v 1529.505n 0.0v 1539.495n 0.0v 1539.505n 0.0v 1549.495n 0.0v 1549.505n 1.8v 1559.495n 1.8v 1559.505n 1.8v 1569.495n 1.8v 1569.505n 1.8v 1579.495n 1.8v 1579.505n 1.8v 1589.495n 1.8v 1589.505n 1.8v 1599.495n 1.8v 1599.505n 1.8v 1609.495n 1.8v 1609.505n 1.8v 1619.495n 1.8v 1619.505n 1.8v 1629.495n 1.8v 1629.505n 1.8v 1639.495n 1.8v 1639.505n 1.8v 1649.495n 1.8v 1649.505n 1.8v 1659.495n 1.8v 1659.505n 1.8v 1669.495n 1.8v 1669.505n 1.8v 1679.495n 1.8v 1679.505n 1.8v 1689.495n 1.8v 1689.505n 1.8v 1699.495n 1.8v 1699.505n 1.8v 1709.495n 1.8v 1709.505n 1.8v 1719.495n 1.8v 1719.505n 1.8v 1729.495n 1.8v 1729.505n 1.8v 1739.495n 1.8v 1739.505n 1.8v 1749.495n 1.8v 1749.505n 1.8v 1759.495n 1.8v 1759.505n 0.0v 1769.495n 0.0v 1769.505n 0.0v 1779.495n 0.0v 1779.505n 0.0v 1789.495n 0.0v 1789.505n 1.8v 1799.495n 1.8v 1799.505n 1.8v 1809.495n 1.8v 1809.505n 1.8v 1819.495n 1.8v 1819.505n 0.0v 1829.495n 0.0v 1829.505n 0.0v 1839.495n 0.0v 1839.505n 0.0v 1849.495n 0.0v 1849.505n 1.8v 1859.495n 1.8v 1859.505n 1.8v 1869.495n 1.8v 1869.505n 1.8v 1879.495n 1.8v 1879.505n 1.8v 1889.495n 1.8v 1889.505n 1.8v 1899.495n 1.8v 1899.505n 1.8v 1909.495n 1.8v 1909.505n 0.0v 1919.495n 0.0v 1919.505n 0.0v 1929.495n 0.0v 1929.505n 0.0v 1939.495n 0.0v 1939.505n 0.0v 1949.495n 0.0v 1949.505n 0.0v 1959.495n 0.0v 1959.505n 0.0v 1969.495n 0.0v 1969.505n 0.0v 1979.495n 0.0v 1979.505n 0.0v 1989.495n 0.0v 1989.505n 0.0v 1999.495n 0.0v 1999.505n 0.0v 2009.495n 0.0v 2009.505n 0.0v 2019.495n 0.0v 2019.505n 0.0v 2029.495n 0.0v 2029.505n 0.0v 2039.495n 0.0v 2039.505n 0.0v 2049.495n 0.0v 2049.505n 0.0v )
* (time, data): [(0, 0), (10, 0), (20, 1), (30, 0), (40, 0), (50, 0), (60, 0), (70, 0), (80, 0), (90, 1), (100, 1), (110, 1), (120, 0), (130, 0), (140, 0), (150, 0), (160, 0), (170, 0), (180, 0), (190, 0), (200, 0), (210, 0), (220, 0), (230, 0), (240, 1), (250, 1), (260, 1), (270, 1), (280, 1), (290, 0), (300, 1), (310, 1), (320, 1), (330, 1), (340, 1), (350, 1), (360, 1), (370, 1), (380, 1), (390, 1), (400, 1), (410, 1), (420, 1), (430, 1), (440, 1), (450, 1), (460, 1), (470, 1), (480, 1), (490, 1), (500, 1), (510, 1), (520, 1), (530, 1), (540, 1), (550, 1), (560, 1), (570, 1), (580, 1), (590, 1), (600, 1), (610, 1), (620, 1), (630, 1), (640, 1), (650, 1), (660, 0), (670, 0), (680, 0), (690, 0), (700, 0), (710, 0), (720, 0), (730, 0), (740, 1), (750, 1), (760, 0), (770, 0), (780, 0), (790, 0), (800, 0), (810, 1), (820, 1), (830, 1), (840, 1), (850, 1), (860, 1), (870, 0), (880, 0), (890, 0), (900, 0), (910, 0), (920, 0), (930, 0), (940, 1), (950, 1), (960, 0), (970, 0), (980, 0), (990, 0), (1000, 0), (1010, 0), (1020, 0), (1030, 0), (1040, 0), (1050, 0), (1060, 1), (1070, 1), (1080, 1), (1090, 1), (1100, 1), (1110, 1), (1120, 1), (1130, 1), (1140, 1), (1150, 1), (1160, 0), (1170, 0), (1180, 0), (1190, 0), (1200, 0), (1210, 0), (1220, 0), (1230, 0), (1240, 0), (1250, 1), (1260, 0), (1270, 0), (1280, 1), (1290, 1), (1300, 1), (1310, 1), (1320, 1), (1330, 1), (1340, 1), (1350, 1), (1360, 1), (1370, 1), (1380, 1), (1390, 1), (1400, 1), (1410, 1), (1420, 0), (1430, 1), (1440, 1), (1450, 1), (1460, 1), (1470, 1), (1480, 1), (1490, 0), (1500, 0), (1510, 0), (1520, 0), (1530, 0), (1540, 0), (1550, 1), (1560, 1), (1570, 1), (1580, 1), (1590, 1), (1600, 1), (1610, 1), (1620, 1), (1630, 1), (1640, 1), (1650, 0), (1660, 0), (1670, 0), (1680, 0), (1690, 0), (1700, 0), (1710, 0), (1720, 0), (1730, 0), (1740, 0), (1750, 0), (1760, 0), (1770, 0), (1780, 0), (1790, 0), (1800, 0), (1810, 0), (1820, 1), (1830, 1), (1840, 1), (1850, 1), (1860, 1), (1870, 1), (1880, 1), (1890, 1), (1900, 1), (1910, 0), (1920, 0), (1930, 0), (1940, 0), (1950, 0), (1960, 0), (1970, 0), (1980, 0), (1990, 0), (2000, 0), (2010, 0), (2020, 0), (2030, 0), (2040, 0), (2050, 0)]
Vdin0_8  din0_8  0 PWL (0n 0.0v 9.495n 0.0v 9.505n 0.0v 19.495n 0.0v 19.505n 1.8v 29.495n 1.8v 29.505n 0.0v 39.495n 0.0v 39.505n 0.0v 49.495n 0.0v 49.505n 0.0v 59.495n 0.0v 59.505n 0.0v 69.495n 0.0v 69.505n 0.0v 79.495n 0.0v 79.505n 0.0v 89.495n 0.0v 89.505n 1.8v 99.495n 1.8v 99.505n 1.8v 109.495n 1.8v 109.505n 1.8v 119.495n 1.8v 119.505n 0.0v 129.495n 0.0v 129.505n 0.0v 139.495n 0.0v 139.505n 0.0v 149.495n 0.0v 149.505n 0.0v 159.495n 0.0v 159.505n 0.0v 169.495n 0.0v 169.505n 0.0v 179.495n 0.0v 179.505n 0.0v 189.495n 0.0v 189.505n 0.0v 199.495n 0.0v 199.505n 0.0v 209.495n 0.0v 209.505n 0.0v 219.495n 0.0v 219.505n 0.0v 229.495n 0.0v 229.505n 0.0v 239.495n 0.0v 239.505n 1.8v 249.495n 1.8v 249.505n 1.8v 259.495n 1.8v 259.505n 1.8v 269.495n 1.8v 269.505n 1.8v 279.495n 1.8v 279.505n 1.8v 289.495n 1.8v 289.505n 0.0v 299.495n 0.0v 299.505n 1.8v 309.495n 1.8v 309.505n 1.8v 319.495n 1.8v 319.505n 1.8v 329.495n 1.8v 329.505n 1.8v 339.495n 1.8v 339.505n 1.8v 349.495n 1.8v 349.505n 1.8v 359.495n 1.8v 359.505n 1.8v 369.495n 1.8v 369.505n 1.8v 379.495n 1.8v 379.505n 1.8v 389.495n 1.8v 389.505n 1.8v 399.495n 1.8v 399.505n 1.8v 409.495n 1.8v 409.505n 1.8v 419.495n 1.8v 419.505n 1.8v 429.495n 1.8v 429.505n 1.8v 439.495n 1.8v 439.505n 1.8v 449.495n 1.8v 449.505n 1.8v 459.495n 1.8v 459.505n 1.8v 469.495n 1.8v 469.505n 1.8v 479.495n 1.8v 479.505n 1.8v 489.495n 1.8v 489.505n 1.8v 499.495n 1.8v 499.505n 1.8v 509.495n 1.8v 509.505n 1.8v 519.495n 1.8v 519.505n 1.8v 529.495n 1.8v 529.505n 1.8v 539.495n 1.8v 539.505n 1.8v 549.495n 1.8v 549.505n 1.8v 559.495n 1.8v 559.505n 1.8v 569.495n 1.8v 569.505n 1.8v 579.495n 1.8v 579.505n 1.8v 589.495n 1.8v 589.505n 1.8v 599.495n 1.8v 599.505n 1.8v 609.495n 1.8v 609.505n 1.8v 619.495n 1.8v 619.505n 1.8v 629.495n 1.8v 629.505n 1.8v 639.495n 1.8v 639.505n 1.8v 649.495n 1.8v 649.505n 1.8v 659.495n 1.8v 659.505n 0.0v 669.495n 0.0v 669.505n 0.0v 679.495n 0.0v 679.505n 0.0v 689.495n 0.0v 689.505n 0.0v 699.495n 0.0v 699.505n 0.0v 709.495n 0.0v 709.505n 0.0v 719.495n 0.0v 719.505n 0.0v 729.495n 0.0v 729.505n 0.0v 739.495n 0.0v 739.505n 1.8v 749.495n 1.8v 749.505n 1.8v 759.495n 1.8v 759.505n 0.0v 769.495n 0.0v 769.505n 0.0v 779.495n 0.0v 779.505n 0.0v 789.495n 0.0v 789.505n 0.0v 799.495n 0.0v 799.505n 0.0v 809.495n 0.0v 809.505n 1.8v 819.495n 1.8v 819.505n 1.8v 829.495n 1.8v 829.505n 1.8v 839.495n 1.8v 839.505n 1.8v 849.495n 1.8v 849.505n 1.8v 859.495n 1.8v 859.505n 1.8v 869.495n 1.8v 869.505n 0.0v 879.495n 0.0v 879.505n 0.0v 889.495n 0.0v 889.505n 0.0v 899.495n 0.0v 899.505n 0.0v 909.495n 0.0v 909.505n 0.0v 919.495n 0.0v 919.505n 0.0v 929.495n 0.0v 929.505n 0.0v 939.495n 0.0v 939.505n 1.8v 949.495n 1.8v 949.505n 1.8v 959.495n 1.8v 959.505n 0.0v 969.495n 0.0v 969.505n 0.0v 979.495n 0.0v 979.505n 0.0v 989.495n 0.0v 989.505n 0.0v 999.495n 0.0v 999.505n 0.0v 1009.495n 0.0v 1009.505n 0.0v 1019.495n 0.0v 1019.505n 0.0v 1029.495n 0.0v 1029.505n 0.0v 1039.495n 0.0v 1039.505n 0.0v 1049.495n 0.0v 1049.505n 0.0v 1059.495n 0.0v 1059.505n 1.8v 1069.495n 1.8v 1069.505n 1.8v 1079.495n 1.8v 1079.505n 1.8v 1089.495n 1.8v 1089.505n 1.8v 1099.495n 1.8v 1099.505n 1.8v 1109.495n 1.8v 1109.505n 1.8v 1119.495n 1.8v 1119.505n 1.8v 1129.495n 1.8v 1129.505n 1.8v 1139.495n 1.8v 1139.505n 1.8v 1149.495n 1.8v 1149.505n 1.8v 1159.495n 1.8v 1159.505n 0.0v 1169.495n 0.0v 1169.505n 0.0v 1179.495n 0.0v 1179.505n 0.0v 1189.495n 0.0v 1189.505n 0.0v 1199.495n 0.0v 1199.505n 0.0v 1209.495n 0.0v 1209.505n 0.0v 1219.495n 0.0v 1219.505n 0.0v 1229.495n 0.0v 1229.505n 0.0v 1239.495n 0.0v 1239.505n 0.0v 1249.495n 0.0v 1249.505n 1.8v 1259.495n 1.8v 1259.505n 0.0v 1269.495n 0.0v 1269.505n 0.0v 1279.495n 0.0v 1279.505n 1.8v 1289.495n 1.8v 1289.505n 1.8v 1299.495n 1.8v 1299.505n 1.8v 1309.495n 1.8v 1309.505n 1.8v 1319.495n 1.8v 1319.505n 1.8v 1329.495n 1.8v 1329.505n 1.8v 1339.495n 1.8v 1339.505n 1.8v 1349.495n 1.8v 1349.505n 1.8v 1359.495n 1.8v 1359.505n 1.8v 1369.495n 1.8v 1369.505n 1.8v 1379.495n 1.8v 1379.505n 1.8v 1389.495n 1.8v 1389.505n 1.8v 1399.495n 1.8v 1399.505n 1.8v 1409.495n 1.8v 1409.505n 1.8v 1419.495n 1.8v 1419.505n 0.0v 1429.495n 0.0v 1429.505n 1.8v 1439.495n 1.8v 1439.505n 1.8v 1449.495n 1.8v 1449.505n 1.8v 1459.495n 1.8v 1459.505n 1.8v 1469.495n 1.8v 1469.505n 1.8v 1479.495n 1.8v 1479.505n 1.8v 1489.495n 1.8v 1489.505n 0.0v 1499.495n 0.0v 1499.505n 0.0v 1509.495n 0.0v 1509.505n 0.0v 1519.495n 0.0v 1519.505n 0.0v 1529.495n 0.0v 1529.505n 0.0v 1539.495n 0.0v 1539.505n 0.0v 1549.495n 0.0v 1549.505n 1.8v 1559.495n 1.8v 1559.505n 1.8v 1569.495n 1.8v 1569.505n 1.8v 1579.495n 1.8v 1579.505n 1.8v 1589.495n 1.8v 1589.505n 1.8v 1599.495n 1.8v 1599.505n 1.8v 1609.495n 1.8v 1609.505n 1.8v 1619.495n 1.8v 1619.505n 1.8v 1629.495n 1.8v 1629.505n 1.8v 1639.495n 1.8v 1639.505n 1.8v 1649.495n 1.8v 1649.505n 0.0v 1659.495n 0.0v 1659.505n 0.0v 1669.495n 0.0v 1669.505n 0.0v 1679.495n 0.0v 1679.505n 0.0v 1689.495n 0.0v 1689.505n 0.0v 1699.495n 0.0v 1699.505n 0.0v 1709.495n 0.0v 1709.505n 0.0v 1719.495n 0.0v 1719.505n 0.0v 1729.495n 0.0v 1729.505n 0.0v 1739.495n 0.0v 1739.505n 0.0v 1749.495n 0.0v 1749.505n 0.0v 1759.495n 0.0v 1759.505n 0.0v 1769.495n 0.0v 1769.505n 0.0v 1779.495n 0.0v 1779.505n 0.0v 1789.495n 0.0v 1789.505n 0.0v 1799.495n 0.0v 1799.505n 0.0v 1809.495n 0.0v 1809.505n 0.0v 1819.495n 0.0v 1819.505n 1.8v 1829.495n 1.8v 1829.505n 1.8v 1839.495n 1.8v 1839.505n 1.8v 1849.495n 1.8v 1849.505n 1.8v 1859.495n 1.8v 1859.505n 1.8v 1869.495n 1.8v 1869.505n 1.8v 1879.495n 1.8v 1879.505n 1.8v 1889.495n 1.8v 1889.505n 1.8v 1899.495n 1.8v 1899.505n 1.8v 1909.495n 1.8v 1909.505n 0.0v 1919.495n 0.0v 1919.505n 0.0v 1929.495n 0.0v 1929.505n 0.0v 1939.495n 0.0v 1939.505n 0.0v 1949.495n 0.0v 1949.505n 0.0v 1959.495n 0.0v 1959.505n 0.0v 1969.495n 0.0v 1969.505n 0.0v 1979.495n 0.0v 1979.505n 0.0v 1989.495n 0.0v 1989.505n 0.0v 1999.495n 0.0v 1999.505n 0.0v 2009.495n 0.0v 2009.505n 0.0v 2019.495n 0.0v 2019.505n 0.0v 2029.495n 0.0v 2029.505n 0.0v 2039.495n 0.0v 2039.505n 0.0v 2049.495n 0.0v 2049.505n 0.0v )
* (time, data): [(0, 0), (10, 0), (20, 1), (30, 1), (40, 1), (50, 1), (60, 1), (70, 1), (80, 1), (90, 0), (100, 1), (110, 1), (120, 0), (130, 0), (140, 0), (150, 0), (160, 0), (170, 0), (180, 0), (190, 0), (200, 0), (210, 0), (220, 0), (230, 1), (240, 1), (250, 1), (260, 1), (270, 1), (280, 1), (290, 1), (300, 0), (310, 0), (320, 0), (330, 1), (340, 1), (350, 1), (360, 1), (370, 0), (380, 0), (390, 0), (400, 0), (410, 0), (420, 0), (430, 0), (440, 0), (450, 0), (460, 1), (470, 0), (480, 0), (490, 0), (500, 0), (510, 0), (520, 0), (530, 0), (540, 0), (550, 0), (560, 1), (570, 1), (580, 1), (590, 1), (600, 1), (610, 1), (620, 1), (630, 1), (640, 0), (650, 0), (660, 0), (670, 0), (680, 0), (690, 0), (700, 1), (710, 1), (720, 1), (730, 1), (740, 0), (750, 0), (760, 0), (770, 0), (780, 0), (790, 0), (800, 0), (810, 1), (820, 1), (830, 1), (840, 1), (850, 1), (860, 1), (870, 1), (880, 1), (890, 1), (900, 1), (910, 1), (920, 1), (930, 1), (940, 0), (950, 0), (960, 1), (970, 1), (980, 1), (990, 1), (1000, 1), (1010, 1), (1020, 1), (1030, 1), (1040, 1), (1050, 0), (1060, 0), (1070, 0), (1080, 0), (1090, 0), (1100, 0), (1110, 0), (1120, 0), (1130, 0), (1140, 1), (1150, 1), (1160, 1), (1170, 1), (1180, 1), (1190, 1), (1200, 1), (1210, 1), (1220, 1), (1230, 1), (1240, 1), (1250, 0), (1260, 1), (1270, 1), (1280, 0), (1290, 0), (1300, 0), (1310, 0), (1320, 0), (1330, 0), (1340, 0), (1350, 0), (1360, 0), (1370, 0), (1380, 0), (1390, 0), (1400, 0), (1410, 0), (1420, 0), (1430, 0), (1440, 0), (1450, 0), (1460, 0), (1470, 0), (1480, 0), (1490, 1), (1500, 1), (1510, 1), (1520, 1), (1530, 1), (1540, 1), (1550, 1), (1560, 1), (1570, 1), (1580, 1), (1590, 1), (1600, 1), (1610, 1), (1620, 1), (1630, 1), (1640, 1), (1650, 1), (1660, 1), (1670, 1), (1680, 1), (1690, 1), (1700, 1), (1710, 1), (1720, 1), (1730, 1), (1740, 1), (1750, 1), (1760, 1), (1770, 1), (1780, 1), (1790, 1), (1800, 1), (1810, 1), (1820, 0), (1830, 0), (1840, 0), (1850, 0), (1860, 0), (1870, 0), (1880, 0), (1890, 0), (1900, 0), (1910, 0), (1920, 0), (1930, 0), (1940, 0), (1950, 0), (1960, 0), (1970, 0), (1980, 0), (1990, 0), (2000, 0), (2010, 0), (2020, 0), (2030, 0), (2040, 0), (2050, 0)]
Vdin0_9  din0_9  0 PWL (0n 0.0v 9.495n 0.0v 9.505n 0.0v 19.495n 0.0v 19.505n 1.8v 29.495n 1.8v 29.505n 1.8v 39.495n 1.8v 39.505n 1.8v 49.495n 1.8v 49.505n 1.8v 59.495n 1.8v 59.505n 1.8v 69.495n 1.8v 69.505n 1.8v 79.495n 1.8v 79.505n 1.8v 89.495n 1.8v 89.505n 0.0v 99.495n 0.0v 99.505n 1.8v 109.495n 1.8v 109.505n 1.8v 119.495n 1.8v 119.505n 0.0v 129.495n 0.0v 129.505n 0.0v 139.495n 0.0v 139.505n 0.0v 149.495n 0.0v 149.505n 0.0v 159.495n 0.0v 159.505n 0.0v 169.495n 0.0v 169.505n 0.0v 179.495n 0.0v 179.505n 0.0v 189.495n 0.0v 189.505n 0.0v 199.495n 0.0v 199.505n 0.0v 209.495n 0.0v 209.505n 0.0v 219.495n 0.0v 219.505n 0.0v 229.495n 0.0v 229.505n 1.8v 239.495n 1.8v 239.505n 1.8v 249.495n 1.8v 249.505n 1.8v 259.495n 1.8v 259.505n 1.8v 269.495n 1.8v 269.505n 1.8v 279.495n 1.8v 279.505n 1.8v 289.495n 1.8v 289.505n 1.8v 299.495n 1.8v 299.505n 0.0v 309.495n 0.0v 309.505n 0.0v 319.495n 0.0v 319.505n 0.0v 329.495n 0.0v 329.505n 1.8v 339.495n 1.8v 339.505n 1.8v 349.495n 1.8v 349.505n 1.8v 359.495n 1.8v 359.505n 1.8v 369.495n 1.8v 369.505n 0.0v 379.495n 0.0v 379.505n 0.0v 389.495n 0.0v 389.505n 0.0v 399.495n 0.0v 399.505n 0.0v 409.495n 0.0v 409.505n 0.0v 419.495n 0.0v 419.505n 0.0v 429.495n 0.0v 429.505n 0.0v 439.495n 0.0v 439.505n 0.0v 449.495n 0.0v 449.505n 0.0v 459.495n 0.0v 459.505n 1.8v 469.495n 1.8v 469.505n 0.0v 479.495n 0.0v 479.505n 0.0v 489.495n 0.0v 489.505n 0.0v 499.495n 0.0v 499.505n 0.0v 509.495n 0.0v 509.505n 0.0v 519.495n 0.0v 519.505n 0.0v 529.495n 0.0v 529.505n 0.0v 539.495n 0.0v 539.505n 0.0v 549.495n 0.0v 549.505n 0.0v 559.495n 0.0v 559.505n 1.8v 569.495n 1.8v 569.505n 1.8v 579.495n 1.8v 579.505n 1.8v 589.495n 1.8v 589.505n 1.8v 599.495n 1.8v 599.505n 1.8v 609.495n 1.8v 609.505n 1.8v 619.495n 1.8v 619.505n 1.8v 629.495n 1.8v 629.505n 1.8v 639.495n 1.8v 639.505n 0.0v 649.495n 0.0v 649.505n 0.0v 659.495n 0.0v 659.505n 0.0v 669.495n 0.0v 669.505n 0.0v 679.495n 0.0v 679.505n 0.0v 689.495n 0.0v 689.505n 0.0v 699.495n 0.0v 699.505n 1.8v 709.495n 1.8v 709.505n 1.8v 719.495n 1.8v 719.505n 1.8v 729.495n 1.8v 729.505n 1.8v 739.495n 1.8v 739.505n 0.0v 749.495n 0.0v 749.505n 0.0v 759.495n 0.0v 759.505n 0.0v 769.495n 0.0v 769.505n 0.0v 779.495n 0.0v 779.505n 0.0v 789.495n 0.0v 789.505n 0.0v 799.495n 0.0v 799.505n 0.0v 809.495n 0.0v 809.505n 1.8v 819.495n 1.8v 819.505n 1.8v 829.495n 1.8v 829.505n 1.8v 839.495n 1.8v 839.505n 1.8v 849.495n 1.8v 849.505n 1.8v 859.495n 1.8v 859.505n 1.8v 869.495n 1.8v 869.505n 1.8v 879.495n 1.8v 879.505n 1.8v 889.495n 1.8v 889.505n 1.8v 899.495n 1.8v 899.505n 1.8v 909.495n 1.8v 909.505n 1.8v 919.495n 1.8v 919.505n 1.8v 929.495n 1.8v 929.505n 1.8v 939.495n 1.8v 939.505n 0.0v 949.495n 0.0v 949.505n 0.0v 959.495n 0.0v 959.505n 1.8v 969.495n 1.8v 969.505n 1.8v 979.495n 1.8v 979.505n 1.8v 989.495n 1.8v 989.505n 1.8v 999.495n 1.8v 999.505n 1.8v 1009.495n 1.8v 1009.505n 1.8v 1019.495n 1.8v 1019.505n 1.8v 1029.495n 1.8v 1029.505n 1.8v 1039.495n 1.8v 1039.505n 1.8v 1049.495n 1.8v 1049.505n 0.0v 1059.495n 0.0v 1059.505n 0.0v 1069.495n 0.0v 1069.505n 0.0v 1079.495n 0.0v 1079.505n 0.0v 1089.495n 0.0v 1089.505n 0.0v 1099.495n 0.0v 1099.505n 0.0v 1109.495n 0.0v 1109.505n 0.0v 1119.495n 0.0v 1119.505n 0.0v 1129.495n 0.0v 1129.505n 0.0v 1139.495n 0.0v 1139.505n 1.8v 1149.495n 1.8v 1149.505n 1.8v 1159.495n 1.8v 1159.505n 1.8v 1169.495n 1.8v 1169.505n 1.8v 1179.495n 1.8v 1179.505n 1.8v 1189.495n 1.8v 1189.505n 1.8v 1199.495n 1.8v 1199.505n 1.8v 1209.495n 1.8v 1209.505n 1.8v 1219.495n 1.8v 1219.505n 1.8v 1229.495n 1.8v 1229.505n 1.8v 1239.495n 1.8v 1239.505n 1.8v 1249.495n 1.8v 1249.505n 0.0v 1259.495n 0.0v 1259.505n 1.8v 1269.495n 1.8v 1269.505n 1.8v 1279.495n 1.8v 1279.505n 0.0v 1289.495n 0.0v 1289.505n 0.0v 1299.495n 0.0v 1299.505n 0.0v 1309.495n 0.0v 1309.505n 0.0v 1319.495n 0.0v 1319.505n 0.0v 1329.495n 0.0v 1329.505n 0.0v 1339.495n 0.0v 1339.505n 0.0v 1349.495n 0.0v 1349.505n 0.0v 1359.495n 0.0v 1359.505n 0.0v 1369.495n 0.0v 1369.505n 0.0v 1379.495n 0.0v 1379.505n 0.0v 1389.495n 0.0v 1389.505n 0.0v 1399.495n 0.0v 1399.505n 0.0v 1409.495n 0.0v 1409.505n 0.0v 1419.495n 0.0v 1419.505n 0.0v 1429.495n 0.0v 1429.505n 0.0v 1439.495n 0.0v 1439.505n 0.0v 1449.495n 0.0v 1449.505n 0.0v 1459.495n 0.0v 1459.505n 0.0v 1469.495n 0.0v 1469.505n 0.0v 1479.495n 0.0v 1479.505n 0.0v 1489.495n 0.0v 1489.505n 1.8v 1499.495n 1.8v 1499.505n 1.8v 1509.495n 1.8v 1509.505n 1.8v 1519.495n 1.8v 1519.505n 1.8v 1529.495n 1.8v 1529.505n 1.8v 1539.495n 1.8v 1539.505n 1.8v 1549.495n 1.8v 1549.505n 1.8v 1559.495n 1.8v 1559.505n 1.8v 1569.495n 1.8v 1569.505n 1.8v 1579.495n 1.8v 1579.505n 1.8v 1589.495n 1.8v 1589.505n 1.8v 1599.495n 1.8v 1599.505n 1.8v 1609.495n 1.8v 1609.505n 1.8v 1619.495n 1.8v 1619.505n 1.8v 1629.495n 1.8v 1629.505n 1.8v 1639.495n 1.8v 1639.505n 1.8v 1649.495n 1.8v 1649.505n 1.8v 1659.495n 1.8v 1659.505n 1.8v 1669.495n 1.8v 1669.505n 1.8v 1679.495n 1.8v 1679.505n 1.8v 1689.495n 1.8v 1689.505n 1.8v 1699.495n 1.8v 1699.505n 1.8v 1709.495n 1.8v 1709.505n 1.8v 1719.495n 1.8v 1719.505n 1.8v 1729.495n 1.8v 1729.505n 1.8v 1739.495n 1.8v 1739.505n 1.8v 1749.495n 1.8v 1749.505n 1.8v 1759.495n 1.8v 1759.505n 1.8v 1769.495n 1.8v 1769.505n 1.8v 1779.495n 1.8v 1779.505n 1.8v 1789.495n 1.8v 1789.505n 1.8v 1799.495n 1.8v 1799.505n 1.8v 1809.495n 1.8v 1809.505n 1.8v 1819.495n 1.8v 1819.505n 0.0v 1829.495n 0.0v 1829.505n 0.0v 1839.495n 0.0v 1839.505n 0.0v 1849.495n 0.0v 1849.505n 0.0v 1859.495n 0.0v 1859.505n 0.0v 1869.495n 0.0v 1869.505n 0.0v 1879.495n 0.0v 1879.505n 0.0v 1889.495n 0.0v 1889.505n 0.0v 1899.495n 0.0v 1899.505n 0.0v 1909.495n 0.0v 1909.505n 0.0v 1919.495n 0.0v 1919.505n 0.0v 1929.495n 0.0v 1929.505n 0.0v 1939.495n 0.0v 1939.505n 0.0v 1949.495n 0.0v 1949.505n 0.0v 1959.495n 0.0v 1959.505n 0.0v 1969.495n 0.0v 1969.505n 0.0v 1979.495n 0.0v 1979.505n 0.0v 1989.495n 0.0v 1989.505n 0.0v 1999.495n 0.0v 1999.505n 0.0v 2009.495n 0.0v 2009.505n 0.0v 2019.495n 0.0v 2019.505n 0.0v 2029.495n 0.0v 2029.505n 0.0v 2039.495n 0.0v 2039.505n 0.0v 2049.495n 0.0v 2049.505n 0.0v )
* (time, data): [(0, 0), (10, 1), (20, 1), (30, 1), (40, 1), (50, 1), (60, 1), (70, 1), (80, 1), (90, 0), (100, 0), (110, 0), (120, 0), (130, 0), (140, 0), (150, 0), (160, 0), (170, 0), (180, 1), (190, 1), (200, 0), (210, 0), (220, 0), (230, 0), (240, 1), (250, 1), (260, 1), (270, 1), (280, 1), (290, 0), (300, 1), (310, 1), (320, 1), (330, 1), (340, 1), (350, 1), (360, 1), (370, 0), (380, 0), (390, 0), (400, 0), (410, 0), (420, 0), (430, 0), (440, 0), (450, 0), (460, 1), (470, 0), (480, 0), (490, 0), (500, 0), (510, 0), (520, 0), (530, 0), (540, 0), (550, 0), (560, 1), (570, 1), (580, 1), (590, 1), (600, 1), (610, 1), (620, 1), (630, 1), (640, 0), (650, 0), (660, 1), (670, 1), (680, 1), (690, 1), (700, 0), (710, 0), (720, 0), (730, 0), (740, 1), (750, 1), (760, 0), (770, 0), (780, 0), (790, 0), (800, 0), (810, 1), (820, 1), (830, 1), (840, 1), (850, 1), (860, 1), (870, 0), (880, 0), (890, 0), (900, 0), (910, 0), (920, 0), (930, 0), (940, 0), (950, 0), (960, 1), (970, 1), (980, 1), (990, 1), (1000, 1), (1010, 1), (1020, 1), (1030, 1), (1040, 1), (1050, 0), (1060, 1), (1070, 1), (1080, 1), (1090, 1), (1100, 1), (1110, 1), (1120, 1), (1130, 1), (1140, 0), (1150, 0), (1160, 1), (1170, 1), (1180, 1), (1190, 1), (1200, 1), (1210, 1), (1220, 1), (1230, 1), (1240, 1), (1250, 1), (1260, 1), (1270, 1), (1280, 1), (1290, 1), (1300, 1), (1310, 1), (1320, 1), (1330, 1), (1340, 1), (1350, 1), (1360, 1), (1370, 0), (1380, 0), (1390, 0), (1400, 1), (1410, 1), (1420, 1), (1430, 0), (1440, 0), (1450, 0), (1460, 0), (1470, 0), (1480, 0), (1490, 1), (1500, 1), (1510, 1), (1520, 1), (1530, 1), (1540, 1), (1550, 1), (1560, 1), (1570, 1), (1580, 1), (1590, 1), (1600, 1), (1610, 1), (1620, 1), (1630, 1), (1640, 1), (1650, 0), (1660, 0), (1670, 0), (1680, 0), (1690, 0), (1700, 0), (1710, 0), (1720, 0), (1730, 0), (1740, 0), (1750, 0), (1760, 0), (1770, 0), (1780, 0), (1790, 0), (1800, 0), (1810, 0), (1820, 1), (1830, 1), (1840, 1), (1850, 0), (1860, 0), (1870, 0), (1880, 0), (1890, 0), (1900, 0), (1910, 0), (1920, 0), (1930, 0), (1940, 0), (1950, 0), (1960, 0), (1970, 0), (1980, 0), (1990, 0), (2000, 0), (2010, 0), (2020, 0), (2030, 0), (2040, 0), (2050, 0)]
Vdin0_10  din0_10  0 PWL (0n 0.0v 9.495n 0.0v 9.505n 1.8v 19.495n 1.8v 19.505n 1.8v 29.495n 1.8v 29.505n 1.8v 39.495n 1.8v 39.505n 1.8v 49.495n 1.8v 49.505n 1.8v 59.495n 1.8v 59.505n 1.8v 69.495n 1.8v 69.505n 1.8v 79.495n 1.8v 79.505n 1.8v 89.495n 1.8v 89.505n 0.0v 99.495n 0.0v 99.505n 0.0v 109.495n 0.0v 109.505n 0.0v 119.495n 0.0v 119.505n 0.0v 129.495n 0.0v 129.505n 0.0v 139.495n 0.0v 139.505n 0.0v 149.495n 0.0v 149.505n 0.0v 159.495n 0.0v 159.505n 0.0v 169.495n 0.0v 169.505n 0.0v 179.495n 0.0v 179.505n 1.8v 189.495n 1.8v 189.505n 1.8v 199.495n 1.8v 199.505n 0.0v 209.495n 0.0v 209.505n 0.0v 219.495n 0.0v 219.505n 0.0v 229.495n 0.0v 229.505n 0.0v 239.495n 0.0v 239.505n 1.8v 249.495n 1.8v 249.505n 1.8v 259.495n 1.8v 259.505n 1.8v 269.495n 1.8v 269.505n 1.8v 279.495n 1.8v 279.505n 1.8v 289.495n 1.8v 289.505n 0.0v 299.495n 0.0v 299.505n 1.8v 309.495n 1.8v 309.505n 1.8v 319.495n 1.8v 319.505n 1.8v 329.495n 1.8v 329.505n 1.8v 339.495n 1.8v 339.505n 1.8v 349.495n 1.8v 349.505n 1.8v 359.495n 1.8v 359.505n 1.8v 369.495n 1.8v 369.505n 0.0v 379.495n 0.0v 379.505n 0.0v 389.495n 0.0v 389.505n 0.0v 399.495n 0.0v 399.505n 0.0v 409.495n 0.0v 409.505n 0.0v 419.495n 0.0v 419.505n 0.0v 429.495n 0.0v 429.505n 0.0v 439.495n 0.0v 439.505n 0.0v 449.495n 0.0v 449.505n 0.0v 459.495n 0.0v 459.505n 1.8v 469.495n 1.8v 469.505n 0.0v 479.495n 0.0v 479.505n 0.0v 489.495n 0.0v 489.505n 0.0v 499.495n 0.0v 499.505n 0.0v 509.495n 0.0v 509.505n 0.0v 519.495n 0.0v 519.505n 0.0v 529.495n 0.0v 529.505n 0.0v 539.495n 0.0v 539.505n 0.0v 549.495n 0.0v 549.505n 0.0v 559.495n 0.0v 559.505n 1.8v 569.495n 1.8v 569.505n 1.8v 579.495n 1.8v 579.505n 1.8v 589.495n 1.8v 589.505n 1.8v 599.495n 1.8v 599.505n 1.8v 609.495n 1.8v 609.505n 1.8v 619.495n 1.8v 619.505n 1.8v 629.495n 1.8v 629.505n 1.8v 639.495n 1.8v 639.505n 0.0v 649.495n 0.0v 649.505n 0.0v 659.495n 0.0v 659.505n 1.8v 669.495n 1.8v 669.505n 1.8v 679.495n 1.8v 679.505n 1.8v 689.495n 1.8v 689.505n 1.8v 699.495n 1.8v 699.505n 0.0v 709.495n 0.0v 709.505n 0.0v 719.495n 0.0v 719.505n 0.0v 729.495n 0.0v 729.505n 0.0v 739.495n 0.0v 739.505n 1.8v 749.495n 1.8v 749.505n 1.8v 759.495n 1.8v 759.505n 0.0v 769.495n 0.0v 769.505n 0.0v 779.495n 0.0v 779.505n 0.0v 789.495n 0.0v 789.505n 0.0v 799.495n 0.0v 799.505n 0.0v 809.495n 0.0v 809.505n 1.8v 819.495n 1.8v 819.505n 1.8v 829.495n 1.8v 829.505n 1.8v 839.495n 1.8v 839.505n 1.8v 849.495n 1.8v 849.505n 1.8v 859.495n 1.8v 859.505n 1.8v 869.495n 1.8v 869.505n 0.0v 879.495n 0.0v 879.505n 0.0v 889.495n 0.0v 889.505n 0.0v 899.495n 0.0v 899.505n 0.0v 909.495n 0.0v 909.505n 0.0v 919.495n 0.0v 919.505n 0.0v 929.495n 0.0v 929.505n 0.0v 939.495n 0.0v 939.505n 0.0v 949.495n 0.0v 949.505n 0.0v 959.495n 0.0v 959.505n 1.8v 969.495n 1.8v 969.505n 1.8v 979.495n 1.8v 979.505n 1.8v 989.495n 1.8v 989.505n 1.8v 999.495n 1.8v 999.505n 1.8v 1009.495n 1.8v 1009.505n 1.8v 1019.495n 1.8v 1019.505n 1.8v 1029.495n 1.8v 1029.505n 1.8v 1039.495n 1.8v 1039.505n 1.8v 1049.495n 1.8v 1049.505n 0.0v 1059.495n 0.0v 1059.505n 1.8v 1069.495n 1.8v 1069.505n 1.8v 1079.495n 1.8v 1079.505n 1.8v 1089.495n 1.8v 1089.505n 1.8v 1099.495n 1.8v 1099.505n 1.8v 1109.495n 1.8v 1109.505n 1.8v 1119.495n 1.8v 1119.505n 1.8v 1129.495n 1.8v 1129.505n 1.8v 1139.495n 1.8v 1139.505n 0.0v 1149.495n 0.0v 1149.505n 0.0v 1159.495n 0.0v 1159.505n 1.8v 1169.495n 1.8v 1169.505n 1.8v 1179.495n 1.8v 1179.505n 1.8v 1189.495n 1.8v 1189.505n 1.8v 1199.495n 1.8v 1199.505n 1.8v 1209.495n 1.8v 1209.505n 1.8v 1219.495n 1.8v 1219.505n 1.8v 1229.495n 1.8v 1229.505n 1.8v 1239.495n 1.8v 1239.505n 1.8v 1249.495n 1.8v 1249.505n 1.8v 1259.495n 1.8v 1259.505n 1.8v 1269.495n 1.8v 1269.505n 1.8v 1279.495n 1.8v 1279.505n 1.8v 1289.495n 1.8v 1289.505n 1.8v 1299.495n 1.8v 1299.505n 1.8v 1309.495n 1.8v 1309.505n 1.8v 1319.495n 1.8v 1319.505n 1.8v 1329.495n 1.8v 1329.505n 1.8v 1339.495n 1.8v 1339.505n 1.8v 1349.495n 1.8v 1349.505n 1.8v 1359.495n 1.8v 1359.505n 1.8v 1369.495n 1.8v 1369.505n 0.0v 1379.495n 0.0v 1379.505n 0.0v 1389.495n 0.0v 1389.505n 0.0v 1399.495n 0.0v 1399.505n 1.8v 1409.495n 1.8v 1409.505n 1.8v 1419.495n 1.8v 1419.505n 1.8v 1429.495n 1.8v 1429.505n 0.0v 1439.495n 0.0v 1439.505n 0.0v 1449.495n 0.0v 1449.505n 0.0v 1459.495n 0.0v 1459.505n 0.0v 1469.495n 0.0v 1469.505n 0.0v 1479.495n 0.0v 1479.505n 0.0v 1489.495n 0.0v 1489.505n 1.8v 1499.495n 1.8v 1499.505n 1.8v 1509.495n 1.8v 1509.505n 1.8v 1519.495n 1.8v 1519.505n 1.8v 1529.495n 1.8v 1529.505n 1.8v 1539.495n 1.8v 1539.505n 1.8v 1549.495n 1.8v 1549.505n 1.8v 1559.495n 1.8v 1559.505n 1.8v 1569.495n 1.8v 1569.505n 1.8v 1579.495n 1.8v 1579.505n 1.8v 1589.495n 1.8v 1589.505n 1.8v 1599.495n 1.8v 1599.505n 1.8v 1609.495n 1.8v 1609.505n 1.8v 1619.495n 1.8v 1619.505n 1.8v 1629.495n 1.8v 1629.505n 1.8v 1639.495n 1.8v 1639.505n 1.8v 1649.495n 1.8v 1649.505n 0.0v 1659.495n 0.0v 1659.505n 0.0v 1669.495n 0.0v 1669.505n 0.0v 1679.495n 0.0v 1679.505n 0.0v 1689.495n 0.0v 1689.505n 0.0v 1699.495n 0.0v 1699.505n 0.0v 1709.495n 0.0v 1709.505n 0.0v 1719.495n 0.0v 1719.505n 0.0v 1729.495n 0.0v 1729.505n 0.0v 1739.495n 0.0v 1739.505n 0.0v 1749.495n 0.0v 1749.505n 0.0v 1759.495n 0.0v 1759.505n 0.0v 1769.495n 0.0v 1769.505n 0.0v 1779.495n 0.0v 1779.505n 0.0v 1789.495n 0.0v 1789.505n 0.0v 1799.495n 0.0v 1799.505n 0.0v 1809.495n 0.0v 1809.505n 0.0v 1819.495n 0.0v 1819.505n 1.8v 1829.495n 1.8v 1829.505n 1.8v 1839.495n 1.8v 1839.505n 1.8v 1849.495n 1.8v 1849.505n 0.0v 1859.495n 0.0v 1859.505n 0.0v 1869.495n 0.0v 1869.505n 0.0v 1879.495n 0.0v 1879.505n 0.0v 1889.495n 0.0v 1889.505n 0.0v 1899.495n 0.0v 1899.505n 0.0v 1909.495n 0.0v 1909.505n 0.0v 1919.495n 0.0v 1919.505n 0.0v 1929.495n 0.0v 1929.505n 0.0v 1939.495n 0.0v 1939.505n 0.0v 1949.495n 0.0v 1949.505n 0.0v 1959.495n 0.0v 1959.505n 0.0v 1969.495n 0.0v 1969.505n 0.0v 1979.495n 0.0v 1979.505n 0.0v 1989.495n 0.0v 1989.505n 0.0v 1999.495n 0.0v 1999.505n 0.0v 2009.495n 0.0v 2009.505n 0.0v 2019.495n 0.0v 2019.505n 0.0v 2029.495n 0.0v 2029.505n 0.0v 2039.495n 0.0v 2039.505n 0.0v 2049.495n 0.0v 2049.505n 0.0v )
* (time, data): [(0, 0), (10, 0), (20, 1), (30, 1), (40, 1), (50, 1), (60, 1), (70, 1), (80, 1), (90, 0), (100, 1), (110, 1), (120, 1), (130, 1), (140, 1), (150, 1), (160, 1), (170, 1), (180, 1), (190, 1), (200, 0), (210, 0), (220, 0), (230, 0), (240, 0), (250, 0), (260, 0), (270, 0), (280, 0), (290, 0), (300, 0), (310, 0), (320, 0), (330, 1), (340, 1), (350, 1), (360, 1), (370, 1), (380, 1), (390, 1), (400, 1), (410, 1), (420, 1), (430, 1), (440, 1), (450, 1), (460, 0), (470, 0), (480, 0), (490, 0), (500, 0), (510, 0), (520, 0), (530, 0), (540, 0), (550, 0), (560, 0), (570, 0), (580, 0), (590, 0), (600, 0), (610, 0), (620, 0), (630, 0), (640, 1), (650, 1), (660, 1), (670, 1), (680, 1), (690, 1), (700, 0), (710, 0), (720, 0), (730, 0), (740, 0), (750, 0), (760, 0), (770, 0), (780, 0), (790, 0), (800, 0), (810, 0), (820, 0), (830, 0), (840, 0), (850, 0), (860, 1), (870, 1), (880, 1), (890, 1), (900, 1), (910, 1), (920, 1), (930, 0), (940, 1), (950, 1), (960, 1), (970, 1), (980, 1), (990, 1), (1000, 1), (1010, 1), (1020, 1), (1030, 1), (1040, 1), (1050, 0), (1060, 0), (1070, 0), (1080, 0), (1090, 1), (1100, 1), (1110, 1), (1120, 1), (1130, 1), (1140, 0), (1150, 0), (1160, 1), (1170, 1), (1180, 1), (1190, 1), (1200, 1), (1210, 1), (1220, 1), (1230, 1), (1240, 1), (1250, 0), (1260, 1), (1270, 1), (1280, 1), (1290, 1), (1300, 1), (1310, 1), (1320, 1), (1330, 0), (1340, 0), (1350, 0), (1360, 0), (1370, 1), (1380, 1), (1390, 1), (1400, 1), (1410, 1), (1420, 0), (1430, 0), (1440, 0), (1450, 0), (1460, 0), (1470, 0), (1480, 0), (1490, 0), (1500, 0), (1510, 0), (1520, 0), (1530, 0), (1540, 0), (1550, 1), (1560, 1), (1570, 1), (1580, 1), (1590, 1), (1600, 1), (1610, 1), (1620, 1), (1630, 1), (1640, 1), (1650, 0), (1660, 0), (1670, 0), (1680, 0), (1690, 0), (1700, 0), (1710, 0), (1720, 0), (1730, 0), (1740, 0), (1750, 0), (1760, 1), (1770, 1), (1780, 1), (1790, 0), (1800, 0), (1810, 0), (1820, 1), (1830, 1), (1840, 1), (1850, 0), (1860, 0), (1870, 0), (1880, 0), (1890, 0), (1900, 0), (1910, 0), (1920, 0), (1930, 0), (1940, 0), (1950, 0), (1960, 0), (1970, 0), (1980, 0), (1990, 0), (2000, 0), (2010, 0), (2020, 0), (2030, 0), (2040, 0), (2050, 0)]
Vdin0_11  din0_11  0 PWL (0n 0.0v 9.495n 0.0v 9.505n 0.0v 19.495n 0.0v 19.505n 1.8v 29.495n 1.8v 29.505n 1.8v 39.495n 1.8v 39.505n 1.8v 49.495n 1.8v 49.505n 1.8v 59.495n 1.8v 59.505n 1.8v 69.495n 1.8v 69.505n 1.8v 79.495n 1.8v 79.505n 1.8v 89.495n 1.8v 89.505n 0.0v 99.495n 0.0v 99.505n 1.8v 109.495n 1.8v 109.505n 1.8v 119.495n 1.8v 119.505n 1.8v 129.495n 1.8v 129.505n 1.8v 139.495n 1.8v 139.505n 1.8v 149.495n 1.8v 149.505n 1.8v 159.495n 1.8v 159.505n 1.8v 169.495n 1.8v 169.505n 1.8v 179.495n 1.8v 179.505n 1.8v 189.495n 1.8v 189.505n 1.8v 199.495n 1.8v 199.505n 0.0v 209.495n 0.0v 209.505n 0.0v 219.495n 0.0v 219.505n 0.0v 229.495n 0.0v 229.505n 0.0v 239.495n 0.0v 239.505n 0.0v 249.495n 0.0v 249.505n 0.0v 259.495n 0.0v 259.505n 0.0v 269.495n 0.0v 269.505n 0.0v 279.495n 0.0v 279.505n 0.0v 289.495n 0.0v 289.505n 0.0v 299.495n 0.0v 299.505n 0.0v 309.495n 0.0v 309.505n 0.0v 319.495n 0.0v 319.505n 0.0v 329.495n 0.0v 329.505n 1.8v 339.495n 1.8v 339.505n 1.8v 349.495n 1.8v 349.505n 1.8v 359.495n 1.8v 359.505n 1.8v 369.495n 1.8v 369.505n 1.8v 379.495n 1.8v 379.505n 1.8v 389.495n 1.8v 389.505n 1.8v 399.495n 1.8v 399.505n 1.8v 409.495n 1.8v 409.505n 1.8v 419.495n 1.8v 419.505n 1.8v 429.495n 1.8v 429.505n 1.8v 439.495n 1.8v 439.505n 1.8v 449.495n 1.8v 449.505n 1.8v 459.495n 1.8v 459.505n 0.0v 469.495n 0.0v 469.505n 0.0v 479.495n 0.0v 479.505n 0.0v 489.495n 0.0v 489.505n 0.0v 499.495n 0.0v 499.505n 0.0v 509.495n 0.0v 509.505n 0.0v 519.495n 0.0v 519.505n 0.0v 529.495n 0.0v 529.505n 0.0v 539.495n 0.0v 539.505n 0.0v 549.495n 0.0v 549.505n 0.0v 559.495n 0.0v 559.505n 0.0v 569.495n 0.0v 569.505n 0.0v 579.495n 0.0v 579.505n 0.0v 589.495n 0.0v 589.505n 0.0v 599.495n 0.0v 599.505n 0.0v 609.495n 0.0v 609.505n 0.0v 619.495n 0.0v 619.505n 0.0v 629.495n 0.0v 629.505n 0.0v 639.495n 0.0v 639.505n 1.8v 649.495n 1.8v 649.505n 1.8v 659.495n 1.8v 659.505n 1.8v 669.495n 1.8v 669.505n 1.8v 679.495n 1.8v 679.505n 1.8v 689.495n 1.8v 689.505n 1.8v 699.495n 1.8v 699.505n 0.0v 709.495n 0.0v 709.505n 0.0v 719.495n 0.0v 719.505n 0.0v 729.495n 0.0v 729.505n 0.0v 739.495n 0.0v 739.505n 0.0v 749.495n 0.0v 749.505n 0.0v 759.495n 0.0v 759.505n 0.0v 769.495n 0.0v 769.505n 0.0v 779.495n 0.0v 779.505n 0.0v 789.495n 0.0v 789.505n 0.0v 799.495n 0.0v 799.505n 0.0v 809.495n 0.0v 809.505n 0.0v 819.495n 0.0v 819.505n 0.0v 829.495n 0.0v 829.505n 0.0v 839.495n 0.0v 839.505n 0.0v 849.495n 0.0v 849.505n 0.0v 859.495n 0.0v 859.505n 1.8v 869.495n 1.8v 869.505n 1.8v 879.495n 1.8v 879.505n 1.8v 889.495n 1.8v 889.505n 1.8v 899.495n 1.8v 899.505n 1.8v 909.495n 1.8v 909.505n 1.8v 919.495n 1.8v 919.505n 1.8v 929.495n 1.8v 929.505n 0.0v 939.495n 0.0v 939.505n 1.8v 949.495n 1.8v 949.505n 1.8v 959.495n 1.8v 959.505n 1.8v 969.495n 1.8v 969.505n 1.8v 979.495n 1.8v 979.505n 1.8v 989.495n 1.8v 989.505n 1.8v 999.495n 1.8v 999.505n 1.8v 1009.495n 1.8v 1009.505n 1.8v 1019.495n 1.8v 1019.505n 1.8v 1029.495n 1.8v 1029.505n 1.8v 1039.495n 1.8v 1039.505n 1.8v 1049.495n 1.8v 1049.505n 0.0v 1059.495n 0.0v 1059.505n 0.0v 1069.495n 0.0v 1069.505n 0.0v 1079.495n 0.0v 1079.505n 0.0v 1089.495n 0.0v 1089.505n 1.8v 1099.495n 1.8v 1099.505n 1.8v 1109.495n 1.8v 1109.505n 1.8v 1119.495n 1.8v 1119.505n 1.8v 1129.495n 1.8v 1129.505n 1.8v 1139.495n 1.8v 1139.505n 0.0v 1149.495n 0.0v 1149.505n 0.0v 1159.495n 0.0v 1159.505n 1.8v 1169.495n 1.8v 1169.505n 1.8v 1179.495n 1.8v 1179.505n 1.8v 1189.495n 1.8v 1189.505n 1.8v 1199.495n 1.8v 1199.505n 1.8v 1209.495n 1.8v 1209.505n 1.8v 1219.495n 1.8v 1219.505n 1.8v 1229.495n 1.8v 1229.505n 1.8v 1239.495n 1.8v 1239.505n 1.8v 1249.495n 1.8v 1249.505n 0.0v 1259.495n 0.0v 1259.505n 1.8v 1269.495n 1.8v 1269.505n 1.8v 1279.495n 1.8v 1279.505n 1.8v 1289.495n 1.8v 1289.505n 1.8v 1299.495n 1.8v 1299.505n 1.8v 1309.495n 1.8v 1309.505n 1.8v 1319.495n 1.8v 1319.505n 1.8v 1329.495n 1.8v 1329.505n 0.0v 1339.495n 0.0v 1339.505n 0.0v 1349.495n 0.0v 1349.505n 0.0v 1359.495n 0.0v 1359.505n 0.0v 1369.495n 0.0v 1369.505n 1.8v 1379.495n 1.8v 1379.505n 1.8v 1389.495n 1.8v 1389.505n 1.8v 1399.495n 1.8v 1399.505n 1.8v 1409.495n 1.8v 1409.505n 1.8v 1419.495n 1.8v 1419.505n 0.0v 1429.495n 0.0v 1429.505n 0.0v 1439.495n 0.0v 1439.505n 0.0v 1449.495n 0.0v 1449.505n 0.0v 1459.495n 0.0v 1459.505n 0.0v 1469.495n 0.0v 1469.505n 0.0v 1479.495n 0.0v 1479.505n 0.0v 1489.495n 0.0v 1489.505n 0.0v 1499.495n 0.0v 1499.505n 0.0v 1509.495n 0.0v 1509.505n 0.0v 1519.495n 0.0v 1519.505n 0.0v 1529.495n 0.0v 1529.505n 0.0v 1539.495n 0.0v 1539.505n 0.0v 1549.495n 0.0v 1549.505n 1.8v 1559.495n 1.8v 1559.505n 1.8v 1569.495n 1.8v 1569.505n 1.8v 1579.495n 1.8v 1579.505n 1.8v 1589.495n 1.8v 1589.505n 1.8v 1599.495n 1.8v 1599.505n 1.8v 1609.495n 1.8v 1609.505n 1.8v 1619.495n 1.8v 1619.505n 1.8v 1629.495n 1.8v 1629.505n 1.8v 1639.495n 1.8v 1639.505n 1.8v 1649.495n 1.8v 1649.505n 0.0v 1659.495n 0.0v 1659.505n 0.0v 1669.495n 0.0v 1669.505n 0.0v 1679.495n 0.0v 1679.505n 0.0v 1689.495n 0.0v 1689.505n 0.0v 1699.495n 0.0v 1699.505n 0.0v 1709.495n 0.0v 1709.505n 0.0v 1719.495n 0.0v 1719.505n 0.0v 1729.495n 0.0v 1729.505n 0.0v 1739.495n 0.0v 1739.505n 0.0v 1749.495n 0.0v 1749.505n 0.0v 1759.495n 0.0v 1759.505n 1.8v 1769.495n 1.8v 1769.505n 1.8v 1779.495n 1.8v 1779.505n 1.8v 1789.495n 1.8v 1789.505n 0.0v 1799.495n 0.0v 1799.505n 0.0v 1809.495n 0.0v 1809.505n 0.0v 1819.495n 0.0v 1819.505n 1.8v 1829.495n 1.8v 1829.505n 1.8v 1839.495n 1.8v 1839.505n 1.8v 1849.495n 1.8v 1849.505n 0.0v 1859.495n 0.0v 1859.505n 0.0v 1869.495n 0.0v 1869.505n 0.0v 1879.495n 0.0v 1879.505n 0.0v 1889.495n 0.0v 1889.505n 0.0v 1899.495n 0.0v 1899.505n 0.0v 1909.495n 0.0v 1909.505n 0.0v 1919.495n 0.0v 1919.505n 0.0v 1929.495n 0.0v 1929.505n 0.0v 1939.495n 0.0v 1939.505n 0.0v 1949.495n 0.0v 1949.505n 0.0v 1959.495n 0.0v 1959.505n 0.0v 1969.495n 0.0v 1969.505n 0.0v 1979.495n 0.0v 1979.505n 0.0v 1989.495n 0.0v 1989.505n 0.0v 1999.495n 0.0v 1999.505n 0.0v 2009.495n 0.0v 2009.505n 0.0v 2019.495n 0.0v 2019.505n 0.0v 2029.495n 0.0v 2029.505n 0.0v 2039.495n 0.0v 2039.505n 0.0v 2049.495n 0.0v 2049.505n 0.0v )
* (time, data): [(0, 0), (10, 1), (20, 0), (30, 0), (40, 0), (50, 0), (60, 0), (70, 0), (80, 0), (90, 0), (100, 1), (110, 1), (120, 0), (130, 0), (140, 0), (150, 0), (160, 0), (170, 0), (180, 1), (190, 1), (200, 1), (210, 1), (220, 1), (230, 1), (240, 1), (250, 1), (260, 1), (270, 1), (280, 1), (290, 1), (300, 0), (310, 0), (320, 0), (330, 1), (340, 1), (350, 1), (360, 1), (370, 0), (380, 0), (390, 0), (400, 0), (410, 0), (420, 0), (430, 0), (440, 0), (450, 0), (460, 0), (470, 1), (480, 1), (490, 1), (500, 1), (510, 1), (520, 1), (530, 1), (540, 1), (550, 1), (560, 0), (570, 0), (580, 0), (590, 0), (600, 0), (610, 0), (620, 0), (630, 0), (640, 1), (650, 1), (660, 1), (670, 1), (680, 1), (690, 1), (700, 0), (710, 0), (720, 0), (730, 0), (740, 0), (750, 0), (760, 1), (770, 1), (780, 1), (790, 1), (800, 1), (810, 1), (820, 1), (830, 1), (840, 1), (850, 1), (860, 0), (870, 1), (880, 1), (890, 1), (900, 1), (910, 1), (920, 1), (930, 1), (940, 1), (950, 1), (960, 1), (970, 1), (980, 1), (990, 1), (1000, 1), (1010, 1), (1020, 1), (1030, 1), (1040, 1), (1050, 0), (1060, 1), (1070, 1), (1080, 1), (1090, 0), (1100, 0), (1110, 0), (1120, 0), (1130, 0), (1140, 0), (1150, 0), (1160, 0), (1170, 0), (1180, 0), (1190, 0), (1200, 0), (1210, 0), (1220, 0), (1230, 0), (1240, 0), (1250, 0), (1260, 0), (1270, 0), (1280, 1), (1290, 1), (1300, 1), (1310, 1), (1320, 1), (1330, 1), (1340, 1), (1350, 1), (1360, 1), (1370, 0), (1380, 0), (1390, 0), (1400, 0), (1410, 0), (1420, 1), (1430, 0), (1440, 0), (1450, 0), (1460, 0), (1470, 0), (1480, 0), (1490, 0), (1500, 0), (1510, 0), (1520, 0), (1530, 0), (1540, 0), (1550, 0), (1560, 0), (1570, 0), (1580, 0), (1590, 0), (1600, 0), (1610, 0), (1620, 0), (1630, 0), (1640, 0), (1650, 1), (1660, 1), (1670, 1), (1680, 1), (1690, 1), (1700, 1), (1710, 1), (1720, 1), (1730, 1), (1740, 1), (1750, 1), (1760, 1), (1770, 1), (1780, 1), (1790, 0), (1800, 0), (1810, 0), (1820, 1), (1830, 1), (1840, 1), (1850, 0), (1860, 0), (1870, 0), (1880, 0), (1890, 0), (1900, 0), (1910, 1), (1920, 1), (1930, 1), (1940, 1), (1950, 1), (1960, 1), (1970, 1), (1980, 1), (1990, 1), (2000, 1), (2010, 1), (2020, 1), (2030, 1), (2040, 1), (2050, 1)]
Vdin0_12  din0_12  0 PWL (0n 0.0v 9.495n 0.0v 9.505n 1.8v 19.495n 1.8v 19.505n 0.0v 29.495n 0.0v 29.505n 0.0v 39.495n 0.0v 39.505n 0.0v 49.495n 0.0v 49.505n 0.0v 59.495n 0.0v 59.505n 0.0v 69.495n 0.0v 69.505n 0.0v 79.495n 0.0v 79.505n 0.0v 89.495n 0.0v 89.505n 0.0v 99.495n 0.0v 99.505n 1.8v 109.495n 1.8v 109.505n 1.8v 119.495n 1.8v 119.505n 0.0v 129.495n 0.0v 129.505n 0.0v 139.495n 0.0v 139.505n 0.0v 149.495n 0.0v 149.505n 0.0v 159.495n 0.0v 159.505n 0.0v 169.495n 0.0v 169.505n 0.0v 179.495n 0.0v 179.505n 1.8v 189.495n 1.8v 189.505n 1.8v 199.495n 1.8v 199.505n 1.8v 209.495n 1.8v 209.505n 1.8v 219.495n 1.8v 219.505n 1.8v 229.495n 1.8v 229.505n 1.8v 239.495n 1.8v 239.505n 1.8v 249.495n 1.8v 249.505n 1.8v 259.495n 1.8v 259.505n 1.8v 269.495n 1.8v 269.505n 1.8v 279.495n 1.8v 279.505n 1.8v 289.495n 1.8v 289.505n 1.8v 299.495n 1.8v 299.505n 0.0v 309.495n 0.0v 309.505n 0.0v 319.495n 0.0v 319.505n 0.0v 329.495n 0.0v 329.505n 1.8v 339.495n 1.8v 339.505n 1.8v 349.495n 1.8v 349.505n 1.8v 359.495n 1.8v 359.505n 1.8v 369.495n 1.8v 369.505n 0.0v 379.495n 0.0v 379.505n 0.0v 389.495n 0.0v 389.505n 0.0v 399.495n 0.0v 399.505n 0.0v 409.495n 0.0v 409.505n 0.0v 419.495n 0.0v 419.505n 0.0v 429.495n 0.0v 429.505n 0.0v 439.495n 0.0v 439.505n 0.0v 449.495n 0.0v 449.505n 0.0v 459.495n 0.0v 459.505n 0.0v 469.495n 0.0v 469.505n 1.8v 479.495n 1.8v 479.505n 1.8v 489.495n 1.8v 489.505n 1.8v 499.495n 1.8v 499.505n 1.8v 509.495n 1.8v 509.505n 1.8v 519.495n 1.8v 519.505n 1.8v 529.495n 1.8v 529.505n 1.8v 539.495n 1.8v 539.505n 1.8v 549.495n 1.8v 549.505n 1.8v 559.495n 1.8v 559.505n 0.0v 569.495n 0.0v 569.505n 0.0v 579.495n 0.0v 579.505n 0.0v 589.495n 0.0v 589.505n 0.0v 599.495n 0.0v 599.505n 0.0v 609.495n 0.0v 609.505n 0.0v 619.495n 0.0v 619.505n 0.0v 629.495n 0.0v 629.505n 0.0v 639.495n 0.0v 639.505n 1.8v 649.495n 1.8v 649.505n 1.8v 659.495n 1.8v 659.505n 1.8v 669.495n 1.8v 669.505n 1.8v 679.495n 1.8v 679.505n 1.8v 689.495n 1.8v 689.505n 1.8v 699.495n 1.8v 699.505n 0.0v 709.495n 0.0v 709.505n 0.0v 719.495n 0.0v 719.505n 0.0v 729.495n 0.0v 729.505n 0.0v 739.495n 0.0v 739.505n 0.0v 749.495n 0.0v 749.505n 0.0v 759.495n 0.0v 759.505n 1.8v 769.495n 1.8v 769.505n 1.8v 779.495n 1.8v 779.505n 1.8v 789.495n 1.8v 789.505n 1.8v 799.495n 1.8v 799.505n 1.8v 809.495n 1.8v 809.505n 1.8v 819.495n 1.8v 819.505n 1.8v 829.495n 1.8v 829.505n 1.8v 839.495n 1.8v 839.505n 1.8v 849.495n 1.8v 849.505n 1.8v 859.495n 1.8v 859.505n 0.0v 869.495n 0.0v 869.505n 1.8v 879.495n 1.8v 879.505n 1.8v 889.495n 1.8v 889.505n 1.8v 899.495n 1.8v 899.505n 1.8v 909.495n 1.8v 909.505n 1.8v 919.495n 1.8v 919.505n 1.8v 929.495n 1.8v 929.505n 1.8v 939.495n 1.8v 939.505n 1.8v 949.495n 1.8v 949.505n 1.8v 959.495n 1.8v 959.505n 1.8v 969.495n 1.8v 969.505n 1.8v 979.495n 1.8v 979.505n 1.8v 989.495n 1.8v 989.505n 1.8v 999.495n 1.8v 999.505n 1.8v 1009.495n 1.8v 1009.505n 1.8v 1019.495n 1.8v 1019.505n 1.8v 1029.495n 1.8v 1029.505n 1.8v 1039.495n 1.8v 1039.505n 1.8v 1049.495n 1.8v 1049.505n 0.0v 1059.495n 0.0v 1059.505n 1.8v 1069.495n 1.8v 1069.505n 1.8v 1079.495n 1.8v 1079.505n 1.8v 1089.495n 1.8v 1089.505n 0.0v 1099.495n 0.0v 1099.505n 0.0v 1109.495n 0.0v 1109.505n 0.0v 1119.495n 0.0v 1119.505n 0.0v 1129.495n 0.0v 1129.505n 0.0v 1139.495n 0.0v 1139.505n 0.0v 1149.495n 0.0v 1149.505n 0.0v 1159.495n 0.0v 1159.505n 0.0v 1169.495n 0.0v 1169.505n 0.0v 1179.495n 0.0v 1179.505n 0.0v 1189.495n 0.0v 1189.505n 0.0v 1199.495n 0.0v 1199.505n 0.0v 1209.495n 0.0v 1209.505n 0.0v 1219.495n 0.0v 1219.505n 0.0v 1229.495n 0.0v 1229.505n 0.0v 1239.495n 0.0v 1239.505n 0.0v 1249.495n 0.0v 1249.505n 0.0v 1259.495n 0.0v 1259.505n 0.0v 1269.495n 0.0v 1269.505n 0.0v 1279.495n 0.0v 1279.505n 1.8v 1289.495n 1.8v 1289.505n 1.8v 1299.495n 1.8v 1299.505n 1.8v 1309.495n 1.8v 1309.505n 1.8v 1319.495n 1.8v 1319.505n 1.8v 1329.495n 1.8v 1329.505n 1.8v 1339.495n 1.8v 1339.505n 1.8v 1349.495n 1.8v 1349.505n 1.8v 1359.495n 1.8v 1359.505n 1.8v 1369.495n 1.8v 1369.505n 0.0v 1379.495n 0.0v 1379.505n 0.0v 1389.495n 0.0v 1389.505n 0.0v 1399.495n 0.0v 1399.505n 0.0v 1409.495n 0.0v 1409.505n 0.0v 1419.495n 0.0v 1419.505n 1.8v 1429.495n 1.8v 1429.505n 0.0v 1439.495n 0.0v 1439.505n 0.0v 1449.495n 0.0v 1449.505n 0.0v 1459.495n 0.0v 1459.505n 0.0v 1469.495n 0.0v 1469.505n 0.0v 1479.495n 0.0v 1479.505n 0.0v 1489.495n 0.0v 1489.505n 0.0v 1499.495n 0.0v 1499.505n 0.0v 1509.495n 0.0v 1509.505n 0.0v 1519.495n 0.0v 1519.505n 0.0v 1529.495n 0.0v 1529.505n 0.0v 1539.495n 0.0v 1539.505n 0.0v 1549.495n 0.0v 1549.505n 0.0v 1559.495n 0.0v 1559.505n 0.0v 1569.495n 0.0v 1569.505n 0.0v 1579.495n 0.0v 1579.505n 0.0v 1589.495n 0.0v 1589.505n 0.0v 1599.495n 0.0v 1599.505n 0.0v 1609.495n 0.0v 1609.505n 0.0v 1619.495n 0.0v 1619.505n 0.0v 1629.495n 0.0v 1629.505n 0.0v 1639.495n 0.0v 1639.505n 0.0v 1649.495n 0.0v 1649.505n 1.8v 1659.495n 1.8v 1659.505n 1.8v 1669.495n 1.8v 1669.505n 1.8v 1679.495n 1.8v 1679.505n 1.8v 1689.495n 1.8v 1689.505n 1.8v 1699.495n 1.8v 1699.505n 1.8v 1709.495n 1.8v 1709.505n 1.8v 1719.495n 1.8v 1719.505n 1.8v 1729.495n 1.8v 1729.505n 1.8v 1739.495n 1.8v 1739.505n 1.8v 1749.495n 1.8v 1749.505n 1.8v 1759.495n 1.8v 1759.505n 1.8v 1769.495n 1.8v 1769.505n 1.8v 1779.495n 1.8v 1779.505n 1.8v 1789.495n 1.8v 1789.505n 0.0v 1799.495n 0.0v 1799.505n 0.0v 1809.495n 0.0v 1809.505n 0.0v 1819.495n 0.0v 1819.505n 1.8v 1829.495n 1.8v 1829.505n 1.8v 1839.495n 1.8v 1839.505n 1.8v 1849.495n 1.8v 1849.505n 0.0v 1859.495n 0.0v 1859.505n 0.0v 1869.495n 0.0v 1869.505n 0.0v 1879.495n 0.0v 1879.505n 0.0v 1889.495n 0.0v 1889.505n 0.0v 1899.495n 0.0v 1899.505n 0.0v 1909.495n 0.0v 1909.505n 1.8v 1919.495n 1.8v 1919.505n 1.8v 1929.495n 1.8v 1929.505n 1.8v 1939.495n 1.8v 1939.505n 1.8v 1949.495n 1.8v 1949.505n 1.8v 1959.495n 1.8v 1959.505n 1.8v 1969.495n 1.8v 1969.505n 1.8v 1979.495n 1.8v 1979.505n 1.8v 1989.495n 1.8v 1989.505n 1.8v 1999.495n 1.8v 1999.505n 1.8v 2009.495n 1.8v 2009.505n 1.8v 2019.495n 1.8v 2019.505n 1.8v 2029.495n 1.8v 2029.505n 1.8v 2039.495n 1.8v 2039.505n 1.8v 2049.495n 1.8v 2049.505n 1.8v )
* (time, data): [(0, 0), (10, 1), (20, 0), (30, 1), (40, 1), (50, 1), (60, 1), (70, 1), (80, 1), (90, 1), (100, 0), (110, 0), (120, 1), (130, 1), (140, 1), (150, 1), (160, 1), (170, 1), (180, 1), (190, 1), (200, 0), (210, 0), (220, 0), (230, 1), (240, 0), (250, 0), (260, 0), (270, 0), (280, 0), (290, 1), (300, 0), (310, 0), (320, 0), (330, 1), (340, 1), (350, 1), (360, 1), (370, 0), (380, 0), (390, 0), (400, 0), (410, 0), (420, 0), (430, 0), (440, 0), (450, 0), (460, 0), (470, 1), (480, 1), (490, 1), (500, 1), (510, 1), (520, 1), (530, 1), (540, 1), (550, 1), (560, 0), (570, 0), (580, 0), (590, 0), (600, 0), (610, 0), (620, 0), (630, 0), (640, 1), (650, 1), (660, 1), (670, 1), (680, 0), (690, 0), (700, 1), (710, 1), (720, 1), (730, 1), (740, 1), (750, 1), (760, 0), (770, 0), (780, 0), (790, 0), (800, 0), (810, 1), (820, 1), (830, 1), (840, 1), (850, 1), (860, 0), (870, 1), (880, 1), (890, 1), (900, 1), (910, 1), (920, 1), (930, 0), (940, 1), (950, 1), (960, 0), (970, 0), (980, 0), (990, 0), (1000, 0), (1010, 0), (1020, 0), (1030, 0), (1040, 0), (1050, 1), (1060, 0), (1070, 0), (1080, 0), (1090, 0), (1100, 0), (1110, 0), (1120, 0), (1130, 0), (1140, 0), (1150, 0), (1160, 1), (1170, 1), (1180, 1), (1190, 1), (1200, 1), (1210, 1), (1220, 1), (1230, 1), (1240, 1), (1250, 0), (1260, 0), (1270, 0), (1280, 1), (1290, 1), (1300, 1), (1310, 1), (1320, 1), (1330, 1), (1340, 1), (1350, 1), (1360, 1), (1370, 0), (1380, 0), (1390, 0), (1400, 1), (1410, 1), (1420, 1), (1430, 1), (1440, 1), (1450, 1), (1460, 1), (1470, 1), (1480, 1), (1490, 0), (1500, 0), (1510, 0), (1520, 0), (1530, 0), (1540, 0), (1550, 0), (1560, 0), (1570, 0), (1580, 0), (1590, 0), (1600, 0), (1610, 0), (1620, 0), (1630, 0), (1640, 0), (1650, 0), (1660, 0), (1670, 0), (1680, 0), (1690, 0), (1700, 0), (1710, 0), (1720, 0), (1730, 0), (1740, 0), (1750, 0), (1760, 1), (1770, 1), (1780, 1), (1790, 0), (1800, 0), (1810, 0), (1820, 0), (1830, 0), (1840, 0), (1850, 0), (1860, 0), (1870, 0), (1880, 0), (1890, 0), (1900, 0), (1910, 1), (1920, 1), (1930, 1), (1940, 1), (1950, 1), (1960, 1), (1970, 1), (1980, 1), (1990, 1), (2000, 1), (2010, 1), (2020, 1), (2030, 1), (2040, 1), (2050, 1)]
Vdin0_13  din0_13  0 PWL (0n 0.0v 9.495n 0.0v 9.505n 1.8v 19.495n 1.8v 19.505n 0.0v 29.495n 0.0v 29.505n 1.8v 39.495n 1.8v 39.505n 1.8v 49.495n 1.8v 49.505n 1.8v 59.495n 1.8v 59.505n 1.8v 69.495n 1.8v 69.505n 1.8v 79.495n 1.8v 79.505n 1.8v 89.495n 1.8v 89.505n 1.8v 99.495n 1.8v 99.505n 0.0v 109.495n 0.0v 109.505n 0.0v 119.495n 0.0v 119.505n 1.8v 129.495n 1.8v 129.505n 1.8v 139.495n 1.8v 139.505n 1.8v 149.495n 1.8v 149.505n 1.8v 159.495n 1.8v 159.505n 1.8v 169.495n 1.8v 169.505n 1.8v 179.495n 1.8v 179.505n 1.8v 189.495n 1.8v 189.505n 1.8v 199.495n 1.8v 199.505n 0.0v 209.495n 0.0v 209.505n 0.0v 219.495n 0.0v 219.505n 0.0v 229.495n 0.0v 229.505n 1.8v 239.495n 1.8v 239.505n 0.0v 249.495n 0.0v 249.505n 0.0v 259.495n 0.0v 259.505n 0.0v 269.495n 0.0v 269.505n 0.0v 279.495n 0.0v 279.505n 0.0v 289.495n 0.0v 289.505n 1.8v 299.495n 1.8v 299.505n 0.0v 309.495n 0.0v 309.505n 0.0v 319.495n 0.0v 319.505n 0.0v 329.495n 0.0v 329.505n 1.8v 339.495n 1.8v 339.505n 1.8v 349.495n 1.8v 349.505n 1.8v 359.495n 1.8v 359.505n 1.8v 369.495n 1.8v 369.505n 0.0v 379.495n 0.0v 379.505n 0.0v 389.495n 0.0v 389.505n 0.0v 399.495n 0.0v 399.505n 0.0v 409.495n 0.0v 409.505n 0.0v 419.495n 0.0v 419.505n 0.0v 429.495n 0.0v 429.505n 0.0v 439.495n 0.0v 439.505n 0.0v 449.495n 0.0v 449.505n 0.0v 459.495n 0.0v 459.505n 0.0v 469.495n 0.0v 469.505n 1.8v 479.495n 1.8v 479.505n 1.8v 489.495n 1.8v 489.505n 1.8v 499.495n 1.8v 499.505n 1.8v 509.495n 1.8v 509.505n 1.8v 519.495n 1.8v 519.505n 1.8v 529.495n 1.8v 529.505n 1.8v 539.495n 1.8v 539.505n 1.8v 549.495n 1.8v 549.505n 1.8v 559.495n 1.8v 559.505n 0.0v 569.495n 0.0v 569.505n 0.0v 579.495n 0.0v 579.505n 0.0v 589.495n 0.0v 589.505n 0.0v 599.495n 0.0v 599.505n 0.0v 609.495n 0.0v 609.505n 0.0v 619.495n 0.0v 619.505n 0.0v 629.495n 0.0v 629.505n 0.0v 639.495n 0.0v 639.505n 1.8v 649.495n 1.8v 649.505n 1.8v 659.495n 1.8v 659.505n 1.8v 669.495n 1.8v 669.505n 1.8v 679.495n 1.8v 679.505n 0.0v 689.495n 0.0v 689.505n 0.0v 699.495n 0.0v 699.505n 1.8v 709.495n 1.8v 709.505n 1.8v 719.495n 1.8v 719.505n 1.8v 729.495n 1.8v 729.505n 1.8v 739.495n 1.8v 739.505n 1.8v 749.495n 1.8v 749.505n 1.8v 759.495n 1.8v 759.505n 0.0v 769.495n 0.0v 769.505n 0.0v 779.495n 0.0v 779.505n 0.0v 789.495n 0.0v 789.505n 0.0v 799.495n 0.0v 799.505n 0.0v 809.495n 0.0v 809.505n 1.8v 819.495n 1.8v 819.505n 1.8v 829.495n 1.8v 829.505n 1.8v 839.495n 1.8v 839.505n 1.8v 849.495n 1.8v 849.505n 1.8v 859.495n 1.8v 859.505n 0.0v 869.495n 0.0v 869.505n 1.8v 879.495n 1.8v 879.505n 1.8v 889.495n 1.8v 889.505n 1.8v 899.495n 1.8v 899.505n 1.8v 909.495n 1.8v 909.505n 1.8v 919.495n 1.8v 919.505n 1.8v 929.495n 1.8v 929.505n 0.0v 939.495n 0.0v 939.505n 1.8v 949.495n 1.8v 949.505n 1.8v 959.495n 1.8v 959.505n 0.0v 969.495n 0.0v 969.505n 0.0v 979.495n 0.0v 979.505n 0.0v 989.495n 0.0v 989.505n 0.0v 999.495n 0.0v 999.505n 0.0v 1009.495n 0.0v 1009.505n 0.0v 1019.495n 0.0v 1019.505n 0.0v 1029.495n 0.0v 1029.505n 0.0v 1039.495n 0.0v 1039.505n 0.0v 1049.495n 0.0v 1049.505n 1.8v 1059.495n 1.8v 1059.505n 0.0v 1069.495n 0.0v 1069.505n 0.0v 1079.495n 0.0v 1079.505n 0.0v 1089.495n 0.0v 1089.505n 0.0v 1099.495n 0.0v 1099.505n 0.0v 1109.495n 0.0v 1109.505n 0.0v 1119.495n 0.0v 1119.505n 0.0v 1129.495n 0.0v 1129.505n 0.0v 1139.495n 0.0v 1139.505n 0.0v 1149.495n 0.0v 1149.505n 0.0v 1159.495n 0.0v 1159.505n 1.8v 1169.495n 1.8v 1169.505n 1.8v 1179.495n 1.8v 1179.505n 1.8v 1189.495n 1.8v 1189.505n 1.8v 1199.495n 1.8v 1199.505n 1.8v 1209.495n 1.8v 1209.505n 1.8v 1219.495n 1.8v 1219.505n 1.8v 1229.495n 1.8v 1229.505n 1.8v 1239.495n 1.8v 1239.505n 1.8v 1249.495n 1.8v 1249.505n 0.0v 1259.495n 0.0v 1259.505n 0.0v 1269.495n 0.0v 1269.505n 0.0v 1279.495n 0.0v 1279.505n 1.8v 1289.495n 1.8v 1289.505n 1.8v 1299.495n 1.8v 1299.505n 1.8v 1309.495n 1.8v 1309.505n 1.8v 1319.495n 1.8v 1319.505n 1.8v 1329.495n 1.8v 1329.505n 1.8v 1339.495n 1.8v 1339.505n 1.8v 1349.495n 1.8v 1349.505n 1.8v 1359.495n 1.8v 1359.505n 1.8v 1369.495n 1.8v 1369.505n 0.0v 1379.495n 0.0v 1379.505n 0.0v 1389.495n 0.0v 1389.505n 0.0v 1399.495n 0.0v 1399.505n 1.8v 1409.495n 1.8v 1409.505n 1.8v 1419.495n 1.8v 1419.505n 1.8v 1429.495n 1.8v 1429.505n 1.8v 1439.495n 1.8v 1439.505n 1.8v 1449.495n 1.8v 1449.505n 1.8v 1459.495n 1.8v 1459.505n 1.8v 1469.495n 1.8v 1469.505n 1.8v 1479.495n 1.8v 1479.505n 1.8v 1489.495n 1.8v 1489.505n 0.0v 1499.495n 0.0v 1499.505n 0.0v 1509.495n 0.0v 1509.505n 0.0v 1519.495n 0.0v 1519.505n 0.0v 1529.495n 0.0v 1529.505n 0.0v 1539.495n 0.0v 1539.505n 0.0v 1549.495n 0.0v 1549.505n 0.0v 1559.495n 0.0v 1559.505n 0.0v 1569.495n 0.0v 1569.505n 0.0v 1579.495n 0.0v 1579.505n 0.0v 1589.495n 0.0v 1589.505n 0.0v 1599.495n 0.0v 1599.505n 0.0v 1609.495n 0.0v 1609.505n 0.0v 1619.495n 0.0v 1619.505n 0.0v 1629.495n 0.0v 1629.505n 0.0v 1639.495n 0.0v 1639.505n 0.0v 1649.495n 0.0v 1649.505n 0.0v 1659.495n 0.0v 1659.505n 0.0v 1669.495n 0.0v 1669.505n 0.0v 1679.495n 0.0v 1679.505n 0.0v 1689.495n 0.0v 1689.505n 0.0v 1699.495n 0.0v 1699.505n 0.0v 1709.495n 0.0v 1709.505n 0.0v 1719.495n 0.0v 1719.505n 0.0v 1729.495n 0.0v 1729.505n 0.0v 1739.495n 0.0v 1739.505n 0.0v 1749.495n 0.0v 1749.505n 0.0v 1759.495n 0.0v 1759.505n 1.8v 1769.495n 1.8v 1769.505n 1.8v 1779.495n 1.8v 1779.505n 1.8v 1789.495n 1.8v 1789.505n 0.0v 1799.495n 0.0v 1799.505n 0.0v 1809.495n 0.0v 1809.505n 0.0v 1819.495n 0.0v 1819.505n 0.0v 1829.495n 0.0v 1829.505n 0.0v 1839.495n 0.0v 1839.505n 0.0v 1849.495n 0.0v 1849.505n 0.0v 1859.495n 0.0v 1859.505n 0.0v 1869.495n 0.0v 1869.505n 0.0v 1879.495n 0.0v 1879.505n 0.0v 1889.495n 0.0v 1889.505n 0.0v 1899.495n 0.0v 1899.505n 0.0v 1909.495n 0.0v 1909.505n 1.8v 1919.495n 1.8v 1919.505n 1.8v 1929.495n 1.8v 1929.505n 1.8v 1939.495n 1.8v 1939.505n 1.8v 1949.495n 1.8v 1949.505n 1.8v 1959.495n 1.8v 1959.505n 1.8v 1969.495n 1.8v 1969.505n 1.8v 1979.495n 1.8v 1979.505n 1.8v 1989.495n 1.8v 1989.505n 1.8v 1999.495n 1.8v 1999.505n 1.8v 2009.495n 1.8v 2009.505n 1.8v 2019.495n 1.8v 2019.505n 1.8v 2029.495n 1.8v 2029.505n 1.8v 2039.495n 1.8v 2039.505n 1.8v 2049.495n 1.8v 2049.505n 1.8v )
* (time, data): [(0, 0), (10, 0), (20, 0), (30, 0), (40, 0), (50, 0), (60, 0), (70, 0), (80, 0), (90, 1), (100, 1), (110, 1), (120, 1), (130, 1), (140, 1), (150, 1), (160, 1), (170, 1), (180, 0), (190, 0), (200, 1), (210, 1), (220, 1), (230, 1), (240, 0), (250, 0), (260, 0), (270, 0), (280, 0), (290, 0), (300, 1), (310, 1), (320, 1), (330, 0), (340, 0), (350, 0), (360, 1), (370, 1), (380, 1), (390, 1), (400, 1), (410, 1), (420, 1), (430, 1), (440, 1), (450, 1), (460, 0), (470, 1), (480, 1), (490, 1), (500, 1), (510, 1), (520, 1), (530, 1), (540, 1), (550, 1), (560, 1), (570, 1), (580, 1), (590, 1), (600, 1), (610, 1), (620, 1), (630, 1), (640, 1), (650, 1), (660, 1), (670, 1), (680, 0), (690, 0), (700, 0), (710, 0), (720, 0), (730, 0), (740, 0), (750, 0), (760, 0), (770, 0), (780, 0), (790, 0), (800, 0), (810, 1), (820, 1), (830, 1), (840, 1), (850, 1), (860, 1), (870, 0), (880, 0), (890, 0), (900, 0), (910, 0), (920, 0), (930, 1), (940, 1), (950, 1), (960, 0), (970, 0), (980, 0), (990, 0), (1000, 0), (1010, 0), (1020, 0), (1030, 0), (1040, 0), (1050, 1), (1060, 1), (1070, 1), (1080, 1), (1090, 1), (1100, 1), (1110, 1), (1120, 1), (1130, 1), (1140, 1), (1150, 1), (1160, 0), (1170, 0), (1180, 0), (1190, 0), (1200, 0), (1210, 0), (1220, 0), (1230, 0), (1240, 0), (1250, 1), (1260, 1), (1270, 1), (1280, 0), (1290, 0), (1300, 0), (1310, 0), (1320, 0), (1330, 0), (1340, 0), (1350, 0), (1360, 0), (1370, 0), (1380, 0), (1390, 0), (1400, 1), (1410, 1), (1420, 1), (1430, 0), (1440, 0), (1450, 0), (1460, 0), (1470, 0), (1480, 0), (1490, 1), (1500, 1), (1510, 1), (1520, 1), (1530, 1), (1540, 1), (1550, 1), (1560, 1), (1570, 1), (1580, 1), (1590, 1), (1600, 1), (1610, 1), (1620, 1), (1630, 1), (1640, 1), (1650, 0), (1660, 0), (1670, 0), (1680, 0), (1690, 0), (1700, 0), (1710, 0), (1720, 0), (1730, 0), (1740, 0), (1750, 0), (1760, 1), (1770, 1), (1780, 1), (1790, 1), (1800, 1), (1810, 1), (1820, 0), (1830, 0), (1840, 0), (1850, 1), (1860, 1), (1870, 1), (1880, 1), (1890, 1), (1900, 1), (1910, 0), (1920, 0), (1930, 0), (1940, 0), (1950, 0), (1960, 0), (1970, 0), (1980, 0), (1990, 0), (2000, 0), (2010, 0), (2020, 0), (2030, 0), (2040, 0), (2050, 0)]
Vdin0_14  din0_14  0 PWL (0n 0.0v 9.495n 0.0v 9.505n 0.0v 19.495n 0.0v 19.505n 0.0v 29.495n 0.0v 29.505n 0.0v 39.495n 0.0v 39.505n 0.0v 49.495n 0.0v 49.505n 0.0v 59.495n 0.0v 59.505n 0.0v 69.495n 0.0v 69.505n 0.0v 79.495n 0.0v 79.505n 0.0v 89.495n 0.0v 89.505n 1.8v 99.495n 1.8v 99.505n 1.8v 109.495n 1.8v 109.505n 1.8v 119.495n 1.8v 119.505n 1.8v 129.495n 1.8v 129.505n 1.8v 139.495n 1.8v 139.505n 1.8v 149.495n 1.8v 149.505n 1.8v 159.495n 1.8v 159.505n 1.8v 169.495n 1.8v 169.505n 1.8v 179.495n 1.8v 179.505n 0.0v 189.495n 0.0v 189.505n 0.0v 199.495n 0.0v 199.505n 1.8v 209.495n 1.8v 209.505n 1.8v 219.495n 1.8v 219.505n 1.8v 229.495n 1.8v 229.505n 1.8v 239.495n 1.8v 239.505n 0.0v 249.495n 0.0v 249.505n 0.0v 259.495n 0.0v 259.505n 0.0v 269.495n 0.0v 269.505n 0.0v 279.495n 0.0v 279.505n 0.0v 289.495n 0.0v 289.505n 0.0v 299.495n 0.0v 299.505n 1.8v 309.495n 1.8v 309.505n 1.8v 319.495n 1.8v 319.505n 1.8v 329.495n 1.8v 329.505n 0.0v 339.495n 0.0v 339.505n 0.0v 349.495n 0.0v 349.505n 0.0v 359.495n 0.0v 359.505n 1.8v 369.495n 1.8v 369.505n 1.8v 379.495n 1.8v 379.505n 1.8v 389.495n 1.8v 389.505n 1.8v 399.495n 1.8v 399.505n 1.8v 409.495n 1.8v 409.505n 1.8v 419.495n 1.8v 419.505n 1.8v 429.495n 1.8v 429.505n 1.8v 439.495n 1.8v 439.505n 1.8v 449.495n 1.8v 449.505n 1.8v 459.495n 1.8v 459.505n 0.0v 469.495n 0.0v 469.505n 1.8v 479.495n 1.8v 479.505n 1.8v 489.495n 1.8v 489.505n 1.8v 499.495n 1.8v 499.505n 1.8v 509.495n 1.8v 509.505n 1.8v 519.495n 1.8v 519.505n 1.8v 529.495n 1.8v 529.505n 1.8v 539.495n 1.8v 539.505n 1.8v 549.495n 1.8v 549.505n 1.8v 559.495n 1.8v 559.505n 1.8v 569.495n 1.8v 569.505n 1.8v 579.495n 1.8v 579.505n 1.8v 589.495n 1.8v 589.505n 1.8v 599.495n 1.8v 599.505n 1.8v 609.495n 1.8v 609.505n 1.8v 619.495n 1.8v 619.505n 1.8v 629.495n 1.8v 629.505n 1.8v 639.495n 1.8v 639.505n 1.8v 649.495n 1.8v 649.505n 1.8v 659.495n 1.8v 659.505n 1.8v 669.495n 1.8v 669.505n 1.8v 679.495n 1.8v 679.505n 0.0v 689.495n 0.0v 689.505n 0.0v 699.495n 0.0v 699.505n 0.0v 709.495n 0.0v 709.505n 0.0v 719.495n 0.0v 719.505n 0.0v 729.495n 0.0v 729.505n 0.0v 739.495n 0.0v 739.505n 0.0v 749.495n 0.0v 749.505n 0.0v 759.495n 0.0v 759.505n 0.0v 769.495n 0.0v 769.505n 0.0v 779.495n 0.0v 779.505n 0.0v 789.495n 0.0v 789.505n 0.0v 799.495n 0.0v 799.505n 0.0v 809.495n 0.0v 809.505n 1.8v 819.495n 1.8v 819.505n 1.8v 829.495n 1.8v 829.505n 1.8v 839.495n 1.8v 839.505n 1.8v 849.495n 1.8v 849.505n 1.8v 859.495n 1.8v 859.505n 1.8v 869.495n 1.8v 869.505n 0.0v 879.495n 0.0v 879.505n 0.0v 889.495n 0.0v 889.505n 0.0v 899.495n 0.0v 899.505n 0.0v 909.495n 0.0v 909.505n 0.0v 919.495n 0.0v 919.505n 0.0v 929.495n 0.0v 929.505n 1.8v 939.495n 1.8v 939.505n 1.8v 949.495n 1.8v 949.505n 1.8v 959.495n 1.8v 959.505n 0.0v 969.495n 0.0v 969.505n 0.0v 979.495n 0.0v 979.505n 0.0v 989.495n 0.0v 989.505n 0.0v 999.495n 0.0v 999.505n 0.0v 1009.495n 0.0v 1009.505n 0.0v 1019.495n 0.0v 1019.505n 0.0v 1029.495n 0.0v 1029.505n 0.0v 1039.495n 0.0v 1039.505n 0.0v 1049.495n 0.0v 1049.505n 1.8v 1059.495n 1.8v 1059.505n 1.8v 1069.495n 1.8v 1069.505n 1.8v 1079.495n 1.8v 1079.505n 1.8v 1089.495n 1.8v 1089.505n 1.8v 1099.495n 1.8v 1099.505n 1.8v 1109.495n 1.8v 1109.505n 1.8v 1119.495n 1.8v 1119.505n 1.8v 1129.495n 1.8v 1129.505n 1.8v 1139.495n 1.8v 1139.505n 1.8v 1149.495n 1.8v 1149.505n 1.8v 1159.495n 1.8v 1159.505n 0.0v 1169.495n 0.0v 1169.505n 0.0v 1179.495n 0.0v 1179.505n 0.0v 1189.495n 0.0v 1189.505n 0.0v 1199.495n 0.0v 1199.505n 0.0v 1209.495n 0.0v 1209.505n 0.0v 1219.495n 0.0v 1219.505n 0.0v 1229.495n 0.0v 1229.505n 0.0v 1239.495n 0.0v 1239.505n 0.0v 1249.495n 0.0v 1249.505n 1.8v 1259.495n 1.8v 1259.505n 1.8v 1269.495n 1.8v 1269.505n 1.8v 1279.495n 1.8v 1279.505n 0.0v 1289.495n 0.0v 1289.505n 0.0v 1299.495n 0.0v 1299.505n 0.0v 1309.495n 0.0v 1309.505n 0.0v 1319.495n 0.0v 1319.505n 0.0v 1329.495n 0.0v 1329.505n 0.0v 1339.495n 0.0v 1339.505n 0.0v 1349.495n 0.0v 1349.505n 0.0v 1359.495n 0.0v 1359.505n 0.0v 1369.495n 0.0v 1369.505n 0.0v 1379.495n 0.0v 1379.505n 0.0v 1389.495n 0.0v 1389.505n 0.0v 1399.495n 0.0v 1399.505n 1.8v 1409.495n 1.8v 1409.505n 1.8v 1419.495n 1.8v 1419.505n 1.8v 1429.495n 1.8v 1429.505n 0.0v 1439.495n 0.0v 1439.505n 0.0v 1449.495n 0.0v 1449.505n 0.0v 1459.495n 0.0v 1459.505n 0.0v 1469.495n 0.0v 1469.505n 0.0v 1479.495n 0.0v 1479.505n 0.0v 1489.495n 0.0v 1489.505n 1.8v 1499.495n 1.8v 1499.505n 1.8v 1509.495n 1.8v 1509.505n 1.8v 1519.495n 1.8v 1519.505n 1.8v 1529.495n 1.8v 1529.505n 1.8v 1539.495n 1.8v 1539.505n 1.8v 1549.495n 1.8v 1549.505n 1.8v 1559.495n 1.8v 1559.505n 1.8v 1569.495n 1.8v 1569.505n 1.8v 1579.495n 1.8v 1579.505n 1.8v 1589.495n 1.8v 1589.505n 1.8v 1599.495n 1.8v 1599.505n 1.8v 1609.495n 1.8v 1609.505n 1.8v 1619.495n 1.8v 1619.505n 1.8v 1629.495n 1.8v 1629.505n 1.8v 1639.495n 1.8v 1639.505n 1.8v 1649.495n 1.8v 1649.505n 0.0v 1659.495n 0.0v 1659.505n 0.0v 1669.495n 0.0v 1669.505n 0.0v 1679.495n 0.0v 1679.505n 0.0v 1689.495n 0.0v 1689.505n 0.0v 1699.495n 0.0v 1699.505n 0.0v 1709.495n 0.0v 1709.505n 0.0v 1719.495n 0.0v 1719.505n 0.0v 1729.495n 0.0v 1729.505n 0.0v 1739.495n 0.0v 1739.505n 0.0v 1749.495n 0.0v 1749.505n 0.0v 1759.495n 0.0v 1759.505n 1.8v 1769.495n 1.8v 1769.505n 1.8v 1779.495n 1.8v 1779.505n 1.8v 1789.495n 1.8v 1789.505n 1.8v 1799.495n 1.8v 1799.505n 1.8v 1809.495n 1.8v 1809.505n 1.8v 1819.495n 1.8v 1819.505n 0.0v 1829.495n 0.0v 1829.505n 0.0v 1839.495n 0.0v 1839.505n 0.0v 1849.495n 0.0v 1849.505n 1.8v 1859.495n 1.8v 1859.505n 1.8v 1869.495n 1.8v 1869.505n 1.8v 1879.495n 1.8v 1879.505n 1.8v 1889.495n 1.8v 1889.505n 1.8v 1899.495n 1.8v 1899.505n 1.8v 1909.495n 1.8v 1909.505n 0.0v 1919.495n 0.0v 1919.505n 0.0v 1929.495n 0.0v 1929.505n 0.0v 1939.495n 0.0v 1939.505n 0.0v 1949.495n 0.0v 1949.505n 0.0v 1959.495n 0.0v 1959.505n 0.0v 1969.495n 0.0v 1969.505n 0.0v 1979.495n 0.0v 1979.505n 0.0v 1989.495n 0.0v 1989.505n 0.0v 1999.495n 0.0v 1999.505n 0.0v 2009.495n 0.0v 2009.505n 0.0v 2019.495n 0.0v 2019.505n 0.0v 2029.495n 0.0v 2029.505n 0.0v 2039.495n 0.0v 2039.505n 0.0v 2049.495n 0.0v 2049.505n 0.0v )
* (time, data): [(0, 0), (10, 1), (20, 0), (30, 0), (40, 0), (50, 0), (60, 0), (70, 0), (80, 0), (90, 0), (100, 0), (110, 0), (120, 1), (130, 1), (140, 1), (150, 1), (160, 1), (170, 1), (180, 0), (190, 0), (200, 1), (210, 1), (220, 1), (230, 1), (240, 0), (250, 0), (260, 0), (270, 0), (280, 0), (290, 0), (300, 1), (310, 1), (320, 1), (330, 1), (340, 1), (350, 1), (360, 0), (370, 1), (380, 1), (390, 1), (400, 1), (410, 1), (420, 1), (430, 1), (440, 1), (450, 1), (460, 0), (470, 1), (480, 1), (490, 1), (500, 1), (510, 1), (520, 1), (530, 1), (540, 1), (550, 1), (560, 0), (570, 0), (580, 0), (590, 0), (600, 0), (610, 0), (620, 0), (630, 0), (640, 0), (650, 0), (660, 0), (670, 0), (680, 0), (690, 0), (700, 0), (710, 0), (720, 0), (730, 0), (740, 0), (750, 0), (760, 1), (770, 1), (780, 1), (790, 1), (800, 1), (810, 1), (820, 1), (830, 1), (840, 1), (850, 1), (860, 0), (870, 1), (880, 1), (890, 1), (900, 1), (910, 1), (920, 1), (930, 1), (940, 1), (950, 1), (960, 1), (970, 1), (980, 1), (990, 1), (1000, 1), (1010, 1), (1020, 1), (1030, 1), (1040, 1), (1050, 0), (1060, 0), (1070, 0), (1080, 0), (1090, 0), (1100, 0), (1110, 0), (1120, 0), (1130, 0), (1140, 1), (1150, 1), (1160, 0), (1170, 0), (1180, 0), (1190, 0), (1200, 0), (1210, 0), (1220, 0), (1230, 0), (1240, 0), (1250, 1), (1260, 0), (1270, 0), (1280, 1), (1290, 1), (1300, 1), (1310, 1), (1320, 1), (1330, 1), (1340, 1), (1350, 1), (1360, 1), (1370, 0), (1380, 0), (1390, 0), (1400, 0), (1410, 0), (1420, 0), (1430, 0), (1440, 0), (1450, 0), (1460, 0), (1470, 0), (1480, 0), (1490, 0), (1500, 0), (1510, 0), (1520, 0), (1530, 0), (1540, 0), (1550, 1), (1560, 1), (1570, 1), (1580, 1), (1590, 1), (1600, 1), (1610, 1), (1620, 1), (1630, 1), (1640, 1), (1650, 0), (1660, 0), (1670, 0), (1680, 0), (1690, 0), (1700, 0), (1710, 0), (1720, 0), (1730, 0), (1740, 0), (1750, 0), (1760, 1), (1770, 1), (1780, 1), (1790, 1), (1800, 1), (1810, 1), (1820, 0), (1830, 0), (1840, 0), (1850, 1), (1860, 1), (1870, 1), (1880, 1), (1890, 1), (1900, 1), (1910, 1), (1920, 1), (1930, 1), (1940, 1), (1950, 1), (1960, 1), (1970, 1), (1980, 1), (1990, 1), (2000, 1), (2010, 1), (2020, 1), (2030, 1), (2040, 1), (2050, 1)]
Vdin0_15  din0_15  0 PWL (0n 0.0v 9.495n 0.0v 9.505n 1.8v 19.495n 1.8v 19.505n 0.0v 29.495n 0.0v 29.505n 0.0v 39.495n 0.0v 39.505n 0.0v 49.495n 0.0v 49.505n 0.0v 59.495n 0.0v 59.505n 0.0v 69.495n 0.0v 69.505n 0.0v 79.495n 0.0v 79.505n 0.0v 89.495n 0.0v 89.505n 0.0v 99.495n 0.0v 99.505n 0.0v 109.495n 0.0v 109.505n 0.0v 119.495n 0.0v 119.505n 1.8v 129.495n 1.8v 129.505n 1.8v 139.495n 1.8v 139.505n 1.8v 149.495n 1.8v 149.505n 1.8v 159.495n 1.8v 159.505n 1.8v 169.495n 1.8v 169.505n 1.8v 179.495n 1.8v 179.505n 0.0v 189.495n 0.0v 189.505n 0.0v 199.495n 0.0v 199.505n 1.8v 209.495n 1.8v 209.505n 1.8v 219.495n 1.8v 219.505n 1.8v 229.495n 1.8v 229.505n 1.8v 239.495n 1.8v 239.505n 0.0v 249.495n 0.0v 249.505n 0.0v 259.495n 0.0v 259.505n 0.0v 269.495n 0.0v 269.505n 0.0v 279.495n 0.0v 279.505n 0.0v 289.495n 0.0v 289.505n 0.0v 299.495n 0.0v 299.505n 1.8v 309.495n 1.8v 309.505n 1.8v 319.495n 1.8v 319.505n 1.8v 329.495n 1.8v 329.505n 1.8v 339.495n 1.8v 339.505n 1.8v 349.495n 1.8v 349.505n 1.8v 359.495n 1.8v 359.505n 0.0v 369.495n 0.0v 369.505n 1.8v 379.495n 1.8v 379.505n 1.8v 389.495n 1.8v 389.505n 1.8v 399.495n 1.8v 399.505n 1.8v 409.495n 1.8v 409.505n 1.8v 419.495n 1.8v 419.505n 1.8v 429.495n 1.8v 429.505n 1.8v 439.495n 1.8v 439.505n 1.8v 449.495n 1.8v 449.505n 1.8v 459.495n 1.8v 459.505n 0.0v 469.495n 0.0v 469.505n 1.8v 479.495n 1.8v 479.505n 1.8v 489.495n 1.8v 489.505n 1.8v 499.495n 1.8v 499.505n 1.8v 509.495n 1.8v 509.505n 1.8v 519.495n 1.8v 519.505n 1.8v 529.495n 1.8v 529.505n 1.8v 539.495n 1.8v 539.505n 1.8v 549.495n 1.8v 549.505n 1.8v 559.495n 1.8v 559.505n 0.0v 569.495n 0.0v 569.505n 0.0v 579.495n 0.0v 579.505n 0.0v 589.495n 0.0v 589.505n 0.0v 599.495n 0.0v 599.505n 0.0v 609.495n 0.0v 609.505n 0.0v 619.495n 0.0v 619.505n 0.0v 629.495n 0.0v 629.505n 0.0v 639.495n 0.0v 639.505n 0.0v 649.495n 0.0v 649.505n 0.0v 659.495n 0.0v 659.505n 0.0v 669.495n 0.0v 669.505n 0.0v 679.495n 0.0v 679.505n 0.0v 689.495n 0.0v 689.505n 0.0v 699.495n 0.0v 699.505n 0.0v 709.495n 0.0v 709.505n 0.0v 719.495n 0.0v 719.505n 0.0v 729.495n 0.0v 729.505n 0.0v 739.495n 0.0v 739.505n 0.0v 749.495n 0.0v 749.505n 0.0v 759.495n 0.0v 759.505n 1.8v 769.495n 1.8v 769.505n 1.8v 779.495n 1.8v 779.505n 1.8v 789.495n 1.8v 789.505n 1.8v 799.495n 1.8v 799.505n 1.8v 809.495n 1.8v 809.505n 1.8v 819.495n 1.8v 819.505n 1.8v 829.495n 1.8v 829.505n 1.8v 839.495n 1.8v 839.505n 1.8v 849.495n 1.8v 849.505n 1.8v 859.495n 1.8v 859.505n 0.0v 869.495n 0.0v 869.505n 1.8v 879.495n 1.8v 879.505n 1.8v 889.495n 1.8v 889.505n 1.8v 899.495n 1.8v 899.505n 1.8v 909.495n 1.8v 909.505n 1.8v 919.495n 1.8v 919.505n 1.8v 929.495n 1.8v 929.505n 1.8v 939.495n 1.8v 939.505n 1.8v 949.495n 1.8v 949.505n 1.8v 959.495n 1.8v 959.505n 1.8v 969.495n 1.8v 969.505n 1.8v 979.495n 1.8v 979.505n 1.8v 989.495n 1.8v 989.505n 1.8v 999.495n 1.8v 999.505n 1.8v 1009.495n 1.8v 1009.505n 1.8v 1019.495n 1.8v 1019.505n 1.8v 1029.495n 1.8v 1029.505n 1.8v 1039.495n 1.8v 1039.505n 1.8v 1049.495n 1.8v 1049.505n 0.0v 1059.495n 0.0v 1059.505n 0.0v 1069.495n 0.0v 1069.505n 0.0v 1079.495n 0.0v 1079.505n 0.0v 1089.495n 0.0v 1089.505n 0.0v 1099.495n 0.0v 1099.505n 0.0v 1109.495n 0.0v 1109.505n 0.0v 1119.495n 0.0v 1119.505n 0.0v 1129.495n 0.0v 1129.505n 0.0v 1139.495n 0.0v 1139.505n 1.8v 1149.495n 1.8v 1149.505n 1.8v 1159.495n 1.8v 1159.505n 0.0v 1169.495n 0.0v 1169.505n 0.0v 1179.495n 0.0v 1179.505n 0.0v 1189.495n 0.0v 1189.505n 0.0v 1199.495n 0.0v 1199.505n 0.0v 1209.495n 0.0v 1209.505n 0.0v 1219.495n 0.0v 1219.505n 0.0v 1229.495n 0.0v 1229.505n 0.0v 1239.495n 0.0v 1239.505n 0.0v 1249.495n 0.0v 1249.505n 1.8v 1259.495n 1.8v 1259.505n 0.0v 1269.495n 0.0v 1269.505n 0.0v 1279.495n 0.0v 1279.505n 1.8v 1289.495n 1.8v 1289.505n 1.8v 1299.495n 1.8v 1299.505n 1.8v 1309.495n 1.8v 1309.505n 1.8v 1319.495n 1.8v 1319.505n 1.8v 1329.495n 1.8v 1329.505n 1.8v 1339.495n 1.8v 1339.505n 1.8v 1349.495n 1.8v 1349.505n 1.8v 1359.495n 1.8v 1359.505n 1.8v 1369.495n 1.8v 1369.505n 0.0v 1379.495n 0.0v 1379.505n 0.0v 1389.495n 0.0v 1389.505n 0.0v 1399.495n 0.0v 1399.505n 0.0v 1409.495n 0.0v 1409.505n 0.0v 1419.495n 0.0v 1419.505n 0.0v 1429.495n 0.0v 1429.505n 0.0v 1439.495n 0.0v 1439.505n 0.0v 1449.495n 0.0v 1449.505n 0.0v 1459.495n 0.0v 1459.505n 0.0v 1469.495n 0.0v 1469.505n 0.0v 1479.495n 0.0v 1479.505n 0.0v 1489.495n 0.0v 1489.505n 0.0v 1499.495n 0.0v 1499.505n 0.0v 1509.495n 0.0v 1509.505n 0.0v 1519.495n 0.0v 1519.505n 0.0v 1529.495n 0.0v 1529.505n 0.0v 1539.495n 0.0v 1539.505n 0.0v 1549.495n 0.0v 1549.505n 1.8v 1559.495n 1.8v 1559.505n 1.8v 1569.495n 1.8v 1569.505n 1.8v 1579.495n 1.8v 1579.505n 1.8v 1589.495n 1.8v 1589.505n 1.8v 1599.495n 1.8v 1599.505n 1.8v 1609.495n 1.8v 1609.505n 1.8v 1619.495n 1.8v 1619.505n 1.8v 1629.495n 1.8v 1629.505n 1.8v 1639.495n 1.8v 1639.505n 1.8v 1649.495n 1.8v 1649.505n 0.0v 1659.495n 0.0v 1659.505n 0.0v 1669.495n 0.0v 1669.505n 0.0v 1679.495n 0.0v 1679.505n 0.0v 1689.495n 0.0v 1689.505n 0.0v 1699.495n 0.0v 1699.505n 0.0v 1709.495n 0.0v 1709.505n 0.0v 1719.495n 0.0v 1719.505n 0.0v 1729.495n 0.0v 1729.505n 0.0v 1739.495n 0.0v 1739.505n 0.0v 1749.495n 0.0v 1749.505n 0.0v 1759.495n 0.0v 1759.505n 1.8v 1769.495n 1.8v 1769.505n 1.8v 1779.495n 1.8v 1779.505n 1.8v 1789.495n 1.8v 1789.505n 1.8v 1799.495n 1.8v 1799.505n 1.8v 1809.495n 1.8v 1809.505n 1.8v 1819.495n 1.8v 1819.505n 0.0v 1829.495n 0.0v 1829.505n 0.0v 1839.495n 0.0v 1839.505n 0.0v 1849.495n 0.0v 1849.505n 1.8v 1859.495n 1.8v 1859.505n 1.8v 1869.495n 1.8v 1869.505n 1.8v 1879.495n 1.8v 1879.505n 1.8v 1889.495n 1.8v 1889.505n 1.8v 1899.495n 1.8v 1899.505n 1.8v 1909.495n 1.8v 1909.505n 1.8v 1919.495n 1.8v 1919.505n 1.8v 1929.495n 1.8v 1929.505n 1.8v 1939.495n 1.8v 1939.505n 1.8v 1949.495n 1.8v 1949.505n 1.8v 1959.495n 1.8v 1959.505n 1.8v 1969.495n 1.8v 1969.505n 1.8v 1979.495n 1.8v 1979.505n 1.8v 1989.495n 1.8v 1989.505n 1.8v 1999.495n 1.8v 1999.505n 1.8v 2009.495n 1.8v 2009.505n 1.8v 2019.495n 1.8v 2019.505n 1.8v 2029.495n 1.8v 2029.505n 1.8v 2039.495n 1.8v 2039.505n 1.8v 2049.495n 1.8v 2049.505n 1.8v )
* (time, data): [(0, 0), (10, 1), (20, 1), (30, 1), (40, 1), (50, 1), (60, 1), (70, 1), (80, 1), (90, 1), (100, 0), (110, 0), (120, 0), (130, 0), (140, 0), (150, 0), (160, 0), (170, 0), (180, 1), (190, 1), (200, 0), (210, 0), (220, 0), (230, 0), (240, 0), (250, 0), (260, 0), (270, 0), (280, 0), (290, 1), (300, 1), (310, 1), (320, 1), (330, 0), (340, 0), (350, 0), (360, 0), (370, 0), (380, 0), (390, 0), (400, 0), (410, 0), (420, 0), (430, 0), (440, 0), (450, 0), (460, 1), (470, 1), (480, 1), (490, 1), (500, 1), (510, 1), (520, 1), (530, 1), (540, 1), (550, 1), (560, 0), (570, 0), (580, 0), (590, 0), (600, 0), (610, 0), (620, 0), (630, 0), (640, 1), (650, 1), (660, 0), (670, 0), (680, 0), (690, 0), (700, 0), (710, 0), (720, 0), (730, 0), (740, 1), (750, 1), (760, 1), (770, 1), (780, 1), (790, 1), (800, 1), (810, 0), (820, 0), (830, 0), (840, 0), (850, 0), (860, 0), (870, 1), (880, 1), (890, 1), (900, 1), (910, 1), (920, 1), (930, 0), (940, 0), (950, 0), (960, 1), (970, 1), (980, 1), (990, 1), (1000, 1), (1010, 1), (1020, 1), (1030, 1), (1040, 1), (1050, 1), (1060, 0), (1070, 0), (1080, 0), (1090, 1), (1100, 1), (1110, 1), (1120, 1), (1130, 1), (1140, 0), (1150, 0), (1160, 1), (1170, 1), (1180, 1), (1190, 1), (1200, 1), (1210, 1), (1220, 1), (1230, 1), (1240, 1), (1250, 0), (1260, 0), (1270, 0), (1280, 1), (1290, 1), (1300, 1), (1310, 1), (1320, 1), (1330, 0), (1340, 0), (1350, 0), (1360, 0), (1370, 1), (1380, 1), (1390, 1), (1400, 0), (1410, 0), (1420, 0), (1430, 0), (1440, 0), (1450, 0), (1460, 0), (1470, 0), (1480, 0), (1490, 1), (1500, 1), (1510, 1), (1520, 1), (1530, 1), (1540, 1), (1550, 1), (1560, 1), (1570, 1), (1580, 1), (1590, 1), (1600, 1), (1610, 1), (1620, 1), (1630, 1), (1640, 1), (1650, 0), (1660, 0), (1670, 0), (1680, 0), (1690, 0), (1700, 0), (1710, 0), (1720, 0), (1730, 0), (1740, 0), (1750, 0), (1760, 0), (1770, 0), (1780, 0), (1790, 1), (1800, 1), (1810, 1), (1820, 0), (1830, 0), (1840, 0), (1850, 0), (1860, 0), (1870, 0), (1880, 0), (1890, 0), (1900, 0), (1910, 1), (1920, 1), (1930, 1), (1940, 1), (1950, 1), (1960, 1), (1970, 1), (1980, 1), (1990, 1), (2000, 1), (2010, 1), (2020, 1), (2030, 1), (2040, 1), (2050, 1)]
Vdin0_16  din0_16  0 PWL (0n 0.0v 9.495n 0.0v 9.505n 1.8v 19.495n 1.8v 19.505n 1.8v 29.495n 1.8v 29.505n 1.8v 39.495n 1.8v 39.505n 1.8v 49.495n 1.8v 49.505n 1.8v 59.495n 1.8v 59.505n 1.8v 69.495n 1.8v 69.505n 1.8v 79.495n 1.8v 79.505n 1.8v 89.495n 1.8v 89.505n 1.8v 99.495n 1.8v 99.505n 0.0v 109.495n 0.0v 109.505n 0.0v 119.495n 0.0v 119.505n 0.0v 129.495n 0.0v 129.505n 0.0v 139.495n 0.0v 139.505n 0.0v 149.495n 0.0v 149.505n 0.0v 159.495n 0.0v 159.505n 0.0v 169.495n 0.0v 169.505n 0.0v 179.495n 0.0v 179.505n 1.8v 189.495n 1.8v 189.505n 1.8v 199.495n 1.8v 199.505n 0.0v 209.495n 0.0v 209.505n 0.0v 219.495n 0.0v 219.505n 0.0v 229.495n 0.0v 229.505n 0.0v 239.495n 0.0v 239.505n 0.0v 249.495n 0.0v 249.505n 0.0v 259.495n 0.0v 259.505n 0.0v 269.495n 0.0v 269.505n 0.0v 279.495n 0.0v 279.505n 0.0v 289.495n 0.0v 289.505n 1.8v 299.495n 1.8v 299.505n 1.8v 309.495n 1.8v 309.505n 1.8v 319.495n 1.8v 319.505n 1.8v 329.495n 1.8v 329.505n 0.0v 339.495n 0.0v 339.505n 0.0v 349.495n 0.0v 349.505n 0.0v 359.495n 0.0v 359.505n 0.0v 369.495n 0.0v 369.505n 0.0v 379.495n 0.0v 379.505n 0.0v 389.495n 0.0v 389.505n 0.0v 399.495n 0.0v 399.505n 0.0v 409.495n 0.0v 409.505n 0.0v 419.495n 0.0v 419.505n 0.0v 429.495n 0.0v 429.505n 0.0v 439.495n 0.0v 439.505n 0.0v 449.495n 0.0v 449.505n 0.0v 459.495n 0.0v 459.505n 1.8v 469.495n 1.8v 469.505n 1.8v 479.495n 1.8v 479.505n 1.8v 489.495n 1.8v 489.505n 1.8v 499.495n 1.8v 499.505n 1.8v 509.495n 1.8v 509.505n 1.8v 519.495n 1.8v 519.505n 1.8v 529.495n 1.8v 529.505n 1.8v 539.495n 1.8v 539.505n 1.8v 549.495n 1.8v 549.505n 1.8v 559.495n 1.8v 559.505n 0.0v 569.495n 0.0v 569.505n 0.0v 579.495n 0.0v 579.505n 0.0v 589.495n 0.0v 589.505n 0.0v 599.495n 0.0v 599.505n 0.0v 609.495n 0.0v 609.505n 0.0v 619.495n 0.0v 619.505n 0.0v 629.495n 0.0v 629.505n 0.0v 639.495n 0.0v 639.505n 1.8v 649.495n 1.8v 649.505n 1.8v 659.495n 1.8v 659.505n 0.0v 669.495n 0.0v 669.505n 0.0v 679.495n 0.0v 679.505n 0.0v 689.495n 0.0v 689.505n 0.0v 699.495n 0.0v 699.505n 0.0v 709.495n 0.0v 709.505n 0.0v 719.495n 0.0v 719.505n 0.0v 729.495n 0.0v 729.505n 0.0v 739.495n 0.0v 739.505n 1.8v 749.495n 1.8v 749.505n 1.8v 759.495n 1.8v 759.505n 1.8v 769.495n 1.8v 769.505n 1.8v 779.495n 1.8v 779.505n 1.8v 789.495n 1.8v 789.505n 1.8v 799.495n 1.8v 799.505n 1.8v 809.495n 1.8v 809.505n 0.0v 819.495n 0.0v 819.505n 0.0v 829.495n 0.0v 829.505n 0.0v 839.495n 0.0v 839.505n 0.0v 849.495n 0.0v 849.505n 0.0v 859.495n 0.0v 859.505n 0.0v 869.495n 0.0v 869.505n 1.8v 879.495n 1.8v 879.505n 1.8v 889.495n 1.8v 889.505n 1.8v 899.495n 1.8v 899.505n 1.8v 909.495n 1.8v 909.505n 1.8v 919.495n 1.8v 919.505n 1.8v 929.495n 1.8v 929.505n 0.0v 939.495n 0.0v 939.505n 0.0v 949.495n 0.0v 949.505n 0.0v 959.495n 0.0v 959.505n 1.8v 969.495n 1.8v 969.505n 1.8v 979.495n 1.8v 979.505n 1.8v 989.495n 1.8v 989.505n 1.8v 999.495n 1.8v 999.505n 1.8v 1009.495n 1.8v 1009.505n 1.8v 1019.495n 1.8v 1019.505n 1.8v 1029.495n 1.8v 1029.505n 1.8v 1039.495n 1.8v 1039.505n 1.8v 1049.495n 1.8v 1049.505n 1.8v 1059.495n 1.8v 1059.505n 0.0v 1069.495n 0.0v 1069.505n 0.0v 1079.495n 0.0v 1079.505n 0.0v 1089.495n 0.0v 1089.505n 1.8v 1099.495n 1.8v 1099.505n 1.8v 1109.495n 1.8v 1109.505n 1.8v 1119.495n 1.8v 1119.505n 1.8v 1129.495n 1.8v 1129.505n 1.8v 1139.495n 1.8v 1139.505n 0.0v 1149.495n 0.0v 1149.505n 0.0v 1159.495n 0.0v 1159.505n 1.8v 1169.495n 1.8v 1169.505n 1.8v 1179.495n 1.8v 1179.505n 1.8v 1189.495n 1.8v 1189.505n 1.8v 1199.495n 1.8v 1199.505n 1.8v 1209.495n 1.8v 1209.505n 1.8v 1219.495n 1.8v 1219.505n 1.8v 1229.495n 1.8v 1229.505n 1.8v 1239.495n 1.8v 1239.505n 1.8v 1249.495n 1.8v 1249.505n 0.0v 1259.495n 0.0v 1259.505n 0.0v 1269.495n 0.0v 1269.505n 0.0v 1279.495n 0.0v 1279.505n 1.8v 1289.495n 1.8v 1289.505n 1.8v 1299.495n 1.8v 1299.505n 1.8v 1309.495n 1.8v 1309.505n 1.8v 1319.495n 1.8v 1319.505n 1.8v 1329.495n 1.8v 1329.505n 0.0v 1339.495n 0.0v 1339.505n 0.0v 1349.495n 0.0v 1349.505n 0.0v 1359.495n 0.0v 1359.505n 0.0v 1369.495n 0.0v 1369.505n 1.8v 1379.495n 1.8v 1379.505n 1.8v 1389.495n 1.8v 1389.505n 1.8v 1399.495n 1.8v 1399.505n 0.0v 1409.495n 0.0v 1409.505n 0.0v 1419.495n 0.0v 1419.505n 0.0v 1429.495n 0.0v 1429.505n 0.0v 1439.495n 0.0v 1439.505n 0.0v 1449.495n 0.0v 1449.505n 0.0v 1459.495n 0.0v 1459.505n 0.0v 1469.495n 0.0v 1469.505n 0.0v 1479.495n 0.0v 1479.505n 0.0v 1489.495n 0.0v 1489.505n 1.8v 1499.495n 1.8v 1499.505n 1.8v 1509.495n 1.8v 1509.505n 1.8v 1519.495n 1.8v 1519.505n 1.8v 1529.495n 1.8v 1529.505n 1.8v 1539.495n 1.8v 1539.505n 1.8v 1549.495n 1.8v 1549.505n 1.8v 1559.495n 1.8v 1559.505n 1.8v 1569.495n 1.8v 1569.505n 1.8v 1579.495n 1.8v 1579.505n 1.8v 1589.495n 1.8v 1589.505n 1.8v 1599.495n 1.8v 1599.505n 1.8v 1609.495n 1.8v 1609.505n 1.8v 1619.495n 1.8v 1619.505n 1.8v 1629.495n 1.8v 1629.505n 1.8v 1639.495n 1.8v 1639.505n 1.8v 1649.495n 1.8v 1649.505n 0.0v 1659.495n 0.0v 1659.505n 0.0v 1669.495n 0.0v 1669.505n 0.0v 1679.495n 0.0v 1679.505n 0.0v 1689.495n 0.0v 1689.505n 0.0v 1699.495n 0.0v 1699.505n 0.0v 1709.495n 0.0v 1709.505n 0.0v 1719.495n 0.0v 1719.505n 0.0v 1729.495n 0.0v 1729.505n 0.0v 1739.495n 0.0v 1739.505n 0.0v 1749.495n 0.0v 1749.505n 0.0v 1759.495n 0.0v 1759.505n 0.0v 1769.495n 0.0v 1769.505n 0.0v 1779.495n 0.0v 1779.505n 0.0v 1789.495n 0.0v 1789.505n 1.8v 1799.495n 1.8v 1799.505n 1.8v 1809.495n 1.8v 1809.505n 1.8v 1819.495n 1.8v 1819.505n 0.0v 1829.495n 0.0v 1829.505n 0.0v 1839.495n 0.0v 1839.505n 0.0v 1849.495n 0.0v 1849.505n 0.0v 1859.495n 0.0v 1859.505n 0.0v 1869.495n 0.0v 1869.505n 0.0v 1879.495n 0.0v 1879.505n 0.0v 1889.495n 0.0v 1889.505n 0.0v 1899.495n 0.0v 1899.505n 0.0v 1909.495n 0.0v 1909.505n 1.8v 1919.495n 1.8v 1919.505n 1.8v 1929.495n 1.8v 1929.505n 1.8v 1939.495n 1.8v 1939.505n 1.8v 1949.495n 1.8v 1949.505n 1.8v 1959.495n 1.8v 1959.505n 1.8v 1969.495n 1.8v 1969.505n 1.8v 1979.495n 1.8v 1979.505n 1.8v 1989.495n 1.8v 1989.505n 1.8v 1999.495n 1.8v 1999.505n 1.8v 2009.495n 1.8v 2009.505n 1.8v 2019.495n 1.8v 2019.505n 1.8v 2029.495n 1.8v 2029.505n 1.8v 2039.495n 1.8v 2039.505n 1.8v 2049.495n 1.8v 2049.505n 1.8v )
* (time, data): [(0, 0), (10, 1), (20, 0), (30, 1), (40, 1), (50, 1), (60, 1), (70, 1), (80, 1), (90, 1), (100, 0), (110, 0), (120, 0), (130, 0), (140, 0), (150, 0), (160, 0), (170, 0), (180, 0), (190, 0), (200, 1), (210, 1), (220, 1), (230, 0), (240, 1), (250, 1), (260, 1), (270, 1), (280, 1), (290, 1), (300, 0), (310, 0), (320, 0), (330, 0), (340, 0), (350, 0), (360, 0), (370, 1), (380, 1), (390, 1), (400, 1), (410, 1), (420, 1), (430, 1), (440, 1), (450, 1), (460, 0), (470, 1), (480, 1), (490, 1), (500, 1), (510, 1), (520, 1), (530, 1), (540, 1), (550, 1), (560, 1), (570, 1), (580, 1), (590, 1), (600, 1), (610, 1), (620, 1), (630, 1), (640, 0), (650, 0), (660, 0), (670, 0), (680, 1), (690, 1), (700, 1), (710, 1), (720, 1), (730, 1), (740, 0), (750, 0), (760, 0), (770, 0), (780, 0), (790, 0), (800, 0), (810, 0), (820, 0), (830, 0), (840, 0), (850, 0), (860, 1), (870, 0), (880, 0), (890, 0), (900, 0), (910, 0), (920, 0), (930, 0), (940, 0), (950, 0), (960, 1), (970, 1), (980, 1), (990, 1), (1000, 1), (1010, 1), (1020, 1), (1030, 1), (1040, 1), (1050, 0), (1060, 1), (1070, 1), (1080, 1), (1090, 1), (1100, 1), (1110, 1), (1120, 1), (1130, 1), (1140, 0), (1150, 0), (1160, 0), (1170, 0), (1180, 0), (1190, 0), (1200, 0), (1210, 0), (1220, 0), (1230, 0), (1240, 0), (1250, 1), (1260, 0), (1270, 0), (1280, 0), (1290, 0), (1300, 0), (1310, 0), (1320, 0), (1330, 0), (1340, 0), (1350, 0), (1360, 0), (1370, 0), (1380, 0), (1390, 0), (1400, 1), (1410, 1), (1420, 0), (1430, 1), (1440, 1), (1450, 1), (1460, 1), (1470, 1), (1480, 1), (1490, 1), (1500, 1), (1510, 1), (1520, 1), (1530, 1), (1540, 1), (1550, 1), (1560, 1), (1570, 1), (1580, 1), (1590, 1), (1600, 1), (1610, 1), (1620, 1), (1630, 1), (1640, 1), (1650, 0), (1660, 0), (1670, 0), (1680, 0), (1690, 0), (1700, 0), (1710, 0), (1720, 0), (1730, 0), (1740, 0), (1750, 0), (1760, 1), (1770, 1), (1780, 1), (1790, 1), (1800, 1), (1810, 1), (1820, 1), (1830, 1), (1840, 1), (1850, 1), (1860, 1), (1870, 1), (1880, 1), (1890, 1), (1900, 1), (1910, 0), (1920, 0), (1930, 0), (1940, 0), (1950, 0), (1960, 0), (1970, 0), (1980, 0), (1990, 0), (2000, 0), (2010, 0), (2020, 0), (2030, 0), (2040, 0), (2050, 0)]
Vdin0_17  din0_17  0 PWL (0n 0.0v 9.495n 0.0v 9.505n 1.8v 19.495n 1.8v 19.505n 0.0v 29.495n 0.0v 29.505n 1.8v 39.495n 1.8v 39.505n 1.8v 49.495n 1.8v 49.505n 1.8v 59.495n 1.8v 59.505n 1.8v 69.495n 1.8v 69.505n 1.8v 79.495n 1.8v 79.505n 1.8v 89.495n 1.8v 89.505n 1.8v 99.495n 1.8v 99.505n 0.0v 109.495n 0.0v 109.505n 0.0v 119.495n 0.0v 119.505n 0.0v 129.495n 0.0v 129.505n 0.0v 139.495n 0.0v 139.505n 0.0v 149.495n 0.0v 149.505n 0.0v 159.495n 0.0v 159.505n 0.0v 169.495n 0.0v 169.505n 0.0v 179.495n 0.0v 179.505n 0.0v 189.495n 0.0v 189.505n 0.0v 199.495n 0.0v 199.505n 1.8v 209.495n 1.8v 209.505n 1.8v 219.495n 1.8v 219.505n 1.8v 229.495n 1.8v 229.505n 0.0v 239.495n 0.0v 239.505n 1.8v 249.495n 1.8v 249.505n 1.8v 259.495n 1.8v 259.505n 1.8v 269.495n 1.8v 269.505n 1.8v 279.495n 1.8v 279.505n 1.8v 289.495n 1.8v 289.505n 1.8v 299.495n 1.8v 299.505n 0.0v 309.495n 0.0v 309.505n 0.0v 319.495n 0.0v 319.505n 0.0v 329.495n 0.0v 329.505n 0.0v 339.495n 0.0v 339.505n 0.0v 349.495n 0.0v 349.505n 0.0v 359.495n 0.0v 359.505n 0.0v 369.495n 0.0v 369.505n 1.8v 379.495n 1.8v 379.505n 1.8v 389.495n 1.8v 389.505n 1.8v 399.495n 1.8v 399.505n 1.8v 409.495n 1.8v 409.505n 1.8v 419.495n 1.8v 419.505n 1.8v 429.495n 1.8v 429.505n 1.8v 439.495n 1.8v 439.505n 1.8v 449.495n 1.8v 449.505n 1.8v 459.495n 1.8v 459.505n 0.0v 469.495n 0.0v 469.505n 1.8v 479.495n 1.8v 479.505n 1.8v 489.495n 1.8v 489.505n 1.8v 499.495n 1.8v 499.505n 1.8v 509.495n 1.8v 509.505n 1.8v 519.495n 1.8v 519.505n 1.8v 529.495n 1.8v 529.505n 1.8v 539.495n 1.8v 539.505n 1.8v 549.495n 1.8v 549.505n 1.8v 559.495n 1.8v 559.505n 1.8v 569.495n 1.8v 569.505n 1.8v 579.495n 1.8v 579.505n 1.8v 589.495n 1.8v 589.505n 1.8v 599.495n 1.8v 599.505n 1.8v 609.495n 1.8v 609.505n 1.8v 619.495n 1.8v 619.505n 1.8v 629.495n 1.8v 629.505n 1.8v 639.495n 1.8v 639.505n 0.0v 649.495n 0.0v 649.505n 0.0v 659.495n 0.0v 659.505n 0.0v 669.495n 0.0v 669.505n 0.0v 679.495n 0.0v 679.505n 1.8v 689.495n 1.8v 689.505n 1.8v 699.495n 1.8v 699.505n 1.8v 709.495n 1.8v 709.505n 1.8v 719.495n 1.8v 719.505n 1.8v 729.495n 1.8v 729.505n 1.8v 739.495n 1.8v 739.505n 0.0v 749.495n 0.0v 749.505n 0.0v 759.495n 0.0v 759.505n 0.0v 769.495n 0.0v 769.505n 0.0v 779.495n 0.0v 779.505n 0.0v 789.495n 0.0v 789.505n 0.0v 799.495n 0.0v 799.505n 0.0v 809.495n 0.0v 809.505n 0.0v 819.495n 0.0v 819.505n 0.0v 829.495n 0.0v 829.505n 0.0v 839.495n 0.0v 839.505n 0.0v 849.495n 0.0v 849.505n 0.0v 859.495n 0.0v 859.505n 1.8v 869.495n 1.8v 869.505n 0.0v 879.495n 0.0v 879.505n 0.0v 889.495n 0.0v 889.505n 0.0v 899.495n 0.0v 899.505n 0.0v 909.495n 0.0v 909.505n 0.0v 919.495n 0.0v 919.505n 0.0v 929.495n 0.0v 929.505n 0.0v 939.495n 0.0v 939.505n 0.0v 949.495n 0.0v 949.505n 0.0v 959.495n 0.0v 959.505n 1.8v 969.495n 1.8v 969.505n 1.8v 979.495n 1.8v 979.505n 1.8v 989.495n 1.8v 989.505n 1.8v 999.495n 1.8v 999.505n 1.8v 1009.495n 1.8v 1009.505n 1.8v 1019.495n 1.8v 1019.505n 1.8v 1029.495n 1.8v 1029.505n 1.8v 1039.495n 1.8v 1039.505n 1.8v 1049.495n 1.8v 1049.505n 0.0v 1059.495n 0.0v 1059.505n 1.8v 1069.495n 1.8v 1069.505n 1.8v 1079.495n 1.8v 1079.505n 1.8v 1089.495n 1.8v 1089.505n 1.8v 1099.495n 1.8v 1099.505n 1.8v 1109.495n 1.8v 1109.505n 1.8v 1119.495n 1.8v 1119.505n 1.8v 1129.495n 1.8v 1129.505n 1.8v 1139.495n 1.8v 1139.505n 0.0v 1149.495n 0.0v 1149.505n 0.0v 1159.495n 0.0v 1159.505n 0.0v 1169.495n 0.0v 1169.505n 0.0v 1179.495n 0.0v 1179.505n 0.0v 1189.495n 0.0v 1189.505n 0.0v 1199.495n 0.0v 1199.505n 0.0v 1209.495n 0.0v 1209.505n 0.0v 1219.495n 0.0v 1219.505n 0.0v 1229.495n 0.0v 1229.505n 0.0v 1239.495n 0.0v 1239.505n 0.0v 1249.495n 0.0v 1249.505n 1.8v 1259.495n 1.8v 1259.505n 0.0v 1269.495n 0.0v 1269.505n 0.0v 1279.495n 0.0v 1279.505n 0.0v 1289.495n 0.0v 1289.505n 0.0v 1299.495n 0.0v 1299.505n 0.0v 1309.495n 0.0v 1309.505n 0.0v 1319.495n 0.0v 1319.505n 0.0v 1329.495n 0.0v 1329.505n 0.0v 1339.495n 0.0v 1339.505n 0.0v 1349.495n 0.0v 1349.505n 0.0v 1359.495n 0.0v 1359.505n 0.0v 1369.495n 0.0v 1369.505n 0.0v 1379.495n 0.0v 1379.505n 0.0v 1389.495n 0.0v 1389.505n 0.0v 1399.495n 0.0v 1399.505n 1.8v 1409.495n 1.8v 1409.505n 1.8v 1419.495n 1.8v 1419.505n 0.0v 1429.495n 0.0v 1429.505n 1.8v 1439.495n 1.8v 1439.505n 1.8v 1449.495n 1.8v 1449.505n 1.8v 1459.495n 1.8v 1459.505n 1.8v 1469.495n 1.8v 1469.505n 1.8v 1479.495n 1.8v 1479.505n 1.8v 1489.495n 1.8v 1489.505n 1.8v 1499.495n 1.8v 1499.505n 1.8v 1509.495n 1.8v 1509.505n 1.8v 1519.495n 1.8v 1519.505n 1.8v 1529.495n 1.8v 1529.505n 1.8v 1539.495n 1.8v 1539.505n 1.8v 1549.495n 1.8v 1549.505n 1.8v 1559.495n 1.8v 1559.505n 1.8v 1569.495n 1.8v 1569.505n 1.8v 1579.495n 1.8v 1579.505n 1.8v 1589.495n 1.8v 1589.505n 1.8v 1599.495n 1.8v 1599.505n 1.8v 1609.495n 1.8v 1609.505n 1.8v 1619.495n 1.8v 1619.505n 1.8v 1629.495n 1.8v 1629.505n 1.8v 1639.495n 1.8v 1639.505n 1.8v 1649.495n 1.8v 1649.505n 0.0v 1659.495n 0.0v 1659.505n 0.0v 1669.495n 0.0v 1669.505n 0.0v 1679.495n 0.0v 1679.505n 0.0v 1689.495n 0.0v 1689.505n 0.0v 1699.495n 0.0v 1699.505n 0.0v 1709.495n 0.0v 1709.505n 0.0v 1719.495n 0.0v 1719.505n 0.0v 1729.495n 0.0v 1729.505n 0.0v 1739.495n 0.0v 1739.505n 0.0v 1749.495n 0.0v 1749.505n 0.0v 1759.495n 0.0v 1759.505n 1.8v 1769.495n 1.8v 1769.505n 1.8v 1779.495n 1.8v 1779.505n 1.8v 1789.495n 1.8v 1789.505n 1.8v 1799.495n 1.8v 1799.505n 1.8v 1809.495n 1.8v 1809.505n 1.8v 1819.495n 1.8v 1819.505n 1.8v 1829.495n 1.8v 1829.505n 1.8v 1839.495n 1.8v 1839.505n 1.8v 1849.495n 1.8v 1849.505n 1.8v 1859.495n 1.8v 1859.505n 1.8v 1869.495n 1.8v 1869.505n 1.8v 1879.495n 1.8v 1879.505n 1.8v 1889.495n 1.8v 1889.505n 1.8v 1899.495n 1.8v 1899.505n 1.8v 1909.495n 1.8v 1909.505n 0.0v 1919.495n 0.0v 1919.505n 0.0v 1929.495n 0.0v 1929.505n 0.0v 1939.495n 0.0v 1939.505n 0.0v 1949.495n 0.0v 1949.505n 0.0v 1959.495n 0.0v 1959.505n 0.0v 1969.495n 0.0v 1969.505n 0.0v 1979.495n 0.0v 1979.505n 0.0v 1989.495n 0.0v 1989.505n 0.0v 1999.495n 0.0v 1999.505n 0.0v 2009.495n 0.0v 2009.505n 0.0v 2019.495n 0.0v 2019.505n 0.0v 2029.495n 0.0v 2029.505n 0.0v 2039.495n 0.0v 2039.505n 0.0v 2049.495n 0.0v 2049.505n 0.0v )
* (time, data): [(0, 0), (10, 1), (20, 0), (30, 1), (40, 1), (50, 1), (60, 1), (70, 1), (80, 1), (90, 0), (100, 0), (110, 0), (120, 1), (130, 1), (140, 1), (150, 1), (160, 1), (170, 1), (180, 1), (190, 1), (200, 0), (210, 0), (220, 0), (230, 0), (240, 0), (250, 0), (260, 0), (270, 0), (280, 0), (290, 0), (300, 1), (310, 1), (320, 1), (330, 1), (340, 1), (350, 1), (360, 1), (370, 1), (380, 1), (390, 1), (400, 1), (410, 1), (420, 1), (430, 1), (440, 1), (450, 1), (460, 0), (470, 0), (480, 0), (490, 0), (500, 0), (510, 0), (520, 0), (530, 0), (540, 0), (550, 0), (560, 0), (570, 0), (580, 0), (590, 0), (600, 0), (610, 0), (620, 0), (630, 0), (640, 0), (650, 0), (660, 0), (670, 0), (680, 0), (690, 0), (700, 0), (710, 0), (720, 0), (730, 0), (740, 1), (750, 1), (760, 0), (770, 0), (780, 0), (790, 0), (800, 0), (810, 1), (820, 1), (830, 1), (840, 1), (850, 1), (860, 1), (870, 0), (880, 0), (890, 0), (900, 0), (910, 0), (920, 0), (930, 0), (940, 1), (950, 1), (960, 1), (970, 1), (980, 1), (990, 1), (1000, 1), (1010, 1), (1020, 1), (1030, 1), (1040, 1), (1050, 1), (1060, 0), (1070, 0), (1080, 0), (1090, 0), (1100, 0), (1110, 0), (1120, 0), (1130, 0), (1140, 0), (1150, 0), (1160, 1), (1170, 1), (1180, 1), (1190, 1), (1200, 1), (1210, 1), (1220, 1), (1230, 1), (1240, 1), (1250, 0), (1260, 1), (1270, 1), (1280, 0), (1290, 0), (1300, 0), (1310, 0), (1320, 0), (1330, 1), (1340, 1), (1350, 1), (1360, 1), (1370, 1), (1380, 1), (1390, 1), (1400, 0), (1410, 0), (1420, 0), (1430, 1), (1440, 1), (1450, 1), (1460, 1), (1470, 1), (1480, 1), (1490, 1), (1500, 1), (1510, 1), (1520, 1), (1530, 1), (1540, 1), (1550, 0), (1560, 0), (1570, 0), (1580, 0), (1590, 0), (1600, 0), (1610, 0), (1620, 0), (1630, 0), (1640, 0), (1650, 0), (1660, 0), (1670, 0), (1680, 0), (1690, 0), (1700, 0), (1710, 0), (1720, 0), (1730, 0), (1740, 0), (1750, 0), (1760, 1), (1770, 1), (1780, 1), (1790, 1), (1800, 1), (1810, 1), (1820, 0), (1830, 0), (1840, 0), (1850, 1), (1860, 1), (1870, 1), (1880, 1), (1890, 1), (1900, 1), (1910, 0), (1920, 0), (1930, 0), (1940, 0), (1950, 0), (1960, 0), (1970, 0), (1980, 0), (1990, 0), (2000, 0), (2010, 0), (2020, 0), (2030, 0), (2040, 0), (2050, 0)]
Vdin0_18  din0_18  0 PWL (0n 0.0v 9.495n 0.0v 9.505n 1.8v 19.495n 1.8v 19.505n 0.0v 29.495n 0.0v 29.505n 1.8v 39.495n 1.8v 39.505n 1.8v 49.495n 1.8v 49.505n 1.8v 59.495n 1.8v 59.505n 1.8v 69.495n 1.8v 69.505n 1.8v 79.495n 1.8v 79.505n 1.8v 89.495n 1.8v 89.505n 0.0v 99.495n 0.0v 99.505n 0.0v 109.495n 0.0v 109.505n 0.0v 119.495n 0.0v 119.505n 1.8v 129.495n 1.8v 129.505n 1.8v 139.495n 1.8v 139.505n 1.8v 149.495n 1.8v 149.505n 1.8v 159.495n 1.8v 159.505n 1.8v 169.495n 1.8v 169.505n 1.8v 179.495n 1.8v 179.505n 1.8v 189.495n 1.8v 189.505n 1.8v 199.495n 1.8v 199.505n 0.0v 209.495n 0.0v 209.505n 0.0v 219.495n 0.0v 219.505n 0.0v 229.495n 0.0v 229.505n 0.0v 239.495n 0.0v 239.505n 0.0v 249.495n 0.0v 249.505n 0.0v 259.495n 0.0v 259.505n 0.0v 269.495n 0.0v 269.505n 0.0v 279.495n 0.0v 279.505n 0.0v 289.495n 0.0v 289.505n 0.0v 299.495n 0.0v 299.505n 1.8v 309.495n 1.8v 309.505n 1.8v 319.495n 1.8v 319.505n 1.8v 329.495n 1.8v 329.505n 1.8v 339.495n 1.8v 339.505n 1.8v 349.495n 1.8v 349.505n 1.8v 359.495n 1.8v 359.505n 1.8v 369.495n 1.8v 369.505n 1.8v 379.495n 1.8v 379.505n 1.8v 389.495n 1.8v 389.505n 1.8v 399.495n 1.8v 399.505n 1.8v 409.495n 1.8v 409.505n 1.8v 419.495n 1.8v 419.505n 1.8v 429.495n 1.8v 429.505n 1.8v 439.495n 1.8v 439.505n 1.8v 449.495n 1.8v 449.505n 1.8v 459.495n 1.8v 459.505n 0.0v 469.495n 0.0v 469.505n 0.0v 479.495n 0.0v 479.505n 0.0v 489.495n 0.0v 489.505n 0.0v 499.495n 0.0v 499.505n 0.0v 509.495n 0.0v 509.505n 0.0v 519.495n 0.0v 519.505n 0.0v 529.495n 0.0v 529.505n 0.0v 539.495n 0.0v 539.505n 0.0v 549.495n 0.0v 549.505n 0.0v 559.495n 0.0v 559.505n 0.0v 569.495n 0.0v 569.505n 0.0v 579.495n 0.0v 579.505n 0.0v 589.495n 0.0v 589.505n 0.0v 599.495n 0.0v 599.505n 0.0v 609.495n 0.0v 609.505n 0.0v 619.495n 0.0v 619.505n 0.0v 629.495n 0.0v 629.505n 0.0v 639.495n 0.0v 639.505n 0.0v 649.495n 0.0v 649.505n 0.0v 659.495n 0.0v 659.505n 0.0v 669.495n 0.0v 669.505n 0.0v 679.495n 0.0v 679.505n 0.0v 689.495n 0.0v 689.505n 0.0v 699.495n 0.0v 699.505n 0.0v 709.495n 0.0v 709.505n 0.0v 719.495n 0.0v 719.505n 0.0v 729.495n 0.0v 729.505n 0.0v 739.495n 0.0v 739.505n 1.8v 749.495n 1.8v 749.505n 1.8v 759.495n 1.8v 759.505n 0.0v 769.495n 0.0v 769.505n 0.0v 779.495n 0.0v 779.505n 0.0v 789.495n 0.0v 789.505n 0.0v 799.495n 0.0v 799.505n 0.0v 809.495n 0.0v 809.505n 1.8v 819.495n 1.8v 819.505n 1.8v 829.495n 1.8v 829.505n 1.8v 839.495n 1.8v 839.505n 1.8v 849.495n 1.8v 849.505n 1.8v 859.495n 1.8v 859.505n 1.8v 869.495n 1.8v 869.505n 0.0v 879.495n 0.0v 879.505n 0.0v 889.495n 0.0v 889.505n 0.0v 899.495n 0.0v 899.505n 0.0v 909.495n 0.0v 909.505n 0.0v 919.495n 0.0v 919.505n 0.0v 929.495n 0.0v 929.505n 0.0v 939.495n 0.0v 939.505n 1.8v 949.495n 1.8v 949.505n 1.8v 959.495n 1.8v 959.505n 1.8v 969.495n 1.8v 969.505n 1.8v 979.495n 1.8v 979.505n 1.8v 989.495n 1.8v 989.505n 1.8v 999.495n 1.8v 999.505n 1.8v 1009.495n 1.8v 1009.505n 1.8v 1019.495n 1.8v 1019.505n 1.8v 1029.495n 1.8v 1029.505n 1.8v 1039.495n 1.8v 1039.505n 1.8v 1049.495n 1.8v 1049.505n 1.8v 1059.495n 1.8v 1059.505n 0.0v 1069.495n 0.0v 1069.505n 0.0v 1079.495n 0.0v 1079.505n 0.0v 1089.495n 0.0v 1089.505n 0.0v 1099.495n 0.0v 1099.505n 0.0v 1109.495n 0.0v 1109.505n 0.0v 1119.495n 0.0v 1119.505n 0.0v 1129.495n 0.0v 1129.505n 0.0v 1139.495n 0.0v 1139.505n 0.0v 1149.495n 0.0v 1149.505n 0.0v 1159.495n 0.0v 1159.505n 1.8v 1169.495n 1.8v 1169.505n 1.8v 1179.495n 1.8v 1179.505n 1.8v 1189.495n 1.8v 1189.505n 1.8v 1199.495n 1.8v 1199.505n 1.8v 1209.495n 1.8v 1209.505n 1.8v 1219.495n 1.8v 1219.505n 1.8v 1229.495n 1.8v 1229.505n 1.8v 1239.495n 1.8v 1239.505n 1.8v 1249.495n 1.8v 1249.505n 0.0v 1259.495n 0.0v 1259.505n 1.8v 1269.495n 1.8v 1269.505n 1.8v 1279.495n 1.8v 1279.505n 0.0v 1289.495n 0.0v 1289.505n 0.0v 1299.495n 0.0v 1299.505n 0.0v 1309.495n 0.0v 1309.505n 0.0v 1319.495n 0.0v 1319.505n 0.0v 1329.495n 0.0v 1329.505n 1.8v 1339.495n 1.8v 1339.505n 1.8v 1349.495n 1.8v 1349.505n 1.8v 1359.495n 1.8v 1359.505n 1.8v 1369.495n 1.8v 1369.505n 1.8v 1379.495n 1.8v 1379.505n 1.8v 1389.495n 1.8v 1389.505n 1.8v 1399.495n 1.8v 1399.505n 0.0v 1409.495n 0.0v 1409.505n 0.0v 1419.495n 0.0v 1419.505n 0.0v 1429.495n 0.0v 1429.505n 1.8v 1439.495n 1.8v 1439.505n 1.8v 1449.495n 1.8v 1449.505n 1.8v 1459.495n 1.8v 1459.505n 1.8v 1469.495n 1.8v 1469.505n 1.8v 1479.495n 1.8v 1479.505n 1.8v 1489.495n 1.8v 1489.505n 1.8v 1499.495n 1.8v 1499.505n 1.8v 1509.495n 1.8v 1509.505n 1.8v 1519.495n 1.8v 1519.505n 1.8v 1529.495n 1.8v 1529.505n 1.8v 1539.495n 1.8v 1539.505n 1.8v 1549.495n 1.8v 1549.505n 0.0v 1559.495n 0.0v 1559.505n 0.0v 1569.495n 0.0v 1569.505n 0.0v 1579.495n 0.0v 1579.505n 0.0v 1589.495n 0.0v 1589.505n 0.0v 1599.495n 0.0v 1599.505n 0.0v 1609.495n 0.0v 1609.505n 0.0v 1619.495n 0.0v 1619.505n 0.0v 1629.495n 0.0v 1629.505n 0.0v 1639.495n 0.0v 1639.505n 0.0v 1649.495n 0.0v 1649.505n 0.0v 1659.495n 0.0v 1659.505n 0.0v 1669.495n 0.0v 1669.505n 0.0v 1679.495n 0.0v 1679.505n 0.0v 1689.495n 0.0v 1689.505n 0.0v 1699.495n 0.0v 1699.505n 0.0v 1709.495n 0.0v 1709.505n 0.0v 1719.495n 0.0v 1719.505n 0.0v 1729.495n 0.0v 1729.505n 0.0v 1739.495n 0.0v 1739.505n 0.0v 1749.495n 0.0v 1749.505n 0.0v 1759.495n 0.0v 1759.505n 1.8v 1769.495n 1.8v 1769.505n 1.8v 1779.495n 1.8v 1779.505n 1.8v 1789.495n 1.8v 1789.505n 1.8v 1799.495n 1.8v 1799.505n 1.8v 1809.495n 1.8v 1809.505n 1.8v 1819.495n 1.8v 1819.505n 0.0v 1829.495n 0.0v 1829.505n 0.0v 1839.495n 0.0v 1839.505n 0.0v 1849.495n 0.0v 1849.505n 1.8v 1859.495n 1.8v 1859.505n 1.8v 1869.495n 1.8v 1869.505n 1.8v 1879.495n 1.8v 1879.505n 1.8v 1889.495n 1.8v 1889.505n 1.8v 1899.495n 1.8v 1899.505n 1.8v 1909.495n 1.8v 1909.505n 0.0v 1919.495n 0.0v 1919.505n 0.0v 1929.495n 0.0v 1929.505n 0.0v 1939.495n 0.0v 1939.505n 0.0v 1949.495n 0.0v 1949.505n 0.0v 1959.495n 0.0v 1959.505n 0.0v 1969.495n 0.0v 1969.505n 0.0v 1979.495n 0.0v 1979.505n 0.0v 1989.495n 0.0v 1989.505n 0.0v 1999.495n 0.0v 1999.505n 0.0v 2009.495n 0.0v 2009.505n 0.0v 2019.495n 0.0v 2019.505n 0.0v 2029.495n 0.0v 2029.505n 0.0v 2039.495n 0.0v 2039.505n 0.0v 2049.495n 0.0v 2049.505n 0.0v )
* (time, data): [(0, 0), (10, 1), (20, 1), (30, 0), (40, 0), (50, 0), (60, 0), (70, 0), (80, 0), (90, 1), (100, 1), (110, 1), (120, 1), (130, 1), (140, 1), (150, 1), (160, 1), (170, 1), (180, 0), (190, 0), (200, 0), (210, 0), (220, 0), (230, 0), (240, 1), (250, 1), (260, 1), (270, 1), (280, 1), (290, 0), (300, 1), (310, 1), (320, 1), (330, 0), (340, 0), (350, 0), (360, 0), (370, 1), (380, 1), (390, 1), (400, 1), (410, 1), (420, 1), (430, 1), (440, 1), (450, 1), (460, 1), (470, 1), (480, 1), (490, 1), (500, 1), (510, 1), (520, 1), (530, 1), (540, 1), (550, 1), (560, 0), (570, 0), (580, 0), (590, 0), (600, 0), (610, 0), (620, 0), (630, 0), (640, 1), (650, 1), (660, 1), (670, 1), (680, 0), (690, 0), (700, 1), (710, 1), (720, 1), (730, 1), (740, 1), (750, 1), (760, 0), (770, 0), (780, 0), (790, 0), (800, 0), (810, 1), (820, 1), (830, 1), (840, 1), (850, 1), (860, 0), (870, 1), (880, 1), (890, 1), (900, 1), (910, 1), (920, 1), (930, 1), (940, 1), (950, 1), (960, 0), (970, 0), (980, 0), (990, 0), (1000, 0), (1010, 0), (1020, 0), (1030, 0), (1040, 0), (1050, 0), (1060, 0), (1070, 0), (1080, 0), (1090, 1), (1100, 1), (1110, 1), (1120, 1), (1130, 1), (1140, 0), (1150, 0), (1160, 1), (1170, 1), (1180, 1), (1190, 1), (1200, 1), (1210, 1), (1220, 1), (1230, 1), (1240, 1), (1250, 0), (1260, 1), (1270, 1), (1280, 1), (1290, 1), (1300, 1), (1310, 1), (1320, 1), (1330, 0), (1340, 0), (1350, 0), (1360, 0), (1370, 1), (1380, 1), (1390, 1), (1400, 0), (1410, 0), (1420, 1), (1430, 0), (1440, 0), (1450, 0), (1460, 0), (1470, 0), (1480, 0), (1490, 1), (1500, 1), (1510, 1), (1520, 1), (1530, 1), (1540, 1), (1550, 0), (1560, 0), (1570, 1), (1580, 1), (1590, 1), (1600, 1), (1610, 1), (1620, 1), (1630, 1), (1640, 1), (1650, 1), (1660, 1), (1670, 1), (1680, 1), (1690, 1), (1700, 1), (1710, 1), (1720, 1), (1730, 1), (1740, 1), (1750, 1), (1760, 1), (1770, 1), (1780, 1), (1790, 1), (1800, 1), (1810, 1), (1820, 1), (1830, 1), (1840, 1), (1850, 1), (1860, 1), (1870, 1), (1880, 1), (1890, 1), (1900, 1), (1910, 0), (1920, 0), (1930, 0), (1940, 0), (1950, 0), (1960, 0), (1970, 0), (1980, 0), (1990, 0), (2000, 0), (2010, 0), (2020, 0), (2030, 0), (2040, 0), (2050, 0)]
Vdin0_19  din0_19  0 PWL (0n 0.0v 9.495n 0.0v 9.505n 1.8v 19.495n 1.8v 19.505n 1.8v 29.495n 1.8v 29.505n 0.0v 39.495n 0.0v 39.505n 0.0v 49.495n 0.0v 49.505n 0.0v 59.495n 0.0v 59.505n 0.0v 69.495n 0.0v 69.505n 0.0v 79.495n 0.0v 79.505n 0.0v 89.495n 0.0v 89.505n 1.8v 99.495n 1.8v 99.505n 1.8v 109.495n 1.8v 109.505n 1.8v 119.495n 1.8v 119.505n 1.8v 129.495n 1.8v 129.505n 1.8v 139.495n 1.8v 139.505n 1.8v 149.495n 1.8v 149.505n 1.8v 159.495n 1.8v 159.505n 1.8v 169.495n 1.8v 169.505n 1.8v 179.495n 1.8v 179.505n 0.0v 189.495n 0.0v 189.505n 0.0v 199.495n 0.0v 199.505n 0.0v 209.495n 0.0v 209.505n 0.0v 219.495n 0.0v 219.505n 0.0v 229.495n 0.0v 229.505n 0.0v 239.495n 0.0v 239.505n 1.8v 249.495n 1.8v 249.505n 1.8v 259.495n 1.8v 259.505n 1.8v 269.495n 1.8v 269.505n 1.8v 279.495n 1.8v 279.505n 1.8v 289.495n 1.8v 289.505n 0.0v 299.495n 0.0v 299.505n 1.8v 309.495n 1.8v 309.505n 1.8v 319.495n 1.8v 319.505n 1.8v 329.495n 1.8v 329.505n 0.0v 339.495n 0.0v 339.505n 0.0v 349.495n 0.0v 349.505n 0.0v 359.495n 0.0v 359.505n 0.0v 369.495n 0.0v 369.505n 1.8v 379.495n 1.8v 379.505n 1.8v 389.495n 1.8v 389.505n 1.8v 399.495n 1.8v 399.505n 1.8v 409.495n 1.8v 409.505n 1.8v 419.495n 1.8v 419.505n 1.8v 429.495n 1.8v 429.505n 1.8v 439.495n 1.8v 439.505n 1.8v 449.495n 1.8v 449.505n 1.8v 459.495n 1.8v 459.505n 1.8v 469.495n 1.8v 469.505n 1.8v 479.495n 1.8v 479.505n 1.8v 489.495n 1.8v 489.505n 1.8v 499.495n 1.8v 499.505n 1.8v 509.495n 1.8v 509.505n 1.8v 519.495n 1.8v 519.505n 1.8v 529.495n 1.8v 529.505n 1.8v 539.495n 1.8v 539.505n 1.8v 549.495n 1.8v 549.505n 1.8v 559.495n 1.8v 559.505n 0.0v 569.495n 0.0v 569.505n 0.0v 579.495n 0.0v 579.505n 0.0v 589.495n 0.0v 589.505n 0.0v 599.495n 0.0v 599.505n 0.0v 609.495n 0.0v 609.505n 0.0v 619.495n 0.0v 619.505n 0.0v 629.495n 0.0v 629.505n 0.0v 639.495n 0.0v 639.505n 1.8v 649.495n 1.8v 649.505n 1.8v 659.495n 1.8v 659.505n 1.8v 669.495n 1.8v 669.505n 1.8v 679.495n 1.8v 679.505n 0.0v 689.495n 0.0v 689.505n 0.0v 699.495n 0.0v 699.505n 1.8v 709.495n 1.8v 709.505n 1.8v 719.495n 1.8v 719.505n 1.8v 729.495n 1.8v 729.505n 1.8v 739.495n 1.8v 739.505n 1.8v 749.495n 1.8v 749.505n 1.8v 759.495n 1.8v 759.505n 0.0v 769.495n 0.0v 769.505n 0.0v 779.495n 0.0v 779.505n 0.0v 789.495n 0.0v 789.505n 0.0v 799.495n 0.0v 799.505n 0.0v 809.495n 0.0v 809.505n 1.8v 819.495n 1.8v 819.505n 1.8v 829.495n 1.8v 829.505n 1.8v 839.495n 1.8v 839.505n 1.8v 849.495n 1.8v 849.505n 1.8v 859.495n 1.8v 859.505n 0.0v 869.495n 0.0v 869.505n 1.8v 879.495n 1.8v 879.505n 1.8v 889.495n 1.8v 889.505n 1.8v 899.495n 1.8v 899.505n 1.8v 909.495n 1.8v 909.505n 1.8v 919.495n 1.8v 919.505n 1.8v 929.495n 1.8v 929.505n 1.8v 939.495n 1.8v 939.505n 1.8v 949.495n 1.8v 949.505n 1.8v 959.495n 1.8v 959.505n 0.0v 969.495n 0.0v 969.505n 0.0v 979.495n 0.0v 979.505n 0.0v 989.495n 0.0v 989.505n 0.0v 999.495n 0.0v 999.505n 0.0v 1009.495n 0.0v 1009.505n 0.0v 1019.495n 0.0v 1019.505n 0.0v 1029.495n 0.0v 1029.505n 0.0v 1039.495n 0.0v 1039.505n 0.0v 1049.495n 0.0v 1049.505n 0.0v 1059.495n 0.0v 1059.505n 0.0v 1069.495n 0.0v 1069.505n 0.0v 1079.495n 0.0v 1079.505n 0.0v 1089.495n 0.0v 1089.505n 1.8v 1099.495n 1.8v 1099.505n 1.8v 1109.495n 1.8v 1109.505n 1.8v 1119.495n 1.8v 1119.505n 1.8v 1129.495n 1.8v 1129.505n 1.8v 1139.495n 1.8v 1139.505n 0.0v 1149.495n 0.0v 1149.505n 0.0v 1159.495n 0.0v 1159.505n 1.8v 1169.495n 1.8v 1169.505n 1.8v 1179.495n 1.8v 1179.505n 1.8v 1189.495n 1.8v 1189.505n 1.8v 1199.495n 1.8v 1199.505n 1.8v 1209.495n 1.8v 1209.505n 1.8v 1219.495n 1.8v 1219.505n 1.8v 1229.495n 1.8v 1229.505n 1.8v 1239.495n 1.8v 1239.505n 1.8v 1249.495n 1.8v 1249.505n 0.0v 1259.495n 0.0v 1259.505n 1.8v 1269.495n 1.8v 1269.505n 1.8v 1279.495n 1.8v 1279.505n 1.8v 1289.495n 1.8v 1289.505n 1.8v 1299.495n 1.8v 1299.505n 1.8v 1309.495n 1.8v 1309.505n 1.8v 1319.495n 1.8v 1319.505n 1.8v 1329.495n 1.8v 1329.505n 0.0v 1339.495n 0.0v 1339.505n 0.0v 1349.495n 0.0v 1349.505n 0.0v 1359.495n 0.0v 1359.505n 0.0v 1369.495n 0.0v 1369.505n 1.8v 1379.495n 1.8v 1379.505n 1.8v 1389.495n 1.8v 1389.505n 1.8v 1399.495n 1.8v 1399.505n 0.0v 1409.495n 0.0v 1409.505n 0.0v 1419.495n 0.0v 1419.505n 1.8v 1429.495n 1.8v 1429.505n 0.0v 1439.495n 0.0v 1439.505n 0.0v 1449.495n 0.0v 1449.505n 0.0v 1459.495n 0.0v 1459.505n 0.0v 1469.495n 0.0v 1469.505n 0.0v 1479.495n 0.0v 1479.505n 0.0v 1489.495n 0.0v 1489.505n 1.8v 1499.495n 1.8v 1499.505n 1.8v 1509.495n 1.8v 1509.505n 1.8v 1519.495n 1.8v 1519.505n 1.8v 1529.495n 1.8v 1529.505n 1.8v 1539.495n 1.8v 1539.505n 1.8v 1549.495n 1.8v 1549.505n 0.0v 1559.495n 0.0v 1559.505n 0.0v 1569.495n 0.0v 1569.505n 1.8v 1579.495n 1.8v 1579.505n 1.8v 1589.495n 1.8v 1589.505n 1.8v 1599.495n 1.8v 1599.505n 1.8v 1609.495n 1.8v 1609.505n 1.8v 1619.495n 1.8v 1619.505n 1.8v 1629.495n 1.8v 1629.505n 1.8v 1639.495n 1.8v 1639.505n 1.8v 1649.495n 1.8v 1649.505n 1.8v 1659.495n 1.8v 1659.505n 1.8v 1669.495n 1.8v 1669.505n 1.8v 1679.495n 1.8v 1679.505n 1.8v 1689.495n 1.8v 1689.505n 1.8v 1699.495n 1.8v 1699.505n 1.8v 1709.495n 1.8v 1709.505n 1.8v 1719.495n 1.8v 1719.505n 1.8v 1729.495n 1.8v 1729.505n 1.8v 1739.495n 1.8v 1739.505n 1.8v 1749.495n 1.8v 1749.505n 1.8v 1759.495n 1.8v 1759.505n 1.8v 1769.495n 1.8v 1769.505n 1.8v 1779.495n 1.8v 1779.505n 1.8v 1789.495n 1.8v 1789.505n 1.8v 1799.495n 1.8v 1799.505n 1.8v 1809.495n 1.8v 1809.505n 1.8v 1819.495n 1.8v 1819.505n 1.8v 1829.495n 1.8v 1829.505n 1.8v 1839.495n 1.8v 1839.505n 1.8v 1849.495n 1.8v 1849.505n 1.8v 1859.495n 1.8v 1859.505n 1.8v 1869.495n 1.8v 1869.505n 1.8v 1879.495n 1.8v 1879.505n 1.8v 1889.495n 1.8v 1889.505n 1.8v 1899.495n 1.8v 1899.505n 1.8v 1909.495n 1.8v 1909.505n 0.0v 1919.495n 0.0v 1919.505n 0.0v 1929.495n 0.0v 1929.505n 0.0v 1939.495n 0.0v 1939.505n 0.0v 1949.495n 0.0v 1949.505n 0.0v 1959.495n 0.0v 1959.505n 0.0v 1969.495n 0.0v 1969.505n 0.0v 1979.495n 0.0v 1979.505n 0.0v 1989.495n 0.0v 1989.505n 0.0v 1999.495n 0.0v 1999.505n 0.0v 2009.495n 0.0v 2009.505n 0.0v 2019.495n 0.0v 2019.505n 0.0v 2029.495n 0.0v 2029.505n 0.0v 2039.495n 0.0v 2039.505n 0.0v 2049.495n 0.0v 2049.505n 0.0v )
* (time, data): [(0, 0), (10, 1), (20, 0), (30, 1), (40, 1), (50, 1), (60, 1), (70, 1), (80, 1), (90, 1), (100, 0), (110, 0), (120, 1), (130, 1), (140, 1), (150, 1), (160, 1), (170, 1), (180, 1), (190, 1), (200, 1), (210, 1), (220, 1), (230, 0), (240, 1), (250, 1), (260, 1), (270, 1), (280, 1), (290, 0), (300, 0), (310, 0), (320, 0), (330, 1), (340, 1), (350, 1), (360, 0), (370, 0), (380, 0), (390, 0), (400, 0), (410, 0), (420, 0), (430, 0), (440, 0), (450, 0), (460, 0), (470, 0), (480, 0), (490, 0), (500, 0), (510, 0), (520, 0), (530, 0), (540, 0), (550, 0), (560, 1), (570, 1), (580, 1), (590, 1), (600, 1), (610, 1), (620, 1), (630, 1), (640, 0), (650, 0), (660, 0), (670, 0), (680, 0), (690, 0), (700, 0), (710, 0), (720, 0), (730, 0), (740, 1), (750, 1), (760, 0), (770, 0), (780, 0), (790, 0), (800, 0), (810, 0), (820, 0), (830, 0), (840, 0), (850, 0), (860, 0), (870, 1), (880, 1), (890, 1), (900, 1), (910, 1), (920, 1), (930, 0), (940, 0), (950, 0), (960, 1), (970, 1), (980, 1), (990, 1), (1000, 1), (1010, 1), (1020, 1), (1030, 1), (1040, 1), (1050, 1), (1060, 0), (1070, 0), (1080, 0), (1090, 0), (1100, 0), (1110, 0), (1120, 0), (1130, 0), (1140, 0), (1150, 0), (1160, 0), (1170, 0), (1180, 0), (1190, 0), (1200, 0), (1210, 0), (1220, 0), (1230, 0), (1240, 0), (1250, 1), (1260, 1), (1270, 1), (1280, 1), (1290, 1), (1300, 1), (1310, 1), (1320, 1), (1330, 0), (1340, 0), (1350, 0), (1360, 0), (1370, 1), (1380, 1), (1390, 1), (1400, 1), (1410, 1), (1420, 0), (1430, 1), (1440, 1), (1450, 1), (1460, 1), (1470, 1), (1480, 1), (1490, 1), (1500, 1), (1510, 1), (1520, 1), (1530, 1), (1540, 1), (1550, 0), (1560, 0), (1570, 0), (1580, 0), (1590, 0), (1600, 0), (1610, 0), (1620, 0), (1630, 0), (1640, 0), (1650, 1), (1660, 1), (1670, 1), (1680, 1), (1690, 1), (1700, 1), (1710, 1), (1720, 1), (1730, 1), (1740, 1), (1750, 1), (1760, 0), (1770, 0), (1780, 0), (1790, 1), (1800, 1), (1810, 1), (1820, 0), (1830, 0), (1840, 0), (1850, 1), (1860, 1), (1870, 1), (1880, 1), (1890, 1), (1900, 1), (1910, 0), (1920, 0), (1930, 0), (1940, 0), (1950, 0), (1960, 0), (1970, 0), (1980, 0), (1990, 0), (2000, 0), (2010, 0), (2020, 0), (2030, 0), (2040, 0), (2050, 0)]
Vdin0_20  din0_20  0 PWL (0n 0.0v 9.495n 0.0v 9.505n 1.8v 19.495n 1.8v 19.505n 0.0v 29.495n 0.0v 29.505n 1.8v 39.495n 1.8v 39.505n 1.8v 49.495n 1.8v 49.505n 1.8v 59.495n 1.8v 59.505n 1.8v 69.495n 1.8v 69.505n 1.8v 79.495n 1.8v 79.505n 1.8v 89.495n 1.8v 89.505n 1.8v 99.495n 1.8v 99.505n 0.0v 109.495n 0.0v 109.505n 0.0v 119.495n 0.0v 119.505n 1.8v 129.495n 1.8v 129.505n 1.8v 139.495n 1.8v 139.505n 1.8v 149.495n 1.8v 149.505n 1.8v 159.495n 1.8v 159.505n 1.8v 169.495n 1.8v 169.505n 1.8v 179.495n 1.8v 179.505n 1.8v 189.495n 1.8v 189.505n 1.8v 199.495n 1.8v 199.505n 1.8v 209.495n 1.8v 209.505n 1.8v 219.495n 1.8v 219.505n 1.8v 229.495n 1.8v 229.505n 0.0v 239.495n 0.0v 239.505n 1.8v 249.495n 1.8v 249.505n 1.8v 259.495n 1.8v 259.505n 1.8v 269.495n 1.8v 269.505n 1.8v 279.495n 1.8v 279.505n 1.8v 289.495n 1.8v 289.505n 0.0v 299.495n 0.0v 299.505n 0.0v 309.495n 0.0v 309.505n 0.0v 319.495n 0.0v 319.505n 0.0v 329.495n 0.0v 329.505n 1.8v 339.495n 1.8v 339.505n 1.8v 349.495n 1.8v 349.505n 1.8v 359.495n 1.8v 359.505n 0.0v 369.495n 0.0v 369.505n 0.0v 379.495n 0.0v 379.505n 0.0v 389.495n 0.0v 389.505n 0.0v 399.495n 0.0v 399.505n 0.0v 409.495n 0.0v 409.505n 0.0v 419.495n 0.0v 419.505n 0.0v 429.495n 0.0v 429.505n 0.0v 439.495n 0.0v 439.505n 0.0v 449.495n 0.0v 449.505n 0.0v 459.495n 0.0v 459.505n 0.0v 469.495n 0.0v 469.505n 0.0v 479.495n 0.0v 479.505n 0.0v 489.495n 0.0v 489.505n 0.0v 499.495n 0.0v 499.505n 0.0v 509.495n 0.0v 509.505n 0.0v 519.495n 0.0v 519.505n 0.0v 529.495n 0.0v 529.505n 0.0v 539.495n 0.0v 539.505n 0.0v 549.495n 0.0v 549.505n 0.0v 559.495n 0.0v 559.505n 1.8v 569.495n 1.8v 569.505n 1.8v 579.495n 1.8v 579.505n 1.8v 589.495n 1.8v 589.505n 1.8v 599.495n 1.8v 599.505n 1.8v 609.495n 1.8v 609.505n 1.8v 619.495n 1.8v 619.505n 1.8v 629.495n 1.8v 629.505n 1.8v 639.495n 1.8v 639.505n 0.0v 649.495n 0.0v 649.505n 0.0v 659.495n 0.0v 659.505n 0.0v 669.495n 0.0v 669.505n 0.0v 679.495n 0.0v 679.505n 0.0v 689.495n 0.0v 689.505n 0.0v 699.495n 0.0v 699.505n 0.0v 709.495n 0.0v 709.505n 0.0v 719.495n 0.0v 719.505n 0.0v 729.495n 0.0v 729.505n 0.0v 739.495n 0.0v 739.505n 1.8v 749.495n 1.8v 749.505n 1.8v 759.495n 1.8v 759.505n 0.0v 769.495n 0.0v 769.505n 0.0v 779.495n 0.0v 779.505n 0.0v 789.495n 0.0v 789.505n 0.0v 799.495n 0.0v 799.505n 0.0v 809.495n 0.0v 809.505n 0.0v 819.495n 0.0v 819.505n 0.0v 829.495n 0.0v 829.505n 0.0v 839.495n 0.0v 839.505n 0.0v 849.495n 0.0v 849.505n 0.0v 859.495n 0.0v 859.505n 0.0v 869.495n 0.0v 869.505n 1.8v 879.495n 1.8v 879.505n 1.8v 889.495n 1.8v 889.505n 1.8v 899.495n 1.8v 899.505n 1.8v 909.495n 1.8v 909.505n 1.8v 919.495n 1.8v 919.505n 1.8v 929.495n 1.8v 929.505n 0.0v 939.495n 0.0v 939.505n 0.0v 949.495n 0.0v 949.505n 0.0v 959.495n 0.0v 959.505n 1.8v 969.495n 1.8v 969.505n 1.8v 979.495n 1.8v 979.505n 1.8v 989.495n 1.8v 989.505n 1.8v 999.495n 1.8v 999.505n 1.8v 1009.495n 1.8v 1009.505n 1.8v 1019.495n 1.8v 1019.505n 1.8v 1029.495n 1.8v 1029.505n 1.8v 1039.495n 1.8v 1039.505n 1.8v 1049.495n 1.8v 1049.505n 1.8v 1059.495n 1.8v 1059.505n 0.0v 1069.495n 0.0v 1069.505n 0.0v 1079.495n 0.0v 1079.505n 0.0v 1089.495n 0.0v 1089.505n 0.0v 1099.495n 0.0v 1099.505n 0.0v 1109.495n 0.0v 1109.505n 0.0v 1119.495n 0.0v 1119.505n 0.0v 1129.495n 0.0v 1129.505n 0.0v 1139.495n 0.0v 1139.505n 0.0v 1149.495n 0.0v 1149.505n 0.0v 1159.495n 0.0v 1159.505n 0.0v 1169.495n 0.0v 1169.505n 0.0v 1179.495n 0.0v 1179.505n 0.0v 1189.495n 0.0v 1189.505n 0.0v 1199.495n 0.0v 1199.505n 0.0v 1209.495n 0.0v 1209.505n 0.0v 1219.495n 0.0v 1219.505n 0.0v 1229.495n 0.0v 1229.505n 0.0v 1239.495n 0.0v 1239.505n 0.0v 1249.495n 0.0v 1249.505n 1.8v 1259.495n 1.8v 1259.505n 1.8v 1269.495n 1.8v 1269.505n 1.8v 1279.495n 1.8v 1279.505n 1.8v 1289.495n 1.8v 1289.505n 1.8v 1299.495n 1.8v 1299.505n 1.8v 1309.495n 1.8v 1309.505n 1.8v 1319.495n 1.8v 1319.505n 1.8v 1329.495n 1.8v 1329.505n 0.0v 1339.495n 0.0v 1339.505n 0.0v 1349.495n 0.0v 1349.505n 0.0v 1359.495n 0.0v 1359.505n 0.0v 1369.495n 0.0v 1369.505n 1.8v 1379.495n 1.8v 1379.505n 1.8v 1389.495n 1.8v 1389.505n 1.8v 1399.495n 1.8v 1399.505n 1.8v 1409.495n 1.8v 1409.505n 1.8v 1419.495n 1.8v 1419.505n 0.0v 1429.495n 0.0v 1429.505n 1.8v 1439.495n 1.8v 1439.505n 1.8v 1449.495n 1.8v 1449.505n 1.8v 1459.495n 1.8v 1459.505n 1.8v 1469.495n 1.8v 1469.505n 1.8v 1479.495n 1.8v 1479.505n 1.8v 1489.495n 1.8v 1489.505n 1.8v 1499.495n 1.8v 1499.505n 1.8v 1509.495n 1.8v 1509.505n 1.8v 1519.495n 1.8v 1519.505n 1.8v 1529.495n 1.8v 1529.505n 1.8v 1539.495n 1.8v 1539.505n 1.8v 1549.495n 1.8v 1549.505n 0.0v 1559.495n 0.0v 1559.505n 0.0v 1569.495n 0.0v 1569.505n 0.0v 1579.495n 0.0v 1579.505n 0.0v 1589.495n 0.0v 1589.505n 0.0v 1599.495n 0.0v 1599.505n 0.0v 1609.495n 0.0v 1609.505n 0.0v 1619.495n 0.0v 1619.505n 0.0v 1629.495n 0.0v 1629.505n 0.0v 1639.495n 0.0v 1639.505n 0.0v 1649.495n 0.0v 1649.505n 1.8v 1659.495n 1.8v 1659.505n 1.8v 1669.495n 1.8v 1669.505n 1.8v 1679.495n 1.8v 1679.505n 1.8v 1689.495n 1.8v 1689.505n 1.8v 1699.495n 1.8v 1699.505n 1.8v 1709.495n 1.8v 1709.505n 1.8v 1719.495n 1.8v 1719.505n 1.8v 1729.495n 1.8v 1729.505n 1.8v 1739.495n 1.8v 1739.505n 1.8v 1749.495n 1.8v 1749.505n 1.8v 1759.495n 1.8v 1759.505n 0.0v 1769.495n 0.0v 1769.505n 0.0v 1779.495n 0.0v 1779.505n 0.0v 1789.495n 0.0v 1789.505n 1.8v 1799.495n 1.8v 1799.505n 1.8v 1809.495n 1.8v 1809.505n 1.8v 1819.495n 1.8v 1819.505n 0.0v 1829.495n 0.0v 1829.505n 0.0v 1839.495n 0.0v 1839.505n 0.0v 1849.495n 0.0v 1849.505n 1.8v 1859.495n 1.8v 1859.505n 1.8v 1869.495n 1.8v 1869.505n 1.8v 1879.495n 1.8v 1879.505n 1.8v 1889.495n 1.8v 1889.505n 1.8v 1899.495n 1.8v 1899.505n 1.8v 1909.495n 1.8v 1909.505n 0.0v 1919.495n 0.0v 1919.505n 0.0v 1929.495n 0.0v 1929.505n 0.0v 1939.495n 0.0v 1939.505n 0.0v 1949.495n 0.0v 1949.505n 0.0v 1959.495n 0.0v 1959.505n 0.0v 1969.495n 0.0v 1969.505n 0.0v 1979.495n 0.0v 1979.505n 0.0v 1989.495n 0.0v 1989.505n 0.0v 1999.495n 0.0v 1999.505n 0.0v 2009.495n 0.0v 2009.505n 0.0v 2019.495n 0.0v 2019.505n 0.0v 2029.495n 0.0v 2029.505n 0.0v 2039.495n 0.0v 2039.505n 0.0v 2049.495n 0.0v 2049.505n 0.0v )
* (time, data): [(0, 0), (10, 0), (20, 1), (30, 1), (40, 1), (50, 1), (60, 1), (70, 1), (80, 1), (90, 1), (100, 0), (110, 0), (120, 1), (130, 1), (140, 1), (150, 1), (160, 1), (170, 1), (180, 0), (190, 0), (200, 1), (210, 1), (220, 1), (230, 1), (240, 1), (250, 1), (260, 1), (270, 1), (280, 1), (290, 1), (300, 1), (310, 1), (320, 1), (330, 0), (340, 0), (350, 0), (360, 0), (370, 0), (380, 0), (390, 0), (400, 0), (410, 0), (420, 0), (430, 0), (440, 0), (450, 0), (460, 0), (470, 1), (480, 1), (490, 1), (500, 1), (510, 1), (520, 1), (530, 1), (540, 1), (550, 1), (560, 1), (570, 1), (580, 1), (590, 1), (600, 1), (610, 1), (620, 1), (630, 1), (640, 1), (650, 1), (660, 1), (670, 1), (680, 0), (690, 0), (700, 0), (710, 0), (720, 0), (730, 0), (740, 1), (750, 1), (760, 1), (770, 1), (780, 1), (790, 1), (800, 1), (810, 1), (820, 1), (830, 1), (840, 1), (850, 1), (860, 1), (870, 1), (880, 1), (890, 1), (900, 1), (910, 1), (920, 1), (930, 1), (940, 0), (950, 0), (960, 1), (970, 1), (980, 1), (990, 1), (1000, 1), (1010, 1), (1020, 1), (1030, 1), (1040, 1), (1050, 0), (1060, 0), (1070, 0), (1080, 0), (1090, 0), (1100, 0), (1110, 0), (1120, 0), (1130, 0), (1140, 0), (1150, 0), (1160, 0), (1170, 0), (1180, 0), (1190, 0), (1200, 0), (1210, 0), (1220, 0), (1230, 0), (1240, 0), (1250, 0), (1260, 1), (1270, 1), (1280, 0), (1290, 0), (1300, 0), (1310, 0), (1320, 0), (1330, 0), (1340, 0), (1350, 0), (1360, 0), (1370, 1), (1380, 1), (1390, 1), (1400, 0), (1410, 0), (1420, 0), (1430, 0), (1440, 0), (1450, 0), (1460, 0), (1470, 0), (1480, 0), (1490, 0), (1500, 0), (1510, 0), (1520, 0), (1530, 0), (1540, 0), (1550, 0), (1560, 0), (1570, 0), (1580, 0), (1590, 0), (1600, 0), (1610, 0), (1620, 0), (1630, 0), (1640, 0), (1650, 0), (1660, 0), (1670, 0), (1680, 0), (1690, 0), (1700, 0), (1710, 0), (1720, 0), (1730, 0), (1740, 0), (1750, 0), (1760, 0), (1770, 0), (1780, 0), (1790, 1), (1800, 1), (1810, 1), (1820, 1), (1830, 1), (1840, 1), (1850, 1), (1860, 1), (1870, 1), (1880, 1), (1890, 1), (1900, 1), (1910, 1), (1920, 1), (1930, 1), (1940, 1), (1950, 1), (1960, 1), (1970, 1), (1980, 1), (1990, 1), (2000, 1), (2010, 1), (2020, 1), (2030, 1), (2040, 1), (2050, 1)]
Vdin0_21  din0_21  0 PWL (0n 0.0v 9.495n 0.0v 9.505n 0.0v 19.495n 0.0v 19.505n 1.8v 29.495n 1.8v 29.505n 1.8v 39.495n 1.8v 39.505n 1.8v 49.495n 1.8v 49.505n 1.8v 59.495n 1.8v 59.505n 1.8v 69.495n 1.8v 69.505n 1.8v 79.495n 1.8v 79.505n 1.8v 89.495n 1.8v 89.505n 1.8v 99.495n 1.8v 99.505n 0.0v 109.495n 0.0v 109.505n 0.0v 119.495n 0.0v 119.505n 1.8v 129.495n 1.8v 129.505n 1.8v 139.495n 1.8v 139.505n 1.8v 149.495n 1.8v 149.505n 1.8v 159.495n 1.8v 159.505n 1.8v 169.495n 1.8v 169.505n 1.8v 179.495n 1.8v 179.505n 0.0v 189.495n 0.0v 189.505n 0.0v 199.495n 0.0v 199.505n 1.8v 209.495n 1.8v 209.505n 1.8v 219.495n 1.8v 219.505n 1.8v 229.495n 1.8v 229.505n 1.8v 239.495n 1.8v 239.505n 1.8v 249.495n 1.8v 249.505n 1.8v 259.495n 1.8v 259.505n 1.8v 269.495n 1.8v 269.505n 1.8v 279.495n 1.8v 279.505n 1.8v 289.495n 1.8v 289.505n 1.8v 299.495n 1.8v 299.505n 1.8v 309.495n 1.8v 309.505n 1.8v 319.495n 1.8v 319.505n 1.8v 329.495n 1.8v 329.505n 0.0v 339.495n 0.0v 339.505n 0.0v 349.495n 0.0v 349.505n 0.0v 359.495n 0.0v 359.505n 0.0v 369.495n 0.0v 369.505n 0.0v 379.495n 0.0v 379.505n 0.0v 389.495n 0.0v 389.505n 0.0v 399.495n 0.0v 399.505n 0.0v 409.495n 0.0v 409.505n 0.0v 419.495n 0.0v 419.505n 0.0v 429.495n 0.0v 429.505n 0.0v 439.495n 0.0v 439.505n 0.0v 449.495n 0.0v 449.505n 0.0v 459.495n 0.0v 459.505n 0.0v 469.495n 0.0v 469.505n 1.8v 479.495n 1.8v 479.505n 1.8v 489.495n 1.8v 489.505n 1.8v 499.495n 1.8v 499.505n 1.8v 509.495n 1.8v 509.505n 1.8v 519.495n 1.8v 519.505n 1.8v 529.495n 1.8v 529.505n 1.8v 539.495n 1.8v 539.505n 1.8v 549.495n 1.8v 549.505n 1.8v 559.495n 1.8v 559.505n 1.8v 569.495n 1.8v 569.505n 1.8v 579.495n 1.8v 579.505n 1.8v 589.495n 1.8v 589.505n 1.8v 599.495n 1.8v 599.505n 1.8v 609.495n 1.8v 609.505n 1.8v 619.495n 1.8v 619.505n 1.8v 629.495n 1.8v 629.505n 1.8v 639.495n 1.8v 639.505n 1.8v 649.495n 1.8v 649.505n 1.8v 659.495n 1.8v 659.505n 1.8v 669.495n 1.8v 669.505n 1.8v 679.495n 1.8v 679.505n 0.0v 689.495n 0.0v 689.505n 0.0v 699.495n 0.0v 699.505n 0.0v 709.495n 0.0v 709.505n 0.0v 719.495n 0.0v 719.505n 0.0v 729.495n 0.0v 729.505n 0.0v 739.495n 0.0v 739.505n 1.8v 749.495n 1.8v 749.505n 1.8v 759.495n 1.8v 759.505n 1.8v 769.495n 1.8v 769.505n 1.8v 779.495n 1.8v 779.505n 1.8v 789.495n 1.8v 789.505n 1.8v 799.495n 1.8v 799.505n 1.8v 809.495n 1.8v 809.505n 1.8v 819.495n 1.8v 819.505n 1.8v 829.495n 1.8v 829.505n 1.8v 839.495n 1.8v 839.505n 1.8v 849.495n 1.8v 849.505n 1.8v 859.495n 1.8v 859.505n 1.8v 869.495n 1.8v 869.505n 1.8v 879.495n 1.8v 879.505n 1.8v 889.495n 1.8v 889.505n 1.8v 899.495n 1.8v 899.505n 1.8v 909.495n 1.8v 909.505n 1.8v 919.495n 1.8v 919.505n 1.8v 929.495n 1.8v 929.505n 1.8v 939.495n 1.8v 939.505n 0.0v 949.495n 0.0v 949.505n 0.0v 959.495n 0.0v 959.505n 1.8v 969.495n 1.8v 969.505n 1.8v 979.495n 1.8v 979.505n 1.8v 989.495n 1.8v 989.505n 1.8v 999.495n 1.8v 999.505n 1.8v 1009.495n 1.8v 1009.505n 1.8v 1019.495n 1.8v 1019.505n 1.8v 1029.495n 1.8v 1029.505n 1.8v 1039.495n 1.8v 1039.505n 1.8v 1049.495n 1.8v 1049.505n 0.0v 1059.495n 0.0v 1059.505n 0.0v 1069.495n 0.0v 1069.505n 0.0v 1079.495n 0.0v 1079.505n 0.0v 1089.495n 0.0v 1089.505n 0.0v 1099.495n 0.0v 1099.505n 0.0v 1109.495n 0.0v 1109.505n 0.0v 1119.495n 0.0v 1119.505n 0.0v 1129.495n 0.0v 1129.505n 0.0v 1139.495n 0.0v 1139.505n 0.0v 1149.495n 0.0v 1149.505n 0.0v 1159.495n 0.0v 1159.505n 0.0v 1169.495n 0.0v 1169.505n 0.0v 1179.495n 0.0v 1179.505n 0.0v 1189.495n 0.0v 1189.505n 0.0v 1199.495n 0.0v 1199.505n 0.0v 1209.495n 0.0v 1209.505n 0.0v 1219.495n 0.0v 1219.505n 0.0v 1229.495n 0.0v 1229.505n 0.0v 1239.495n 0.0v 1239.505n 0.0v 1249.495n 0.0v 1249.505n 0.0v 1259.495n 0.0v 1259.505n 1.8v 1269.495n 1.8v 1269.505n 1.8v 1279.495n 1.8v 1279.505n 0.0v 1289.495n 0.0v 1289.505n 0.0v 1299.495n 0.0v 1299.505n 0.0v 1309.495n 0.0v 1309.505n 0.0v 1319.495n 0.0v 1319.505n 0.0v 1329.495n 0.0v 1329.505n 0.0v 1339.495n 0.0v 1339.505n 0.0v 1349.495n 0.0v 1349.505n 0.0v 1359.495n 0.0v 1359.505n 0.0v 1369.495n 0.0v 1369.505n 1.8v 1379.495n 1.8v 1379.505n 1.8v 1389.495n 1.8v 1389.505n 1.8v 1399.495n 1.8v 1399.505n 0.0v 1409.495n 0.0v 1409.505n 0.0v 1419.495n 0.0v 1419.505n 0.0v 1429.495n 0.0v 1429.505n 0.0v 1439.495n 0.0v 1439.505n 0.0v 1449.495n 0.0v 1449.505n 0.0v 1459.495n 0.0v 1459.505n 0.0v 1469.495n 0.0v 1469.505n 0.0v 1479.495n 0.0v 1479.505n 0.0v 1489.495n 0.0v 1489.505n 0.0v 1499.495n 0.0v 1499.505n 0.0v 1509.495n 0.0v 1509.505n 0.0v 1519.495n 0.0v 1519.505n 0.0v 1529.495n 0.0v 1529.505n 0.0v 1539.495n 0.0v 1539.505n 0.0v 1549.495n 0.0v 1549.505n 0.0v 1559.495n 0.0v 1559.505n 0.0v 1569.495n 0.0v 1569.505n 0.0v 1579.495n 0.0v 1579.505n 0.0v 1589.495n 0.0v 1589.505n 0.0v 1599.495n 0.0v 1599.505n 0.0v 1609.495n 0.0v 1609.505n 0.0v 1619.495n 0.0v 1619.505n 0.0v 1629.495n 0.0v 1629.505n 0.0v 1639.495n 0.0v 1639.505n 0.0v 1649.495n 0.0v 1649.505n 0.0v 1659.495n 0.0v 1659.505n 0.0v 1669.495n 0.0v 1669.505n 0.0v 1679.495n 0.0v 1679.505n 0.0v 1689.495n 0.0v 1689.505n 0.0v 1699.495n 0.0v 1699.505n 0.0v 1709.495n 0.0v 1709.505n 0.0v 1719.495n 0.0v 1719.505n 0.0v 1729.495n 0.0v 1729.505n 0.0v 1739.495n 0.0v 1739.505n 0.0v 1749.495n 0.0v 1749.505n 0.0v 1759.495n 0.0v 1759.505n 0.0v 1769.495n 0.0v 1769.505n 0.0v 1779.495n 0.0v 1779.505n 0.0v 1789.495n 0.0v 1789.505n 1.8v 1799.495n 1.8v 1799.505n 1.8v 1809.495n 1.8v 1809.505n 1.8v 1819.495n 1.8v 1819.505n 1.8v 1829.495n 1.8v 1829.505n 1.8v 1839.495n 1.8v 1839.505n 1.8v 1849.495n 1.8v 1849.505n 1.8v 1859.495n 1.8v 1859.505n 1.8v 1869.495n 1.8v 1869.505n 1.8v 1879.495n 1.8v 1879.505n 1.8v 1889.495n 1.8v 1889.505n 1.8v 1899.495n 1.8v 1899.505n 1.8v 1909.495n 1.8v 1909.505n 1.8v 1919.495n 1.8v 1919.505n 1.8v 1929.495n 1.8v 1929.505n 1.8v 1939.495n 1.8v 1939.505n 1.8v 1949.495n 1.8v 1949.505n 1.8v 1959.495n 1.8v 1959.505n 1.8v 1969.495n 1.8v 1969.505n 1.8v 1979.495n 1.8v 1979.505n 1.8v 1989.495n 1.8v 1989.505n 1.8v 1999.495n 1.8v 1999.505n 1.8v 2009.495n 1.8v 2009.505n 1.8v 2019.495n 1.8v 2019.505n 1.8v 2029.495n 1.8v 2029.505n 1.8v 2039.495n 1.8v 2039.505n 1.8v 2049.495n 1.8v 2049.505n 1.8v )
* (time, data): [(0, 0), (10, 0), (20, 1), (30, 0), (40, 0), (50, 0), (60, 0), (70, 0), (80, 0), (90, 0), (100, 1), (110, 1), (120, 0), (130, 0), (140, 0), (150, 0), (160, 0), (170, 0), (180, 0), (190, 0), (200, 0), (210, 0), (220, 0), (230, 0), (240, 0), (250, 0), (260, 0), (270, 0), (280, 0), (290, 0), (300, 0), (310, 0), (320, 0), (330, 1), (340, 1), (350, 1), (360, 0), (370, 1), (380, 1), (390, 1), (400, 1), (410, 1), (420, 1), (430, 1), (440, 1), (450, 1), (460, 0), (470, 1), (480, 1), (490, 1), (500, 1), (510, 1), (520, 1), (530, 1), (540, 1), (550, 1), (560, 1), (570, 1), (580, 1), (590, 1), (600, 1), (610, 1), (620, 1), (630, 1), (640, 0), (650, 0), (660, 1), (670, 1), (680, 0), (690, 0), (700, 1), (710, 1), (720, 1), (730, 1), (740, 1), (750, 1), (760, 1), (770, 1), (780, 1), (790, 1), (800, 1), (810, 1), (820, 1), (830, 1), (840, 1), (850, 1), (860, 0), (870, 0), (880, 0), (890, 0), (900, 0), (910, 0), (920, 0), (930, 1), (940, 1), (950, 1), (960, 0), (970, 0), (980, 0), (990, 0), (1000, 0), (1010, 0), (1020, 0), (1030, 0), (1040, 0), (1050, 1), (1060, 1), (1070, 1), (1080, 1), (1090, 0), (1100, 0), (1110, 0), (1120, 0), (1130, 0), (1140, 0), (1150, 0), (1160, 1), (1170, 1), (1180, 1), (1190, 1), (1200, 1), (1210, 1), (1220, 1), (1230, 1), (1240, 1), (1250, 1), (1260, 1), (1270, 1), (1280, 0), (1290, 0), (1300, 0), (1310, 0), (1320, 0), (1330, 0), (1340, 0), (1350, 0), (1360, 0), (1370, 0), (1380, 0), (1390, 0), (1400, 0), (1410, 0), (1420, 1), (1430, 0), (1440, 0), (1450, 0), (1460, 0), (1470, 0), (1480, 0), (1490, 1), (1500, 1), (1510, 1), (1520, 1), (1530, 1), (1540, 1), (1550, 1), (1560, 1), (1570, 1), (1580, 1), (1590, 1), (1600, 1), (1610, 1), (1620, 1), (1630, 1), (1640, 1), (1650, 1), (1660, 1), (1670, 1), (1680, 1), (1690, 1), (1700, 1), (1710, 1), (1720, 1), (1730, 1), (1740, 1), (1750, 1), (1760, 1), (1770, 1), (1780, 1), (1790, 1), (1800, 1), (1810, 1), (1820, 1), (1830, 1), (1840, 1), (1850, 0), (1860, 0), (1870, 0), (1880, 0), (1890, 0), (1900, 0), (1910, 1), (1920, 1), (1930, 1), (1940, 1), (1950, 1), (1960, 1), (1970, 1), (1980, 1), (1990, 1), (2000, 1), (2010, 1), (2020, 1), (2030, 1), (2040, 1), (2050, 1)]
Vdin0_22  din0_22  0 PWL (0n 0.0v 9.495n 0.0v 9.505n 0.0v 19.495n 0.0v 19.505n 1.8v 29.495n 1.8v 29.505n 0.0v 39.495n 0.0v 39.505n 0.0v 49.495n 0.0v 49.505n 0.0v 59.495n 0.0v 59.505n 0.0v 69.495n 0.0v 69.505n 0.0v 79.495n 0.0v 79.505n 0.0v 89.495n 0.0v 89.505n 0.0v 99.495n 0.0v 99.505n 1.8v 109.495n 1.8v 109.505n 1.8v 119.495n 1.8v 119.505n 0.0v 129.495n 0.0v 129.505n 0.0v 139.495n 0.0v 139.505n 0.0v 149.495n 0.0v 149.505n 0.0v 159.495n 0.0v 159.505n 0.0v 169.495n 0.0v 169.505n 0.0v 179.495n 0.0v 179.505n 0.0v 189.495n 0.0v 189.505n 0.0v 199.495n 0.0v 199.505n 0.0v 209.495n 0.0v 209.505n 0.0v 219.495n 0.0v 219.505n 0.0v 229.495n 0.0v 229.505n 0.0v 239.495n 0.0v 239.505n 0.0v 249.495n 0.0v 249.505n 0.0v 259.495n 0.0v 259.505n 0.0v 269.495n 0.0v 269.505n 0.0v 279.495n 0.0v 279.505n 0.0v 289.495n 0.0v 289.505n 0.0v 299.495n 0.0v 299.505n 0.0v 309.495n 0.0v 309.505n 0.0v 319.495n 0.0v 319.505n 0.0v 329.495n 0.0v 329.505n 1.8v 339.495n 1.8v 339.505n 1.8v 349.495n 1.8v 349.505n 1.8v 359.495n 1.8v 359.505n 0.0v 369.495n 0.0v 369.505n 1.8v 379.495n 1.8v 379.505n 1.8v 389.495n 1.8v 389.505n 1.8v 399.495n 1.8v 399.505n 1.8v 409.495n 1.8v 409.505n 1.8v 419.495n 1.8v 419.505n 1.8v 429.495n 1.8v 429.505n 1.8v 439.495n 1.8v 439.505n 1.8v 449.495n 1.8v 449.505n 1.8v 459.495n 1.8v 459.505n 0.0v 469.495n 0.0v 469.505n 1.8v 479.495n 1.8v 479.505n 1.8v 489.495n 1.8v 489.505n 1.8v 499.495n 1.8v 499.505n 1.8v 509.495n 1.8v 509.505n 1.8v 519.495n 1.8v 519.505n 1.8v 529.495n 1.8v 529.505n 1.8v 539.495n 1.8v 539.505n 1.8v 549.495n 1.8v 549.505n 1.8v 559.495n 1.8v 559.505n 1.8v 569.495n 1.8v 569.505n 1.8v 579.495n 1.8v 579.505n 1.8v 589.495n 1.8v 589.505n 1.8v 599.495n 1.8v 599.505n 1.8v 609.495n 1.8v 609.505n 1.8v 619.495n 1.8v 619.505n 1.8v 629.495n 1.8v 629.505n 1.8v 639.495n 1.8v 639.505n 0.0v 649.495n 0.0v 649.505n 0.0v 659.495n 0.0v 659.505n 1.8v 669.495n 1.8v 669.505n 1.8v 679.495n 1.8v 679.505n 0.0v 689.495n 0.0v 689.505n 0.0v 699.495n 0.0v 699.505n 1.8v 709.495n 1.8v 709.505n 1.8v 719.495n 1.8v 719.505n 1.8v 729.495n 1.8v 729.505n 1.8v 739.495n 1.8v 739.505n 1.8v 749.495n 1.8v 749.505n 1.8v 759.495n 1.8v 759.505n 1.8v 769.495n 1.8v 769.505n 1.8v 779.495n 1.8v 779.505n 1.8v 789.495n 1.8v 789.505n 1.8v 799.495n 1.8v 799.505n 1.8v 809.495n 1.8v 809.505n 1.8v 819.495n 1.8v 819.505n 1.8v 829.495n 1.8v 829.505n 1.8v 839.495n 1.8v 839.505n 1.8v 849.495n 1.8v 849.505n 1.8v 859.495n 1.8v 859.505n 0.0v 869.495n 0.0v 869.505n 0.0v 879.495n 0.0v 879.505n 0.0v 889.495n 0.0v 889.505n 0.0v 899.495n 0.0v 899.505n 0.0v 909.495n 0.0v 909.505n 0.0v 919.495n 0.0v 919.505n 0.0v 929.495n 0.0v 929.505n 1.8v 939.495n 1.8v 939.505n 1.8v 949.495n 1.8v 949.505n 1.8v 959.495n 1.8v 959.505n 0.0v 969.495n 0.0v 969.505n 0.0v 979.495n 0.0v 979.505n 0.0v 989.495n 0.0v 989.505n 0.0v 999.495n 0.0v 999.505n 0.0v 1009.495n 0.0v 1009.505n 0.0v 1019.495n 0.0v 1019.505n 0.0v 1029.495n 0.0v 1029.505n 0.0v 1039.495n 0.0v 1039.505n 0.0v 1049.495n 0.0v 1049.505n 1.8v 1059.495n 1.8v 1059.505n 1.8v 1069.495n 1.8v 1069.505n 1.8v 1079.495n 1.8v 1079.505n 1.8v 1089.495n 1.8v 1089.505n 0.0v 1099.495n 0.0v 1099.505n 0.0v 1109.495n 0.0v 1109.505n 0.0v 1119.495n 0.0v 1119.505n 0.0v 1129.495n 0.0v 1129.505n 0.0v 1139.495n 0.0v 1139.505n 0.0v 1149.495n 0.0v 1149.505n 0.0v 1159.495n 0.0v 1159.505n 1.8v 1169.495n 1.8v 1169.505n 1.8v 1179.495n 1.8v 1179.505n 1.8v 1189.495n 1.8v 1189.505n 1.8v 1199.495n 1.8v 1199.505n 1.8v 1209.495n 1.8v 1209.505n 1.8v 1219.495n 1.8v 1219.505n 1.8v 1229.495n 1.8v 1229.505n 1.8v 1239.495n 1.8v 1239.505n 1.8v 1249.495n 1.8v 1249.505n 1.8v 1259.495n 1.8v 1259.505n 1.8v 1269.495n 1.8v 1269.505n 1.8v 1279.495n 1.8v 1279.505n 0.0v 1289.495n 0.0v 1289.505n 0.0v 1299.495n 0.0v 1299.505n 0.0v 1309.495n 0.0v 1309.505n 0.0v 1319.495n 0.0v 1319.505n 0.0v 1329.495n 0.0v 1329.505n 0.0v 1339.495n 0.0v 1339.505n 0.0v 1349.495n 0.0v 1349.505n 0.0v 1359.495n 0.0v 1359.505n 0.0v 1369.495n 0.0v 1369.505n 0.0v 1379.495n 0.0v 1379.505n 0.0v 1389.495n 0.0v 1389.505n 0.0v 1399.495n 0.0v 1399.505n 0.0v 1409.495n 0.0v 1409.505n 0.0v 1419.495n 0.0v 1419.505n 1.8v 1429.495n 1.8v 1429.505n 0.0v 1439.495n 0.0v 1439.505n 0.0v 1449.495n 0.0v 1449.505n 0.0v 1459.495n 0.0v 1459.505n 0.0v 1469.495n 0.0v 1469.505n 0.0v 1479.495n 0.0v 1479.505n 0.0v 1489.495n 0.0v 1489.505n 1.8v 1499.495n 1.8v 1499.505n 1.8v 1509.495n 1.8v 1509.505n 1.8v 1519.495n 1.8v 1519.505n 1.8v 1529.495n 1.8v 1529.505n 1.8v 1539.495n 1.8v 1539.505n 1.8v 1549.495n 1.8v 1549.505n 1.8v 1559.495n 1.8v 1559.505n 1.8v 1569.495n 1.8v 1569.505n 1.8v 1579.495n 1.8v 1579.505n 1.8v 1589.495n 1.8v 1589.505n 1.8v 1599.495n 1.8v 1599.505n 1.8v 1609.495n 1.8v 1609.505n 1.8v 1619.495n 1.8v 1619.505n 1.8v 1629.495n 1.8v 1629.505n 1.8v 1639.495n 1.8v 1639.505n 1.8v 1649.495n 1.8v 1649.505n 1.8v 1659.495n 1.8v 1659.505n 1.8v 1669.495n 1.8v 1669.505n 1.8v 1679.495n 1.8v 1679.505n 1.8v 1689.495n 1.8v 1689.505n 1.8v 1699.495n 1.8v 1699.505n 1.8v 1709.495n 1.8v 1709.505n 1.8v 1719.495n 1.8v 1719.505n 1.8v 1729.495n 1.8v 1729.505n 1.8v 1739.495n 1.8v 1739.505n 1.8v 1749.495n 1.8v 1749.505n 1.8v 1759.495n 1.8v 1759.505n 1.8v 1769.495n 1.8v 1769.505n 1.8v 1779.495n 1.8v 1779.505n 1.8v 1789.495n 1.8v 1789.505n 1.8v 1799.495n 1.8v 1799.505n 1.8v 1809.495n 1.8v 1809.505n 1.8v 1819.495n 1.8v 1819.505n 1.8v 1829.495n 1.8v 1829.505n 1.8v 1839.495n 1.8v 1839.505n 1.8v 1849.495n 1.8v 1849.505n 0.0v 1859.495n 0.0v 1859.505n 0.0v 1869.495n 0.0v 1869.505n 0.0v 1879.495n 0.0v 1879.505n 0.0v 1889.495n 0.0v 1889.505n 0.0v 1899.495n 0.0v 1899.505n 0.0v 1909.495n 0.0v 1909.505n 1.8v 1919.495n 1.8v 1919.505n 1.8v 1929.495n 1.8v 1929.505n 1.8v 1939.495n 1.8v 1939.505n 1.8v 1949.495n 1.8v 1949.505n 1.8v 1959.495n 1.8v 1959.505n 1.8v 1969.495n 1.8v 1969.505n 1.8v 1979.495n 1.8v 1979.505n 1.8v 1989.495n 1.8v 1989.505n 1.8v 1999.495n 1.8v 1999.505n 1.8v 2009.495n 1.8v 2009.505n 1.8v 2019.495n 1.8v 2019.505n 1.8v 2029.495n 1.8v 2029.505n 1.8v 2039.495n 1.8v 2039.505n 1.8v 2049.495n 1.8v 2049.505n 1.8v )
* (time, data): [(0, 0), (10, 1), (20, 0), (30, 1), (40, 1), (50, 1), (60, 1), (70, 1), (80, 1), (90, 0), (100, 1), (110, 1), (120, 1), (130, 1), (140, 1), (150, 1), (160, 1), (170, 1), (180, 0), (190, 0), (200, 1), (210, 1), (220, 1), (230, 0), (240, 1), (250, 1), (260, 1), (270, 1), (280, 1), (290, 0), (300, 1), (310, 1), (320, 1), (330, 0), (340, 0), (350, 0), (360, 1), (370, 0), (380, 0), (390, 0), (400, 0), (410, 0), (420, 0), (430, 0), (440, 0), (450, 0), (460, 0), (470, 0), (480, 0), (490, 0), (500, 0), (510, 0), (520, 0), (530, 0), (540, 0), (550, 0), (560, 0), (570, 0), (580, 0), (590, 0), (600, 0), (610, 0), (620, 0), (630, 0), (640, 0), (650, 0), (660, 1), (670, 1), (680, 1), (690, 1), (700, 1), (710, 1), (720, 1), (730, 1), (740, 0), (750, 0), (760, 0), (770, 0), (780, 0), (790, 0), (800, 0), (810, 1), (820, 1), (830, 1), (840, 1), (850, 1), (860, 1), (870, 0), (880, 0), (890, 0), (900, 0), (910, 0), (920, 0), (930, 1), (940, 1), (950, 1), (960, 0), (970, 0), (980, 0), (990, 0), (1000, 0), (1010, 0), (1020, 0), (1030, 0), (1040, 0), (1050, 1), (1060, 1), (1070, 1), (1080, 1), (1090, 1), (1100, 1), (1110, 1), (1120, 1), (1130, 1), (1140, 0), (1150, 0), (1160, 1), (1170, 1), (1180, 1), (1190, 1), (1200, 1), (1210, 1), (1220, 1), (1230, 1), (1240, 1), (1250, 1), (1260, 0), (1270, 0), (1280, 0), (1290, 0), (1300, 0), (1310, 0), (1320, 0), (1330, 0), (1340, 0), (1350, 0), (1360, 0), (1370, 1), (1380, 1), (1390, 1), (1400, 1), (1410, 1), (1420, 0), (1430, 1), (1440, 1), (1450, 1), (1460, 1), (1470, 1), (1480, 1), (1490, 1), (1500, 1), (1510, 1), (1520, 1), (1530, 1), (1540, 1), (1550, 0), (1560, 0), (1570, 0), (1580, 0), (1590, 0), (1600, 0), (1610, 0), (1620, 0), (1630, 0), (1640, 0), (1650, 0), (1660, 0), (1670, 0), (1680, 0), (1690, 0), (1700, 0), (1710, 0), (1720, 0), (1730, 0), (1740, 0), (1750, 0), (1760, 1), (1770, 1), (1780, 1), (1790, 1), (1800, 1), (1810, 1), (1820, 0), (1830, 0), (1840, 0), (1850, 1), (1860, 1), (1870, 1), (1880, 1), (1890, 1), (1900, 1), (1910, 1), (1920, 1), (1930, 1), (1940, 1), (1950, 1), (1960, 1), (1970, 1), (1980, 1), (1990, 1), (2000, 1), (2010, 1), (2020, 1), (2030, 1), (2040, 1), (2050, 1)]
Vdin0_23  din0_23  0 PWL (0n 0.0v 9.495n 0.0v 9.505n 1.8v 19.495n 1.8v 19.505n 0.0v 29.495n 0.0v 29.505n 1.8v 39.495n 1.8v 39.505n 1.8v 49.495n 1.8v 49.505n 1.8v 59.495n 1.8v 59.505n 1.8v 69.495n 1.8v 69.505n 1.8v 79.495n 1.8v 79.505n 1.8v 89.495n 1.8v 89.505n 0.0v 99.495n 0.0v 99.505n 1.8v 109.495n 1.8v 109.505n 1.8v 119.495n 1.8v 119.505n 1.8v 129.495n 1.8v 129.505n 1.8v 139.495n 1.8v 139.505n 1.8v 149.495n 1.8v 149.505n 1.8v 159.495n 1.8v 159.505n 1.8v 169.495n 1.8v 169.505n 1.8v 179.495n 1.8v 179.505n 0.0v 189.495n 0.0v 189.505n 0.0v 199.495n 0.0v 199.505n 1.8v 209.495n 1.8v 209.505n 1.8v 219.495n 1.8v 219.505n 1.8v 229.495n 1.8v 229.505n 0.0v 239.495n 0.0v 239.505n 1.8v 249.495n 1.8v 249.505n 1.8v 259.495n 1.8v 259.505n 1.8v 269.495n 1.8v 269.505n 1.8v 279.495n 1.8v 279.505n 1.8v 289.495n 1.8v 289.505n 0.0v 299.495n 0.0v 299.505n 1.8v 309.495n 1.8v 309.505n 1.8v 319.495n 1.8v 319.505n 1.8v 329.495n 1.8v 329.505n 0.0v 339.495n 0.0v 339.505n 0.0v 349.495n 0.0v 349.505n 0.0v 359.495n 0.0v 359.505n 1.8v 369.495n 1.8v 369.505n 0.0v 379.495n 0.0v 379.505n 0.0v 389.495n 0.0v 389.505n 0.0v 399.495n 0.0v 399.505n 0.0v 409.495n 0.0v 409.505n 0.0v 419.495n 0.0v 419.505n 0.0v 429.495n 0.0v 429.505n 0.0v 439.495n 0.0v 439.505n 0.0v 449.495n 0.0v 449.505n 0.0v 459.495n 0.0v 459.505n 0.0v 469.495n 0.0v 469.505n 0.0v 479.495n 0.0v 479.505n 0.0v 489.495n 0.0v 489.505n 0.0v 499.495n 0.0v 499.505n 0.0v 509.495n 0.0v 509.505n 0.0v 519.495n 0.0v 519.505n 0.0v 529.495n 0.0v 529.505n 0.0v 539.495n 0.0v 539.505n 0.0v 549.495n 0.0v 549.505n 0.0v 559.495n 0.0v 559.505n 0.0v 569.495n 0.0v 569.505n 0.0v 579.495n 0.0v 579.505n 0.0v 589.495n 0.0v 589.505n 0.0v 599.495n 0.0v 599.505n 0.0v 609.495n 0.0v 609.505n 0.0v 619.495n 0.0v 619.505n 0.0v 629.495n 0.0v 629.505n 0.0v 639.495n 0.0v 639.505n 0.0v 649.495n 0.0v 649.505n 0.0v 659.495n 0.0v 659.505n 1.8v 669.495n 1.8v 669.505n 1.8v 679.495n 1.8v 679.505n 1.8v 689.495n 1.8v 689.505n 1.8v 699.495n 1.8v 699.505n 1.8v 709.495n 1.8v 709.505n 1.8v 719.495n 1.8v 719.505n 1.8v 729.495n 1.8v 729.505n 1.8v 739.495n 1.8v 739.505n 0.0v 749.495n 0.0v 749.505n 0.0v 759.495n 0.0v 759.505n 0.0v 769.495n 0.0v 769.505n 0.0v 779.495n 0.0v 779.505n 0.0v 789.495n 0.0v 789.505n 0.0v 799.495n 0.0v 799.505n 0.0v 809.495n 0.0v 809.505n 1.8v 819.495n 1.8v 819.505n 1.8v 829.495n 1.8v 829.505n 1.8v 839.495n 1.8v 839.505n 1.8v 849.495n 1.8v 849.505n 1.8v 859.495n 1.8v 859.505n 1.8v 869.495n 1.8v 869.505n 0.0v 879.495n 0.0v 879.505n 0.0v 889.495n 0.0v 889.505n 0.0v 899.495n 0.0v 899.505n 0.0v 909.495n 0.0v 909.505n 0.0v 919.495n 0.0v 919.505n 0.0v 929.495n 0.0v 929.505n 1.8v 939.495n 1.8v 939.505n 1.8v 949.495n 1.8v 949.505n 1.8v 959.495n 1.8v 959.505n 0.0v 969.495n 0.0v 969.505n 0.0v 979.495n 0.0v 979.505n 0.0v 989.495n 0.0v 989.505n 0.0v 999.495n 0.0v 999.505n 0.0v 1009.495n 0.0v 1009.505n 0.0v 1019.495n 0.0v 1019.505n 0.0v 1029.495n 0.0v 1029.505n 0.0v 1039.495n 0.0v 1039.505n 0.0v 1049.495n 0.0v 1049.505n 1.8v 1059.495n 1.8v 1059.505n 1.8v 1069.495n 1.8v 1069.505n 1.8v 1079.495n 1.8v 1079.505n 1.8v 1089.495n 1.8v 1089.505n 1.8v 1099.495n 1.8v 1099.505n 1.8v 1109.495n 1.8v 1109.505n 1.8v 1119.495n 1.8v 1119.505n 1.8v 1129.495n 1.8v 1129.505n 1.8v 1139.495n 1.8v 1139.505n 0.0v 1149.495n 0.0v 1149.505n 0.0v 1159.495n 0.0v 1159.505n 1.8v 1169.495n 1.8v 1169.505n 1.8v 1179.495n 1.8v 1179.505n 1.8v 1189.495n 1.8v 1189.505n 1.8v 1199.495n 1.8v 1199.505n 1.8v 1209.495n 1.8v 1209.505n 1.8v 1219.495n 1.8v 1219.505n 1.8v 1229.495n 1.8v 1229.505n 1.8v 1239.495n 1.8v 1239.505n 1.8v 1249.495n 1.8v 1249.505n 1.8v 1259.495n 1.8v 1259.505n 0.0v 1269.495n 0.0v 1269.505n 0.0v 1279.495n 0.0v 1279.505n 0.0v 1289.495n 0.0v 1289.505n 0.0v 1299.495n 0.0v 1299.505n 0.0v 1309.495n 0.0v 1309.505n 0.0v 1319.495n 0.0v 1319.505n 0.0v 1329.495n 0.0v 1329.505n 0.0v 1339.495n 0.0v 1339.505n 0.0v 1349.495n 0.0v 1349.505n 0.0v 1359.495n 0.0v 1359.505n 0.0v 1369.495n 0.0v 1369.505n 1.8v 1379.495n 1.8v 1379.505n 1.8v 1389.495n 1.8v 1389.505n 1.8v 1399.495n 1.8v 1399.505n 1.8v 1409.495n 1.8v 1409.505n 1.8v 1419.495n 1.8v 1419.505n 0.0v 1429.495n 0.0v 1429.505n 1.8v 1439.495n 1.8v 1439.505n 1.8v 1449.495n 1.8v 1449.505n 1.8v 1459.495n 1.8v 1459.505n 1.8v 1469.495n 1.8v 1469.505n 1.8v 1479.495n 1.8v 1479.505n 1.8v 1489.495n 1.8v 1489.505n 1.8v 1499.495n 1.8v 1499.505n 1.8v 1509.495n 1.8v 1509.505n 1.8v 1519.495n 1.8v 1519.505n 1.8v 1529.495n 1.8v 1529.505n 1.8v 1539.495n 1.8v 1539.505n 1.8v 1549.495n 1.8v 1549.505n 0.0v 1559.495n 0.0v 1559.505n 0.0v 1569.495n 0.0v 1569.505n 0.0v 1579.495n 0.0v 1579.505n 0.0v 1589.495n 0.0v 1589.505n 0.0v 1599.495n 0.0v 1599.505n 0.0v 1609.495n 0.0v 1609.505n 0.0v 1619.495n 0.0v 1619.505n 0.0v 1629.495n 0.0v 1629.505n 0.0v 1639.495n 0.0v 1639.505n 0.0v 1649.495n 0.0v 1649.505n 0.0v 1659.495n 0.0v 1659.505n 0.0v 1669.495n 0.0v 1669.505n 0.0v 1679.495n 0.0v 1679.505n 0.0v 1689.495n 0.0v 1689.505n 0.0v 1699.495n 0.0v 1699.505n 0.0v 1709.495n 0.0v 1709.505n 0.0v 1719.495n 0.0v 1719.505n 0.0v 1729.495n 0.0v 1729.505n 0.0v 1739.495n 0.0v 1739.505n 0.0v 1749.495n 0.0v 1749.505n 0.0v 1759.495n 0.0v 1759.505n 1.8v 1769.495n 1.8v 1769.505n 1.8v 1779.495n 1.8v 1779.505n 1.8v 1789.495n 1.8v 1789.505n 1.8v 1799.495n 1.8v 1799.505n 1.8v 1809.495n 1.8v 1809.505n 1.8v 1819.495n 1.8v 1819.505n 0.0v 1829.495n 0.0v 1829.505n 0.0v 1839.495n 0.0v 1839.505n 0.0v 1849.495n 0.0v 1849.505n 1.8v 1859.495n 1.8v 1859.505n 1.8v 1869.495n 1.8v 1869.505n 1.8v 1879.495n 1.8v 1879.505n 1.8v 1889.495n 1.8v 1889.505n 1.8v 1899.495n 1.8v 1899.505n 1.8v 1909.495n 1.8v 1909.505n 1.8v 1919.495n 1.8v 1919.505n 1.8v 1929.495n 1.8v 1929.505n 1.8v 1939.495n 1.8v 1939.505n 1.8v 1949.495n 1.8v 1949.505n 1.8v 1959.495n 1.8v 1959.505n 1.8v 1969.495n 1.8v 1969.505n 1.8v 1979.495n 1.8v 1979.505n 1.8v 1989.495n 1.8v 1989.505n 1.8v 1999.495n 1.8v 1999.505n 1.8v 2009.495n 1.8v 2009.505n 1.8v 2019.495n 1.8v 2019.505n 1.8v 2029.495n 1.8v 2029.505n 1.8v 2039.495n 1.8v 2039.505n 1.8v 2049.495n 1.8v 2049.505n 1.8v )
* (time, data): [(0, 0), (10, 1), (20, 1), (30, 1), (40, 1), (50, 1), (60, 1), (70, 1), (80, 1), (90, 1), (100, 0), (110, 0), (120, 0), (130, 0), (140, 0), (150, 0), (160, 0), (170, 0), (180, 1), (190, 1), (200, 1), (210, 1), (220, 1), (230, 1), (240, 0), (250, 0), (260, 0), (270, 0), (280, 0), (290, 1), (300, 1), (310, 1), (320, 1), (330, 1), (340, 1), (350, 1), (360, 1), (370, 1), (380, 1), (390, 1), (400, 1), (410, 1), (420, 1), (430, 1), (440, 1), (450, 1), (460, 0), (470, 0), (480, 0), (490, 0), (500, 0), (510, 0), (520, 0), (530, 0), (540, 0), (550, 0), (560, 0), (570, 0), (580, 0), (590, 0), (600, 0), (610, 0), (620, 0), (630, 0), (640, 0), (650, 0), (660, 0), (670, 0), (680, 0), (690, 0), (700, 0), (710, 0), (720, 0), (730, 0), (740, 0), (750, 0), (760, 1), (770, 1), (780, 1), (790, 1), (800, 1), (810, 1), (820, 1), (830, 1), (840, 1), (850, 1), (860, 0), (870, 0), (880, 0), (890, 0), (900, 0), (910, 0), (920, 0), (930, 1), (940, 0), (950, 0), (960, 1), (970, 1), (980, 1), (990, 1), (1000, 1), (1010, 1), (1020, 1), (1030, 1), (1040, 1), (1050, 1), (1060, 0), (1070, 0), (1080, 0), (1090, 1), (1100, 1), (1110, 1), (1120, 1), (1130, 1), (1140, 0), (1150, 0), (1160, 0), (1170, 0), (1180, 0), (1190, 0), (1200, 0), (1210, 0), (1220, 0), (1230, 0), (1240, 0), (1250, 0), (1260, 0), (1270, 0), (1280, 0), (1290, 0), (1300, 0), (1310, 0), (1320, 0), (1330, 0), (1340, 0), (1350, 0), (1360, 0), (1370, 1), (1380, 1), (1390, 1), (1400, 0), (1410, 0), (1420, 0), (1430, 1), (1440, 1), (1450, 1), (1460, 1), (1470, 1), (1480, 1), (1490, 1), (1500, 1), (1510, 1), (1520, 1), (1530, 1), (1540, 1), (1550, 0), (1560, 0), (1570, 1), (1580, 1), (1590, 1), (1600, 1), (1610, 1), (1620, 1), (1630, 1), (1640, 1), (1650, 1), (1660, 1), (1670, 1), (1680, 1), (1690, 1), (1700, 1), (1710, 1), (1720, 1), (1730, 1), (1740, 1), (1750, 1), (1760, 1), (1770, 1), (1780, 1), (1790, 0), (1800, 0), (1810, 0), (1820, 1), (1830, 1), (1840, 1), (1850, 0), (1860, 0), (1870, 0), (1880, 0), (1890, 0), (1900, 0), (1910, 1), (1920, 1), (1930, 1), (1940, 1), (1950, 1), (1960, 1), (1970, 1), (1980, 1), (1990, 1), (2000, 1), (2010, 1), (2020, 1), (2030, 1), (2040, 1), (2050, 1)]
Vdin0_24  din0_24  0 PWL (0n 0.0v 9.495n 0.0v 9.505n 1.8v 19.495n 1.8v 19.505n 1.8v 29.495n 1.8v 29.505n 1.8v 39.495n 1.8v 39.505n 1.8v 49.495n 1.8v 49.505n 1.8v 59.495n 1.8v 59.505n 1.8v 69.495n 1.8v 69.505n 1.8v 79.495n 1.8v 79.505n 1.8v 89.495n 1.8v 89.505n 1.8v 99.495n 1.8v 99.505n 0.0v 109.495n 0.0v 109.505n 0.0v 119.495n 0.0v 119.505n 0.0v 129.495n 0.0v 129.505n 0.0v 139.495n 0.0v 139.505n 0.0v 149.495n 0.0v 149.505n 0.0v 159.495n 0.0v 159.505n 0.0v 169.495n 0.0v 169.505n 0.0v 179.495n 0.0v 179.505n 1.8v 189.495n 1.8v 189.505n 1.8v 199.495n 1.8v 199.505n 1.8v 209.495n 1.8v 209.505n 1.8v 219.495n 1.8v 219.505n 1.8v 229.495n 1.8v 229.505n 1.8v 239.495n 1.8v 239.505n 0.0v 249.495n 0.0v 249.505n 0.0v 259.495n 0.0v 259.505n 0.0v 269.495n 0.0v 269.505n 0.0v 279.495n 0.0v 279.505n 0.0v 289.495n 0.0v 289.505n 1.8v 299.495n 1.8v 299.505n 1.8v 309.495n 1.8v 309.505n 1.8v 319.495n 1.8v 319.505n 1.8v 329.495n 1.8v 329.505n 1.8v 339.495n 1.8v 339.505n 1.8v 349.495n 1.8v 349.505n 1.8v 359.495n 1.8v 359.505n 1.8v 369.495n 1.8v 369.505n 1.8v 379.495n 1.8v 379.505n 1.8v 389.495n 1.8v 389.505n 1.8v 399.495n 1.8v 399.505n 1.8v 409.495n 1.8v 409.505n 1.8v 419.495n 1.8v 419.505n 1.8v 429.495n 1.8v 429.505n 1.8v 439.495n 1.8v 439.505n 1.8v 449.495n 1.8v 449.505n 1.8v 459.495n 1.8v 459.505n 0.0v 469.495n 0.0v 469.505n 0.0v 479.495n 0.0v 479.505n 0.0v 489.495n 0.0v 489.505n 0.0v 499.495n 0.0v 499.505n 0.0v 509.495n 0.0v 509.505n 0.0v 519.495n 0.0v 519.505n 0.0v 529.495n 0.0v 529.505n 0.0v 539.495n 0.0v 539.505n 0.0v 549.495n 0.0v 549.505n 0.0v 559.495n 0.0v 559.505n 0.0v 569.495n 0.0v 569.505n 0.0v 579.495n 0.0v 579.505n 0.0v 589.495n 0.0v 589.505n 0.0v 599.495n 0.0v 599.505n 0.0v 609.495n 0.0v 609.505n 0.0v 619.495n 0.0v 619.505n 0.0v 629.495n 0.0v 629.505n 0.0v 639.495n 0.0v 639.505n 0.0v 649.495n 0.0v 649.505n 0.0v 659.495n 0.0v 659.505n 0.0v 669.495n 0.0v 669.505n 0.0v 679.495n 0.0v 679.505n 0.0v 689.495n 0.0v 689.505n 0.0v 699.495n 0.0v 699.505n 0.0v 709.495n 0.0v 709.505n 0.0v 719.495n 0.0v 719.505n 0.0v 729.495n 0.0v 729.505n 0.0v 739.495n 0.0v 739.505n 0.0v 749.495n 0.0v 749.505n 0.0v 759.495n 0.0v 759.505n 1.8v 769.495n 1.8v 769.505n 1.8v 779.495n 1.8v 779.505n 1.8v 789.495n 1.8v 789.505n 1.8v 799.495n 1.8v 799.505n 1.8v 809.495n 1.8v 809.505n 1.8v 819.495n 1.8v 819.505n 1.8v 829.495n 1.8v 829.505n 1.8v 839.495n 1.8v 839.505n 1.8v 849.495n 1.8v 849.505n 1.8v 859.495n 1.8v 859.505n 0.0v 869.495n 0.0v 869.505n 0.0v 879.495n 0.0v 879.505n 0.0v 889.495n 0.0v 889.505n 0.0v 899.495n 0.0v 899.505n 0.0v 909.495n 0.0v 909.505n 0.0v 919.495n 0.0v 919.505n 0.0v 929.495n 0.0v 929.505n 1.8v 939.495n 1.8v 939.505n 0.0v 949.495n 0.0v 949.505n 0.0v 959.495n 0.0v 959.505n 1.8v 969.495n 1.8v 969.505n 1.8v 979.495n 1.8v 979.505n 1.8v 989.495n 1.8v 989.505n 1.8v 999.495n 1.8v 999.505n 1.8v 1009.495n 1.8v 1009.505n 1.8v 1019.495n 1.8v 1019.505n 1.8v 1029.495n 1.8v 1029.505n 1.8v 1039.495n 1.8v 1039.505n 1.8v 1049.495n 1.8v 1049.505n 1.8v 1059.495n 1.8v 1059.505n 0.0v 1069.495n 0.0v 1069.505n 0.0v 1079.495n 0.0v 1079.505n 0.0v 1089.495n 0.0v 1089.505n 1.8v 1099.495n 1.8v 1099.505n 1.8v 1109.495n 1.8v 1109.505n 1.8v 1119.495n 1.8v 1119.505n 1.8v 1129.495n 1.8v 1129.505n 1.8v 1139.495n 1.8v 1139.505n 0.0v 1149.495n 0.0v 1149.505n 0.0v 1159.495n 0.0v 1159.505n 0.0v 1169.495n 0.0v 1169.505n 0.0v 1179.495n 0.0v 1179.505n 0.0v 1189.495n 0.0v 1189.505n 0.0v 1199.495n 0.0v 1199.505n 0.0v 1209.495n 0.0v 1209.505n 0.0v 1219.495n 0.0v 1219.505n 0.0v 1229.495n 0.0v 1229.505n 0.0v 1239.495n 0.0v 1239.505n 0.0v 1249.495n 0.0v 1249.505n 0.0v 1259.495n 0.0v 1259.505n 0.0v 1269.495n 0.0v 1269.505n 0.0v 1279.495n 0.0v 1279.505n 0.0v 1289.495n 0.0v 1289.505n 0.0v 1299.495n 0.0v 1299.505n 0.0v 1309.495n 0.0v 1309.505n 0.0v 1319.495n 0.0v 1319.505n 0.0v 1329.495n 0.0v 1329.505n 0.0v 1339.495n 0.0v 1339.505n 0.0v 1349.495n 0.0v 1349.505n 0.0v 1359.495n 0.0v 1359.505n 0.0v 1369.495n 0.0v 1369.505n 1.8v 1379.495n 1.8v 1379.505n 1.8v 1389.495n 1.8v 1389.505n 1.8v 1399.495n 1.8v 1399.505n 0.0v 1409.495n 0.0v 1409.505n 0.0v 1419.495n 0.0v 1419.505n 0.0v 1429.495n 0.0v 1429.505n 1.8v 1439.495n 1.8v 1439.505n 1.8v 1449.495n 1.8v 1449.505n 1.8v 1459.495n 1.8v 1459.505n 1.8v 1469.495n 1.8v 1469.505n 1.8v 1479.495n 1.8v 1479.505n 1.8v 1489.495n 1.8v 1489.505n 1.8v 1499.495n 1.8v 1499.505n 1.8v 1509.495n 1.8v 1509.505n 1.8v 1519.495n 1.8v 1519.505n 1.8v 1529.495n 1.8v 1529.505n 1.8v 1539.495n 1.8v 1539.505n 1.8v 1549.495n 1.8v 1549.505n 0.0v 1559.495n 0.0v 1559.505n 0.0v 1569.495n 0.0v 1569.505n 1.8v 1579.495n 1.8v 1579.505n 1.8v 1589.495n 1.8v 1589.505n 1.8v 1599.495n 1.8v 1599.505n 1.8v 1609.495n 1.8v 1609.505n 1.8v 1619.495n 1.8v 1619.505n 1.8v 1629.495n 1.8v 1629.505n 1.8v 1639.495n 1.8v 1639.505n 1.8v 1649.495n 1.8v 1649.505n 1.8v 1659.495n 1.8v 1659.505n 1.8v 1669.495n 1.8v 1669.505n 1.8v 1679.495n 1.8v 1679.505n 1.8v 1689.495n 1.8v 1689.505n 1.8v 1699.495n 1.8v 1699.505n 1.8v 1709.495n 1.8v 1709.505n 1.8v 1719.495n 1.8v 1719.505n 1.8v 1729.495n 1.8v 1729.505n 1.8v 1739.495n 1.8v 1739.505n 1.8v 1749.495n 1.8v 1749.505n 1.8v 1759.495n 1.8v 1759.505n 1.8v 1769.495n 1.8v 1769.505n 1.8v 1779.495n 1.8v 1779.505n 1.8v 1789.495n 1.8v 1789.505n 0.0v 1799.495n 0.0v 1799.505n 0.0v 1809.495n 0.0v 1809.505n 0.0v 1819.495n 0.0v 1819.505n 1.8v 1829.495n 1.8v 1829.505n 1.8v 1839.495n 1.8v 1839.505n 1.8v 1849.495n 1.8v 1849.505n 0.0v 1859.495n 0.0v 1859.505n 0.0v 1869.495n 0.0v 1869.505n 0.0v 1879.495n 0.0v 1879.505n 0.0v 1889.495n 0.0v 1889.505n 0.0v 1899.495n 0.0v 1899.505n 0.0v 1909.495n 0.0v 1909.505n 1.8v 1919.495n 1.8v 1919.505n 1.8v 1929.495n 1.8v 1929.505n 1.8v 1939.495n 1.8v 1939.505n 1.8v 1949.495n 1.8v 1949.505n 1.8v 1959.495n 1.8v 1959.505n 1.8v 1969.495n 1.8v 1969.505n 1.8v 1979.495n 1.8v 1979.505n 1.8v 1989.495n 1.8v 1989.505n 1.8v 1999.495n 1.8v 1999.505n 1.8v 2009.495n 1.8v 2009.505n 1.8v 2019.495n 1.8v 2019.505n 1.8v 2029.495n 1.8v 2029.505n 1.8v 2039.495n 1.8v 2039.505n 1.8v 2049.495n 1.8v 2049.505n 1.8v )
* (time, data): [(0, 0), (10, 1), (20, 0), (30, 0), (40, 0), (50, 0), (60, 0), (70, 0), (80, 0), (90, 0), (100, 1), (110, 1), (120, 1), (130, 1), (140, 1), (150, 1), (160, 1), (170, 1), (180, 0), (190, 0), (200, 0), (210, 0), (220, 0), (230, 1), (240, 1), (250, 1), (260, 1), (270, 1), (280, 1), (290, 1), (300, 1), (310, 1), (320, 1), (330, 0), (340, 0), (350, 0), (360, 0), (370, 0), (380, 0), (390, 0), (400, 0), (410, 0), (420, 0), (430, 0), (440, 0), (450, 0), (460, 0), (470, 1), (480, 1), (490, 1), (500, 1), (510, 1), (520, 1), (530, 1), (540, 1), (550, 1), (560, 0), (570, 0), (580, 0), (590, 0), (600, 0), (610, 0), (620, 0), (630, 0), (640, 1), (650, 1), (660, 1), (670, 1), (680, 0), (690, 0), (700, 1), (710, 1), (720, 1), (730, 1), (740, 1), (750, 1), (760, 1), (770, 1), (780, 1), (790, 1), (800, 1), (810, 0), (820, 0), (830, 0), (840, 0), (850, 0), (860, 1), (870, 0), (880, 0), (890, 0), (900, 0), (910, 0), (920, 0), (930, 0), (940, 0), (950, 0), (960, 0), (970, 0), (980, 0), (990, 0), (1000, 0), (1010, 0), (1020, 0), (1030, 0), (1040, 0), (1050, 1), (1060, 0), (1070, 0), (1080, 0), (1090, 0), (1100, 0), (1110, 0), (1120, 0), (1130, 0), (1140, 1), (1150, 1), (1160, 1), (1170, 1), (1180, 1), (1190, 1), (1200, 1), (1210, 1), (1220, 1), (1230, 1), (1240, 1), (1250, 1), (1260, 0), (1270, 0), (1280, 0), (1290, 0), (1300, 0), (1310, 0), (1320, 0), (1330, 1), (1340, 1), (1350, 1), (1360, 1), (1370, 1), (1380, 1), (1390, 1), (1400, 0), (1410, 0), (1420, 1), (1430, 1), (1440, 1), (1450, 1), (1460, 1), (1470, 1), (1480, 1), (1490, 1), (1500, 1), (1510, 1), (1520, 1), (1530, 1), (1540, 1), (1550, 0), (1560, 0), (1570, 1), (1580, 1), (1590, 1), (1600, 1), (1610, 1), (1620, 1), (1630, 1), (1640, 1), (1650, 1), (1660, 1), (1670, 1), (1680, 1), (1690, 1), (1700, 1), (1710, 1), (1720, 1), (1730, 1), (1740, 1), (1750, 1), (1760, 1), (1770, 1), (1780, 1), (1790, 1), (1800, 1), (1810, 1), (1820, 1), (1830, 1), (1840, 1), (1850, 1), (1860, 1), (1870, 1), (1880, 1), (1890, 1), (1900, 1), (1910, 1), (1920, 1), (1930, 1), (1940, 1), (1950, 1), (1960, 1), (1970, 1), (1980, 1), (1990, 1), (2000, 1), (2010, 1), (2020, 1), (2030, 1), (2040, 1), (2050, 1)]
Vdin0_25  din0_25  0 PWL (0n 0.0v 9.495n 0.0v 9.505n 1.8v 19.495n 1.8v 19.505n 0.0v 29.495n 0.0v 29.505n 0.0v 39.495n 0.0v 39.505n 0.0v 49.495n 0.0v 49.505n 0.0v 59.495n 0.0v 59.505n 0.0v 69.495n 0.0v 69.505n 0.0v 79.495n 0.0v 79.505n 0.0v 89.495n 0.0v 89.505n 0.0v 99.495n 0.0v 99.505n 1.8v 109.495n 1.8v 109.505n 1.8v 119.495n 1.8v 119.505n 1.8v 129.495n 1.8v 129.505n 1.8v 139.495n 1.8v 139.505n 1.8v 149.495n 1.8v 149.505n 1.8v 159.495n 1.8v 159.505n 1.8v 169.495n 1.8v 169.505n 1.8v 179.495n 1.8v 179.505n 0.0v 189.495n 0.0v 189.505n 0.0v 199.495n 0.0v 199.505n 0.0v 209.495n 0.0v 209.505n 0.0v 219.495n 0.0v 219.505n 0.0v 229.495n 0.0v 229.505n 1.8v 239.495n 1.8v 239.505n 1.8v 249.495n 1.8v 249.505n 1.8v 259.495n 1.8v 259.505n 1.8v 269.495n 1.8v 269.505n 1.8v 279.495n 1.8v 279.505n 1.8v 289.495n 1.8v 289.505n 1.8v 299.495n 1.8v 299.505n 1.8v 309.495n 1.8v 309.505n 1.8v 319.495n 1.8v 319.505n 1.8v 329.495n 1.8v 329.505n 0.0v 339.495n 0.0v 339.505n 0.0v 349.495n 0.0v 349.505n 0.0v 359.495n 0.0v 359.505n 0.0v 369.495n 0.0v 369.505n 0.0v 379.495n 0.0v 379.505n 0.0v 389.495n 0.0v 389.505n 0.0v 399.495n 0.0v 399.505n 0.0v 409.495n 0.0v 409.505n 0.0v 419.495n 0.0v 419.505n 0.0v 429.495n 0.0v 429.505n 0.0v 439.495n 0.0v 439.505n 0.0v 449.495n 0.0v 449.505n 0.0v 459.495n 0.0v 459.505n 0.0v 469.495n 0.0v 469.505n 1.8v 479.495n 1.8v 479.505n 1.8v 489.495n 1.8v 489.505n 1.8v 499.495n 1.8v 499.505n 1.8v 509.495n 1.8v 509.505n 1.8v 519.495n 1.8v 519.505n 1.8v 529.495n 1.8v 529.505n 1.8v 539.495n 1.8v 539.505n 1.8v 549.495n 1.8v 549.505n 1.8v 559.495n 1.8v 559.505n 0.0v 569.495n 0.0v 569.505n 0.0v 579.495n 0.0v 579.505n 0.0v 589.495n 0.0v 589.505n 0.0v 599.495n 0.0v 599.505n 0.0v 609.495n 0.0v 609.505n 0.0v 619.495n 0.0v 619.505n 0.0v 629.495n 0.0v 629.505n 0.0v 639.495n 0.0v 639.505n 1.8v 649.495n 1.8v 649.505n 1.8v 659.495n 1.8v 659.505n 1.8v 669.495n 1.8v 669.505n 1.8v 679.495n 1.8v 679.505n 0.0v 689.495n 0.0v 689.505n 0.0v 699.495n 0.0v 699.505n 1.8v 709.495n 1.8v 709.505n 1.8v 719.495n 1.8v 719.505n 1.8v 729.495n 1.8v 729.505n 1.8v 739.495n 1.8v 739.505n 1.8v 749.495n 1.8v 749.505n 1.8v 759.495n 1.8v 759.505n 1.8v 769.495n 1.8v 769.505n 1.8v 779.495n 1.8v 779.505n 1.8v 789.495n 1.8v 789.505n 1.8v 799.495n 1.8v 799.505n 1.8v 809.495n 1.8v 809.505n 0.0v 819.495n 0.0v 819.505n 0.0v 829.495n 0.0v 829.505n 0.0v 839.495n 0.0v 839.505n 0.0v 849.495n 0.0v 849.505n 0.0v 859.495n 0.0v 859.505n 1.8v 869.495n 1.8v 869.505n 0.0v 879.495n 0.0v 879.505n 0.0v 889.495n 0.0v 889.505n 0.0v 899.495n 0.0v 899.505n 0.0v 909.495n 0.0v 909.505n 0.0v 919.495n 0.0v 919.505n 0.0v 929.495n 0.0v 929.505n 0.0v 939.495n 0.0v 939.505n 0.0v 949.495n 0.0v 949.505n 0.0v 959.495n 0.0v 959.505n 0.0v 969.495n 0.0v 969.505n 0.0v 979.495n 0.0v 979.505n 0.0v 989.495n 0.0v 989.505n 0.0v 999.495n 0.0v 999.505n 0.0v 1009.495n 0.0v 1009.505n 0.0v 1019.495n 0.0v 1019.505n 0.0v 1029.495n 0.0v 1029.505n 0.0v 1039.495n 0.0v 1039.505n 0.0v 1049.495n 0.0v 1049.505n 1.8v 1059.495n 1.8v 1059.505n 0.0v 1069.495n 0.0v 1069.505n 0.0v 1079.495n 0.0v 1079.505n 0.0v 1089.495n 0.0v 1089.505n 0.0v 1099.495n 0.0v 1099.505n 0.0v 1109.495n 0.0v 1109.505n 0.0v 1119.495n 0.0v 1119.505n 0.0v 1129.495n 0.0v 1129.505n 0.0v 1139.495n 0.0v 1139.505n 1.8v 1149.495n 1.8v 1149.505n 1.8v 1159.495n 1.8v 1159.505n 1.8v 1169.495n 1.8v 1169.505n 1.8v 1179.495n 1.8v 1179.505n 1.8v 1189.495n 1.8v 1189.505n 1.8v 1199.495n 1.8v 1199.505n 1.8v 1209.495n 1.8v 1209.505n 1.8v 1219.495n 1.8v 1219.505n 1.8v 1229.495n 1.8v 1229.505n 1.8v 1239.495n 1.8v 1239.505n 1.8v 1249.495n 1.8v 1249.505n 1.8v 1259.495n 1.8v 1259.505n 0.0v 1269.495n 0.0v 1269.505n 0.0v 1279.495n 0.0v 1279.505n 0.0v 1289.495n 0.0v 1289.505n 0.0v 1299.495n 0.0v 1299.505n 0.0v 1309.495n 0.0v 1309.505n 0.0v 1319.495n 0.0v 1319.505n 0.0v 1329.495n 0.0v 1329.505n 1.8v 1339.495n 1.8v 1339.505n 1.8v 1349.495n 1.8v 1349.505n 1.8v 1359.495n 1.8v 1359.505n 1.8v 1369.495n 1.8v 1369.505n 1.8v 1379.495n 1.8v 1379.505n 1.8v 1389.495n 1.8v 1389.505n 1.8v 1399.495n 1.8v 1399.505n 0.0v 1409.495n 0.0v 1409.505n 0.0v 1419.495n 0.0v 1419.505n 1.8v 1429.495n 1.8v 1429.505n 1.8v 1439.495n 1.8v 1439.505n 1.8v 1449.495n 1.8v 1449.505n 1.8v 1459.495n 1.8v 1459.505n 1.8v 1469.495n 1.8v 1469.505n 1.8v 1479.495n 1.8v 1479.505n 1.8v 1489.495n 1.8v 1489.505n 1.8v 1499.495n 1.8v 1499.505n 1.8v 1509.495n 1.8v 1509.505n 1.8v 1519.495n 1.8v 1519.505n 1.8v 1529.495n 1.8v 1529.505n 1.8v 1539.495n 1.8v 1539.505n 1.8v 1549.495n 1.8v 1549.505n 0.0v 1559.495n 0.0v 1559.505n 0.0v 1569.495n 0.0v 1569.505n 1.8v 1579.495n 1.8v 1579.505n 1.8v 1589.495n 1.8v 1589.505n 1.8v 1599.495n 1.8v 1599.505n 1.8v 1609.495n 1.8v 1609.505n 1.8v 1619.495n 1.8v 1619.505n 1.8v 1629.495n 1.8v 1629.505n 1.8v 1639.495n 1.8v 1639.505n 1.8v 1649.495n 1.8v 1649.505n 1.8v 1659.495n 1.8v 1659.505n 1.8v 1669.495n 1.8v 1669.505n 1.8v 1679.495n 1.8v 1679.505n 1.8v 1689.495n 1.8v 1689.505n 1.8v 1699.495n 1.8v 1699.505n 1.8v 1709.495n 1.8v 1709.505n 1.8v 1719.495n 1.8v 1719.505n 1.8v 1729.495n 1.8v 1729.505n 1.8v 1739.495n 1.8v 1739.505n 1.8v 1749.495n 1.8v 1749.505n 1.8v 1759.495n 1.8v 1759.505n 1.8v 1769.495n 1.8v 1769.505n 1.8v 1779.495n 1.8v 1779.505n 1.8v 1789.495n 1.8v 1789.505n 1.8v 1799.495n 1.8v 1799.505n 1.8v 1809.495n 1.8v 1809.505n 1.8v 1819.495n 1.8v 1819.505n 1.8v 1829.495n 1.8v 1829.505n 1.8v 1839.495n 1.8v 1839.505n 1.8v 1849.495n 1.8v 1849.505n 1.8v 1859.495n 1.8v 1859.505n 1.8v 1869.495n 1.8v 1869.505n 1.8v 1879.495n 1.8v 1879.505n 1.8v 1889.495n 1.8v 1889.505n 1.8v 1899.495n 1.8v 1899.505n 1.8v 1909.495n 1.8v 1909.505n 1.8v 1919.495n 1.8v 1919.505n 1.8v 1929.495n 1.8v 1929.505n 1.8v 1939.495n 1.8v 1939.505n 1.8v 1949.495n 1.8v 1949.505n 1.8v 1959.495n 1.8v 1959.505n 1.8v 1969.495n 1.8v 1969.505n 1.8v 1979.495n 1.8v 1979.505n 1.8v 1989.495n 1.8v 1989.505n 1.8v 1999.495n 1.8v 1999.505n 1.8v 2009.495n 1.8v 2009.505n 1.8v 2019.495n 1.8v 2019.505n 1.8v 2029.495n 1.8v 2029.505n 1.8v 2039.495n 1.8v 2039.505n 1.8v 2049.495n 1.8v 2049.505n 1.8v )
* (time, data): [(0, 0), (10, 1), (20, 0), (30, 1), (40, 1), (50, 1), (60, 1), (70, 1), (80, 1), (90, 1), (100, 0), (110, 0), (120, 0), (130, 0), (140, 0), (150, 0), (160, 0), (170, 0), (180, 0), (190, 0), (200, 0), (210, 0), (220, 0), (230, 1), (240, 0), (250, 0), (260, 0), (270, 0), (280, 0), (290, 1), (300, 0), (310, 0), (320, 0), (330, 1), (340, 1), (350, 1), (360, 1), (370, 0), (380, 0), (390, 0), (400, 0), (410, 0), (420, 0), (430, 0), (440, 0), (450, 0), (460, 1), (470, 1), (480, 1), (490, 1), (500, 1), (510, 1), (520, 1), (530, 1), (540, 1), (550, 1), (560, 0), (570, 0), (580, 0), (590, 0), (600, 0), (610, 0), (620, 0), (630, 0), (640, 1), (650, 1), (660, 0), (670, 0), (680, 1), (690, 1), (700, 0), (710, 0), (720, 0), (730, 0), (740, 1), (750, 1), (760, 0), (770, 0), (780, 0), (790, 0), (800, 0), (810, 0), (820, 0), (830, 0), (840, 0), (850, 0), (860, 1), (870, 0), (880, 0), (890, 0), (900, 0), (910, 0), (920, 0), (930, 0), (940, 0), (950, 0), (960, 0), (970, 0), (980, 0), (990, 0), (1000, 0), (1010, 0), (1020, 0), (1030, 0), (1040, 0), (1050, 1), (1060, 1), (1070, 1), (1080, 1), (1090, 1), (1100, 1), (1110, 1), (1120, 1), (1130, 1), (1140, 0), (1150, 0), (1160, 0), (1170, 0), (1180, 0), (1190, 0), (1200, 0), (1210, 0), (1220, 0), (1230, 0), (1240, 0), (1250, 1), (1260, 1), (1270, 1), (1280, 1), (1290, 1), (1300, 1), (1310, 1), (1320, 1), (1330, 0), (1340, 0), (1350, 0), (1360, 0), (1370, 0), (1380, 0), (1390, 0), (1400, 0), (1410, 0), (1420, 0), (1430, 1), (1440, 1), (1450, 1), (1460, 1), (1470, 1), (1480, 1), (1490, 0), (1500, 0), (1510, 0), (1520, 0), (1530, 0), (1540, 0), (1550, 1), (1560, 1), (1570, 0), (1580, 0), (1590, 0), (1600, 0), (1610, 0), (1620, 0), (1630, 0), (1640, 0), (1650, 0), (1660, 0), (1670, 0), (1680, 0), (1690, 0), (1700, 0), (1710, 0), (1720, 0), (1730, 0), (1740, 0), (1750, 0), (1760, 0), (1770, 0), (1780, 0), (1790, 0), (1800, 0), (1810, 0), (1820, 0), (1830, 0), (1840, 0), (1850, 1), (1860, 1), (1870, 1), (1880, 1), (1890, 1), (1900, 1), (1910, 1), (1920, 1), (1930, 1), (1940, 1), (1950, 1), (1960, 1), (1970, 1), (1980, 1), (1990, 1), (2000, 1), (2010, 1), (2020, 1), (2030, 1), (2040, 1), (2050, 1)]
Vdin0_26  din0_26  0 PWL (0n 0.0v 9.495n 0.0v 9.505n 1.8v 19.495n 1.8v 19.505n 0.0v 29.495n 0.0v 29.505n 1.8v 39.495n 1.8v 39.505n 1.8v 49.495n 1.8v 49.505n 1.8v 59.495n 1.8v 59.505n 1.8v 69.495n 1.8v 69.505n 1.8v 79.495n 1.8v 79.505n 1.8v 89.495n 1.8v 89.505n 1.8v 99.495n 1.8v 99.505n 0.0v 109.495n 0.0v 109.505n 0.0v 119.495n 0.0v 119.505n 0.0v 129.495n 0.0v 129.505n 0.0v 139.495n 0.0v 139.505n 0.0v 149.495n 0.0v 149.505n 0.0v 159.495n 0.0v 159.505n 0.0v 169.495n 0.0v 169.505n 0.0v 179.495n 0.0v 179.505n 0.0v 189.495n 0.0v 189.505n 0.0v 199.495n 0.0v 199.505n 0.0v 209.495n 0.0v 209.505n 0.0v 219.495n 0.0v 219.505n 0.0v 229.495n 0.0v 229.505n 1.8v 239.495n 1.8v 239.505n 0.0v 249.495n 0.0v 249.505n 0.0v 259.495n 0.0v 259.505n 0.0v 269.495n 0.0v 269.505n 0.0v 279.495n 0.0v 279.505n 0.0v 289.495n 0.0v 289.505n 1.8v 299.495n 1.8v 299.505n 0.0v 309.495n 0.0v 309.505n 0.0v 319.495n 0.0v 319.505n 0.0v 329.495n 0.0v 329.505n 1.8v 339.495n 1.8v 339.505n 1.8v 349.495n 1.8v 349.505n 1.8v 359.495n 1.8v 359.505n 1.8v 369.495n 1.8v 369.505n 0.0v 379.495n 0.0v 379.505n 0.0v 389.495n 0.0v 389.505n 0.0v 399.495n 0.0v 399.505n 0.0v 409.495n 0.0v 409.505n 0.0v 419.495n 0.0v 419.505n 0.0v 429.495n 0.0v 429.505n 0.0v 439.495n 0.0v 439.505n 0.0v 449.495n 0.0v 449.505n 0.0v 459.495n 0.0v 459.505n 1.8v 469.495n 1.8v 469.505n 1.8v 479.495n 1.8v 479.505n 1.8v 489.495n 1.8v 489.505n 1.8v 499.495n 1.8v 499.505n 1.8v 509.495n 1.8v 509.505n 1.8v 519.495n 1.8v 519.505n 1.8v 529.495n 1.8v 529.505n 1.8v 539.495n 1.8v 539.505n 1.8v 549.495n 1.8v 549.505n 1.8v 559.495n 1.8v 559.505n 0.0v 569.495n 0.0v 569.505n 0.0v 579.495n 0.0v 579.505n 0.0v 589.495n 0.0v 589.505n 0.0v 599.495n 0.0v 599.505n 0.0v 609.495n 0.0v 609.505n 0.0v 619.495n 0.0v 619.505n 0.0v 629.495n 0.0v 629.505n 0.0v 639.495n 0.0v 639.505n 1.8v 649.495n 1.8v 649.505n 1.8v 659.495n 1.8v 659.505n 0.0v 669.495n 0.0v 669.505n 0.0v 679.495n 0.0v 679.505n 1.8v 689.495n 1.8v 689.505n 1.8v 699.495n 1.8v 699.505n 0.0v 709.495n 0.0v 709.505n 0.0v 719.495n 0.0v 719.505n 0.0v 729.495n 0.0v 729.505n 0.0v 739.495n 0.0v 739.505n 1.8v 749.495n 1.8v 749.505n 1.8v 759.495n 1.8v 759.505n 0.0v 769.495n 0.0v 769.505n 0.0v 779.495n 0.0v 779.505n 0.0v 789.495n 0.0v 789.505n 0.0v 799.495n 0.0v 799.505n 0.0v 809.495n 0.0v 809.505n 0.0v 819.495n 0.0v 819.505n 0.0v 829.495n 0.0v 829.505n 0.0v 839.495n 0.0v 839.505n 0.0v 849.495n 0.0v 849.505n 0.0v 859.495n 0.0v 859.505n 1.8v 869.495n 1.8v 869.505n 0.0v 879.495n 0.0v 879.505n 0.0v 889.495n 0.0v 889.505n 0.0v 899.495n 0.0v 899.505n 0.0v 909.495n 0.0v 909.505n 0.0v 919.495n 0.0v 919.505n 0.0v 929.495n 0.0v 929.505n 0.0v 939.495n 0.0v 939.505n 0.0v 949.495n 0.0v 949.505n 0.0v 959.495n 0.0v 959.505n 0.0v 969.495n 0.0v 969.505n 0.0v 979.495n 0.0v 979.505n 0.0v 989.495n 0.0v 989.505n 0.0v 999.495n 0.0v 999.505n 0.0v 1009.495n 0.0v 1009.505n 0.0v 1019.495n 0.0v 1019.505n 0.0v 1029.495n 0.0v 1029.505n 0.0v 1039.495n 0.0v 1039.505n 0.0v 1049.495n 0.0v 1049.505n 1.8v 1059.495n 1.8v 1059.505n 1.8v 1069.495n 1.8v 1069.505n 1.8v 1079.495n 1.8v 1079.505n 1.8v 1089.495n 1.8v 1089.505n 1.8v 1099.495n 1.8v 1099.505n 1.8v 1109.495n 1.8v 1109.505n 1.8v 1119.495n 1.8v 1119.505n 1.8v 1129.495n 1.8v 1129.505n 1.8v 1139.495n 1.8v 1139.505n 0.0v 1149.495n 0.0v 1149.505n 0.0v 1159.495n 0.0v 1159.505n 0.0v 1169.495n 0.0v 1169.505n 0.0v 1179.495n 0.0v 1179.505n 0.0v 1189.495n 0.0v 1189.505n 0.0v 1199.495n 0.0v 1199.505n 0.0v 1209.495n 0.0v 1209.505n 0.0v 1219.495n 0.0v 1219.505n 0.0v 1229.495n 0.0v 1229.505n 0.0v 1239.495n 0.0v 1239.505n 0.0v 1249.495n 0.0v 1249.505n 1.8v 1259.495n 1.8v 1259.505n 1.8v 1269.495n 1.8v 1269.505n 1.8v 1279.495n 1.8v 1279.505n 1.8v 1289.495n 1.8v 1289.505n 1.8v 1299.495n 1.8v 1299.505n 1.8v 1309.495n 1.8v 1309.505n 1.8v 1319.495n 1.8v 1319.505n 1.8v 1329.495n 1.8v 1329.505n 0.0v 1339.495n 0.0v 1339.505n 0.0v 1349.495n 0.0v 1349.505n 0.0v 1359.495n 0.0v 1359.505n 0.0v 1369.495n 0.0v 1369.505n 0.0v 1379.495n 0.0v 1379.505n 0.0v 1389.495n 0.0v 1389.505n 0.0v 1399.495n 0.0v 1399.505n 0.0v 1409.495n 0.0v 1409.505n 0.0v 1419.495n 0.0v 1419.505n 0.0v 1429.495n 0.0v 1429.505n 1.8v 1439.495n 1.8v 1439.505n 1.8v 1449.495n 1.8v 1449.505n 1.8v 1459.495n 1.8v 1459.505n 1.8v 1469.495n 1.8v 1469.505n 1.8v 1479.495n 1.8v 1479.505n 1.8v 1489.495n 1.8v 1489.505n 0.0v 1499.495n 0.0v 1499.505n 0.0v 1509.495n 0.0v 1509.505n 0.0v 1519.495n 0.0v 1519.505n 0.0v 1529.495n 0.0v 1529.505n 0.0v 1539.495n 0.0v 1539.505n 0.0v 1549.495n 0.0v 1549.505n 1.8v 1559.495n 1.8v 1559.505n 1.8v 1569.495n 1.8v 1569.505n 0.0v 1579.495n 0.0v 1579.505n 0.0v 1589.495n 0.0v 1589.505n 0.0v 1599.495n 0.0v 1599.505n 0.0v 1609.495n 0.0v 1609.505n 0.0v 1619.495n 0.0v 1619.505n 0.0v 1629.495n 0.0v 1629.505n 0.0v 1639.495n 0.0v 1639.505n 0.0v 1649.495n 0.0v 1649.505n 0.0v 1659.495n 0.0v 1659.505n 0.0v 1669.495n 0.0v 1669.505n 0.0v 1679.495n 0.0v 1679.505n 0.0v 1689.495n 0.0v 1689.505n 0.0v 1699.495n 0.0v 1699.505n 0.0v 1709.495n 0.0v 1709.505n 0.0v 1719.495n 0.0v 1719.505n 0.0v 1729.495n 0.0v 1729.505n 0.0v 1739.495n 0.0v 1739.505n 0.0v 1749.495n 0.0v 1749.505n 0.0v 1759.495n 0.0v 1759.505n 0.0v 1769.495n 0.0v 1769.505n 0.0v 1779.495n 0.0v 1779.505n 0.0v 1789.495n 0.0v 1789.505n 0.0v 1799.495n 0.0v 1799.505n 0.0v 1809.495n 0.0v 1809.505n 0.0v 1819.495n 0.0v 1819.505n 0.0v 1829.495n 0.0v 1829.505n 0.0v 1839.495n 0.0v 1839.505n 0.0v 1849.495n 0.0v 1849.505n 1.8v 1859.495n 1.8v 1859.505n 1.8v 1869.495n 1.8v 1869.505n 1.8v 1879.495n 1.8v 1879.505n 1.8v 1889.495n 1.8v 1889.505n 1.8v 1899.495n 1.8v 1899.505n 1.8v 1909.495n 1.8v 1909.505n 1.8v 1919.495n 1.8v 1919.505n 1.8v 1929.495n 1.8v 1929.505n 1.8v 1939.495n 1.8v 1939.505n 1.8v 1949.495n 1.8v 1949.505n 1.8v 1959.495n 1.8v 1959.505n 1.8v 1969.495n 1.8v 1969.505n 1.8v 1979.495n 1.8v 1979.505n 1.8v 1989.495n 1.8v 1989.505n 1.8v 1999.495n 1.8v 1999.505n 1.8v 2009.495n 1.8v 2009.505n 1.8v 2019.495n 1.8v 2019.505n 1.8v 2029.495n 1.8v 2029.505n 1.8v 2039.495n 1.8v 2039.505n 1.8v 2049.495n 1.8v 2049.505n 1.8v )
* (time, data): [(0, 0), (10, 1), (20, 0), (30, 0), (40, 0), (50, 0), (60, 0), (70, 0), (80, 0), (90, 1), (100, 1), (110, 1), (120, 0), (130, 0), (140, 0), (150, 0), (160, 0), (170, 0), (180, 0), (190, 0), (200, 0), (210, 0), (220, 0), (230, 0), (240, 0), (250, 0), (260, 0), (270, 0), (280, 0), (290, 0), (300, 0), (310, 0), (320, 0), (330, 1), (340, 1), (350, 1), (360, 1), (370, 0), (380, 0), (390, 0), (400, 0), (410, 0), (420, 0), (430, 0), (440, 0), (450, 0), (460, 1), (470, 1), (480, 1), (490, 1), (500, 1), (510, 1), (520, 1), (530, 1), (540, 1), (550, 1), (560, 1), (570, 1), (580, 1), (590, 1), (600, 1), (610, 1), (620, 1), (630, 1), (640, 1), (650, 1), (660, 1), (670, 1), (680, 1), (690, 1), (700, 1), (710, 1), (720, 1), (730, 1), (740, 1), (750, 1), (760, 0), (770, 0), (780, 0), (790, 0), (800, 0), (810, 1), (820, 1), (830, 1), (840, 1), (850, 1), (860, 1), (870, 1), (880, 1), (890, 1), (900, 1), (910, 1), (920, 1), (930, 0), (940, 0), (950, 0), (960, 1), (970, 1), (980, 1), (990, 1), (1000, 1), (1010, 1), (1020, 1), (1030, 1), (1040, 1), (1050, 0), (1060, 1), (1070, 1), (1080, 1), (1090, 0), (1100, 0), (1110, 0), (1120, 0), (1130, 0), (1140, 0), (1150, 0), (1160, 1), (1170, 1), (1180, 1), (1190, 1), (1200, 1), (1210, 1), (1220, 1), (1230, 1), (1240, 1), (1250, 0), (1260, 0), (1270, 0), (1280, 0), (1290, 0), (1300, 0), (1310, 0), (1320, 0), (1330, 1), (1340, 1), (1350, 1), (1360, 1), (1370, 0), (1380, 0), (1390, 0), (1400, 0), (1410, 0), (1420, 1), (1430, 0), (1440, 0), (1450, 0), (1460, 0), (1470, 0), (1480, 0), (1490, 0), (1500, 0), (1510, 0), (1520, 0), (1530, 0), (1540, 0), (1550, 1), (1560, 1), (1570, 1), (1580, 1), (1590, 1), (1600, 1), (1610, 1), (1620, 1), (1630, 1), (1640, 1), (1650, 1), (1660, 1), (1670, 1), (1680, 1), (1690, 1), (1700, 1), (1710, 1), (1720, 1), (1730, 1), (1740, 1), (1750, 1), (1760, 0), (1770, 0), (1780, 0), (1790, 0), (1800, 0), (1810, 0), (1820, 0), (1830, 0), (1840, 0), (1850, 1), (1860, 1), (1870, 1), (1880, 1), (1890, 1), (1900, 1), (1910, 0), (1920, 0), (1930, 0), (1940, 0), (1950, 0), (1960, 0), (1970, 0), (1980, 0), (1990, 0), (2000, 0), (2010, 0), (2020, 0), (2030, 0), (2040, 0), (2050, 0)]
Vdin0_27  din0_27  0 PWL (0n 0.0v 9.495n 0.0v 9.505n 1.8v 19.495n 1.8v 19.505n 0.0v 29.495n 0.0v 29.505n 0.0v 39.495n 0.0v 39.505n 0.0v 49.495n 0.0v 49.505n 0.0v 59.495n 0.0v 59.505n 0.0v 69.495n 0.0v 69.505n 0.0v 79.495n 0.0v 79.505n 0.0v 89.495n 0.0v 89.505n 1.8v 99.495n 1.8v 99.505n 1.8v 109.495n 1.8v 109.505n 1.8v 119.495n 1.8v 119.505n 0.0v 129.495n 0.0v 129.505n 0.0v 139.495n 0.0v 139.505n 0.0v 149.495n 0.0v 149.505n 0.0v 159.495n 0.0v 159.505n 0.0v 169.495n 0.0v 169.505n 0.0v 179.495n 0.0v 179.505n 0.0v 189.495n 0.0v 189.505n 0.0v 199.495n 0.0v 199.505n 0.0v 209.495n 0.0v 209.505n 0.0v 219.495n 0.0v 219.505n 0.0v 229.495n 0.0v 229.505n 0.0v 239.495n 0.0v 239.505n 0.0v 249.495n 0.0v 249.505n 0.0v 259.495n 0.0v 259.505n 0.0v 269.495n 0.0v 269.505n 0.0v 279.495n 0.0v 279.505n 0.0v 289.495n 0.0v 289.505n 0.0v 299.495n 0.0v 299.505n 0.0v 309.495n 0.0v 309.505n 0.0v 319.495n 0.0v 319.505n 0.0v 329.495n 0.0v 329.505n 1.8v 339.495n 1.8v 339.505n 1.8v 349.495n 1.8v 349.505n 1.8v 359.495n 1.8v 359.505n 1.8v 369.495n 1.8v 369.505n 0.0v 379.495n 0.0v 379.505n 0.0v 389.495n 0.0v 389.505n 0.0v 399.495n 0.0v 399.505n 0.0v 409.495n 0.0v 409.505n 0.0v 419.495n 0.0v 419.505n 0.0v 429.495n 0.0v 429.505n 0.0v 439.495n 0.0v 439.505n 0.0v 449.495n 0.0v 449.505n 0.0v 459.495n 0.0v 459.505n 1.8v 469.495n 1.8v 469.505n 1.8v 479.495n 1.8v 479.505n 1.8v 489.495n 1.8v 489.505n 1.8v 499.495n 1.8v 499.505n 1.8v 509.495n 1.8v 509.505n 1.8v 519.495n 1.8v 519.505n 1.8v 529.495n 1.8v 529.505n 1.8v 539.495n 1.8v 539.505n 1.8v 549.495n 1.8v 549.505n 1.8v 559.495n 1.8v 559.505n 1.8v 569.495n 1.8v 569.505n 1.8v 579.495n 1.8v 579.505n 1.8v 589.495n 1.8v 589.505n 1.8v 599.495n 1.8v 599.505n 1.8v 609.495n 1.8v 609.505n 1.8v 619.495n 1.8v 619.505n 1.8v 629.495n 1.8v 629.505n 1.8v 639.495n 1.8v 639.505n 1.8v 649.495n 1.8v 649.505n 1.8v 659.495n 1.8v 659.505n 1.8v 669.495n 1.8v 669.505n 1.8v 679.495n 1.8v 679.505n 1.8v 689.495n 1.8v 689.505n 1.8v 699.495n 1.8v 699.505n 1.8v 709.495n 1.8v 709.505n 1.8v 719.495n 1.8v 719.505n 1.8v 729.495n 1.8v 729.505n 1.8v 739.495n 1.8v 739.505n 1.8v 749.495n 1.8v 749.505n 1.8v 759.495n 1.8v 759.505n 0.0v 769.495n 0.0v 769.505n 0.0v 779.495n 0.0v 779.505n 0.0v 789.495n 0.0v 789.505n 0.0v 799.495n 0.0v 799.505n 0.0v 809.495n 0.0v 809.505n 1.8v 819.495n 1.8v 819.505n 1.8v 829.495n 1.8v 829.505n 1.8v 839.495n 1.8v 839.505n 1.8v 849.495n 1.8v 849.505n 1.8v 859.495n 1.8v 859.505n 1.8v 869.495n 1.8v 869.505n 1.8v 879.495n 1.8v 879.505n 1.8v 889.495n 1.8v 889.505n 1.8v 899.495n 1.8v 899.505n 1.8v 909.495n 1.8v 909.505n 1.8v 919.495n 1.8v 919.505n 1.8v 929.495n 1.8v 929.505n 0.0v 939.495n 0.0v 939.505n 0.0v 949.495n 0.0v 949.505n 0.0v 959.495n 0.0v 959.505n 1.8v 969.495n 1.8v 969.505n 1.8v 979.495n 1.8v 979.505n 1.8v 989.495n 1.8v 989.505n 1.8v 999.495n 1.8v 999.505n 1.8v 1009.495n 1.8v 1009.505n 1.8v 1019.495n 1.8v 1019.505n 1.8v 1029.495n 1.8v 1029.505n 1.8v 1039.495n 1.8v 1039.505n 1.8v 1049.495n 1.8v 1049.505n 0.0v 1059.495n 0.0v 1059.505n 1.8v 1069.495n 1.8v 1069.505n 1.8v 1079.495n 1.8v 1079.505n 1.8v 1089.495n 1.8v 1089.505n 0.0v 1099.495n 0.0v 1099.505n 0.0v 1109.495n 0.0v 1109.505n 0.0v 1119.495n 0.0v 1119.505n 0.0v 1129.495n 0.0v 1129.505n 0.0v 1139.495n 0.0v 1139.505n 0.0v 1149.495n 0.0v 1149.505n 0.0v 1159.495n 0.0v 1159.505n 1.8v 1169.495n 1.8v 1169.505n 1.8v 1179.495n 1.8v 1179.505n 1.8v 1189.495n 1.8v 1189.505n 1.8v 1199.495n 1.8v 1199.505n 1.8v 1209.495n 1.8v 1209.505n 1.8v 1219.495n 1.8v 1219.505n 1.8v 1229.495n 1.8v 1229.505n 1.8v 1239.495n 1.8v 1239.505n 1.8v 1249.495n 1.8v 1249.505n 0.0v 1259.495n 0.0v 1259.505n 0.0v 1269.495n 0.0v 1269.505n 0.0v 1279.495n 0.0v 1279.505n 0.0v 1289.495n 0.0v 1289.505n 0.0v 1299.495n 0.0v 1299.505n 0.0v 1309.495n 0.0v 1309.505n 0.0v 1319.495n 0.0v 1319.505n 0.0v 1329.495n 0.0v 1329.505n 1.8v 1339.495n 1.8v 1339.505n 1.8v 1349.495n 1.8v 1349.505n 1.8v 1359.495n 1.8v 1359.505n 1.8v 1369.495n 1.8v 1369.505n 0.0v 1379.495n 0.0v 1379.505n 0.0v 1389.495n 0.0v 1389.505n 0.0v 1399.495n 0.0v 1399.505n 0.0v 1409.495n 0.0v 1409.505n 0.0v 1419.495n 0.0v 1419.505n 1.8v 1429.495n 1.8v 1429.505n 0.0v 1439.495n 0.0v 1439.505n 0.0v 1449.495n 0.0v 1449.505n 0.0v 1459.495n 0.0v 1459.505n 0.0v 1469.495n 0.0v 1469.505n 0.0v 1479.495n 0.0v 1479.505n 0.0v 1489.495n 0.0v 1489.505n 0.0v 1499.495n 0.0v 1499.505n 0.0v 1509.495n 0.0v 1509.505n 0.0v 1519.495n 0.0v 1519.505n 0.0v 1529.495n 0.0v 1529.505n 0.0v 1539.495n 0.0v 1539.505n 0.0v 1549.495n 0.0v 1549.505n 1.8v 1559.495n 1.8v 1559.505n 1.8v 1569.495n 1.8v 1569.505n 1.8v 1579.495n 1.8v 1579.505n 1.8v 1589.495n 1.8v 1589.505n 1.8v 1599.495n 1.8v 1599.505n 1.8v 1609.495n 1.8v 1609.505n 1.8v 1619.495n 1.8v 1619.505n 1.8v 1629.495n 1.8v 1629.505n 1.8v 1639.495n 1.8v 1639.505n 1.8v 1649.495n 1.8v 1649.505n 1.8v 1659.495n 1.8v 1659.505n 1.8v 1669.495n 1.8v 1669.505n 1.8v 1679.495n 1.8v 1679.505n 1.8v 1689.495n 1.8v 1689.505n 1.8v 1699.495n 1.8v 1699.505n 1.8v 1709.495n 1.8v 1709.505n 1.8v 1719.495n 1.8v 1719.505n 1.8v 1729.495n 1.8v 1729.505n 1.8v 1739.495n 1.8v 1739.505n 1.8v 1749.495n 1.8v 1749.505n 1.8v 1759.495n 1.8v 1759.505n 0.0v 1769.495n 0.0v 1769.505n 0.0v 1779.495n 0.0v 1779.505n 0.0v 1789.495n 0.0v 1789.505n 0.0v 1799.495n 0.0v 1799.505n 0.0v 1809.495n 0.0v 1809.505n 0.0v 1819.495n 0.0v 1819.505n 0.0v 1829.495n 0.0v 1829.505n 0.0v 1839.495n 0.0v 1839.505n 0.0v 1849.495n 0.0v 1849.505n 1.8v 1859.495n 1.8v 1859.505n 1.8v 1869.495n 1.8v 1869.505n 1.8v 1879.495n 1.8v 1879.505n 1.8v 1889.495n 1.8v 1889.505n 1.8v 1899.495n 1.8v 1899.505n 1.8v 1909.495n 1.8v 1909.505n 0.0v 1919.495n 0.0v 1919.505n 0.0v 1929.495n 0.0v 1929.505n 0.0v 1939.495n 0.0v 1939.505n 0.0v 1949.495n 0.0v 1949.505n 0.0v 1959.495n 0.0v 1959.505n 0.0v 1969.495n 0.0v 1969.505n 0.0v 1979.495n 0.0v 1979.505n 0.0v 1989.495n 0.0v 1989.505n 0.0v 1999.495n 0.0v 1999.505n 0.0v 2009.495n 0.0v 2009.505n 0.0v 2019.495n 0.0v 2019.505n 0.0v 2029.495n 0.0v 2029.505n 0.0v 2039.495n 0.0v 2039.505n 0.0v 2049.495n 0.0v 2049.505n 0.0v )
* (time, data): [(0, 0), (10, 0), (20, 1), (30, 1), (40, 1), (50, 1), (60, 1), (70, 1), (80, 1), (90, 1), (100, 0), (110, 0), (120, 1), (130, 1), (140, 1), (150, 1), (160, 1), (170, 1), (180, 0), (190, 0), (200, 0), (210, 0), (220, 0), (230, 0), (240, 1), (250, 1), (260, 1), (270, 1), (280, 1), (290, 0), (300, 1), (310, 1), (320, 1), (330, 1), (340, 1), (350, 1), (360, 1), (370, 1), (380, 1), (390, 1), (400, 1), (410, 1), (420, 1), (430, 1), (440, 1), (450, 1), (460, 1), (470, 0), (480, 0), (490, 0), (500, 0), (510, 0), (520, 0), (530, 0), (540, 0), (550, 0), (560, 1), (570, 1), (580, 1), (590, 1), (600, 1), (610, 1), (620, 1), (630, 1), (640, 0), (650, 0), (660, 0), (670, 0), (680, 1), (690, 1), (700, 1), (710, 1), (720, 1), (730, 1), (740, 1), (750, 1), (760, 1), (770, 1), (780, 1), (790, 1), (800, 1), (810, 1), (820, 1), (830, 1), (840, 1), (850, 1), (860, 1), (870, 1), (880, 1), (890, 1), (900, 1), (910, 1), (920, 1), (930, 0), (940, 1), (950, 1), (960, 0), (970, 0), (980, 0), (990, 0), (1000, 0), (1010, 0), (1020, 0), (1030, 0), (1040, 0), (1050, 1), (1060, 1), (1070, 1), (1080, 1), (1090, 1), (1100, 1), (1110, 1), (1120, 1), (1130, 1), (1140, 1), (1150, 1), (1160, 1), (1170, 1), (1180, 1), (1190, 1), (1200, 1), (1210, 1), (1220, 1), (1230, 1), (1240, 1), (1250, 0), (1260, 1), (1270, 1), (1280, 0), (1290, 0), (1300, 0), (1310, 0), (1320, 0), (1330, 0), (1340, 0), (1350, 0), (1360, 0), (1370, 1), (1380, 1), (1390, 1), (1400, 0), (1410, 0), (1420, 0), (1430, 0), (1440, 0), (1450, 0), (1460, 0), (1470, 0), (1480, 0), (1490, 0), (1500, 0), (1510, 0), (1520, 0), (1530, 0), (1540, 0), (1550, 0), (1560, 0), (1570, 0), (1580, 0), (1590, 0), (1600, 0), (1610, 0), (1620, 0), (1630, 0), (1640, 0), (1650, 1), (1660, 1), (1670, 1), (1680, 1), (1690, 1), (1700, 1), (1710, 1), (1720, 1), (1730, 1), (1740, 1), (1750, 1), (1760, 1), (1770, 1), (1780, 1), (1790, 1), (1800, 1), (1810, 1), (1820, 0), (1830, 0), (1840, 0), (1850, 0), (1860, 0), (1870, 0), (1880, 0), (1890, 0), (1900, 0), (1910, 0), (1920, 0), (1930, 0), (1940, 0), (1950, 0), (1960, 0), (1970, 0), (1980, 0), (1990, 0), (2000, 0), (2010, 0), (2020, 0), (2030, 0), (2040, 0), (2050, 0)]
Vdin0_28  din0_28  0 PWL (0n 0.0v 9.495n 0.0v 9.505n 0.0v 19.495n 0.0v 19.505n 1.8v 29.495n 1.8v 29.505n 1.8v 39.495n 1.8v 39.505n 1.8v 49.495n 1.8v 49.505n 1.8v 59.495n 1.8v 59.505n 1.8v 69.495n 1.8v 69.505n 1.8v 79.495n 1.8v 79.505n 1.8v 89.495n 1.8v 89.505n 1.8v 99.495n 1.8v 99.505n 0.0v 109.495n 0.0v 109.505n 0.0v 119.495n 0.0v 119.505n 1.8v 129.495n 1.8v 129.505n 1.8v 139.495n 1.8v 139.505n 1.8v 149.495n 1.8v 149.505n 1.8v 159.495n 1.8v 159.505n 1.8v 169.495n 1.8v 169.505n 1.8v 179.495n 1.8v 179.505n 0.0v 189.495n 0.0v 189.505n 0.0v 199.495n 0.0v 199.505n 0.0v 209.495n 0.0v 209.505n 0.0v 219.495n 0.0v 219.505n 0.0v 229.495n 0.0v 229.505n 0.0v 239.495n 0.0v 239.505n 1.8v 249.495n 1.8v 249.505n 1.8v 259.495n 1.8v 259.505n 1.8v 269.495n 1.8v 269.505n 1.8v 279.495n 1.8v 279.505n 1.8v 289.495n 1.8v 289.505n 0.0v 299.495n 0.0v 299.505n 1.8v 309.495n 1.8v 309.505n 1.8v 319.495n 1.8v 319.505n 1.8v 329.495n 1.8v 329.505n 1.8v 339.495n 1.8v 339.505n 1.8v 349.495n 1.8v 349.505n 1.8v 359.495n 1.8v 359.505n 1.8v 369.495n 1.8v 369.505n 1.8v 379.495n 1.8v 379.505n 1.8v 389.495n 1.8v 389.505n 1.8v 399.495n 1.8v 399.505n 1.8v 409.495n 1.8v 409.505n 1.8v 419.495n 1.8v 419.505n 1.8v 429.495n 1.8v 429.505n 1.8v 439.495n 1.8v 439.505n 1.8v 449.495n 1.8v 449.505n 1.8v 459.495n 1.8v 459.505n 1.8v 469.495n 1.8v 469.505n 0.0v 479.495n 0.0v 479.505n 0.0v 489.495n 0.0v 489.505n 0.0v 499.495n 0.0v 499.505n 0.0v 509.495n 0.0v 509.505n 0.0v 519.495n 0.0v 519.505n 0.0v 529.495n 0.0v 529.505n 0.0v 539.495n 0.0v 539.505n 0.0v 549.495n 0.0v 549.505n 0.0v 559.495n 0.0v 559.505n 1.8v 569.495n 1.8v 569.505n 1.8v 579.495n 1.8v 579.505n 1.8v 589.495n 1.8v 589.505n 1.8v 599.495n 1.8v 599.505n 1.8v 609.495n 1.8v 609.505n 1.8v 619.495n 1.8v 619.505n 1.8v 629.495n 1.8v 629.505n 1.8v 639.495n 1.8v 639.505n 0.0v 649.495n 0.0v 649.505n 0.0v 659.495n 0.0v 659.505n 0.0v 669.495n 0.0v 669.505n 0.0v 679.495n 0.0v 679.505n 1.8v 689.495n 1.8v 689.505n 1.8v 699.495n 1.8v 699.505n 1.8v 709.495n 1.8v 709.505n 1.8v 719.495n 1.8v 719.505n 1.8v 729.495n 1.8v 729.505n 1.8v 739.495n 1.8v 739.505n 1.8v 749.495n 1.8v 749.505n 1.8v 759.495n 1.8v 759.505n 1.8v 769.495n 1.8v 769.505n 1.8v 779.495n 1.8v 779.505n 1.8v 789.495n 1.8v 789.505n 1.8v 799.495n 1.8v 799.505n 1.8v 809.495n 1.8v 809.505n 1.8v 819.495n 1.8v 819.505n 1.8v 829.495n 1.8v 829.505n 1.8v 839.495n 1.8v 839.505n 1.8v 849.495n 1.8v 849.505n 1.8v 859.495n 1.8v 859.505n 1.8v 869.495n 1.8v 869.505n 1.8v 879.495n 1.8v 879.505n 1.8v 889.495n 1.8v 889.505n 1.8v 899.495n 1.8v 899.505n 1.8v 909.495n 1.8v 909.505n 1.8v 919.495n 1.8v 919.505n 1.8v 929.495n 1.8v 929.505n 0.0v 939.495n 0.0v 939.505n 1.8v 949.495n 1.8v 949.505n 1.8v 959.495n 1.8v 959.505n 0.0v 969.495n 0.0v 969.505n 0.0v 979.495n 0.0v 979.505n 0.0v 989.495n 0.0v 989.505n 0.0v 999.495n 0.0v 999.505n 0.0v 1009.495n 0.0v 1009.505n 0.0v 1019.495n 0.0v 1019.505n 0.0v 1029.495n 0.0v 1029.505n 0.0v 1039.495n 0.0v 1039.505n 0.0v 1049.495n 0.0v 1049.505n 1.8v 1059.495n 1.8v 1059.505n 1.8v 1069.495n 1.8v 1069.505n 1.8v 1079.495n 1.8v 1079.505n 1.8v 1089.495n 1.8v 1089.505n 1.8v 1099.495n 1.8v 1099.505n 1.8v 1109.495n 1.8v 1109.505n 1.8v 1119.495n 1.8v 1119.505n 1.8v 1129.495n 1.8v 1129.505n 1.8v 1139.495n 1.8v 1139.505n 1.8v 1149.495n 1.8v 1149.505n 1.8v 1159.495n 1.8v 1159.505n 1.8v 1169.495n 1.8v 1169.505n 1.8v 1179.495n 1.8v 1179.505n 1.8v 1189.495n 1.8v 1189.505n 1.8v 1199.495n 1.8v 1199.505n 1.8v 1209.495n 1.8v 1209.505n 1.8v 1219.495n 1.8v 1219.505n 1.8v 1229.495n 1.8v 1229.505n 1.8v 1239.495n 1.8v 1239.505n 1.8v 1249.495n 1.8v 1249.505n 0.0v 1259.495n 0.0v 1259.505n 1.8v 1269.495n 1.8v 1269.505n 1.8v 1279.495n 1.8v 1279.505n 0.0v 1289.495n 0.0v 1289.505n 0.0v 1299.495n 0.0v 1299.505n 0.0v 1309.495n 0.0v 1309.505n 0.0v 1319.495n 0.0v 1319.505n 0.0v 1329.495n 0.0v 1329.505n 0.0v 1339.495n 0.0v 1339.505n 0.0v 1349.495n 0.0v 1349.505n 0.0v 1359.495n 0.0v 1359.505n 0.0v 1369.495n 0.0v 1369.505n 1.8v 1379.495n 1.8v 1379.505n 1.8v 1389.495n 1.8v 1389.505n 1.8v 1399.495n 1.8v 1399.505n 0.0v 1409.495n 0.0v 1409.505n 0.0v 1419.495n 0.0v 1419.505n 0.0v 1429.495n 0.0v 1429.505n 0.0v 1439.495n 0.0v 1439.505n 0.0v 1449.495n 0.0v 1449.505n 0.0v 1459.495n 0.0v 1459.505n 0.0v 1469.495n 0.0v 1469.505n 0.0v 1479.495n 0.0v 1479.505n 0.0v 1489.495n 0.0v 1489.505n 0.0v 1499.495n 0.0v 1499.505n 0.0v 1509.495n 0.0v 1509.505n 0.0v 1519.495n 0.0v 1519.505n 0.0v 1529.495n 0.0v 1529.505n 0.0v 1539.495n 0.0v 1539.505n 0.0v 1549.495n 0.0v 1549.505n 0.0v 1559.495n 0.0v 1559.505n 0.0v 1569.495n 0.0v 1569.505n 0.0v 1579.495n 0.0v 1579.505n 0.0v 1589.495n 0.0v 1589.505n 0.0v 1599.495n 0.0v 1599.505n 0.0v 1609.495n 0.0v 1609.505n 0.0v 1619.495n 0.0v 1619.505n 0.0v 1629.495n 0.0v 1629.505n 0.0v 1639.495n 0.0v 1639.505n 0.0v 1649.495n 0.0v 1649.505n 1.8v 1659.495n 1.8v 1659.505n 1.8v 1669.495n 1.8v 1669.505n 1.8v 1679.495n 1.8v 1679.505n 1.8v 1689.495n 1.8v 1689.505n 1.8v 1699.495n 1.8v 1699.505n 1.8v 1709.495n 1.8v 1709.505n 1.8v 1719.495n 1.8v 1719.505n 1.8v 1729.495n 1.8v 1729.505n 1.8v 1739.495n 1.8v 1739.505n 1.8v 1749.495n 1.8v 1749.505n 1.8v 1759.495n 1.8v 1759.505n 1.8v 1769.495n 1.8v 1769.505n 1.8v 1779.495n 1.8v 1779.505n 1.8v 1789.495n 1.8v 1789.505n 1.8v 1799.495n 1.8v 1799.505n 1.8v 1809.495n 1.8v 1809.505n 1.8v 1819.495n 1.8v 1819.505n 0.0v 1829.495n 0.0v 1829.505n 0.0v 1839.495n 0.0v 1839.505n 0.0v 1849.495n 0.0v 1849.505n 0.0v 1859.495n 0.0v 1859.505n 0.0v 1869.495n 0.0v 1869.505n 0.0v 1879.495n 0.0v 1879.505n 0.0v 1889.495n 0.0v 1889.505n 0.0v 1899.495n 0.0v 1899.505n 0.0v 1909.495n 0.0v 1909.505n 0.0v 1919.495n 0.0v 1919.505n 0.0v 1929.495n 0.0v 1929.505n 0.0v 1939.495n 0.0v 1939.505n 0.0v 1949.495n 0.0v 1949.505n 0.0v 1959.495n 0.0v 1959.505n 0.0v 1969.495n 0.0v 1969.505n 0.0v 1979.495n 0.0v 1979.505n 0.0v 1989.495n 0.0v 1989.505n 0.0v 1999.495n 0.0v 1999.505n 0.0v 2009.495n 0.0v 2009.505n 0.0v 2019.495n 0.0v 2019.505n 0.0v 2029.495n 0.0v 2029.505n 0.0v 2039.495n 0.0v 2039.505n 0.0v 2049.495n 0.0v 2049.505n 0.0v )
* (time, data): [(0, 0), (10, 1), (20, 0), (30, 1), (40, 1), (50, 1), (60, 1), (70, 1), (80, 1), (90, 0), (100, 1), (110, 1), (120, 0), (130, 0), (140, 0), (150, 0), (160, 0), (170, 0), (180, 0), (190, 0), (200, 0), (210, 0), (220, 0), (230, 1), (240, 1), (250, 1), (260, 1), (270, 1), (280, 1), (290, 0), (300, 1), (310, 1), (320, 1), (330, 0), (340, 0), (350, 0), (360, 1), (370, 1), (380, 1), (390, 1), (400, 1), (410, 1), (420, 1), (430, 1), (440, 1), (450, 1), (460, 0), (470, 0), (480, 0), (490, 0), (500, 0), (510, 0), (520, 0), (530, 0), (540, 0), (550, 0), (560, 1), (570, 1), (580, 1), (590, 1), (600, 1), (610, 1), (620, 1), (630, 1), (640, 0), (650, 0), (660, 1), (670, 1), (680, 1), (690, 1), (700, 1), (710, 1), (720, 1), (730, 1), (740, 0), (750, 0), (760, 0), (770, 0), (780, 0), (790, 0), (800, 0), (810, 1), (820, 1), (830, 1), (840, 1), (850, 1), (860, 0), (870, 0), (880, 0), (890, 0), (900, 0), (910, 0), (920, 0), (930, 0), (940, 1), (950, 1), (960, 1), (970, 1), (980, 1), (990, 1), (1000, 1), (1010, 1), (1020, 1), (1030, 1), (1040, 1), (1050, 0), (1060, 1), (1070, 1), (1080, 1), (1090, 1), (1100, 1), (1110, 1), (1120, 1), (1130, 1), (1140, 1), (1150, 1), (1160, 0), (1170, 0), (1180, 0), (1190, 0), (1200, 0), (1210, 0), (1220, 0), (1230, 0), (1240, 0), (1250, 1), (1260, 0), (1270, 0), (1280, 0), (1290, 0), (1300, 0), (1310, 0), (1320, 0), (1330, 1), (1340, 1), (1350, 1), (1360, 1), (1370, 1), (1380, 1), (1390, 1), (1400, 0), (1410, 0), (1420, 1), (1430, 0), (1440, 0), (1450, 0), (1460, 0), (1470, 0), (1480, 0), (1490, 1), (1500, 1), (1510, 1), (1520, 1), (1530, 1), (1540, 1), (1550, 0), (1560, 0), (1570, 0), (1580, 0), (1590, 0), (1600, 0), (1610, 0), (1620, 0), (1630, 0), (1640, 0), (1650, 1), (1660, 1), (1670, 1), (1680, 1), (1690, 1), (1700, 1), (1710, 1), (1720, 1), (1730, 1), (1740, 1), (1750, 1), (1760, 0), (1770, 0), (1780, 0), (1790, 0), (1800, 0), (1810, 0), (1820, 1), (1830, 1), (1840, 1), (1850, 1), (1860, 1), (1870, 1), (1880, 1), (1890, 1), (1900, 1), (1910, 1), (1920, 1), (1930, 1), (1940, 1), (1950, 1), (1960, 1), (1970, 1), (1980, 1), (1990, 1), (2000, 1), (2010, 1), (2020, 1), (2030, 1), (2040, 1), (2050, 1)]
Vdin0_29  din0_29  0 PWL (0n 0.0v 9.495n 0.0v 9.505n 1.8v 19.495n 1.8v 19.505n 0.0v 29.495n 0.0v 29.505n 1.8v 39.495n 1.8v 39.505n 1.8v 49.495n 1.8v 49.505n 1.8v 59.495n 1.8v 59.505n 1.8v 69.495n 1.8v 69.505n 1.8v 79.495n 1.8v 79.505n 1.8v 89.495n 1.8v 89.505n 0.0v 99.495n 0.0v 99.505n 1.8v 109.495n 1.8v 109.505n 1.8v 119.495n 1.8v 119.505n 0.0v 129.495n 0.0v 129.505n 0.0v 139.495n 0.0v 139.505n 0.0v 149.495n 0.0v 149.505n 0.0v 159.495n 0.0v 159.505n 0.0v 169.495n 0.0v 169.505n 0.0v 179.495n 0.0v 179.505n 0.0v 189.495n 0.0v 189.505n 0.0v 199.495n 0.0v 199.505n 0.0v 209.495n 0.0v 209.505n 0.0v 219.495n 0.0v 219.505n 0.0v 229.495n 0.0v 229.505n 1.8v 239.495n 1.8v 239.505n 1.8v 249.495n 1.8v 249.505n 1.8v 259.495n 1.8v 259.505n 1.8v 269.495n 1.8v 269.505n 1.8v 279.495n 1.8v 279.505n 1.8v 289.495n 1.8v 289.505n 0.0v 299.495n 0.0v 299.505n 1.8v 309.495n 1.8v 309.505n 1.8v 319.495n 1.8v 319.505n 1.8v 329.495n 1.8v 329.505n 0.0v 339.495n 0.0v 339.505n 0.0v 349.495n 0.0v 349.505n 0.0v 359.495n 0.0v 359.505n 1.8v 369.495n 1.8v 369.505n 1.8v 379.495n 1.8v 379.505n 1.8v 389.495n 1.8v 389.505n 1.8v 399.495n 1.8v 399.505n 1.8v 409.495n 1.8v 409.505n 1.8v 419.495n 1.8v 419.505n 1.8v 429.495n 1.8v 429.505n 1.8v 439.495n 1.8v 439.505n 1.8v 449.495n 1.8v 449.505n 1.8v 459.495n 1.8v 459.505n 0.0v 469.495n 0.0v 469.505n 0.0v 479.495n 0.0v 479.505n 0.0v 489.495n 0.0v 489.505n 0.0v 499.495n 0.0v 499.505n 0.0v 509.495n 0.0v 509.505n 0.0v 519.495n 0.0v 519.505n 0.0v 529.495n 0.0v 529.505n 0.0v 539.495n 0.0v 539.505n 0.0v 549.495n 0.0v 549.505n 0.0v 559.495n 0.0v 559.505n 1.8v 569.495n 1.8v 569.505n 1.8v 579.495n 1.8v 579.505n 1.8v 589.495n 1.8v 589.505n 1.8v 599.495n 1.8v 599.505n 1.8v 609.495n 1.8v 609.505n 1.8v 619.495n 1.8v 619.505n 1.8v 629.495n 1.8v 629.505n 1.8v 639.495n 1.8v 639.505n 0.0v 649.495n 0.0v 649.505n 0.0v 659.495n 0.0v 659.505n 1.8v 669.495n 1.8v 669.505n 1.8v 679.495n 1.8v 679.505n 1.8v 689.495n 1.8v 689.505n 1.8v 699.495n 1.8v 699.505n 1.8v 709.495n 1.8v 709.505n 1.8v 719.495n 1.8v 719.505n 1.8v 729.495n 1.8v 729.505n 1.8v 739.495n 1.8v 739.505n 0.0v 749.495n 0.0v 749.505n 0.0v 759.495n 0.0v 759.505n 0.0v 769.495n 0.0v 769.505n 0.0v 779.495n 0.0v 779.505n 0.0v 789.495n 0.0v 789.505n 0.0v 799.495n 0.0v 799.505n 0.0v 809.495n 0.0v 809.505n 1.8v 819.495n 1.8v 819.505n 1.8v 829.495n 1.8v 829.505n 1.8v 839.495n 1.8v 839.505n 1.8v 849.495n 1.8v 849.505n 1.8v 859.495n 1.8v 859.505n 0.0v 869.495n 0.0v 869.505n 0.0v 879.495n 0.0v 879.505n 0.0v 889.495n 0.0v 889.505n 0.0v 899.495n 0.0v 899.505n 0.0v 909.495n 0.0v 909.505n 0.0v 919.495n 0.0v 919.505n 0.0v 929.495n 0.0v 929.505n 0.0v 939.495n 0.0v 939.505n 1.8v 949.495n 1.8v 949.505n 1.8v 959.495n 1.8v 959.505n 1.8v 969.495n 1.8v 969.505n 1.8v 979.495n 1.8v 979.505n 1.8v 989.495n 1.8v 989.505n 1.8v 999.495n 1.8v 999.505n 1.8v 1009.495n 1.8v 1009.505n 1.8v 1019.495n 1.8v 1019.505n 1.8v 1029.495n 1.8v 1029.505n 1.8v 1039.495n 1.8v 1039.505n 1.8v 1049.495n 1.8v 1049.505n 0.0v 1059.495n 0.0v 1059.505n 1.8v 1069.495n 1.8v 1069.505n 1.8v 1079.495n 1.8v 1079.505n 1.8v 1089.495n 1.8v 1089.505n 1.8v 1099.495n 1.8v 1099.505n 1.8v 1109.495n 1.8v 1109.505n 1.8v 1119.495n 1.8v 1119.505n 1.8v 1129.495n 1.8v 1129.505n 1.8v 1139.495n 1.8v 1139.505n 1.8v 1149.495n 1.8v 1149.505n 1.8v 1159.495n 1.8v 1159.505n 0.0v 1169.495n 0.0v 1169.505n 0.0v 1179.495n 0.0v 1179.505n 0.0v 1189.495n 0.0v 1189.505n 0.0v 1199.495n 0.0v 1199.505n 0.0v 1209.495n 0.0v 1209.505n 0.0v 1219.495n 0.0v 1219.505n 0.0v 1229.495n 0.0v 1229.505n 0.0v 1239.495n 0.0v 1239.505n 0.0v 1249.495n 0.0v 1249.505n 1.8v 1259.495n 1.8v 1259.505n 0.0v 1269.495n 0.0v 1269.505n 0.0v 1279.495n 0.0v 1279.505n 0.0v 1289.495n 0.0v 1289.505n 0.0v 1299.495n 0.0v 1299.505n 0.0v 1309.495n 0.0v 1309.505n 0.0v 1319.495n 0.0v 1319.505n 0.0v 1329.495n 0.0v 1329.505n 1.8v 1339.495n 1.8v 1339.505n 1.8v 1349.495n 1.8v 1349.505n 1.8v 1359.495n 1.8v 1359.505n 1.8v 1369.495n 1.8v 1369.505n 1.8v 1379.495n 1.8v 1379.505n 1.8v 1389.495n 1.8v 1389.505n 1.8v 1399.495n 1.8v 1399.505n 0.0v 1409.495n 0.0v 1409.505n 0.0v 1419.495n 0.0v 1419.505n 1.8v 1429.495n 1.8v 1429.505n 0.0v 1439.495n 0.0v 1439.505n 0.0v 1449.495n 0.0v 1449.505n 0.0v 1459.495n 0.0v 1459.505n 0.0v 1469.495n 0.0v 1469.505n 0.0v 1479.495n 0.0v 1479.505n 0.0v 1489.495n 0.0v 1489.505n 1.8v 1499.495n 1.8v 1499.505n 1.8v 1509.495n 1.8v 1509.505n 1.8v 1519.495n 1.8v 1519.505n 1.8v 1529.495n 1.8v 1529.505n 1.8v 1539.495n 1.8v 1539.505n 1.8v 1549.495n 1.8v 1549.505n 0.0v 1559.495n 0.0v 1559.505n 0.0v 1569.495n 0.0v 1569.505n 0.0v 1579.495n 0.0v 1579.505n 0.0v 1589.495n 0.0v 1589.505n 0.0v 1599.495n 0.0v 1599.505n 0.0v 1609.495n 0.0v 1609.505n 0.0v 1619.495n 0.0v 1619.505n 0.0v 1629.495n 0.0v 1629.505n 0.0v 1639.495n 0.0v 1639.505n 0.0v 1649.495n 0.0v 1649.505n 1.8v 1659.495n 1.8v 1659.505n 1.8v 1669.495n 1.8v 1669.505n 1.8v 1679.495n 1.8v 1679.505n 1.8v 1689.495n 1.8v 1689.505n 1.8v 1699.495n 1.8v 1699.505n 1.8v 1709.495n 1.8v 1709.505n 1.8v 1719.495n 1.8v 1719.505n 1.8v 1729.495n 1.8v 1729.505n 1.8v 1739.495n 1.8v 1739.505n 1.8v 1749.495n 1.8v 1749.505n 1.8v 1759.495n 1.8v 1759.505n 0.0v 1769.495n 0.0v 1769.505n 0.0v 1779.495n 0.0v 1779.505n 0.0v 1789.495n 0.0v 1789.505n 0.0v 1799.495n 0.0v 1799.505n 0.0v 1809.495n 0.0v 1809.505n 0.0v 1819.495n 0.0v 1819.505n 1.8v 1829.495n 1.8v 1829.505n 1.8v 1839.495n 1.8v 1839.505n 1.8v 1849.495n 1.8v 1849.505n 1.8v 1859.495n 1.8v 1859.505n 1.8v 1869.495n 1.8v 1869.505n 1.8v 1879.495n 1.8v 1879.505n 1.8v 1889.495n 1.8v 1889.505n 1.8v 1899.495n 1.8v 1899.505n 1.8v 1909.495n 1.8v 1909.505n 1.8v 1919.495n 1.8v 1919.505n 1.8v 1929.495n 1.8v 1929.505n 1.8v 1939.495n 1.8v 1939.505n 1.8v 1949.495n 1.8v 1949.505n 1.8v 1959.495n 1.8v 1959.505n 1.8v 1969.495n 1.8v 1969.505n 1.8v 1979.495n 1.8v 1979.505n 1.8v 1989.495n 1.8v 1989.505n 1.8v 1999.495n 1.8v 1999.505n 1.8v 2009.495n 1.8v 2009.505n 1.8v 2019.495n 1.8v 2019.505n 1.8v 2029.495n 1.8v 2029.505n 1.8v 2039.495n 1.8v 2039.505n 1.8v 2049.495n 1.8v 2049.505n 1.8v )
* (time, data): [(0, 0), (10, 0), (20, 0), (30, 0), (40, 0), (50, 0), (60, 0), (70, 0), (80, 0), (90, 1), (100, 0), (110, 0), (120, 0), (130, 0), (140, 0), (150, 0), (160, 0), (170, 0), (180, 1), (190, 1), (200, 1), (210, 1), (220, 1), (230, 0), (240, 1), (250, 1), (260, 1), (270, 1), (280, 1), (290, 1), (300, 1), (310, 1), (320, 1), (330, 0), (340, 0), (350, 0), (360, 1), (370, 1), (380, 1), (390, 1), (400, 1), (410, 1), (420, 1), (430, 1), (440, 1), (450, 1), (460, 1), (470, 0), (480, 0), (490, 0), (500, 0), (510, 0), (520, 0), (530, 0), (540, 0), (550, 0), (560, 1), (570, 1), (580, 1), (590, 1), (600, 1), (610, 1), (620, 1), (630, 1), (640, 0), (650, 0), (660, 1), (670, 1), (680, 0), (690, 0), (700, 0), (710, 0), (720, 0), (730, 0), (740, 1), (750, 1), (760, 0), (770, 0), (780, 0), (790, 0), (800, 0), (810, 0), (820, 0), (830, 0), (840, 0), (850, 0), (860, 0), (870, 0), (880, 0), (890, 0), (900, 0), (910, 0), (920, 0), (930, 1), (940, 1), (950, 1), (960, 0), (970, 0), (980, 0), (990, 0), (1000, 0), (1010, 0), (1020, 0), (1030, 0), (1040, 0), (1050, 1), (1060, 1), (1070, 1), (1080, 1), (1090, 0), (1100, 0), (1110, 0), (1120, 0), (1130, 0), (1140, 1), (1150, 1), (1160, 1), (1170, 1), (1180, 1), (1190, 1), (1200, 1), (1210, 1), (1220, 1), (1230, 1), (1240, 1), (1250, 1), (1260, 1), (1270, 1), (1280, 1), (1290, 1), (1300, 1), (1310, 1), (1320, 1), (1330, 0), (1340, 0), (1350, 0), (1360, 0), (1370, 1), (1380, 1), (1390, 1), (1400, 0), (1410, 0), (1420, 1), (1430, 0), (1440, 0), (1450, 0), (1460, 0), (1470, 0), (1480, 0), (1490, 1), (1500, 1), (1510, 1), (1520, 1), (1530, 1), (1540, 1), (1550, 1), (1560, 1), (1570, 1), (1580, 1), (1590, 1), (1600, 1), (1610, 1), (1620, 1), (1630, 1), (1640, 1), (1650, 1), (1660, 1), (1670, 1), (1680, 1), (1690, 1), (1700, 1), (1710, 1), (1720, 1), (1730, 1), (1740, 1), (1750, 1), (1760, 0), (1770, 0), (1780, 0), (1790, 0), (1800, 0), (1810, 0), (1820, 1), (1830, 1), (1840, 1), (1850, 0), (1860, 0), (1870, 0), (1880, 0), (1890, 0), (1900, 0), (1910, 0), (1920, 0), (1930, 0), (1940, 0), (1950, 0), (1960, 0), (1970, 0), (1980, 0), (1990, 0), (2000, 0), (2010, 0), (2020, 0), (2030, 0), (2040, 0), (2050, 0)]
Vdin0_30  din0_30  0 PWL (0n 0.0v 9.495n 0.0v 9.505n 0.0v 19.495n 0.0v 19.505n 0.0v 29.495n 0.0v 29.505n 0.0v 39.495n 0.0v 39.505n 0.0v 49.495n 0.0v 49.505n 0.0v 59.495n 0.0v 59.505n 0.0v 69.495n 0.0v 69.505n 0.0v 79.495n 0.0v 79.505n 0.0v 89.495n 0.0v 89.505n 1.8v 99.495n 1.8v 99.505n 0.0v 109.495n 0.0v 109.505n 0.0v 119.495n 0.0v 119.505n 0.0v 129.495n 0.0v 129.505n 0.0v 139.495n 0.0v 139.505n 0.0v 149.495n 0.0v 149.505n 0.0v 159.495n 0.0v 159.505n 0.0v 169.495n 0.0v 169.505n 0.0v 179.495n 0.0v 179.505n 1.8v 189.495n 1.8v 189.505n 1.8v 199.495n 1.8v 199.505n 1.8v 209.495n 1.8v 209.505n 1.8v 219.495n 1.8v 219.505n 1.8v 229.495n 1.8v 229.505n 0.0v 239.495n 0.0v 239.505n 1.8v 249.495n 1.8v 249.505n 1.8v 259.495n 1.8v 259.505n 1.8v 269.495n 1.8v 269.505n 1.8v 279.495n 1.8v 279.505n 1.8v 289.495n 1.8v 289.505n 1.8v 299.495n 1.8v 299.505n 1.8v 309.495n 1.8v 309.505n 1.8v 319.495n 1.8v 319.505n 1.8v 329.495n 1.8v 329.505n 0.0v 339.495n 0.0v 339.505n 0.0v 349.495n 0.0v 349.505n 0.0v 359.495n 0.0v 359.505n 1.8v 369.495n 1.8v 369.505n 1.8v 379.495n 1.8v 379.505n 1.8v 389.495n 1.8v 389.505n 1.8v 399.495n 1.8v 399.505n 1.8v 409.495n 1.8v 409.505n 1.8v 419.495n 1.8v 419.505n 1.8v 429.495n 1.8v 429.505n 1.8v 439.495n 1.8v 439.505n 1.8v 449.495n 1.8v 449.505n 1.8v 459.495n 1.8v 459.505n 1.8v 469.495n 1.8v 469.505n 0.0v 479.495n 0.0v 479.505n 0.0v 489.495n 0.0v 489.505n 0.0v 499.495n 0.0v 499.505n 0.0v 509.495n 0.0v 509.505n 0.0v 519.495n 0.0v 519.505n 0.0v 529.495n 0.0v 529.505n 0.0v 539.495n 0.0v 539.505n 0.0v 549.495n 0.0v 549.505n 0.0v 559.495n 0.0v 559.505n 1.8v 569.495n 1.8v 569.505n 1.8v 579.495n 1.8v 579.505n 1.8v 589.495n 1.8v 589.505n 1.8v 599.495n 1.8v 599.505n 1.8v 609.495n 1.8v 609.505n 1.8v 619.495n 1.8v 619.505n 1.8v 629.495n 1.8v 629.505n 1.8v 639.495n 1.8v 639.505n 0.0v 649.495n 0.0v 649.505n 0.0v 659.495n 0.0v 659.505n 1.8v 669.495n 1.8v 669.505n 1.8v 679.495n 1.8v 679.505n 0.0v 689.495n 0.0v 689.505n 0.0v 699.495n 0.0v 699.505n 0.0v 709.495n 0.0v 709.505n 0.0v 719.495n 0.0v 719.505n 0.0v 729.495n 0.0v 729.505n 0.0v 739.495n 0.0v 739.505n 1.8v 749.495n 1.8v 749.505n 1.8v 759.495n 1.8v 759.505n 0.0v 769.495n 0.0v 769.505n 0.0v 779.495n 0.0v 779.505n 0.0v 789.495n 0.0v 789.505n 0.0v 799.495n 0.0v 799.505n 0.0v 809.495n 0.0v 809.505n 0.0v 819.495n 0.0v 819.505n 0.0v 829.495n 0.0v 829.505n 0.0v 839.495n 0.0v 839.505n 0.0v 849.495n 0.0v 849.505n 0.0v 859.495n 0.0v 859.505n 0.0v 869.495n 0.0v 869.505n 0.0v 879.495n 0.0v 879.505n 0.0v 889.495n 0.0v 889.505n 0.0v 899.495n 0.0v 899.505n 0.0v 909.495n 0.0v 909.505n 0.0v 919.495n 0.0v 919.505n 0.0v 929.495n 0.0v 929.505n 1.8v 939.495n 1.8v 939.505n 1.8v 949.495n 1.8v 949.505n 1.8v 959.495n 1.8v 959.505n 0.0v 969.495n 0.0v 969.505n 0.0v 979.495n 0.0v 979.505n 0.0v 989.495n 0.0v 989.505n 0.0v 999.495n 0.0v 999.505n 0.0v 1009.495n 0.0v 1009.505n 0.0v 1019.495n 0.0v 1019.505n 0.0v 1029.495n 0.0v 1029.505n 0.0v 1039.495n 0.0v 1039.505n 0.0v 1049.495n 0.0v 1049.505n 1.8v 1059.495n 1.8v 1059.505n 1.8v 1069.495n 1.8v 1069.505n 1.8v 1079.495n 1.8v 1079.505n 1.8v 1089.495n 1.8v 1089.505n 0.0v 1099.495n 0.0v 1099.505n 0.0v 1109.495n 0.0v 1109.505n 0.0v 1119.495n 0.0v 1119.505n 0.0v 1129.495n 0.0v 1129.505n 0.0v 1139.495n 0.0v 1139.505n 1.8v 1149.495n 1.8v 1149.505n 1.8v 1159.495n 1.8v 1159.505n 1.8v 1169.495n 1.8v 1169.505n 1.8v 1179.495n 1.8v 1179.505n 1.8v 1189.495n 1.8v 1189.505n 1.8v 1199.495n 1.8v 1199.505n 1.8v 1209.495n 1.8v 1209.505n 1.8v 1219.495n 1.8v 1219.505n 1.8v 1229.495n 1.8v 1229.505n 1.8v 1239.495n 1.8v 1239.505n 1.8v 1249.495n 1.8v 1249.505n 1.8v 1259.495n 1.8v 1259.505n 1.8v 1269.495n 1.8v 1269.505n 1.8v 1279.495n 1.8v 1279.505n 1.8v 1289.495n 1.8v 1289.505n 1.8v 1299.495n 1.8v 1299.505n 1.8v 1309.495n 1.8v 1309.505n 1.8v 1319.495n 1.8v 1319.505n 1.8v 1329.495n 1.8v 1329.505n 0.0v 1339.495n 0.0v 1339.505n 0.0v 1349.495n 0.0v 1349.505n 0.0v 1359.495n 0.0v 1359.505n 0.0v 1369.495n 0.0v 1369.505n 1.8v 1379.495n 1.8v 1379.505n 1.8v 1389.495n 1.8v 1389.505n 1.8v 1399.495n 1.8v 1399.505n 0.0v 1409.495n 0.0v 1409.505n 0.0v 1419.495n 0.0v 1419.505n 1.8v 1429.495n 1.8v 1429.505n 0.0v 1439.495n 0.0v 1439.505n 0.0v 1449.495n 0.0v 1449.505n 0.0v 1459.495n 0.0v 1459.505n 0.0v 1469.495n 0.0v 1469.505n 0.0v 1479.495n 0.0v 1479.505n 0.0v 1489.495n 0.0v 1489.505n 1.8v 1499.495n 1.8v 1499.505n 1.8v 1509.495n 1.8v 1509.505n 1.8v 1519.495n 1.8v 1519.505n 1.8v 1529.495n 1.8v 1529.505n 1.8v 1539.495n 1.8v 1539.505n 1.8v 1549.495n 1.8v 1549.505n 1.8v 1559.495n 1.8v 1559.505n 1.8v 1569.495n 1.8v 1569.505n 1.8v 1579.495n 1.8v 1579.505n 1.8v 1589.495n 1.8v 1589.505n 1.8v 1599.495n 1.8v 1599.505n 1.8v 1609.495n 1.8v 1609.505n 1.8v 1619.495n 1.8v 1619.505n 1.8v 1629.495n 1.8v 1629.505n 1.8v 1639.495n 1.8v 1639.505n 1.8v 1649.495n 1.8v 1649.505n 1.8v 1659.495n 1.8v 1659.505n 1.8v 1669.495n 1.8v 1669.505n 1.8v 1679.495n 1.8v 1679.505n 1.8v 1689.495n 1.8v 1689.505n 1.8v 1699.495n 1.8v 1699.505n 1.8v 1709.495n 1.8v 1709.505n 1.8v 1719.495n 1.8v 1719.505n 1.8v 1729.495n 1.8v 1729.505n 1.8v 1739.495n 1.8v 1739.505n 1.8v 1749.495n 1.8v 1749.505n 1.8v 1759.495n 1.8v 1759.505n 0.0v 1769.495n 0.0v 1769.505n 0.0v 1779.495n 0.0v 1779.505n 0.0v 1789.495n 0.0v 1789.505n 0.0v 1799.495n 0.0v 1799.505n 0.0v 1809.495n 0.0v 1809.505n 0.0v 1819.495n 0.0v 1819.505n 1.8v 1829.495n 1.8v 1829.505n 1.8v 1839.495n 1.8v 1839.505n 1.8v 1849.495n 1.8v 1849.505n 0.0v 1859.495n 0.0v 1859.505n 0.0v 1869.495n 0.0v 1869.505n 0.0v 1879.495n 0.0v 1879.505n 0.0v 1889.495n 0.0v 1889.505n 0.0v 1899.495n 0.0v 1899.505n 0.0v 1909.495n 0.0v 1909.505n 0.0v 1919.495n 0.0v 1919.505n 0.0v 1929.495n 0.0v 1929.505n 0.0v 1939.495n 0.0v 1939.505n 0.0v 1949.495n 0.0v 1949.505n 0.0v 1959.495n 0.0v 1959.505n 0.0v 1969.495n 0.0v 1969.505n 0.0v 1979.495n 0.0v 1979.505n 0.0v 1989.495n 0.0v 1989.505n 0.0v 1999.495n 0.0v 1999.505n 0.0v 2009.495n 0.0v 2009.505n 0.0v 2019.495n 0.0v 2019.505n 0.0v 2029.495n 0.0v 2029.505n 0.0v 2039.495n 0.0v 2039.505n 0.0v 2049.495n 0.0v 2049.505n 0.0v )
* (time, data): [(0, 0), (10, 0), (20, 0), (30, 0), (40, 0), (50, 0), (60, 0), (70, 0), (80, 0), (90, 0), (100, 1), (110, 1), (120, 1), (130, 1), (140, 1), (150, 1), (160, 1), (170, 1), (180, 0), (190, 0), (200, 1), (210, 1), (220, 1), (230, 0), (240, 1), (250, 1), (260, 1), (270, 1), (280, 1), (290, 1), (300, 1), (310, 1), (320, 1), (330, 0), (340, 0), (350, 0), (360, 0), (370, 1), (380, 1), (390, 1), (400, 1), (410, 1), (420, 1), (430, 1), (440, 1), (450, 1), (460, 1), (470, 1), (480, 1), (490, 1), (500, 1), (510, 1), (520, 1), (530, 1), (540, 1), (550, 1), (560, 0), (570, 0), (580, 0), (590, 0), (600, 0), (610, 0), (620, 0), (630, 0), (640, 1), (650, 1), (660, 1), (670, 1), (680, 0), (690, 0), (700, 0), (710, 0), (720, 0), (730, 0), (740, 1), (750, 1), (760, 0), (770, 0), (780, 0), (790, 0), (800, 0), (810, 0), (820, 0), (830, 0), (840, 0), (850, 0), (860, 0), (870, 1), (880, 1), (890, 1), (900, 1), (910, 1), (920, 1), (930, 0), (940, 0), (950, 0), (960, 0), (970, 0), (980, 0), (990, 0), (1000, 0), (1010, 0), (1020, 0), (1030, 0), (1040, 0), (1050, 1), (1060, 0), (1070, 0), (1080, 0), (1090, 1), (1100, 1), (1110, 1), (1120, 1), (1130, 1), (1140, 0), (1150, 0), (1160, 0), (1170, 0), (1180, 0), (1190, 0), (1200, 0), (1210, 0), (1220, 0), (1230, 0), (1240, 0), (1250, 0), (1260, 0), (1270, 0), (1280, 0), (1290, 0), (1300, 0), (1310, 0), (1320, 0), (1330, 0), (1340, 0), (1350, 0), (1360, 0), (1370, 0), (1380, 0), (1390, 0), (1400, 1), (1410, 1), (1420, 0), (1430, 1), (1440, 1), (1450, 1), (1460, 1), (1470, 1), (1480, 1), (1490, 0), (1500, 0), (1510, 0), (1520, 0), (1530, 0), (1540, 0), (1550, 1), (1560, 1), (1570, 0), (1580, 0), (1590, 0), (1600, 0), (1610, 0), (1620, 0), (1630, 0), (1640, 0), (1650, 0), (1660, 0), (1670, 0), (1680, 0), (1690, 0), (1700, 0), (1710, 0), (1720, 0), (1730, 0), (1740, 0), (1750, 0), (1760, 0), (1770, 0), (1780, 0), (1790, 0), (1800, 0), (1810, 0), (1820, 1), (1830, 1), (1840, 1), (1850, 1), (1860, 1), (1870, 1), (1880, 1), (1890, 1), (1900, 1), (1910, 1), (1920, 1), (1930, 1), (1940, 1), (1950, 1), (1960, 1), (1970, 1), (1980, 1), (1990, 1), (2000, 1), (2010, 1), (2020, 1), (2030, 1), (2040, 1), (2050, 1)]
Vdin0_31  din0_31  0 PWL (0n 0.0v 9.495n 0.0v 9.505n 0.0v 19.495n 0.0v 19.505n 0.0v 29.495n 0.0v 29.505n 0.0v 39.495n 0.0v 39.505n 0.0v 49.495n 0.0v 49.505n 0.0v 59.495n 0.0v 59.505n 0.0v 69.495n 0.0v 69.505n 0.0v 79.495n 0.0v 79.505n 0.0v 89.495n 0.0v 89.505n 0.0v 99.495n 0.0v 99.505n 1.8v 109.495n 1.8v 109.505n 1.8v 119.495n 1.8v 119.505n 1.8v 129.495n 1.8v 129.505n 1.8v 139.495n 1.8v 139.505n 1.8v 149.495n 1.8v 149.505n 1.8v 159.495n 1.8v 159.505n 1.8v 169.495n 1.8v 169.505n 1.8v 179.495n 1.8v 179.505n 0.0v 189.495n 0.0v 189.505n 0.0v 199.495n 0.0v 199.505n 1.8v 209.495n 1.8v 209.505n 1.8v 219.495n 1.8v 219.505n 1.8v 229.495n 1.8v 229.505n 0.0v 239.495n 0.0v 239.505n 1.8v 249.495n 1.8v 249.505n 1.8v 259.495n 1.8v 259.505n 1.8v 269.495n 1.8v 269.505n 1.8v 279.495n 1.8v 279.505n 1.8v 289.495n 1.8v 289.505n 1.8v 299.495n 1.8v 299.505n 1.8v 309.495n 1.8v 309.505n 1.8v 319.495n 1.8v 319.505n 1.8v 329.495n 1.8v 329.505n 0.0v 339.495n 0.0v 339.505n 0.0v 349.495n 0.0v 349.505n 0.0v 359.495n 0.0v 359.505n 0.0v 369.495n 0.0v 369.505n 1.8v 379.495n 1.8v 379.505n 1.8v 389.495n 1.8v 389.505n 1.8v 399.495n 1.8v 399.505n 1.8v 409.495n 1.8v 409.505n 1.8v 419.495n 1.8v 419.505n 1.8v 429.495n 1.8v 429.505n 1.8v 439.495n 1.8v 439.505n 1.8v 449.495n 1.8v 449.505n 1.8v 459.495n 1.8v 459.505n 1.8v 469.495n 1.8v 469.505n 1.8v 479.495n 1.8v 479.505n 1.8v 489.495n 1.8v 489.505n 1.8v 499.495n 1.8v 499.505n 1.8v 509.495n 1.8v 509.505n 1.8v 519.495n 1.8v 519.505n 1.8v 529.495n 1.8v 529.505n 1.8v 539.495n 1.8v 539.505n 1.8v 549.495n 1.8v 549.505n 1.8v 559.495n 1.8v 559.505n 0.0v 569.495n 0.0v 569.505n 0.0v 579.495n 0.0v 579.505n 0.0v 589.495n 0.0v 589.505n 0.0v 599.495n 0.0v 599.505n 0.0v 609.495n 0.0v 609.505n 0.0v 619.495n 0.0v 619.505n 0.0v 629.495n 0.0v 629.505n 0.0v 639.495n 0.0v 639.505n 1.8v 649.495n 1.8v 649.505n 1.8v 659.495n 1.8v 659.505n 1.8v 669.495n 1.8v 669.505n 1.8v 679.495n 1.8v 679.505n 0.0v 689.495n 0.0v 689.505n 0.0v 699.495n 0.0v 699.505n 0.0v 709.495n 0.0v 709.505n 0.0v 719.495n 0.0v 719.505n 0.0v 729.495n 0.0v 729.505n 0.0v 739.495n 0.0v 739.505n 1.8v 749.495n 1.8v 749.505n 1.8v 759.495n 1.8v 759.505n 0.0v 769.495n 0.0v 769.505n 0.0v 779.495n 0.0v 779.505n 0.0v 789.495n 0.0v 789.505n 0.0v 799.495n 0.0v 799.505n 0.0v 809.495n 0.0v 809.505n 0.0v 819.495n 0.0v 819.505n 0.0v 829.495n 0.0v 829.505n 0.0v 839.495n 0.0v 839.505n 0.0v 849.495n 0.0v 849.505n 0.0v 859.495n 0.0v 859.505n 0.0v 869.495n 0.0v 869.505n 1.8v 879.495n 1.8v 879.505n 1.8v 889.495n 1.8v 889.505n 1.8v 899.495n 1.8v 899.505n 1.8v 909.495n 1.8v 909.505n 1.8v 919.495n 1.8v 919.505n 1.8v 929.495n 1.8v 929.505n 0.0v 939.495n 0.0v 939.505n 0.0v 949.495n 0.0v 949.505n 0.0v 959.495n 0.0v 959.505n 0.0v 969.495n 0.0v 969.505n 0.0v 979.495n 0.0v 979.505n 0.0v 989.495n 0.0v 989.505n 0.0v 999.495n 0.0v 999.505n 0.0v 1009.495n 0.0v 1009.505n 0.0v 1019.495n 0.0v 1019.505n 0.0v 1029.495n 0.0v 1029.505n 0.0v 1039.495n 0.0v 1039.505n 0.0v 1049.495n 0.0v 1049.505n 1.8v 1059.495n 1.8v 1059.505n 0.0v 1069.495n 0.0v 1069.505n 0.0v 1079.495n 0.0v 1079.505n 0.0v 1089.495n 0.0v 1089.505n 1.8v 1099.495n 1.8v 1099.505n 1.8v 1109.495n 1.8v 1109.505n 1.8v 1119.495n 1.8v 1119.505n 1.8v 1129.495n 1.8v 1129.505n 1.8v 1139.495n 1.8v 1139.505n 0.0v 1149.495n 0.0v 1149.505n 0.0v 1159.495n 0.0v 1159.505n 0.0v 1169.495n 0.0v 1169.505n 0.0v 1179.495n 0.0v 1179.505n 0.0v 1189.495n 0.0v 1189.505n 0.0v 1199.495n 0.0v 1199.505n 0.0v 1209.495n 0.0v 1209.505n 0.0v 1219.495n 0.0v 1219.505n 0.0v 1229.495n 0.0v 1229.505n 0.0v 1239.495n 0.0v 1239.505n 0.0v 1249.495n 0.0v 1249.505n 0.0v 1259.495n 0.0v 1259.505n 0.0v 1269.495n 0.0v 1269.505n 0.0v 1279.495n 0.0v 1279.505n 0.0v 1289.495n 0.0v 1289.505n 0.0v 1299.495n 0.0v 1299.505n 0.0v 1309.495n 0.0v 1309.505n 0.0v 1319.495n 0.0v 1319.505n 0.0v 1329.495n 0.0v 1329.505n 0.0v 1339.495n 0.0v 1339.505n 0.0v 1349.495n 0.0v 1349.505n 0.0v 1359.495n 0.0v 1359.505n 0.0v 1369.495n 0.0v 1369.505n 0.0v 1379.495n 0.0v 1379.505n 0.0v 1389.495n 0.0v 1389.505n 0.0v 1399.495n 0.0v 1399.505n 1.8v 1409.495n 1.8v 1409.505n 1.8v 1419.495n 1.8v 1419.505n 0.0v 1429.495n 0.0v 1429.505n 1.8v 1439.495n 1.8v 1439.505n 1.8v 1449.495n 1.8v 1449.505n 1.8v 1459.495n 1.8v 1459.505n 1.8v 1469.495n 1.8v 1469.505n 1.8v 1479.495n 1.8v 1479.505n 1.8v 1489.495n 1.8v 1489.505n 0.0v 1499.495n 0.0v 1499.505n 0.0v 1509.495n 0.0v 1509.505n 0.0v 1519.495n 0.0v 1519.505n 0.0v 1529.495n 0.0v 1529.505n 0.0v 1539.495n 0.0v 1539.505n 0.0v 1549.495n 0.0v 1549.505n 1.8v 1559.495n 1.8v 1559.505n 1.8v 1569.495n 1.8v 1569.505n 0.0v 1579.495n 0.0v 1579.505n 0.0v 1589.495n 0.0v 1589.505n 0.0v 1599.495n 0.0v 1599.505n 0.0v 1609.495n 0.0v 1609.505n 0.0v 1619.495n 0.0v 1619.505n 0.0v 1629.495n 0.0v 1629.505n 0.0v 1639.495n 0.0v 1639.505n 0.0v 1649.495n 0.0v 1649.505n 0.0v 1659.495n 0.0v 1659.505n 0.0v 1669.495n 0.0v 1669.505n 0.0v 1679.495n 0.0v 1679.505n 0.0v 1689.495n 0.0v 1689.505n 0.0v 1699.495n 0.0v 1699.505n 0.0v 1709.495n 0.0v 1709.505n 0.0v 1719.495n 0.0v 1719.505n 0.0v 1729.495n 0.0v 1729.505n 0.0v 1739.495n 0.0v 1739.505n 0.0v 1749.495n 0.0v 1749.505n 0.0v 1759.495n 0.0v 1759.505n 0.0v 1769.495n 0.0v 1769.505n 0.0v 1779.495n 0.0v 1779.505n 0.0v 1789.495n 0.0v 1789.505n 0.0v 1799.495n 0.0v 1799.505n 0.0v 1809.495n 0.0v 1809.505n 0.0v 1819.495n 0.0v 1819.505n 1.8v 1829.495n 1.8v 1829.505n 1.8v 1839.495n 1.8v 1839.505n 1.8v 1849.495n 1.8v 1849.505n 1.8v 1859.495n 1.8v 1859.505n 1.8v 1869.495n 1.8v 1869.505n 1.8v 1879.495n 1.8v 1879.505n 1.8v 1889.495n 1.8v 1889.505n 1.8v 1899.495n 1.8v 1899.505n 1.8v 1909.495n 1.8v 1909.505n 1.8v 1919.495n 1.8v 1919.505n 1.8v 1929.495n 1.8v 1929.505n 1.8v 1939.495n 1.8v 1939.505n 1.8v 1949.495n 1.8v 1949.505n 1.8v 1959.495n 1.8v 1959.505n 1.8v 1969.495n 1.8v 1969.505n 1.8v 1979.495n 1.8v 1979.505n 1.8v 1989.495n 1.8v 1989.505n 1.8v 1999.495n 1.8v 1999.505n 1.8v 2009.495n 1.8v 2009.505n 1.8v 2019.495n 1.8v 2019.505n 1.8v 2029.495n 1.8v 2029.505n 1.8v 2039.495n 1.8v 2039.505n 1.8v 2049.495n 1.8v 2049.505n 1.8v )
* (time, data): [(0, 0), (10, 0), (20, 0), (30, 0), (40, 0), (50, 0), (60, 0), (70, 0), (80, 0), (90, 0), (100, 0), (110, 0), (120, 0), (130, 0), (140, 0), (150, 0), (160, 0), (170, 0), (180, 0), (190, 0), (200, 0), (210, 0), (220, 0), (230, 0), (240, 0), (250, 0), (260, 0), (270, 0), (280, 0), (290, 0), (300, 0), (310, 0), (320, 0), (330, 0), (340, 0), (350, 0), (360, 0), (370, 0), (380, 0), (390, 0), (400, 0), (410, 0), (420, 0), (430, 0), (440, 0), (450, 0), (460, 0), (470, 0), (480, 0), (490, 0), (500, 0), (510, 0), (520, 0), (530, 0), (540, 0), (550, 0), (560, 0), (570, 0), (580, 0), (590, 0), (600, 0), (610, 0), (620, 0), (630, 0), (640, 0), (650, 0), (660, 0), (670, 0), (680, 0), (690, 0), (700, 0), (710, 0), (720, 0), (730, 0), (740, 0), (750, 0), (760, 0), (770, 0), (780, 0), (790, 0), (800, 0), (810, 0), (820, 0), (830, 0), (840, 0), (850, 0), (860, 0), (870, 0), (880, 0), (890, 0), (900, 0), (910, 0), (920, 0), (930, 0), (940, 0), (950, 0), (960, 0), (970, 0), (980, 0), (990, 0), (1000, 0), (1010, 0), (1020, 0), (1030, 0), (1040, 0), (1050, 0), (1060, 0), (1070, 0), (1080, 0), (1090, 0), (1100, 0), (1110, 0), (1120, 0), (1130, 0), (1140, 0), (1150, 0), (1160, 0), (1170, 0), (1180, 0), (1190, 0), (1200, 0), (1210, 0), (1220, 0), (1230, 0), (1240, 0), (1250, 0), (1260, 0), (1270, 0), (1280, 0), (1290, 0), (1300, 0), (1310, 0), (1320, 0), (1330, 0), (1340, 0), (1350, 0), (1360, 0), (1370, 0), (1380, 0), (1390, 0), (1400, 0), (1410, 0), (1420, 0), (1430, 0), (1440, 0), (1450, 0), (1460, 0), (1470, 0), (1480, 0), (1490, 0), (1500, 0), (1510, 0), (1520, 0), (1530, 0), (1540, 0), (1550, 0), (1560, 0), (1570, 0), (1580, 0), (1590, 0), (1600, 0), (1610, 0), (1620, 0), (1630, 0), (1640, 0), (1650, 0), (1660, 0), (1670, 0), (1680, 0), (1690, 0), (1700, 0), (1710, 0), (1720, 0), (1730, 0), (1740, 0), (1750, 0), (1760, 0), (1770, 0), (1780, 0), (1790, 0), (1800, 0), (1810, 0), (1820, 0), (1830, 0), (1840, 0), (1850, 0), (1860, 0), (1870, 0), (1880, 0), (1890, 0), (1900, 0), (1910, 0), (1920, 0), (1930, 0), (1940, 0), (1950, 0), (1960, 0), (1970, 0), (1980, 0), (1990, 0), (2000, 0), (2010, 0), (2020, 0), (2030, 0), (2040, 0), (2050, 0)]
Va0_0  a0_0  0 PWL (0n 0.0v 9.495n 0.0v 9.505n 0.0v 19.495n 0.0v 19.505n 0.0v 29.495n 0.0v 29.505n 0.0v 39.495n 0.0v 39.505n 0.0v 49.495n 0.0v 49.505n 0.0v 59.495n 0.0v 59.505n 0.0v 69.495n 0.0v 69.505n 0.0v 79.495n 0.0v 79.505n 0.0v 89.495n 0.0v 89.505n 0.0v 99.495n 0.0v 99.505n 0.0v 109.495n 0.0v 109.505n 0.0v 119.495n 0.0v 119.505n 0.0v 129.495n 0.0v 129.505n 0.0v 139.495n 0.0v 139.505n 0.0v 149.495n 0.0v 149.505n 0.0v 159.495n 0.0v 159.505n 0.0v 169.495n 0.0v 169.505n 0.0v 179.495n 0.0v 179.505n 0.0v 189.495n 0.0v 189.505n 0.0v 199.495n 0.0v 199.505n 0.0v 209.495n 0.0v 209.505n 0.0v 219.495n 0.0v 219.505n 0.0v 229.495n 0.0v 229.505n 0.0v 239.495n 0.0v 239.505n 0.0v 249.495n 0.0v 249.505n 0.0v 259.495n 0.0v 259.505n 0.0v 269.495n 0.0v 269.505n 0.0v 279.495n 0.0v 279.505n 0.0v 289.495n 0.0v 289.505n 0.0v 299.495n 0.0v 299.505n 0.0v 309.495n 0.0v 309.505n 0.0v 319.495n 0.0v 319.505n 0.0v 329.495n 0.0v 329.505n 0.0v 339.495n 0.0v 339.505n 0.0v 349.495n 0.0v 349.505n 0.0v 359.495n 0.0v 359.505n 0.0v 369.495n 0.0v 369.505n 0.0v 379.495n 0.0v 379.505n 0.0v 389.495n 0.0v 389.505n 0.0v 399.495n 0.0v 399.505n 0.0v 409.495n 0.0v 409.505n 0.0v 419.495n 0.0v 419.505n 0.0v 429.495n 0.0v 429.505n 0.0v 439.495n 0.0v 439.505n 0.0v 449.495n 0.0v 449.505n 0.0v 459.495n 0.0v 459.505n 0.0v 469.495n 0.0v 469.505n 0.0v 479.495n 0.0v 479.505n 0.0v 489.495n 0.0v 489.505n 0.0v 499.495n 0.0v 499.505n 0.0v 509.495n 0.0v 509.505n 0.0v 519.495n 0.0v 519.505n 0.0v 529.495n 0.0v 529.505n 0.0v 539.495n 0.0v 539.505n 0.0v 549.495n 0.0v 549.505n 0.0v 559.495n 0.0v 559.505n 0.0v 569.495n 0.0v 569.505n 0.0v 579.495n 0.0v 579.505n 0.0v 589.495n 0.0v 589.505n 0.0v 599.495n 0.0v 599.505n 0.0v 609.495n 0.0v 609.505n 0.0v 619.495n 0.0v 619.505n 0.0v 629.495n 0.0v 629.505n 0.0v 639.495n 0.0v 639.505n 0.0v 649.495n 0.0v 649.505n 0.0v 659.495n 0.0v 659.505n 0.0v 669.495n 0.0v 669.505n 0.0v 679.495n 0.0v 679.505n 0.0v 689.495n 0.0v 689.505n 0.0v 699.495n 0.0v 699.505n 0.0v 709.495n 0.0v 709.505n 0.0v 719.495n 0.0v 719.505n 0.0v 729.495n 0.0v 729.505n 0.0v 739.495n 0.0v 739.505n 0.0v 749.495n 0.0v 749.505n 0.0v 759.495n 0.0v 759.505n 0.0v 769.495n 0.0v 769.505n 0.0v 779.495n 0.0v 779.505n 0.0v 789.495n 0.0v 789.505n 0.0v 799.495n 0.0v 799.505n 0.0v 809.495n 0.0v 809.505n 0.0v 819.495n 0.0v 819.505n 0.0v 829.495n 0.0v 829.505n 0.0v 839.495n 0.0v 839.505n 0.0v 849.495n 0.0v 849.505n 0.0v 859.495n 0.0v 859.505n 0.0v 869.495n 0.0v 869.505n 0.0v 879.495n 0.0v 879.505n 0.0v 889.495n 0.0v 889.505n 0.0v 899.495n 0.0v 899.505n 0.0v 909.495n 0.0v 909.505n 0.0v 919.495n 0.0v 919.505n 0.0v 929.495n 0.0v 929.505n 0.0v 939.495n 0.0v 939.505n 0.0v 949.495n 0.0v 949.505n 0.0v 959.495n 0.0v 959.505n 0.0v 969.495n 0.0v 969.505n 0.0v 979.495n 0.0v 979.505n 0.0v 989.495n 0.0v 989.505n 0.0v 999.495n 0.0v 999.505n 0.0v 1009.495n 0.0v 1009.505n 0.0v 1019.495n 0.0v 1019.505n 0.0v 1029.495n 0.0v 1029.505n 0.0v 1039.495n 0.0v 1039.505n 0.0v 1049.495n 0.0v 1049.505n 0.0v 1059.495n 0.0v 1059.505n 0.0v 1069.495n 0.0v 1069.505n 0.0v 1079.495n 0.0v 1079.505n 0.0v 1089.495n 0.0v 1089.505n 0.0v 1099.495n 0.0v 1099.505n 0.0v 1109.495n 0.0v 1109.505n 0.0v 1119.495n 0.0v 1119.505n 0.0v 1129.495n 0.0v 1129.505n 0.0v 1139.495n 0.0v 1139.505n 0.0v 1149.495n 0.0v 1149.505n 0.0v 1159.495n 0.0v 1159.505n 0.0v 1169.495n 0.0v 1169.505n 0.0v 1179.495n 0.0v 1179.505n 0.0v 1189.495n 0.0v 1189.505n 0.0v 1199.495n 0.0v 1199.505n 0.0v 1209.495n 0.0v 1209.505n 0.0v 1219.495n 0.0v 1219.505n 0.0v 1229.495n 0.0v 1229.505n 0.0v 1239.495n 0.0v 1239.505n 0.0v 1249.495n 0.0v 1249.505n 0.0v 1259.495n 0.0v 1259.505n 0.0v 1269.495n 0.0v 1269.505n 0.0v 1279.495n 0.0v 1279.505n 0.0v 1289.495n 0.0v 1289.505n 0.0v 1299.495n 0.0v 1299.505n 0.0v 1309.495n 0.0v 1309.505n 0.0v 1319.495n 0.0v 1319.505n 0.0v 1329.495n 0.0v 1329.505n 0.0v 1339.495n 0.0v 1339.505n 0.0v 1349.495n 0.0v 1349.505n 0.0v 1359.495n 0.0v 1359.505n 0.0v 1369.495n 0.0v 1369.505n 0.0v 1379.495n 0.0v 1379.505n 0.0v 1389.495n 0.0v 1389.505n 0.0v 1399.495n 0.0v 1399.505n 0.0v 1409.495n 0.0v 1409.505n 0.0v 1419.495n 0.0v 1419.505n 0.0v 1429.495n 0.0v 1429.505n 0.0v 1439.495n 0.0v 1439.505n 0.0v 1449.495n 0.0v 1449.505n 0.0v 1459.495n 0.0v 1459.505n 0.0v 1469.495n 0.0v 1469.505n 0.0v 1479.495n 0.0v 1479.505n 0.0v 1489.495n 0.0v 1489.505n 0.0v 1499.495n 0.0v 1499.505n 0.0v 1509.495n 0.0v 1509.505n 0.0v 1519.495n 0.0v 1519.505n 0.0v 1529.495n 0.0v 1529.505n 0.0v 1539.495n 0.0v 1539.505n 0.0v 1549.495n 0.0v 1549.505n 0.0v 1559.495n 0.0v 1559.505n 0.0v 1569.495n 0.0v 1569.505n 0.0v 1579.495n 0.0v 1579.505n 0.0v 1589.495n 0.0v 1589.505n 0.0v 1599.495n 0.0v 1599.505n 0.0v 1609.495n 0.0v 1609.505n 0.0v 1619.495n 0.0v 1619.505n 0.0v 1629.495n 0.0v 1629.505n 0.0v 1639.495n 0.0v 1639.505n 0.0v 1649.495n 0.0v 1649.505n 0.0v 1659.495n 0.0v 1659.505n 0.0v 1669.495n 0.0v 1669.505n 0.0v 1679.495n 0.0v 1679.505n 0.0v 1689.495n 0.0v 1689.505n 0.0v 1699.495n 0.0v 1699.505n 0.0v 1709.495n 0.0v 1709.505n 0.0v 1719.495n 0.0v 1719.505n 0.0v 1729.495n 0.0v 1729.505n 0.0v 1739.495n 0.0v 1739.505n 0.0v 1749.495n 0.0v 1749.505n 0.0v 1759.495n 0.0v 1759.505n 0.0v 1769.495n 0.0v 1769.505n 0.0v 1779.495n 0.0v 1779.505n 0.0v 1789.495n 0.0v 1789.505n 0.0v 1799.495n 0.0v 1799.505n 0.0v 1809.495n 0.0v 1809.505n 0.0v 1819.495n 0.0v 1819.505n 0.0v 1829.495n 0.0v 1829.505n 0.0v 1839.495n 0.0v 1839.505n 0.0v 1849.495n 0.0v 1849.505n 0.0v 1859.495n 0.0v 1859.505n 0.0v 1869.495n 0.0v 1869.505n 0.0v 1879.495n 0.0v 1879.505n 0.0v 1889.495n 0.0v 1889.505n 0.0v 1899.495n 0.0v 1899.505n 0.0v 1909.495n 0.0v 1909.505n 0.0v 1919.495n 0.0v 1919.505n 0.0v 1929.495n 0.0v 1929.505n 0.0v 1939.495n 0.0v 1939.505n 0.0v 1949.495n 0.0v 1949.505n 0.0v 1959.495n 0.0v 1959.505n 0.0v 1969.495n 0.0v 1969.505n 0.0v 1979.495n 0.0v 1979.505n 0.0v 1989.495n 0.0v 1989.505n 0.0v 1999.495n 0.0v 1999.505n 0.0v 2009.495n 0.0v 2009.505n 0.0v 2019.495n 0.0v 2019.505n 0.0v 2029.495n 0.0v 2029.505n 0.0v 2039.495n 0.0v 2039.505n 0.0v 2049.495n 0.0v 2049.505n 0.0v )
* (time, data): [(0, 0), (10, 0), (20, 0), (30, 0), (40, 0), (50, 0), (60, 0), (70, 0), (80, 0), (90, 1), (100, 1), (110, 1), (120, 0), (130, 0), (140, 0), (150, 1), (160, 1), (170, 1), (180, 0), (190, 0), (200, 1), (210, 1), (220, 1), (230, 1), (240, 1), (250, 1), (260, 1), (270, 1), (280, 1), (290, 1), (300, 0), (310, 0), (320, 0), (330, 1), (340, 0), (350, 1), (360, 1), (370, 1), (380, 0), (390, 0), (400, 1), (410, 1), (420, 0), (430, 1), (440, 1), (450, 1), (460, 1), (470, 0), (480, 0), (490, 1), (500, 0), (510, 0), (520, 0), (530, 1), (540, 1), (550, 1), (560, 1), (570, 1), (580, 0), (590, 1), (600, 0), (610, 1), (620, 1), (630, 1), (640, 0), (650, 0), (660, 1), (670, 0), (680, 0), (690, 1), (700, 0), (710, 0), (720, 0), (730, 0), (740, 1), (750, 1), (760, 0), (770, 0), (780, 0), (790, 1), (800, 1), (810, 0), (820, 1), (830, 1), (840, 0), (850, 1), (860, 0), (870, 0), (880, 1), (890, 0), (900, 0), (910, 0), (920, 1), (930, 1), (940, 1), (950, 1), (960, 1), (970, 0), (980, 1), (990, 1), (1000, 1), (1010, 1), (1020, 1), (1030, 1), (1040, 1), (1050, 0), (1060, 0), (1070, 0), (1080, 1), (1090, 1), (1100, 0), (1110, 0), (1120, 1), (1130, 0), (1140, 0), (1150, 0), (1160, 0), (1170, 1), (1180, 0), (1190, 1), (1200, 1), (1210, 1), (1220, 1), (1230, 0), (1240, 0), (1250, 0), (1260, 0), (1270, 0), (1280, 1), (1290, 0), (1300, 0), (1310, 0), (1320, 1), (1330, 0), (1340, 0), (1350, 1), (1360, 1), (1370, 1), (1380, 1), (1390, 1), (1400, 0), (1410, 0), (1420, 0), (1430, 1), (1440, 1), (1450, 1), (1460, 1), (1470, 1), (1480, 1), (1490, 1), (1500, 1), (1510, 0), (1520, 1), (1530, 1), (1540, 1), (1550, 0), (1560, 0), (1570, 0), (1580, 0), (1590, 0), (1600, 0), (1610, 0), (1620, 1), (1630, 0), (1640, 0), (1650, 1), (1660, 1), (1670, 0), (1680, 1), (1690, 1), (1700, 1), (1710, 1), (1720, 1), (1730, 0), (1740, 0), (1750, 0), (1760, 0), (1770, 1), (1780, 1), (1790, 0), (1800, 0), (1810, 0), (1820, 1), (1830, 0), (1840, 0), (1850, 1), (1860, 0), (1870, 0), (1880, 0), (1890, 0), (1900, 0), (1910, 1), (1920, 1), (1930, 1), (1940, 1), (1950, 0), (1960, 0), (1970, 0), (1980, 1), (1990, 0), (2000, 0), (2010, 1), (2020, 0), (2030, 0), (2040, 0), (2050, 0)]
Va0_1  a0_1  0 PWL (0n 0.0v 9.495n 0.0v 9.505n 0.0v 19.495n 0.0v 19.505n 0.0v 29.495n 0.0v 29.505n 0.0v 39.495n 0.0v 39.505n 0.0v 49.495n 0.0v 49.505n 0.0v 59.495n 0.0v 59.505n 0.0v 69.495n 0.0v 69.505n 0.0v 79.495n 0.0v 79.505n 0.0v 89.495n 0.0v 89.505n 1.8v 99.495n 1.8v 99.505n 1.8v 109.495n 1.8v 109.505n 1.8v 119.495n 1.8v 119.505n 0.0v 129.495n 0.0v 129.505n 0.0v 139.495n 0.0v 139.505n 0.0v 149.495n 0.0v 149.505n 1.8v 159.495n 1.8v 159.505n 1.8v 169.495n 1.8v 169.505n 1.8v 179.495n 1.8v 179.505n 0.0v 189.495n 0.0v 189.505n 0.0v 199.495n 0.0v 199.505n 1.8v 209.495n 1.8v 209.505n 1.8v 219.495n 1.8v 219.505n 1.8v 229.495n 1.8v 229.505n 1.8v 239.495n 1.8v 239.505n 1.8v 249.495n 1.8v 249.505n 1.8v 259.495n 1.8v 259.505n 1.8v 269.495n 1.8v 269.505n 1.8v 279.495n 1.8v 279.505n 1.8v 289.495n 1.8v 289.505n 1.8v 299.495n 1.8v 299.505n 0.0v 309.495n 0.0v 309.505n 0.0v 319.495n 0.0v 319.505n 0.0v 329.495n 0.0v 329.505n 1.8v 339.495n 1.8v 339.505n 0.0v 349.495n 0.0v 349.505n 1.8v 359.495n 1.8v 359.505n 1.8v 369.495n 1.8v 369.505n 1.8v 379.495n 1.8v 379.505n 0.0v 389.495n 0.0v 389.505n 0.0v 399.495n 0.0v 399.505n 1.8v 409.495n 1.8v 409.505n 1.8v 419.495n 1.8v 419.505n 0.0v 429.495n 0.0v 429.505n 1.8v 439.495n 1.8v 439.505n 1.8v 449.495n 1.8v 449.505n 1.8v 459.495n 1.8v 459.505n 1.8v 469.495n 1.8v 469.505n 0.0v 479.495n 0.0v 479.505n 0.0v 489.495n 0.0v 489.505n 1.8v 499.495n 1.8v 499.505n 0.0v 509.495n 0.0v 509.505n 0.0v 519.495n 0.0v 519.505n 0.0v 529.495n 0.0v 529.505n 1.8v 539.495n 1.8v 539.505n 1.8v 549.495n 1.8v 549.505n 1.8v 559.495n 1.8v 559.505n 1.8v 569.495n 1.8v 569.505n 1.8v 579.495n 1.8v 579.505n 0.0v 589.495n 0.0v 589.505n 1.8v 599.495n 1.8v 599.505n 0.0v 609.495n 0.0v 609.505n 1.8v 619.495n 1.8v 619.505n 1.8v 629.495n 1.8v 629.505n 1.8v 639.495n 1.8v 639.505n 0.0v 649.495n 0.0v 649.505n 0.0v 659.495n 0.0v 659.505n 1.8v 669.495n 1.8v 669.505n 0.0v 679.495n 0.0v 679.505n 0.0v 689.495n 0.0v 689.505n 1.8v 699.495n 1.8v 699.505n 0.0v 709.495n 0.0v 709.505n 0.0v 719.495n 0.0v 719.505n 0.0v 729.495n 0.0v 729.505n 0.0v 739.495n 0.0v 739.505n 1.8v 749.495n 1.8v 749.505n 1.8v 759.495n 1.8v 759.505n 0.0v 769.495n 0.0v 769.505n 0.0v 779.495n 0.0v 779.505n 0.0v 789.495n 0.0v 789.505n 1.8v 799.495n 1.8v 799.505n 1.8v 809.495n 1.8v 809.505n 0.0v 819.495n 0.0v 819.505n 1.8v 829.495n 1.8v 829.505n 1.8v 839.495n 1.8v 839.505n 0.0v 849.495n 0.0v 849.505n 1.8v 859.495n 1.8v 859.505n 0.0v 869.495n 0.0v 869.505n 0.0v 879.495n 0.0v 879.505n 1.8v 889.495n 1.8v 889.505n 0.0v 899.495n 0.0v 899.505n 0.0v 909.495n 0.0v 909.505n 0.0v 919.495n 0.0v 919.505n 1.8v 929.495n 1.8v 929.505n 1.8v 939.495n 1.8v 939.505n 1.8v 949.495n 1.8v 949.505n 1.8v 959.495n 1.8v 959.505n 1.8v 969.495n 1.8v 969.505n 0.0v 979.495n 0.0v 979.505n 1.8v 989.495n 1.8v 989.505n 1.8v 999.495n 1.8v 999.505n 1.8v 1009.495n 1.8v 1009.505n 1.8v 1019.495n 1.8v 1019.505n 1.8v 1029.495n 1.8v 1029.505n 1.8v 1039.495n 1.8v 1039.505n 1.8v 1049.495n 1.8v 1049.505n 0.0v 1059.495n 0.0v 1059.505n 0.0v 1069.495n 0.0v 1069.505n 0.0v 1079.495n 0.0v 1079.505n 1.8v 1089.495n 1.8v 1089.505n 1.8v 1099.495n 1.8v 1099.505n 0.0v 1109.495n 0.0v 1109.505n 0.0v 1119.495n 0.0v 1119.505n 1.8v 1129.495n 1.8v 1129.505n 0.0v 1139.495n 0.0v 1139.505n 0.0v 1149.495n 0.0v 1149.505n 0.0v 1159.495n 0.0v 1159.505n 0.0v 1169.495n 0.0v 1169.505n 1.8v 1179.495n 1.8v 1179.505n 0.0v 1189.495n 0.0v 1189.505n 1.8v 1199.495n 1.8v 1199.505n 1.8v 1209.495n 1.8v 1209.505n 1.8v 1219.495n 1.8v 1219.505n 1.8v 1229.495n 1.8v 1229.505n 0.0v 1239.495n 0.0v 1239.505n 0.0v 1249.495n 0.0v 1249.505n 0.0v 1259.495n 0.0v 1259.505n 0.0v 1269.495n 0.0v 1269.505n 0.0v 1279.495n 0.0v 1279.505n 1.8v 1289.495n 1.8v 1289.505n 0.0v 1299.495n 0.0v 1299.505n 0.0v 1309.495n 0.0v 1309.505n 0.0v 1319.495n 0.0v 1319.505n 1.8v 1329.495n 1.8v 1329.505n 0.0v 1339.495n 0.0v 1339.505n 0.0v 1349.495n 0.0v 1349.505n 1.8v 1359.495n 1.8v 1359.505n 1.8v 1369.495n 1.8v 1369.505n 1.8v 1379.495n 1.8v 1379.505n 1.8v 1389.495n 1.8v 1389.505n 1.8v 1399.495n 1.8v 1399.505n 0.0v 1409.495n 0.0v 1409.505n 0.0v 1419.495n 0.0v 1419.505n 0.0v 1429.495n 0.0v 1429.505n 1.8v 1439.495n 1.8v 1439.505n 1.8v 1449.495n 1.8v 1449.505n 1.8v 1459.495n 1.8v 1459.505n 1.8v 1469.495n 1.8v 1469.505n 1.8v 1479.495n 1.8v 1479.505n 1.8v 1489.495n 1.8v 1489.505n 1.8v 1499.495n 1.8v 1499.505n 1.8v 1509.495n 1.8v 1509.505n 0.0v 1519.495n 0.0v 1519.505n 1.8v 1529.495n 1.8v 1529.505n 1.8v 1539.495n 1.8v 1539.505n 1.8v 1549.495n 1.8v 1549.505n 0.0v 1559.495n 0.0v 1559.505n 0.0v 1569.495n 0.0v 1569.505n 0.0v 1579.495n 0.0v 1579.505n 0.0v 1589.495n 0.0v 1589.505n 0.0v 1599.495n 0.0v 1599.505n 0.0v 1609.495n 0.0v 1609.505n 0.0v 1619.495n 0.0v 1619.505n 1.8v 1629.495n 1.8v 1629.505n 0.0v 1639.495n 0.0v 1639.505n 0.0v 1649.495n 0.0v 1649.505n 1.8v 1659.495n 1.8v 1659.505n 1.8v 1669.495n 1.8v 1669.505n 0.0v 1679.495n 0.0v 1679.505n 1.8v 1689.495n 1.8v 1689.505n 1.8v 1699.495n 1.8v 1699.505n 1.8v 1709.495n 1.8v 1709.505n 1.8v 1719.495n 1.8v 1719.505n 1.8v 1729.495n 1.8v 1729.505n 0.0v 1739.495n 0.0v 1739.505n 0.0v 1749.495n 0.0v 1749.505n 0.0v 1759.495n 0.0v 1759.505n 0.0v 1769.495n 0.0v 1769.505n 1.8v 1779.495n 1.8v 1779.505n 1.8v 1789.495n 1.8v 1789.505n 0.0v 1799.495n 0.0v 1799.505n 0.0v 1809.495n 0.0v 1809.505n 0.0v 1819.495n 0.0v 1819.505n 1.8v 1829.495n 1.8v 1829.505n 0.0v 1839.495n 0.0v 1839.505n 0.0v 1849.495n 0.0v 1849.505n 1.8v 1859.495n 1.8v 1859.505n 0.0v 1869.495n 0.0v 1869.505n 0.0v 1879.495n 0.0v 1879.505n 0.0v 1889.495n 0.0v 1889.505n 0.0v 1899.495n 0.0v 1899.505n 0.0v 1909.495n 0.0v 1909.505n 1.8v 1919.495n 1.8v 1919.505n 1.8v 1929.495n 1.8v 1929.505n 1.8v 1939.495n 1.8v 1939.505n 1.8v 1949.495n 1.8v 1949.505n 0.0v 1959.495n 0.0v 1959.505n 0.0v 1969.495n 0.0v 1969.505n 0.0v 1979.495n 0.0v 1979.505n 1.8v 1989.495n 1.8v 1989.505n 0.0v 1999.495n 0.0v 1999.505n 0.0v 2009.495n 0.0v 2009.505n 1.8v 2019.495n 1.8v 2019.505n 0.0v 2029.495n 0.0v 2029.505n 0.0v 2039.495n 0.0v 2039.505n 0.0v 2049.495n 0.0v 2049.505n 0.0v )
* (time, data): [(0, 0), (10, 0), (20, 0), (30, 0), (40, 0), (50, 0), (60, 0), (70, 0), (80, 0), (90, 1), (100, 1), (110, 1), (120, 0), (130, 0), (140, 0), (150, 1), (160, 1), (170, 1), (180, 0), (190, 0), (200, 1), (210, 1), (220, 1), (230, 1), (240, 1), (250, 1), (260, 1), (270, 1), (280, 1), (290, 1), (300, 0), (310, 0), (320, 0), (330, 1), (340, 0), (350, 1), (360, 1), (370, 1), (380, 0), (390, 0), (400, 1), (410, 1), (420, 0), (430, 1), (440, 1), (450, 1), (460, 1), (470, 0), (480, 0), (490, 1), (500, 0), (510, 0), (520, 0), (530, 1), (540, 1), (550, 1), (560, 1), (570, 1), (580, 0), (590, 1), (600, 0), (610, 1), (620, 1), (630, 1), (640, 0), (650, 0), (660, 1), (670, 0), (680, 0), (690, 1), (700, 0), (710, 0), (720, 0), (730, 0), (740, 1), (750, 1), (760, 0), (770, 0), (780, 0), (790, 1), (800, 1), (810, 0), (820, 1), (830, 1), (840, 0), (850, 1), (860, 0), (870, 0), (880, 1), (890, 0), (900, 0), (910, 0), (920, 1), (930, 1), (940, 1), (950, 1), (960, 1), (970, 0), (980, 1), (990, 1), (1000, 1), (1010, 1), (1020, 1), (1030, 1), (1040, 1), (1050, 0), (1060, 0), (1070, 0), (1080, 1), (1090, 1), (1100, 0), (1110, 0), (1120, 1), (1130, 0), (1140, 0), (1150, 0), (1160, 0), (1170, 1), (1180, 0), (1190, 1), (1200, 1), (1210, 1), (1220, 1), (1230, 0), (1240, 0), (1250, 0), (1260, 0), (1270, 0), (1280, 1), (1290, 0), (1300, 0), (1310, 0), (1320, 1), (1330, 0), (1340, 0), (1350, 1), (1360, 1), (1370, 1), (1380, 1), (1390, 1), (1400, 0), (1410, 0), (1420, 0), (1430, 1), (1440, 1), (1450, 1), (1460, 1), (1470, 1), (1480, 1), (1490, 1), (1500, 1), (1510, 0), (1520, 1), (1530, 1), (1540, 1), (1550, 0), (1560, 0), (1570, 0), (1580, 0), (1590, 0), (1600, 0), (1610, 0), (1620, 1), (1630, 0), (1640, 0), (1650, 1), (1660, 1), (1670, 0), (1680, 1), (1690, 1), (1700, 1), (1710, 1), (1720, 1), (1730, 0), (1740, 0), (1750, 0), (1760, 0), (1770, 1), (1780, 1), (1790, 0), (1800, 0), (1810, 0), (1820, 1), (1830, 0), (1840, 0), (1850, 1), (1860, 0), (1870, 0), (1880, 0), (1890, 0), (1900, 0), (1910, 1), (1920, 1), (1930, 1), (1940, 1), (1950, 0), (1960, 0), (1970, 0), (1980, 1), (1990, 0), (2000, 0), (2010, 1), (2020, 0), (2030, 0), (2040, 0), (2050, 0)]
Va0_2  a0_2  0 PWL (0n 0.0v 9.495n 0.0v 9.505n 0.0v 19.495n 0.0v 19.505n 0.0v 29.495n 0.0v 29.505n 0.0v 39.495n 0.0v 39.505n 0.0v 49.495n 0.0v 49.505n 0.0v 59.495n 0.0v 59.505n 0.0v 69.495n 0.0v 69.505n 0.0v 79.495n 0.0v 79.505n 0.0v 89.495n 0.0v 89.505n 1.8v 99.495n 1.8v 99.505n 1.8v 109.495n 1.8v 109.505n 1.8v 119.495n 1.8v 119.505n 0.0v 129.495n 0.0v 129.505n 0.0v 139.495n 0.0v 139.505n 0.0v 149.495n 0.0v 149.505n 1.8v 159.495n 1.8v 159.505n 1.8v 169.495n 1.8v 169.505n 1.8v 179.495n 1.8v 179.505n 0.0v 189.495n 0.0v 189.505n 0.0v 199.495n 0.0v 199.505n 1.8v 209.495n 1.8v 209.505n 1.8v 219.495n 1.8v 219.505n 1.8v 229.495n 1.8v 229.505n 1.8v 239.495n 1.8v 239.505n 1.8v 249.495n 1.8v 249.505n 1.8v 259.495n 1.8v 259.505n 1.8v 269.495n 1.8v 269.505n 1.8v 279.495n 1.8v 279.505n 1.8v 289.495n 1.8v 289.505n 1.8v 299.495n 1.8v 299.505n 0.0v 309.495n 0.0v 309.505n 0.0v 319.495n 0.0v 319.505n 0.0v 329.495n 0.0v 329.505n 1.8v 339.495n 1.8v 339.505n 0.0v 349.495n 0.0v 349.505n 1.8v 359.495n 1.8v 359.505n 1.8v 369.495n 1.8v 369.505n 1.8v 379.495n 1.8v 379.505n 0.0v 389.495n 0.0v 389.505n 0.0v 399.495n 0.0v 399.505n 1.8v 409.495n 1.8v 409.505n 1.8v 419.495n 1.8v 419.505n 0.0v 429.495n 0.0v 429.505n 1.8v 439.495n 1.8v 439.505n 1.8v 449.495n 1.8v 449.505n 1.8v 459.495n 1.8v 459.505n 1.8v 469.495n 1.8v 469.505n 0.0v 479.495n 0.0v 479.505n 0.0v 489.495n 0.0v 489.505n 1.8v 499.495n 1.8v 499.505n 0.0v 509.495n 0.0v 509.505n 0.0v 519.495n 0.0v 519.505n 0.0v 529.495n 0.0v 529.505n 1.8v 539.495n 1.8v 539.505n 1.8v 549.495n 1.8v 549.505n 1.8v 559.495n 1.8v 559.505n 1.8v 569.495n 1.8v 569.505n 1.8v 579.495n 1.8v 579.505n 0.0v 589.495n 0.0v 589.505n 1.8v 599.495n 1.8v 599.505n 0.0v 609.495n 0.0v 609.505n 1.8v 619.495n 1.8v 619.505n 1.8v 629.495n 1.8v 629.505n 1.8v 639.495n 1.8v 639.505n 0.0v 649.495n 0.0v 649.505n 0.0v 659.495n 0.0v 659.505n 1.8v 669.495n 1.8v 669.505n 0.0v 679.495n 0.0v 679.505n 0.0v 689.495n 0.0v 689.505n 1.8v 699.495n 1.8v 699.505n 0.0v 709.495n 0.0v 709.505n 0.0v 719.495n 0.0v 719.505n 0.0v 729.495n 0.0v 729.505n 0.0v 739.495n 0.0v 739.505n 1.8v 749.495n 1.8v 749.505n 1.8v 759.495n 1.8v 759.505n 0.0v 769.495n 0.0v 769.505n 0.0v 779.495n 0.0v 779.505n 0.0v 789.495n 0.0v 789.505n 1.8v 799.495n 1.8v 799.505n 1.8v 809.495n 1.8v 809.505n 0.0v 819.495n 0.0v 819.505n 1.8v 829.495n 1.8v 829.505n 1.8v 839.495n 1.8v 839.505n 0.0v 849.495n 0.0v 849.505n 1.8v 859.495n 1.8v 859.505n 0.0v 869.495n 0.0v 869.505n 0.0v 879.495n 0.0v 879.505n 1.8v 889.495n 1.8v 889.505n 0.0v 899.495n 0.0v 899.505n 0.0v 909.495n 0.0v 909.505n 0.0v 919.495n 0.0v 919.505n 1.8v 929.495n 1.8v 929.505n 1.8v 939.495n 1.8v 939.505n 1.8v 949.495n 1.8v 949.505n 1.8v 959.495n 1.8v 959.505n 1.8v 969.495n 1.8v 969.505n 0.0v 979.495n 0.0v 979.505n 1.8v 989.495n 1.8v 989.505n 1.8v 999.495n 1.8v 999.505n 1.8v 1009.495n 1.8v 1009.505n 1.8v 1019.495n 1.8v 1019.505n 1.8v 1029.495n 1.8v 1029.505n 1.8v 1039.495n 1.8v 1039.505n 1.8v 1049.495n 1.8v 1049.505n 0.0v 1059.495n 0.0v 1059.505n 0.0v 1069.495n 0.0v 1069.505n 0.0v 1079.495n 0.0v 1079.505n 1.8v 1089.495n 1.8v 1089.505n 1.8v 1099.495n 1.8v 1099.505n 0.0v 1109.495n 0.0v 1109.505n 0.0v 1119.495n 0.0v 1119.505n 1.8v 1129.495n 1.8v 1129.505n 0.0v 1139.495n 0.0v 1139.505n 0.0v 1149.495n 0.0v 1149.505n 0.0v 1159.495n 0.0v 1159.505n 0.0v 1169.495n 0.0v 1169.505n 1.8v 1179.495n 1.8v 1179.505n 0.0v 1189.495n 0.0v 1189.505n 1.8v 1199.495n 1.8v 1199.505n 1.8v 1209.495n 1.8v 1209.505n 1.8v 1219.495n 1.8v 1219.505n 1.8v 1229.495n 1.8v 1229.505n 0.0v 1239.495n 0.0v 1239.505n 0.0v 1249.495n 0.0v 1249.505n 0.0v 1259.495n 0.0v 1259.505n 0.0v 1269.495n 0.0v 1269.505n 0.0v 1279.495n 0.0v 1279.505n 1.8v 1289.495n 1.8v 1289.505n 0.0v 1299.495n 0.0v 1299.505n 0.0v 1309.495n 0.0v 1309.505n 0.0v 1319.495n 0.0v 1319.505n 1.8v 1329.495n 1.8v 1329.505n 0.0v 1339.495n 0.0v 1339.505n 0.0v 1349.495n 0.0v 1349.505n 1.8v 1359.495n 1.8v 1359.505n 1.8v 1369.495n 1.8v 1369.505n 1.8v 1379.495n 1.8v 1379.505n 1.8v 1389.495n 1.8v 1389.505n 1.8v 1399.495n 1.8v 1399.505n 0.0v 1409.495n 0.0v 1409.505n 0.0v 1419.495n 0.0v 1419.505n 0.0v 1429.495n 0.0v 1429.505n 1.8v 1439.495n 1.8v 1439.505n 1.8v 1449.495n 1.8v 1449.505n 1.8v 1459.495n 1.8v 1459.505n 1.8v 1469.495n 1.8v 1469.505n 1.8v 1479.495n 1.8v 1479.505n 1.8v 1489.495n 1.8v 1489.505n 1.8v 1499.495n 1.8v 1499.505n 1.8v 1509.495n 1.8v 1509.505n 0.0v 1519.495n 0.0v 1519.505n 1.8v 1529.495n 1.8v 1529.505n 1.8v 1539.495n 1.8v 1539.505n 1.8v 1549.495n 1.8v 1549.505n 0.0v 1559.495n 0.0v 1559.505n 0.0v 1569.495n 0.0v 1569.505n 0.0v 1579.495n 0.0v 1579.505n 0.0v 1589.495n 0.0v 1589.505n 0.0v 1599.495n 0.0v 1599.505n 0.0v 1609.495n 0.0v 1609.505n 0.0v 1619.495n 0.0v 1619.505n 1.8v 1629.495n 1.8v 1629.505n 0.0v 1639.495n 0.0v 1639.505n 0.0v 1649.495n 0.0v 1649.505n 1.8v 1659.495n 1.8v 1659.505n 1.8v 1669.495n 1.8v 1669.505n 0.0v 1679.495n 0.0v 1679.505n 1.8v 1689.495n 1.8v 1689.505n 1.8v 1699.495n 1.8v 1699.505n 1.8v 1709.495n 1.8v 1709.505n 1.8v 1719.495n 1.8v 1719.505n 1.8v 1729.495n 1.8v 1729.505n 0.0v 1739.495n 0.0v 1739.505n 0.0v 1749.495n 0.0v 1749.505n 0.0v 1759.495n 0.0v 1759.505n 0.0v 1769.495n 0.0v 1769.505n 1.8v 1779.495n 1.8v 1779.505n 1.8v 1789.495n 1.8v 1789.505n 0.0v 1799.495n 0.0v 1799.505n 0.0v 1809.495n 0.0v 1809.505n 0.0v 1819.495n 0.0v 1819.505n 1.8v 1829.495n 1.8v 1829.505n 0.0v 1839.495n 0.0v 1839.505n 0.0v 1849.495n 0.0v 1849.505n 1.8v 1859.495n 1.8v 1859.505n 0.0v 1869.495n 0.0v 1869.505n 0.0v 1879.495n 0.0v 1879.505n 0.0v 1889.495n 0.0v 1889.505n 0.0v 1899.495n 0.0v 1899.505n 0.0v 1909.495n 0.0v 1909.505n 1.8v 1919.495n 1.8v 1919.505n 1.8v 1929.495n 1.8v 1929.505n 1.8v 1939.495n 1.8v 1939.505n 1.8v 1949.495n 1.8v 1949.505n 0.0v 1959.495n 0.0v 1959.505n 0.0v 1969.495n 0.0v 1969.505n 0.0v 1979.495n 0.0v 1979.505n 1.8v 1989.495n 1.8v 1989.505n 0.0v 1999.495n 0.0v 1999.505n 0.0v 2009.495n 0.0v 2009.505n 1.8v 2019.495n 1.8v 2019.505n 0.0v 2029.495n 0.0v 2029.505n 0.0v 2039.495n 0.0v 2039.505n 0.0v 2049.495n 0.0v 2049.505n 0.0v )
* (time, data): [(0, 0), (10, 0), (20, 0), (30, 0), (40, 0), (50, 0), (60, 0), (70, 0), (80, 0), (90, 1), (100, 1), (110, 1), (120, 0), (130, 0), (140, 0), (150, 1), (160, 1), (170, 1), (180, 0), (190, 0), (200, 1), (210, 1), (220, 1), (230, 1), (240, 1), (250, 1), (260, 1), (270, 1), (280, 1), (290, 1), (300, 0), (310, 0), (320, 0), (330, 1), (340, 0), (350, 1), (360, 1), (370, 1), (380, 0), (390, 0), (400, 1), (410, 1), (420, 0), (430, 1), (440, 1), (450, 1), (460, 1), (470, 0), (480, 0), (490, 1), (500, 0), (510, 0), (520, 0), (530, 1), (540, 1), (550, 1), (560, 1), (570, 1), (580, 0), (590, 1), (600, 0), (610, 1), (620, 1), (630, 1), (640, 0), (650, 0), (660, 1), (670, 0), (680, 0), (690, 1), (700, 0), (710, 0), (720, 0), (730, 0), (740, 1), (750, 1), (760, 0), (770, 0), (780, 0), (790, 1), (800, 1), (810, 0), (820, 1), (830, 1), (840, 0), (850, 1), (860, 0), (870, 0), (880, 1), (890, 0), (900, 0), (910, 0), (920, 1), (930, 1), (940, 1), (950, 1), (960, 1), (970, 0), (980, 1), (990, 1), (1000, 1), (1010, 1), (1020, 1), (1030, 1), (1040, 1), (1050, 0), (1060, 0), (1070, 0), (1080, 1), (1090, 1), (1100, 0), (1110, 0), (1120, 1), (1130, 0), (1140, 0), (1150, 0), (1160, 0), (1170, 1), (1180, 0), (1190, 1), (1200, 1), (1210, 1), (1220, 1), (1230, 0), (1240, 0), (1250, 0), (1260, 0), (1270, 0), (1280, 1), (1290, 0), (1300, 0), (1310, 0), (1320, 1), (1330, 0), (1340, 0), (1350, 1), (1360, 1), (1370, 1), (1380, 1), (1390, 1), (1400, 0), (1410, 0), (1420, 0), (1430, 1), (1440, 1), (1450, 1), (1460, 1), (1470, 1), (1480, 1), (1490, 1), (1500, 1), (1510, 0), (1520, 1), (1530, 1), (1540, 1), (1550, 0), (1560, 0), (1570, 0), (1580, 0), (1590, 0), (1600, 0), (1610, 0), (1620, 1), (1630, 0), (1640, 0), (1650, 1), (1660, 1), (1670, 0), (1680, 1), (1690, 1), (1700, 1), (1710, 1), (1720, 1), (1730, 0), (1740, 0), (1750, 0), (1760, 0), (1770, 1), (1780, 1), (1790, 0), (1800, 0), (1810, 0), (1820, 1), (1830, 0), (1840, 0), (1850, 1), (1860, 0), (1870, 0), (1880, 0), (1890, 0), (1900, 0), (1910, 1), (1920, 1), (1930, 1), (1940, 1), (1950, 0), (1960, 0), (1970, 0), (1980, 1), (1990, 0), (2000, 0), (2010, 1), (2020, 0), (2030, 0), (2040, 0), (2050, 0)]
Va0_3  a0_3  0 PWL (0n 0.0v 9.495n 0.0v 9.505n 0.0v 19.495n 0.0v 19.505n 0.0v 29.495n 0.0v 29.505n 0.0v 39.495n 0.0v 39.505n 0.0v 49.495n 0.0v 49.505n 0.0v 59.495n 0.0v 59.505n 0.0v 69.495n 0.0v 69.505n 0.0v 79.495n 0.0v 79.505n 0.0v 89.495n 0.0v 89.505n 1.8v 99.495n 1.8v 99.505n 1.8v 109.495n 1.8v 109.505n 1.8v 119.495n 1.8v 119.505n 0.0v 129.495n 0.0v 129.505n 0.0v 139.495n 0.0v 139.505n 0.0v 149.495n 0.0v 149.505n 1.8v 159.495n 1.8v 159.505n 1.8v 169.495n 1.8v 169.505n 1.8v 179.495n 1.8v 179.505n 0.0v 189.495n 0.0v 189.505n 0.0v 199.495n 0.0v 199.505n 1.8v 209.495n 1.8v 209.505n 1.8v 219.495n 1.8v 219.505n 1.8v 229.495n 1.8v 229.505n 1.8v 239.495n 1.8v 239.505n 1.8v 249.495n 1.8v 249.505n 1.8v 259.495n 1.8v 259.505n 1.8v 269.495n 1.8v 269.505n 1.8v 279.495n 1.8v 279.505n 1.8v 289.495n 1.8v 289.505n 1.8v 299.495n 1.8v 299.505n 0.0v 309.495n 0.0v 309.505n 0.0v 319.495n 0.0v 319.505n 0.0v 329.495n 0.0v 329.505n 1.8v 339.495n 1.8v 339.505n 0.0v 349.495n 0.0v 349.505n 1.8v 359.495n 1.8v 359.505n 1.8v 369.495n 1.8v 369.505n 1.8v 379.495n 1.8v 379.505n 0.0v 389.495n 0.0v 389.505n 0.0v 399.495n 0.0v 399.505n 1.8v 409.495n 1.8v 409.505n 1.8v 419.495n 1.8v 419.505n 0.0v 429.495n 0.0v 429.505n 1.8v 439.495n 1.8v 439.505n 1.8v 449.495n 1.8v 449.505n 1.8v 459.495n 1.8v 459.505n 1.8v 469.495n 1.8v 469.505n 0.0v 479.495n 0.0v 479.505n 0.0v 489.495n 0.0v 489.505n 1.8v 499.495n 1.8v 499.505n 0.0v 509.495n 0.0v 509.505n 0.0v 519.495n 0.0v 519.505n 0.0v 529.495n 0.0v 529.505n 1.8v 539.495n 1.8v 539.505n 1.8v 549.495n 1.8v 549.505n 1.8v 559.495n 1.8v 559.505n 1.8v 569.495n 1.8v 569.505n 1.8v 579.495n 1.8v 579.505n 0.0v 589.495n 0.0v 589.505n 1.8v 599.495n 1.8v 599.505n 0.0v 609.495n 0.0v 609.505n 1.8v 619.495n 1.8v 619.505n 1.8v 629.495n 1.8v 629.505n 1.8v 639.495n 1.8v 639.505n 0.0v 649.495n 0.0v 649.505n 0.0v 659.495n 0.0v 659.505n 1.8v 669.495n 1.8v 669.505n 0.0v 679.495n 0.0v 679.505n 0.0v 689.495n 0.0v 689.505n 1.8v 699.495n 1.8v 699.505n 0.0v 709.495n 0.0v 709.505n 0.0v 719.495n 0.0v 719.505n 0.0v 729.495n 0.0v 729.505n 0.0v 739.495n 0.0v 739.505n 1.8v 749.495n 1.8v 749.505n 1.8v 759.495n 1.8v 759.505n 0.0v 769.495n 0.0v 769.505n 0.0v 779.495n 0.0v 779.505n 0.0v 789.495n 0.0v 789.505n 1.8v 799.495n 1.8v 799.505n 1.8v 809.495n 1.8v 809.505n 0.0v 819.495n 0.0v 819.505n 1.8v 829.495n 1.8v 829.505n 1.8v 839.495n 1.8v 839.505n 0.0v 849.495n 0.0v 849.505n 1.8v 859.495n 1.8v 859.505n 0.0v 869.495n 0.0v 869.505n 0.0v 879.495n 0.0v 879.505n 1.8v 889.495n 1.8v 889.505n 0.0v 899.495n 0.0v 899.505n 0.0v 909.495n 0.0v 909.505n 0.0v 919.495n 0.0v 919.505n 1.8v 929.495n 1.8v 929.505n 1.8v 939.495n 1.8v 939.505n 1.8v 949.495n 1.8v 949.505n 1.8v 959.495n 1.8v 959.505n 1.8v 969.495n 1.8v 969.505n 0.0v 979.495n 0.0v 979.505n 1.8v 989.495n 1.8v 989.505n 1.8v 999.495n 1.8v 999.505n 1.8v 1009.495n 1.8v 1009.505n 1.8v 1019.495n 1.8v 1019.505n 1.8v 1029.495n 1.8v 1029.505n 1.8v 1039.495n 1.8v 1039.505n 1.8v 1049.495n 1.8v 1049.505n 0.0v 1059.495n 0.0v 1059.505n 0.0v 1069.495n 0.0v 1069.505n 0.0v 1079.495n 0.0v 1079.505n 1.8v 1089.495n 1.8v 1089.505n 1.8v 1099.495n 1.8v 1099.505n 0.0v 1109.495n 0.0v 1109.505n 0.0v 1119.495n 0.0v 1119.505n 1.8v 1129.495n 1.8v 1129.505n 0.0v 1139.495n 0.0v 1139.505n 0.0v 1149.495n 0.0v 1149.505n 0.0v 1159.495n 0.0v 1159.505n 0.0v 1169.495n 0.0v 1169.505n 1.8v 1179.495n 1.8v 1179.505n 0.0v 1189.495n 0.0v 1189.505n 1.8v 1199.495n 1.8v 1199.505n 1.8v 1209.495n 1.8v 1209.505n 1.8v 1219.495n 1.8v 1219.505n 1.8v 1229.495n 1.8v 1229.505n 0.0v 1239.495n 0.0v 1239.505n 0.0v 1249.495n 0.0v 1249.505n 0.0v 1259.495n 0.0v 1259.505n 0.0v 1269.495n 0.0v 1269.505n 0.0v 1279.495n 0.0v 1279.505n 1.8v 1289.495n 1.8v 1289.505n 0.0v 1299.495n 0.0v 1299.505n 0.0v 1309.495n 0.0v 1309.505n 0.0v 1319.495n 0.0v 1319.505n 1.8v 1329.495n 1.8v 1329.505n 0.0v 1339.495n 0.0v 1339.505n 0.0v 1349.495n 0.0v 1349.505n 1.8v 1359.495n 1.8v 1359.505n 1.8v 1369.495n 1.8v 1369.505n 1.8v 1379.495n 1.8v 1379.505n 1.8v 1389.495n 1.8v 1389.505n 1.8v 1399.495n 1.8v 1399.505n 0.0v 1409.495n 0.0v 1409.505n 0.0v 1419.495n 0.0v 1419.505n 0.0v 1429.495n 0.0v 1429.505n 1.8v 1439.495n 1.8v 1439.505n 1.8v 1449.495n 1.8v 1449.505n 1.8v 1459.495n 1.8v 1459.505n 1.8v 1469.495n 1.8v 1469.505n 1.8v 1479.495n 1.8v 1479.505n 1.8v 1489.495n 1.8v 1489.505n 1.8v 1499.495n 1.8v 1499.505n 1.8v 1509.495n 1.8v 1509.505n 0.0v 1519.495n 0.0v 1519.505n 1.8v 1529.495n 1.8v 1529.505n 1.8v 1539.495n 1.8v 1539.505n 1.8v 1549.495n 1.8v 1549.505n 0.0v 1559.495n 0.0v 1559.505n 0.0v 1569.495n 0.0v 1569.505n 0.0v 1579.495n 0.0v 1579.505n 0.0v 1589.495n 0.0v 1589.505n 0.0v 1599.495n 0.0v 1599.505n 0.0v 1609.495n 0.0v 1609.505n 0.0v 1619.495n 0.0v 1619.505n 1.8v 1629.495n 1.8v 1629.505n 0.0v 1639.495n 0.0v 1639.505n 0.0v 1649.495n 0.0v 1649.505n 1.8v 1659.495n 1.8v 1659.505n 1.8v 1669.495n 1.8v 1669.505n 0.0v 1679.495n 0.0v 1679.505n 1.8v 1689.495n 1.8v 1689.505n 1.8v 1699.495n 1.8v 1699.505n 1.8v 1709.495n 1.8v 1709.505n 1.8v 1719.495n 1.8v 1719.505n 1.8v 1729.495n 1.8v 1729.505n 0.0v 1739.495n 0.0v 1739.505n 0.0v 1749.495n 0.0v 1749.505n 0.0v 1759.495n 0.0v 1759.505n 0.0v 1769.495n 0.0v 1769.505n 1.8v 1779.495n 1.8v 1779.505n 1.8v 1789.495n 1.8v 1789.505n 0.0v 1799.495n 0.0v 1799.505n 0.0v 1809.495n 0.0v 1809.505n 0.0v 1819.495n 0.0v 1819.505n 1.8v 1829.495n 1.8v 1829.505n 0.0v 1839.495n 0.0v 1839.505n 0.0v 1849.495n 0.0v 1849.505n 1.8v 1859.495n 1.8v 1859.505n 0.0v 1869.495n 0.0v 1869.505n 0.0v 1879.495n 0.0v 1879.505n 0.0v 1889.495n 0.0v 1889.505n 0.0v 1899.495n 0.0v 1899.505n 0.0v 1909.495n 0.0v 1909.505n 1.8v 1919.495n 1.8v 1919.505n 1.8v 1929.495n 1.8v 1929.505n 1.8v 1939.495n 1.8v 1939.505n 1.8v 1949.495n 1.8v 1949.505n 0.0v 1959.495n 0.0v 1959.505n 0.0v 1969.495n 0.0v 1969.505n 0.0v 1979.495n 0.0v 1979.505n 1.8v 1989.495n 1.8v 1989.505n 0.0v 1999.495n 0.0v 1999.505n 0.0v 2009.495n 0.0v 2009.505n 1.8v 2019.495n 1.8v 2019.505n 0.0v 2029.495n 0.0v 2029.505n 0.0v 2039.495n 0.0v 2039.505n 0.0v 2049.495n 0.0v 2049.505n 0.0v )
* (time, data): [(0, 0), (10, 0), (20, 0), (30, 0), (40, 0), (50, 0), (60, 0), (70, 0), (80, 0), (90, 0), (100, 0), (110, 0), (120, 0), (130, 0), (140, 0), (150, 0), (160, 0), (170, 0), (180, 0), (190, 0), (200, 0), (210, 0), (220, 0), (230, 0), (240, 0), (250, 0), (260, 0), (270, 0), (280, 0), (290, 0), (300, 0), (310, 0), (320, 0), (330, 0), (340, 0), (350, 0), (360, 0), (370, 0), (380, 0), (390, 0), (400, 0), (410, 0), (420, 0), (430, 0), (440, 0), (450, 0), (460, 0), (470, 0), (480, 0), (490, 0), (500, 0), (510, 0), (520, 0), (530, 0), (540, 0), (550, 0), (560, 0), (570, 0), (580, 0), (590, 0), (600, 0), (610, 0), (620, 0), (630, 0), (640, 0), (650, 0), (660, 0), (670, 0), (680, 0), (690, 0), (700, 0), (710, 0), (720, 0), (730, 0), (740, 0), (750, 0), (760, 0), (770, 0), (780, 0), (790, 0), (800, 0), (810, 0), (820, 0), (830, 0), (840, 0), (850, 0), (860, 0), (870, 0), (880, 0), (890, 0), (900, 0), (910, 0), (920, 0), (930, 0), (940, 0), (950, 0), (960, 0), (970, 0), (980, 0), (990, 0), (1000, 0), (1010, 0), (1020, 0), (1030, 0), (1040, 0), (1050, 0), (1060, 0), (1070, 0), (1080, 0), (1090, 0), (1100, 0), (1110, 0), (1120, 0), (1130, 0), (1140, 0), (1150, 0), (1160, 0), (1170, 0), (1180, 0), (1190, 0), (1200, 0), (1210, 0), (1220, 0), (1230, 0), (1240, 0), (1250, 0), (1260, 0), (1270, 0), (1280, 0), (1290, 0), (1300, 0), (1310, 0), (1320, 0), (1330, 0), (1340, 0), (1350, 0), (1360, 0), (1370, 0), (1380, 0), (1390, 0), (1400, 0), (1410, 0), (1420, 0), (1430, 0), (1440, 0), (1450, 0), (1460, 0), (1470, 0), (1480, 0), (1490, 0), (1500, 0), (1510, 0), (1520, 0), (1530, 0), (1540, 0), (1550, 0), (1560, 0), (1570, 0), (1580, 0), (1590, 0), (1600, 0), (1610, 0), (1620, 0), (1630, 0), (1640, 0), (1650, 0), (1660, 0), (1670, 0), (1680, 0), (1690, 0), (1700, 0), (1710, 0), (1720, 0), (1730, 0), (1740, 0), (1750, 0), (1760, 0), (1770, 0), (1780, 0), (1790, 0), (1800, 0), (1810, 0), (1820, 0), (1830, 0), (1840, 0), (1850, 0), (1860, 0), (1870, 0), (1880, 0), (1890, 0), (1900, 0), (1910, 0), (1920, 0), (1930, 0), (1940, 0), (1950, 0), (1960, 0), (1970, 0), (1980, 0), (1990, 0), (2000, 0), (2010, 0), (2020, 0), (2030, 0), (2040, 0), (2050, 0)]
Va1_0  a1_0  0 PWL (0n 0.0v 9.495n 0.0v 9.505n 0.0v 19.495n 0.0v 19.505n 0.0v 29.495n 0.0v 29.505n 0.0v 39.495n 0.0v 39.505n 0.0v 49.495n 0.0v 49.505n 0.0v 59.495n 0.0v 59.505n 0.0v 69.495n 0.0v 69.505n 0.0v 79.495n 0.0v 79.505n 0.0v 89.495n 0.0v 89.505n 0.0v 99.495n 0.0v 99.505n 0.0v 109.495n 0.0v 109.505n 0.0v 119.495n 0.0v 119.505n 0.0v 129.495n 0.0v 129.505n 0.0v 139.495n 0.0v 139.505n 0.0v 149.495n 0.0v 149.505n 0.0v 159.495n 0.0v 159.505n 0.0v 169.495n 0.0v 169.505n 0.0v 179.495n 0.0v 179.505n 0.0v 189.495n 0.0v 189.505n 0.0v 199.495n 0.0v 199.505n 0.0v 209.495n 0.0v 209.505n 0.0v 219.495n 0.0v 219.505n 0.0v 229.495n 0.0v 229.505n 0.0v 239.495n 0.0v 239.505n 0.0v 249.495n 0.0v 249.505n 0.0v 259.495n 0.0v 259.505n 0.0v 269.495n 0.0v 269.505n 0.0v 279.495n 0.0v 279.505n 0.0v 289.495n 0.0v 289.505n 0.0v 299.495n 0.0v 299.505n 0.0v 309.495n 0.0v 309.505n 0.0v 319.495n 0.0v 319.505n 0.0v 329.495n 0.0v 329.505n 0.0v 339.495n 0.0v 339.505n 0.0v 349.495n 0.0v 349.505n 0.0v 359.495n 0.0v 359.505n 0.0v 369.495n 0.0v 369.505n 0.0v 379.495n 0.0v 379.505n 0.0v 389.495n 0.0v 389.505n 0.0v 399.495n 0.0v 399.505n 0.0v 409.495n 0.0v 409.505n 0.0v 419.495n 0.0v 419.505n 0.0v 429.495n 0.0v 429.505n 0.0v 439.495n 0.0v 439.505n 0.0v 449.495n 0.0v 449.505n 0.0v 459.495n 0.0v 459.505n 0.0v 469.495n 0.0v 469.505n 0.0v 479.495n 0.0v 479.505n 0.0v 489.495n 0.0v 489.505n 0.0v 499.495n 0.0v 499.505n 0.0v 509.495n 0.0v 509.505n 0.0v 519.495n 0.0v 519.505n 0.0v 529.495n 0.0v 529.505n 0.0v 539.495n 0.0v 539.505n 0.0v 549.495n 0.0v 549.505n 0.0v 559.495n 0.0v 559.505n 0.0v 569.495n 0.0v 569.505n 0.0v 579.495n 0.0v 579.505n 0.0v 589.495n 0.0v 589.505n 0.0v 599.495n 0.0v 599.505n 0.0v 609.495n 0.0v 609.505n 0.0v 619.495n 0.0v 619.505n 0.0v 629.495n 0.0v 629.505n 0.0v 639.495n 0.0v 639.505n 0.0v 649.495n 0.0v 649.505n 0.0v 659.495n 0.0v 659.505n 0.0v 669.495n 0.0v 669.505n 0.0v 679.495n 0.0v 679.505n 0.0v 689.495n 0.0v 689.505n 0.0v 699.495n 0.0v 699.505n 0.0v 709.495n 0.0v 709.505n 0.0v 719.495n 0.0v 719.505n 0.0v 729.495n 0.0v 729.505n 0.0v 739.495n 0.0v 739.505n 0.0v 749.495n 0.0v 749.505n 0.0v 759.495n 0.0v 759.505n 0.0v 769.495n 0.0v 769.505n 0.0v 779.495n 0.0v 779.505n 0.0v 789.495n 0.0v 789.505n 0.0v 799.495n 0.0v 799.505n 0.0v 809.495n 0.0v 809.505n 0.0v 819.495n 0.0v 819.505n 0.0v 829.495n 0.0v 829.505n 0.0v 839.495n 0.0v 839.505n 0.0v 849.495n 0.0v 849.505n 0.0v 859.495n 0.0v 859.505n 0.0v 869.495n 0.0v 869.505n 0.0v 879.495n 0.0v 879.505n 0.0v 889.495n 0.0v 889.505n 0.0v 899.495n 0.0v 899.505n 0.0v 909.495n 0.0v 909.505n 0.0v 919.495n 0.0v 919.505n 0.0v 929.495n 0.0v 929.505n 0.0v 939.495n 0.0v 939.505n 0.0v 949.495n 0.0v 949.505n 0.0v 959.495n 0.0v 959.505n 0.0v 969.495n 0.0v 969.505n 0.0v 979.495n 0.0v 979.505n 0.0v 989.495n 0.0v 989.505n 0.0v 999.495n 0.0v 999.505n 0.0v 1009.495n 0.0v 1009.505n 0.0v 1019.495n 0.0v 1019.505n 0.0v 1029.495n 0.0v 1029.505n 0.0v 1039.495n 0.0v 1039.505n 0.0v 1049.495n 0.0v 1049.505n 0.0v 1059.495n 0.0v 1059.505n 0.0v 1069.495n 0.0v 1069.505n 0.0v 1079.495n 0.0v 1079.505n 0.0v 1089.495n 0.0v 1089.505n 0.0v 1099.495n 0.0v 1099.505n 0.0v 1109.495n 0.0v 1109.505n 0.0v 1119.495n 0.0v 1119.505n 0.0v 1129.495n 0.0v 1129.505n 0.0v 1139.495n 0.0v 1139.505n 0.0v 1149.495n 0.0v 1149.505n 0.0v 1159.495n 0.0v 1159.505n 0.0v 1169.495n 0.0v 1169.505n 0.0v 1179.495n 0.0v 1179.505n 0.0v 1189.495n 0.0v 1189.505n 0.0v 1199.495n 0.0v 1199.505n 0.0v 1209.495n 0.0v 1209.505n 0.0v 1219.495n 0.0v 1219.505n 0.0v 1229.495n 0.0v 1229.505n 0.0v 1239.495n 0.0v 1239.505n 0.0v 1249.495n 0.0v 1249.505n 0.0v 1259.495n 0.0v 1259.505n 0.0v 1269.495n 0.0v 1269.505n 0.0v 1279.495n 0.0v 1279.505n 0.0v 1289.495n 0.0v 1289.505n 0.0v 1299.495n 0.0v 1299.505n 0.0v 1309.495n 0.0v 1309.505n 0.0v 1319.495n 0.0v 1319.505n 0.0v 1329.495n 0.0v 1329.505n 0.0v 1339.495n 0.0v 1339.505n 0.0v 1349.495n 0.0v 1349.505n 0.0v 1359.495n 0.0v 1359.505n 0.0v 1369.495n 0.0v 1369.505n 0.0v 1379.495n 0.0v 1379.505n 0.0v 1389.495n 0.0v 1389.505n 0.0v 1399.495n 0.0v 1399.505n 0.0v 1409.495n 0.0v 1409.505n 0.0v 1419.495n 0.0v 1419.505n 0.0v 1429.495n 0.0v 1429.505n 0.0v 1439.495n 0.0v 1439.505n 0.0v 1449.495n 0.0v 1449.505n 0.0v 1459.495n 0.0v 1459.505n 0.0v 1469.495n 0.0v 1469.505n 0.0v 1479.495n 0.0v 1479.505n 0.0v 1489.495n 0.0v 1489.505n 0.0v 1499.495n 0.0v 1499.505n 0.0v 1509.495n 0.0v 1509.505n 0.0v 1519.495n 0.0v 1519.505n 0.0v 1529.495n 0.0v 1529.505n 0.0v 1539.495n 0.0v 1539.505n 0.0v 1549.495n 0.0v 1549.505n 0.0v 1559.495n 0.0v 1559.505n 0.0v 1569.495n 0.0v 1569.505n 0.0v 1579.495n 0.0v 1579.505n 0.0v 1589.495n 0.0v 1589.505n 0.0v 1599.495n 0.0v 1599.505n 0.0v 1609.495n 0.0v 1609.505n 0.0v 1619.495n 0.0v 1619.505n 0.0v 1629.495n 0.0v 1629.505n 0.0v 1639.495n 0.0v 1639.505n 0.0v 1649.495n 0.0v 1649.505n 0.0v 1659.495n 0.0v 1659.505n 0.0v 1669.495n 0.0v 1669.505n 0.0v 1679.495n 0.0v 1679.505n 0.0v 1689.495n 0.0v 1689.505n 0.0v 1699.495n 0.0v 1699.505n 0.0v 1709.495n 0.0v 1709.505n 0.0v 1719.495n 0.0v 1719.505n 0.0v 1729.495n 0.0v 1729.505n 0.0v 1739.495n 0.0v 1739.505n 0.0v 1749.495n 0.0v 1749.505n 0.0v 1759.495n 0.0v 1759.505n 0.0v 1769.495n 0.0v 1769.505n 0.0v 1779.495n 0.0v 1779.505n 0.0v 1789.495n 0.0v 1789.505n 0.0v 1799.495n 0.0v 1799.505n 0.0v 1809.495n 0.0v 1809.505n 0.0v 1819.495n 0.0v 1819.505n 0.0v 1829.495n 0.0v 1829.505n 0.0v 1839.495n 0.0v 1839.505n 0.0v 1849.495n 0.0v 1849.505n 0.0v 1859.495n 0.0v 1859.505n 0.0v 1869.495n 0.0v 1869.505n 0.0v 1879.495n 0.0v 1879.505n 0.0v 1889.495n 0.0v 1889.505n 0.0v 1899.495n 0.0v 1899.505n 0.0v 1909.495n 0.0v 1909.505n 0.0v 1919.495n 0.0v 1919.505n 0.0v 1929.495n 0.0v 1929.505n 0.0v 1939.495n 0.0v 1939.505n 0.0v 1949.495n 0.0v 1949.505n 0.0v 1959.495n 0.0v 1959.505n 0.0v 1969.495n 0.0v 1969.505n 0.0v 1979.495n 0.0v 1979.505n 0.0v 1989.495n 0.0v 1989.505n 0.0v 1999.495n 0.0v 1999.505n 0.0v 2009.495n 0.0v 2009.505n 0.0v 2019.495n 0.0v 2019.505n 0.0v 2029.495n 0.0v 2029.505n 0.0v 2039.495n 0.0v 2039.505n 0.0v 2049.495n 0.0v 2049.505n 0.0v )
* (time, data): [(0, 0), (10, 0), (20, 0), (30, 0), (40, 0), (50, 0), (60, 0), (70, 0), (80, 0), (90, 0), (100, 0), (110, 0), (120, 0), (130, 0), (140, 0), (150, 0), (160, 1), (170, 0), (180, 0), (190, 0), (200, 0), (210, 0), (220, 0), (230, 0), (240, 0), (250, 0), (260, 0), (270, 0), (280, 0), (290, 0), (300, 1), (310, 0), (320, 0), (330, 0), (340, 0), (350, 1), (360, 1), (370, 1), (380, 1), (390, 1), (400, 0), (410, 1), (420, 0), (430, 0), (440, 0), (450, 0), (460, 0), (470, 0), (480, 0), (490, 0), (500, 0), (510, 0), (520, 0), (530, 1), (540, 1), (550, 1), (560, 0), (570, 0), (580, 0), (590, 0), (600, 0), (610, 0), (620, 0), (630, 0), (640, 0), (650, 1), (660, 1), (670, 1), (680, 1), (690, 1), (700, 1), (710, 1), (720, 1), (730, 0), (740, 0), (750, 0), (760, 0), (770, 0), (780, 1), (790, 1), (800, 1), (810, 1), (820, 0), (830, 0), (840, 1), (850, 1), (860, 1), (870, 1), (880, 1), (890, 1), (900, 0), (910, 0), (920, 1), (930, 1), (940, 1), (950, 1), (960, 1), (970, 1), (980, 1), (990, 0), (1000, 0), (1010, 0), (1020, 1), (1030, 1), (1040, 1), (1050, 1), (1060, 1), (1070, 1), (1080, 1), (1090, 1), (1100, 1), (1110, 0), (1120, 0), (1130, 0), (1140, 0), (1150, 0), (1160, 0), (1170, 0), (1180, 1), (1190, 1), (1200, 1), (1210, 1), (1220, 0), (1230, 0), (1240, 1), (1250, 1), (1260, 1), (1270, 1), (1280, 1), (1290, 1), (1300, 1), (1310, 1), (1320, 1), (1330, 1), (1340, 0), (1350, 1), (1360, 1), (1370, 1), (1380, 1), (1390, 1), (1400, 1), (1410, 1), (1420, 1), (1430, 0), (1440, 0), (1450, 0), (1460, 0), (1470, 0), (1480, 0), (1490, 0), (1500, 0), (1510, 0), (1520, 0), (1530, 0), (1540, 0), (1550, 0), (1560, 1), (1570, 1), (1580, 1), (1590, 1), (1600, 1), (1610, 0), (1620, 0), (1630, 0), (1640, 1), (1650, 1), (1660, 1), (1670, 0), (1680, 1), (1690, 1), (1700, 1), (1710, 1), (1720, 0), (1730, 1), (1740, 1), (1750, 0), (1760, 1), (1770, 1), (1780, 1), (1790, 1), (1800, 1), (1810, 1), (1820, 1), (1830, 1), (1840, 0), (1850, 0), (1860, 1), (1870, 1), (1880, 1), (1890, 1), (1900, 1), (1910, 1), (1920, 1), (1930, 1), (1940, 1), (1950, 1), (1960, 1), (1970, 1), (1980, 1), (1990, 1), (2000, 0), (2010, 1), (2020, 0), (2030, 0), (2040, 0), (2050, 0)]
Va1_1  a1_1  0 PWL (0n 0.0v 9.495n 0.0v 9.505n 0.0v 19.495n 0.0v 19.505n 0.0v 29.495n 0.0v 29.505n 0.0v 39.495n 0.0v 39.505n 0.0v 49.495n 0.0v 49.505n 0.0v 59.495n 0.0v 59.505n 0.0v 69.495n 0.0v 69.505n 0.0v 79.495n 0.0v 79.505n 0.0v 89.495n 0.0v 89.505n 0.0v 99.495n 0.0v 99.505n 0.0v 109.495n 0.0v 109.505n 0.0v 119.495n 0.0v 119.505n 0.0v 129.495n 0.0v 129.505n 0.0v 139.495n 0.0v 139.505n 0.0v 149.495n 0.0v 149.505n 0.0v 159.495n 0.0v 159.505n 1.8v 169.495n 1.8v 169.505n 0.0v 179.495n 0.0v 179.505n 0.0v 189.495n 0.0v 189.505n 0.0v 199.495n 0.0v 199.505n 0.0v 209.495n 0.0v 209.505n 0.0v 219.495n 0.0v 219.505n 0.0v 229.495n 0.0v 229.505n 0.0v 239.495n 0.0v 239.505n 0.0v 249.495n 0.0v 249.505n 0.0v 259.495n 0.0v 259.505n 0.0v 269.495n 0.0v 269.505n 0.0v 279.495n 0.0v 279.505n 0.0v 289.495n 0.0v 289.505n 0.0v 299.495n 0.0v 299.505n 1.8v 309.495n 1.8v 309.505n 0.0v 319.495n 0.0v 319.505n 0.0v 329.495n 0.0v 329.505n 0.0v 339.495n 0.0v 339.505n 0.0v 349.495n 0.0v 349.505n 1.8v 359.495n 1.8v 359.505n 1.8v 369.495n 1.8v 369.505n 1.8v 379.495n 1.8v 379.505n 1.8v 389.495n 1.8v 389.505n 1.8v 399.495n 1.8v 399.505n 0.0v 409.495n 0.0v 409.505n 1.8v 419.495n 1.8v 419.505n 0.0v 429.495n 0.0v 429.505n 0.0v 439.495n 0.0v 439.505n 0.0v 449.495n 0.0v 449.505n 0.0v 459.495n 0.0v 459.505n 0.0v 469.495n 0.0v 469.505n 0.0v 479.495n 0.0v 479.505n 0.0v 489.495n 0.0v 489.505n 0.0v 499.495n 0.0v 499.505n 0.0v 509.495n 0.0v 509.505n 0.0v 519.495n 0.0v 519.505n 0.0v 529.495n 0.0v 529.505n 1.8v 539.495n 1.8v 539.505n 1.8v 549.495n 1.8v 549.505n 1.8v 559.495n 1.8v 559.505n 0.0v 569.495n 0.0v 569.505n 0.0v 579.495n 0.0v 579.505n 0.0v 589.495n 0.0v 589.505n 0.0v 599.495n 0.0v 599.505n 0.0v 609.495n 0.0v 609.505n 0.0v 619.495n 0.0v 619.505n 0.0v 629.495n 0.0v 629.505n 0.0v 639.495n 0.0v 639.505n 0.0v 649.495n 0.0v 649.505n 1.8v 659.495n 1.8v 659.505n 1.8v 669.495n 1.8v 669.505n 1.8v 679.495n 1.8v 679.505n 1.8v 689.495n 1.8v 689.505n 1.8v 699.495n 1.8v 699.505n 1.8v 709.495n 1.8v 709.505n 1.8v 719.495n 1.8v 719.505n 1.8v 729.495n 1.8v 729.505n 0.0v 739.495n 0.0v 739.505n 0.0v 749.495n 0.0v 749.505n 0.0v 759.495n 0.0v 759.505n 0.0v 769.495n 0.0v 769.505n 0.0v 779.495n 0.0v 779.505n 1.8v 789.495n 1.8v 789.505n 1.8v 799.495n 1.8v 799.505n 1.8v 809.495n 1.8v 809.505n 1.8v 819.495n 1.8v 819.505n 0.0v 829.495n 0.0v 829.505n 0.0v 839.495n 0.0v 839.505n 1.8v 849.495n 1.8v 849.505n 1.8v 859.495n 1.8v 859.505n 1.8v 869.495n 1.8v 869.505n 1.8v 879.495n 1.8v 879.505n 1.8v 889.495n 1.8v 889.505n 1.8v 899.495n 1.8v 899.505n 0.0v 909.495n 0.0v 909.505n 0.0v 919.495n 0.0v 919.505n 1.8v 929.495n 1.8v 929.505n 1.8v 939.495n 1.8v 939.505n 1.8v 949.495n 1.8v 949.505n 1.8v 959.495n 1.8v 959.505n 1.8v 969.495n 1.8v 969.505n 1.8v 979.495n 1.8v 979.505n 1.8v 989.495n 1.8v 989.505n 0.0v 999.495n 0.0v 999.505n 0.0v 1009.495n 0.0v 1009.505n 0.0v 1019.495n 0.0v 1019.505n 1.8v 1029.495n 1.8v 1029.505n 1.8v 1039.495n 1.8v 1039.505n 1.8v 1049.495n 1.8v 1049.505n 1.8v 1059.495n 1.8v 1059.505n 1.8v 1069.495n 1.8v 1069.505n 1.8v 1079.495n 1.8v 1079.505n 1.8v 1089.495n 1.8v 1089.505n 1.8v 1099.495n 1.8v 1099.505n 1.8v 1109.495n 1.8v 1109.505n 0.0v 1119.495n 0.0v 1119.505n 0.0v 1129.495n 0.0v 1129.505n 0.0v 1139.495n 0.0v 1139.505n 0.0v 1149.495n 0.0v 1149.505n 0.0v 1159.495n 0.0v 1159.505n 0.0v 1169.495n 0.0v 1169.505n 0.0v 1179.495n 0.0v 1179.505n 1.8v 1189.495n 1.8v 1189.505n 1.8v 1199.495n 1.8v 1199.505n 1.8v 1209.495n 1.8v 1209.505n 1.8v 1219.495n 1.8v 1219.505n 0.0v 1229.495n 0.0v 1229.505n 0.0v 1239.495n 0.0v 1239.505n 1.8v 1249.495n 1.8v 1249.505n 1.8v 1259.495n 1.8v 1259.505n 1.8v 1269.495n 1.8v 1269.505n 1.8v 1279.495n 1.8v 1279.505n 1.8v 1289.495n 1.8v 1289.505n 1.8v 1299.495n 1.8v 1299.505n 1.8v 1309.495n 1.8v 1309.505n 1.8v 1319.495n 1.8v 1319.505n 1.8v 1329.495n 1.8v 1329.505n 1.8v 1339.495n 1.8v 1339.505n 0.0v 1349.495n 0.0v 1349.505n 1.8v 1359.495n 1.8v 1359.505n 1.8v 1369.495n 1.8v 1369.505n 1.8v 1379.495n 1.8v 1379.505n 1.8v 1389.495n 1.8v 1389.505n 1.8v 1399.495n 1.8v 1399.505n 1.8v 1409.495n 1.8v 1409.505n 1.8v 1419.495n 1.8v 1419.505n 1.8v 1429.495n 1.8v 1429.505n 0.0v 1439.495n 0.0v 1439.505n 0.0v 1449.495n 0.0v 1449.505n 0.0v 1459.495n 0.0v 1459.505n 0.0v 1469.495n 0.0v 1469.505n 0.0v 1479.495n 0.0v 1479.505n 0.0v 1489.495n 0.0v 1489.505n 0.0v 1499.495n 0.0v 1499.505n 0.0v 1509.495n 0.0v 1509.505n 0.0v 1519.495n 0.0v 1519.505n 0.0v 1529.495n 0.0v 1529.505n 0.0v 1539.495n 0.0v 1539.505n 0.0v 1549.495n 0.0v 1549.505n 0.0v 1559.495n 0.0v 1559.505n 1.8v 1569.495n 1.8v 1569.505n 1.8v 1579.495n 1.8v 1579.505n 1.8v 1589.495n 1.8v 1589.505n 1.8v 1599.495n 1.8v 1599.505n 1.8v 1609.495n 1.8v 1609.505n 0.0v 1619.495n 0.0v 1619.505n 0.0v 1629.495n 0.0v 1629.505n 0.0v 1639.495n 0.0v 1639.505n 1.8v 1649.495n 1.8v 1649.505n 1.8v 1659.495n 1.8v 1659.505n 1.8v 1669.495n 1.8v 1669.505n 0.0v 1679.495n 0.0v 1679.505n 1.8v 1689.495n 1.8v 1689.505n 1.8v 1699.495n 1.8v 1699.505n 1.8v 1709.495n 1.8v 1709.505n 1.8v 1719.495n 1.8v 1719.505n 0.0v 1729.495n 0.0v 1729.505n 1.8v 1739.495n 1.8v 1739.505n 1.8v 1749.495n 1.8v 1749.505n 0.0v 1759.495n 0.0v 1759.505n 1.8v 1769.495n 1.8v 1769.505n 1.8v 1779.495n 1.8v 1779.505n 1.8v 1789.495n 1.8v 1789.505n 1.8v 1799.495n 1.8v 1799.505n 1.8v 1809.495n 1.8v 1809.505n 1.8v 1819.495n 1.8v 1819.505n 1.8v 1829.495n 1.8v 1829.505n 1.8v 1839.495n 1.8v 1839.505n 0.0v 1849.495n 0.0v 1849.505n 0.0v 1859.495n 0.0v 1859.505n 1.8v 1869.495n 1.8v 1869.505n 1.8v 1879.495n 1.8v 1879.505n 1.8v 1889.495n 1.8v 1889.505n 1.8v 1899.495n 1.8v 1899.505n 1.8v 1909.495n 1.8v 1909.505n 1.8v 1919.495n 1.8v 1919.505n 1.8v 1929.495n 1.8v 1929.505n 1.8v 1939.495n 1.8v 1939.505n 1.8v 1949.495n 1.8v 1949.505n 1.8v 1959.495n 1.8v 1959.505n 1.8v 1969.495n 1.8v 1969.505n 1.8v 1979.495n 1.8v 1979.505n 1.8v 1989.495n 1.8v 1989.505n 1.8v 1999.495n 1.8v 1999.505n 0.0v 2009.495n 0.0v 2009.505n 1.8v 2019.495n 1.8v 2019.505n 0.0v 2029.495n 0.0v 2029.505n 0.0v 2039.495n 0.0v 2039.505n 0.0v 2049.495n 0.0v 2049.505n 0.0v )
* (time, data): [(0, 0), (10, 0), (20, 0), (30, 0), (40, 0), (50, 0), (60, 0), (70, 0), (80, 0), (90, 0), (100, 0), (110, 0), (120, 0), (130, 0), (140, 0), (150, 0), (160, 1), (170, 0), (180, 0), (190, 0), (200, 0), (210, 0), (220, 0), (230, 0), (240, 0), (250, 0), (260, 0), (270, 0), (280, 0), (290, 0), (300, 1), (310, 0), (320, 0), (330, 0), (340, 0), (350, 1), (360, 1), (370, 1), (380, 1), (390, 1), (400, 0), (410, 1), (420, 0), (430, 0), (440, 0), (450, 0), (460, 0), (470, 0), (480, 0), (490, 0), (500, 0), (510, 0), (520, 0), (530, 1), (540, 1), (550, 1), (560, 0), (570, 0), (580, 0), (590, 0), (600, 0), (610, 0), (620, 0), (630, 0), (640, 0), (650, 1), (660, 1), (670, 1), (680, 1), (690, 1), (700, 1), (710, 1), (720, 1), (730, 0), (740, 0), (750, 0), (760, 0), (770, 0), (780, 1), (790, 1), (800, 1), (810, 1), (820, 0), (830, 0), (840, 1), (850, 1), (860, 1), (870, 1), (880, 1), (890, 1), (900, 0), (910, 0), (920, 1), (930, 1), (940, 1), (950, 1), (960, 1), (970, 1), (980, 1), (990, 0), (1000, 0), (1010, 0), (1020, 1), (1030, 1), (1040, 1), (1050, 1), (1060, 1), (1070, 1), (1080, 1), (1090, 1), (1100, 1), (1110, 0), (1120, 0), (1130, 0), (1140, 0), (1150, 0), (1160, 0), (1170, 0), (1180, 1), (1190, 1), (1200, 1), (1210, 1), (1220, 0), (1230, 0), (1240, 1), (1250, 1), (1260, 1), (1270, 1), (1280, 1), (1290, 1), (1300, 1), (1310, 1), (1320, 1), (1330, 1), (1340, 0), (1350, 1), (1360, 1), (1370, 1), (1380, 1), (1390, 1), (1400, 1), (1410, 1), (1420, 1), (1430, 0), (1440, 0), (1450, 0), (1460, 0), (1470, 0), (1480, 0), (1490, 0), (1500, 0), (1510, 0), (1520, 0), (1530, 0), (1540, 0), (1550, 0), (1560, 1), (1570, 1), (1580, 1), (1590, 1), (1600, 1), (1610, 0), (1620, 0), (1630, 0), (1640, 1), (1650, 1), (1660, 1), (1670, 0), (1680, 1), (1690, 1), (1700, 1), (1710, 1), (1720, 0), (1730, 1), (1740, 1), (1750, 0), (1760, 1), (1770, 1), (1780, 1), (1790, 1), (1800, 1), (1810, 1), (1820, 1), (1830, 1), (1840, 0), (1850, 0), (1860, 1), (1870, 1), (1880, 1), (1890, 1), (1900, 1), (1910, 1), (1920, 1), (1930, 1), (1940, 1), (1950, 1), (1960, 1), (1970, 1), (1980, 1), (1990, 1), (2000, 0), (2010, 1), (2020, 0), (2030, 0), (2040, 0), (2050, 0)]
Va1_2  a1_2  0 PWL (0n 0.0v 9.495n 0.0v 9.505n 0.0v 19.495n 0.0v 19.505n 0.0v 29.495n 0.0v 29.505n 0.0v 39.495n 0.0v 39.505n 0.0v 49.495n 0.0v 49.505n 0.0v 59.495n 0.0v 59.505n 0.0v 69.495n 0.0v 69.505n 0.0v 79.495n 0.0v 79.505n 0.0v 89.495n 0.0v 89.505n 0.0v 99.495n 0.0v 99.505n 0.0v 109.495n 0.0v 109.505n 0.0v 119.495n 0.0v 119.505n 0.0v 129.495n 0.0v 129.505n 0.0v 139.495n 0.0v 139.505n 0.0v 149.495n 0.0v 149.505n 0.0v 159.495n 0.0v 159.505n 1.8v 169.495n 1.8v 169.505n 0.0v 179.495n 0.0v 179.505n 0.0v 189.495n 0.0v 189.505n 0.0v 199.495n 0.0v 199.505n 0.0v 209.495n 0.0v 209.505n 0.0v 219.495n 0.0v 219.505n 0.0v 229.495n 0.0v 229.505n 0.0v 239.495n 0.0v 239.505n 0.0v 249.495n 0.0v 249.505n 0.0v 259.495n 0.0v 259.505n 0.0v 269.495n 0.0v 269.505n 0.0v 279.495n 0.0v 279.505n 0.0v 289.495n 0.0v 289.505n 0.0v 299.495n 0.0v 299.505n 1.8v 309.495n 1.8v 309.505n 0.0v 319.495n 0.0v 319.505n 0.0v 329.495n 0.0v 329.505n 0.0v 339.495n 0.0v 339.505n 0.0v 349.495n 0.0v 349.505n 1.8v 359.495n 1.8v 359.505n 1.8v 369.495n 1.8v 369.505n 1.8v 379.495n 1.8v 379.505n 1.8v 389.495n 1.8v 389.505n 1.8v 399.495n 1.8v 399.505n 0.0v 409.495n 0.0v 409.505n 1.8v 419.495n 1.8v 419.505n 0.0v 429.495n 0.0v 429.505n 0.0v 439.495n 0.0v 439.505n 0.0v 449.495n 0.0v 449.505n 0.0v 459.495n 0.0v 459.505n 0.0v 469.495n 0.0v 469.505n 0.0v 479.495n 0.0v 479.505n 0.0v 489.495n 0.0v 489.505n 0.0v 499.495n 0.0v 499.505n 0.0v 509.495n 0.0v 509.505n 0.0v 519.495n 0.0v 519.505n 0.0v 529.495n 0.0v 529.505n 1.8v 539.495n 1.8v 539.505n 1.8v 549.495n 1.8v 549.505n 1.8v 559.495n 1.8v 559.505n 0.0v 569.495n 0.0v 569.505n 0.0v 579.495n 0.0v 579.505n 0.0v 589.495n 0.0v 589.505n 0.0v 599.495n 0.0v 599.505n 0.0v 609.495n 0.0v 609.505n 0.0v 619.495n 0.0v 619.505n 0.0v 629.495n 0.0v 629.505n 0.0v 639.495n 0.0v 639.505n 0.0v 649.495n 0.0v 649.505n 1.8v 659.495n 1.8v 659.505n 1.8v 669.495n 1.8v 669.505n 1.8v 679.495n 1.8v 679.505n 1.8v 689.495n 1.8v 689.505n 1.8v 699.495n 1.8v 699.505n 1.8v 709.495n 1.8v 709.505n 1.8v 719.495n 1.8v 719.505n 1.8v 729.495n 1.8v 729.505n 0.0v 739.495n 0.0v 739.505n 0.0v 749.495n 0.0v 749.505n 0.0v 759.495n 0.0v 759.505n 0.0v 769.495n 0.0v 769.505n 0.0v 779.495n 0.0v 779.505n 1.8v 789.495n 1.8v 789.505n 1.8v 799.495n 1.8v 799.505n 1.8v 809.495n 1.8v 809.505n 1.8v 819.495n 1.8v 819.505n 0.0v 829.495n 0.0v 829.505n 0.0v 839.495n 0.0v 839.505n 1.8v 849.495n 1.8v 849.505n 1.8v 859.495n 1.8v 859.505n 1.8v 869.495n 1.8v 869.505n 1.8v 879.495n 1.8v 879.505n 1.8v 889.495n 1.8v 889.505n 1.8v 899.495n 1.8v 899.505n 0.0v 909.495n 0.0v 909.505n 0.0v 919.495n 0.0v 919.505n 1.8v 929.495n 1.8v 929.505n 1.8v 939.495n 1.8v 939.505n 1.8v 949.495n 1.8v 949.505n 1.8v 959.495n 1.8v 959.505n 1.8v 969.495n 1.8v 969.505n 1.8v 979.495n 1.8v 979.505n 1.8v 989.495n 1.8v 989.505n 0.0v 999.495n 0.0v 999.505n 0.0v 1009.495n 0.0v 1009.505n 0.0v 1019.495n 0.0v 1019.505n 1.8v 1029.495n 1.8v 1029.505n 1.8v 1039.495n 1.8v 1039.505n 1.8v 1049.495n 1.8v 1049.505n 1.8v 1059.495n 1.8v 1059.505n 1.8v 1069.495n 1.8v 1069.505n 1.8v 1079.495n 1.8v 1079.505n 1.8v 1089.495n 1.8v 1089.505n 1.8v 1099.495n 1.8v 1099.505n 1.8v 1109.495n 1.8v 1109.505n 0.0v 1119.495n 0.0v 1119.505n 0.0v 1129.495n 0.0v 1129.505n 0.0v 1139.495n 0.0v 1139.505n 0.0v 1149.495n 0.0v 1149.505n 0.0v 1159.495n 0.0v 1159.505n 0.0v 1169.495n 0.0v 1169.505n 0.0v 1179.495n 0.0v 1179.505n 1.8v 1189.495n 1.8v 1189.505n 1.8v 1199.495n 1.8v 1199.505n 1.8v 1209.495n 1.8v 1209.505n 1.8v 1219.495n 1.8v 1219.505n 0.0v 1229.495n 0.0v 1229.505n 0.0v 1239.495n 0.0v 1239.505n 1.8v 1249.495n 1.8v 1249.505n 1.8v 1259.495n 1.8v 1259.505n 1.8v 1269.495n 1.8v 1269.505n 1.8v 1279.495n 1.8v 1279.505n 1.8v 1289.495n 1.8v 1289.505n 1.8v 1299.495n 1.8v 1299.505n 1.8v 1309.495n 1.8v 1309.505n 1.8v 1319.495n 1.8v 1319.505n 1.8v 1329.495n 1.8v 1329.505n 1.8v 1339.495n 1.8v 1339.505n 0.0v 1349.495n 0.0v 1349.505n 1.8v 1359.495n 1.8v 1359.505n 1.8v 1369.495n 1.8v 1369.505n 1.8v 1379.495n 1.8v 1379.505n 1.8v 1389.495n 1.8v 1389.505n 1.8v 1399.495n 1.8v 1399.505n 1.8v 1409.495n 1.8v 1409.505n 1.8v 1419.495n 1.8v 1419.505n 1.8v 1429.495n 1.8v 1429.505n 0.0v 1439.495n 0.0v 1439.505n 0.0v 1449.495n 0.0v 1449.505n 0.0v 1459.495n 0.0v 1459.505n 0.0v 1469.495n 0.0v 1469.505n 0.0v 1479.495n 0.0v 1479.505n 0.0v 1489.495n 0.0v 1489.505n 0.0v 1499.495n 0.0v 1499.505n 0.0v 1509.495n 0.0v 1509.505n 0.0v 1519.495n 0.0v 1519.505n 0.0v 1529.495n 0.0v 1529.505n 0.0v 1539.495n 0.0v 1539.505n 0.0v 1549.495n 0.0v 1549.505n 0.0v 1559.495n 0.0v 1559.505n 1.8v 1569.495n 1.8v 1569.505n 1.8v 1579.495n 1.8v 1579.505n 1.8v 1589.495n 1.8v 1589.505n 1.8v 1599.495n 1.8v 1599.505n 1.8v 1609.495n 1.8v 1609.505n 0.0v 1619.495n 0.0v 1619.505n 0.0v 1629.495n 0.0v 1629.505n 0.0v 1639.495n 0.0v 1639.505n 1.8v 1649.495n 1.8v 1649.505n 1.8v 1659.495n 1.8v 1659.505n 1.8v 1669.495n 1.8v 1669.505n 0.0v 1679.495n 0.0v 1679.505n 1.8v 1689.495n 1.8v 1689.505n 1.8v 1699.495n 1.8v 1699.505n 1.8v 1709.495n 1.8v 1709.505n 1.8v 1719.495n 1.8v 1719.505n 0.0v 1729.495n 0.0v 1729.505n 1.8v 1739.495n 1.8v 1739.505n 1.8v 1749.495n 1.8v 1749.505n 0.0v 1759.495n 0.0v 1759.505n 1.8v 1769.495n 1.8v 1769.505n 1.8v 1779.495n 1.8v 1779.505n 1.8v 1789.495n 1.8v 1789.505n 1.8v 1799.495n 1.8v 1799.505n 1.8v 1809.495n 1.8v 1809.505n 1.8v 1819.495n 1.8v 1819.505n 1.8v 1829.495n 1.8v 1829.505n 1.8v 1839.495n 1.8v 1839.505n 0.0v 1849.495n 0.0v 1849.505n 0.0v 1859.495n 0.0v 1859.505n 1.8v 1869.495n 1.8v 1869.505n 1.8v 1879.495n 1.8v 1879.505n 1.8v 1889.495n 1.8v 1889.505n 1.8v 1899.495n 1.8v 1899.505n 1.8v 1909.495n 1.8v 1909.505n 1.8v 1919.495n 1.8v 1919.505n 1.8v 1929.495n 1.8v 1929.505n 1.8v 1939.495n 1.8v 1939.505n 1.8v 1949.495n 1.8v 1949.505n 1.8v 1959.495n 1.8v 1959.505n 1.8v 1969.495n 1.8v 1969.505n 1.8v 1979.495n 1.8v 1979.505n 1.8v 1989.495n 1.8v 1989.505n 1.8v 1999.495n 1.8v 1999.505n 0.0v 2009.495n 0.0v 2009.505n 1.8v 2019.495n 1.8v 2019.505n 0.0v 2029.495n 0.0v 2029.505n 0.0v 2039.495n 0.0v 2039.505n 0.0v 2049.495n 0.0v 2049.505n 0.0v )
* (time, data): [(0, 0), (10, 0), (20, 0), (30, 0), (40, 0), (50, 0), (60, 0), (70, 0), (80, 0), (90, 0), (100, 0), (110, 0), (120, 0), (130, 0), (140, 0), (150, 0), (160, 1), (170, 0), (180, 0), (190, 0), (200, 0), (210, 0), (220, 0), (230, 0), (240, 0), (250, 0), (260, 0), (270, 0), (280, 0), (290, 0), (300, 1), (310, 0), (320, 0), (330, 0), (340, 0), (350, 1), (360, 1), (370, 1), (380, 1), (390, 1), (400, 0), (410, 1), (420, 0), (430, 0), (440, 0), (450, 0), (460, 0), (470, 0), (480, 0), (490, 0), (500, 0), (510, 0), (520, 0), (530, 1), (540, 1), (550, 1), (560, 0), (570, 0), (580, 0), (590, 0), (600, 0), (610, 0), (620, 0), (630, 0), (640, 0), (650, 1), (660, 1), (670, 1), (680, 1), (690, 1), (700, 1), (710, 1), (720, 1), (730, 0), (740, 0), (750, 0), (760, 0), (770, 0), (780, 1), (790, 1), (800, 1), (810, 1), (820, 0), (830, 0), (840, 1), (850, 1), (860, 1), (870, 1), (880, 1), (890, 1), (900, 0), (910, 0), (920, 1), (930, 1), (940, 1), (950, 1), (960, 1), (970, 1), (980, 1), (990, 0), (1000, 0), (1010, 0), (1020, 1), (1030, 1), (1040, 1), (1050, 1), (1060, 1), (1070, 1), (1080, 1), (1090, 1), (1100, 1), (1110, 0), (1120, 0), (1130, 0), (1140, 0), (1150, 0), (1160, 0), (1170, 0), (1180, 1), (1190, 1), (1200, 1), (1210, 1), (1220, 0), (1230, 0), (1240, 1), (1250, 1), (1260, 1), (1270, 1), (1280, 1), (1290, 1), (1300, 1), (1310, 1), (1320, 1), (1330, 1), (1340, 0), (1350, 1), (1360, 1), (1370, 1), (1380, 1), (1390, 1), (1400, 1), (1410, 1), (1420, 1), (1430, 0), (1440, 0), (1450, 0), (1460, 0), (1470, 0), (1480, 0), (1490, 0), (1500, 0), (1510, 0), (1520, 0), (1530, 0), (1540, 0), (1550, 0), (1560, 1), (1570, 1), (1580, 1), (1590, 1), (1600, 1), (1610, 0), (1620, 0), (1630, 0), (1640, 1), (1650, 1), (1660, 1), (1670, 0), (1680, 1), (1690, 1), (1700, 1), (1710, 1), (1720, 0), (1730, 1), (1740, 1), (1750, 0), (1760, 1), (1770, 1), (1780, 1), (1790, 1), (1800, 1), (1810, 1), (1820, 1), (1830, 1), (1840, 0), (1850, 0), (1860, 1), (1870, 1), (1880, 1), (1890, 1), (1900, 1), (1910, 1), (1920, 1), (1930, 1), (1940, 1), (1950, 1), (1960, 1), (1970, 1), (1980, 1), (1990, 1), (2000, 0), (2010, 1), (2020, 0), (2030, 0), (2040, 0), (2050, 0)]
Va1_3  a1_3  0 PWL (0n 0.0v 9.495n 0.0v 9.505n 0.0v 19.495n 0.0v 19.505n 0.0v 29.495n 0.0v 29.505n 0.0v 39.495n 0.0v 39.505n 0.0v 49.495n 0.0v 49.505n 0.0v 59.495n 0.0v 59.505n 0.0v 69.495n 0.0v 69.505n 0.0v 79.495n 0.0v 79.505n 0.0v 89.495n 0.0v 89.505n 0.0v 99.495n 0.0v 99.505n 0.0v 109.495n 0.0v 109.505n 0.0v 119.495n 0.0v 119.505n 0.0v 129.495n 0.0v 129.505n 0.0v 139.495n 0.0v 139.505n 0.0v 149.495n 0.0v 149.505n 0.0v 159.495n 0.0v 159.505n 1.8v 169.495n 1.8v 169.505n 0.0v 179.495n 0.0v 179.505n 0.0v 189.495n 0.0v 189.505n 0.0v 199.495n 0.0v 199.505n 0.0v 209.495n 0.0v 209.505n 0.0v 219.495n 0.0v 219.505n 0.0v 229.495n 0.0v 229.505n 0.0v 239.495n 0.0v 239.505n 0.0v 249.495n 0.0v 249.505n 0.0v 259.495n 0.0v 259.505n 0.0v 269.495n 0.0v 269.505n 0.0v 279.495n 0.0v 279.505n 0.0v 289.495n 0.0v 289.505n 0.0v 299.495n 0.0v 299.505n 1.8v 309.495n 1.8v 309.505n 0.0v 319.495n 0.0v 319.505n 0.0v 329.495n 0.0v 329.505n 0.0v 339.495n 0.0v 339.505n 0.0v 349.495n 0.0v 349.505n 1.8v 359.495n 1.8v 359.505n 1.8v 369.495n 1.8v 369.505n 1.8v 379.495n 1.8v 379.505n 1.8v 389.495n 1.8v 389.505n 1.8v 399.495n 1.8v 399.505n 0.0v 409.495n 0.0v 409.505n 1.8v 419.495n 1.8v 419.505n 0.0v 429.495n 0.0v 429.505n 0.0v 439.495n 0.0v 439.505n 0.0v 449.495n 0.0v 449.505n 0.0v 459.495n 0.0v 459.505n 0.0v 469.495n 0.0v 469.505n 0.0v 479.495n 0.0v 479.505n 0.0v 489.495n 0.0v 489.505n 0.0v 499.495n 0.0v 499.505n 0.0v 509.495n 0.0v 509.505n 0.0v 519.495n 0.0v 519.505n 0.0v 529.495n 0.0v 529.505n 1.8v 539.495n 1.8v 539.505n 1.8v 549.495n 1.8v 549.505n 1.8v 559.495n 1.8v 559.505n 0.0v 569.495n 0.0v 569.505n 0.0v 579.495n 0.0v 579.505n 0.0v 589.495n 0.0v 589.505n 0.0v 599.495n 0.0v 599.505n 0.0v 609.495n 0.0v 609.505n 0.0v 619.495n 0.0v 619.505n 0.0v 629.495n 0.0v 629.505n 0.0v 639.495n 0.0v 639.505n 0.0v 649.495n 0.0v 649.505n 1.8v 659.495n 1.8v 659.505n 1.8v 669.495n 1.8v 669.505n 1.8v 679.495n 1.8v 679.505n 1.8v 689.495n 1.8v 689.505n 1.8v 699.495n 1.8v 699.505n 1.8v 709.495n 1.8v 709.505n 1.8v 719.495n 1.8v 719.505n 1.8v 729.495n 1.8v 729.505n 0.0v 739.495n 0.0v 739.505n 0.0v 749.495n 0.0v 749.505n 0.0v 759.495n 0.0v 759.505n 0.0v 769.495n 0.0v 769.505n 0.0v 779.495n 0.0v 779.505n 1.8v 789.495n 1.8v 789.505n 1.8v 799.495n 1.8v 799.505n 1.8v 809.495n 1.8v 809.505n 1.8v 819.495n 1.8v 819.505n 0.0v 829.495n 0.0v 829.505n 0.0v 839.495n 0.0v 839.505n 1.8v 849.495n 1.8v 849.505n 1.8v 859.495n 1.8v 859.505n 1.8v 869.495n 1.8v 869.505n 1.8v 879.495n 1.8v 879.505n 1.8v 889.495n 1.8v 889.505n 1.8v 899.495n 1.8v 899.505n 0.0v 909.495n 0.0v 909.505n 0.0v 919.495n 0.0v 919.505n 1.8v 929.495n 1.8v 929.505n 1.8v 939.495n 1.8v 939.505n 1.8v 949.495n 1.8v 949.505n 1.8v 959.495n 1.8v 959.505n 1.8v 969.495n 1.8v 969.505n 1.8v 979.495n 1.8v 979.505n 1.8v 989.495n 1.8v 989.505n 0.0v 999.495n 0.0v 999.505n 0.0v 1009.495n 0.0v 1009.505n 0.0v 1019.495n 0.0v 1019.505n 1.8v 1029.495n 1.8v 1029.505n 1.8v 1039.495n 1.8v 1039.505n 1.8v 1049.495n 1.8v 1049.505n 1.8v 1059.495n 1.8v 1059.505n 1.8v 1069.495n 1.8v 1069.505n 1.8v 1079.495n 1.8v 1079.505n 1.8v 1089.495n 1.8v 1089.505n 1.8v 1099.495n 1.8v 1099.505n 1.8v 1109.495n 1.8v 1109.505n 0.0v 1119.495n 0.0v 1119.505n 0.0v 1129.495n 0.0v 1129.505n 0.0v 1139.495n 0.0v 1139.505n 0.0v 1149.495n 0.0v 1149.505n 0.0v 1159.495n 0.0v 1159.505n 0.0v 1169.495n 0.0v 1169.505n 0.0v 1179.495n 0.0v 1179.505n 1.8v 1189.495n 1.8v 1189.505n 1.8v 1199.495n 1.8v 1199.505n 1.8v 1209.495n 1.8v 1209.505n 1.8v 1219.495n 1.8v 1219.505n 0.0v 1229.495n 0.0v 1229.505n 0.0v 1239.495n 0.0v 1239.505n 1.8v 1249.495n 1.8v 1249.505n 1.8v 1259.495n 1.8v 1259.505n 1.8v 1269.495n 1.8v 1269.505n 1.8v 1279.495n 1.8v 1279.505n 1.8v 1289.495n 1.8v 1289.505n 1.8v 1299.495n 1.8v 1299.505n 1.8v 1309.495n 1.8v 1309.505n 1.8v 1319.495n 1.8v 1319.505n 1.8v 1329.495n 1.8v 1329.505n 1.8v 1339.495n 1.8v 1339.505n 0.0v 1349.495n 0.0v 1349.505n 1.8v 1359.495n 1.8v 1359.505n 1.8v 1369.495n 1.8v 1369.505n 1.8v 1379.495n 1.8v 1379.505n 1.8v 1389.495n 1.8v 1389.505n 1.8v 1399.495n 1.8v 1399.505n 1.8v 1409.495n 1.8v 1409.505n 1.8v 1419.495n 1.8v 1419.505n 1.8v 1429.495n 1.8v 1429.505n 0.0v 1439.495n 0.0v 1439.505n 0.0v 1449.495n 0.0v 1449.505n 0.0v 1459.495n 0.0v 1459.505n 0.0v 1469.495n 0.0v 1469.505n 0.0v 1479.495n 0.0v 1479.505n 0.0v 1489.495n 0.0v 1489.505n 0.0v 1499.495n 0.0v 1499.505n 0.0v 1509.495n 0.0v 1509.505n 0.0v 1519.495n 0.0v 1519.505n 0.0v 1529.495n 0.0v 1529.505n 0.0v 1539.495n 0.0v 1539.505n 0.0v 1549.495n 0.0v 1549.505n 0.0v 1559.495n 0.0v 1559.505n 1.8v 1569.495n 1.8v 1569.505n 1.8v 1579.495n 1.8v 1579.505n 1.8v 1589.495n 1.8v 1589.505n 1.8v 1599.495n 1.8v 1599.505n 1.8v 1609.495n 1.8v 1609.505n 0.0v 1619.495n 0.0v 1619.505n 0.0v 1629.495n 0.0v 1629.505n 0.0v 1639.495n 0.0v 1639.505n 1.8v 1649.495n 1.8v 1649.505n 1.8v 1659.495n 1.8v 1659.505n 1.8v 1669.495n 1.8v 1669.505n 0.0v 1679.495n 0.0v 1679.505n 1.8v 1689.495n 1.8v 1689.505n 1.8v 1699.495n 1.8v 1699.505n 1.8v 1709.495n 1.8v 1709.505n 1.8v 1719.495n 1.8v 1719.505n 0.0v 1729.495n 0.0v 1729.505n 1.8v 1739.495n 1.8v 1739.505n 1.8v 1749.495n 1.8v 1749.505n 0.0v 1759.495n 0.0v 1759.505n 1.8v 1769.495n 1.8v 1769.505n 1.8v 1779.495n 1.8v 1779.505n 1.8v 1789.495n 1.8v 1789.505n 1.8v 1799.495n 1.8v 1799.505n 1.8v 1809.495n 1.8v 1809.505n 1.8v 1819.495n 1.8v 1819.505n 1.8v 1829.495n 1.8v 1829.505n 1.8v 1839.495n 1.8v 1839.505n 0.0v 1849.495n 0.0v 1849.505n 0.0v 1859.495n 0.0v 1859.505n 1.8v 1869.495n 1.8v 1869.505n 1.8v 1879.495n 1.8v 1879.505n 1.8v 1889.495n 1.8v 1889.505n 1.8v 1899.495n 1.8v 1899.505n 1.8v 1909.495n 1.8v 1909.505n 1.8v 1919.495n 1.8v 1919.505n 1.8v 1929.495n 1.8v 1929.505n 1.8v 1939.495n 1.8v 1939.505n 1.8v 1949.495n 1.8v 1949.505n 1.8v 1959.495n 1.8v 1959.505n 1.8v 1969.495n 1.8v 1969.505n 1.8v 1979.495n 1.8v 1979.505n 1.8v 1989.495n 1.8v 1989.505n 1.8v 1999.495n 1.8v 1999.505n 0.0v 2009.495n 0.0v 2009.505n 1.8v 2019.495n 1.8v 2019.505n 0.0v 2029.495n 0.0v 2029.505n 0.0v 2039.495n 0.0v 2039.505n 0.0v 2049.495n 0.0v 2049.505n 0.0v )

 * Generation of control signals
* (time, data): [(0, 1), (10, 0), (20, 0), (30, 0), (40, 0), (50, 1), (60, 0), (70, 1), (80, 1), (90, 0), (100, 0), (110, 0), (120, 0), (130, 0), (140, 1), (150, 0), (160, 0), (170, 1), (180, 0), (190, 1), (200, 0), (210, 1), (220, 1), (230, 0), (240, 0), (250, 1), (260, 1), (270, 1), (280, 0), (290, 0), (300, 0), (310, 1), (320, 1), (330, 0), (340, 0), (350, 0), (360, 0), (370, 0), (380, 0), (390, 0), (400, 0), (410, 1), (420, 0), (430, 0), (440, 1), (450, 1), (460, 0), (470, 0), (480, 1), (490, 0), (500, 0), (510, 1), (520, 1), (530, 0), (540, 0), (550, 0), (560, 0), (570, 1), (580, 0), (590, 0), (600, 0), (610, 0), (620, 1), (630, 0), (640, 0), (650, 1), (660, 0), (670, 0), (680, 0), (690, 0), (700, 0), (710, 1), (720, 0), (730, 1), (740, 0), (750, 1), (760, 0), (770, 1), (780, 0), (790, 0), (800, 1), (810, 0), (820, 0), (830, 1), (840, 0), (850, 0), (860, 0), (870, 0), (880, 0), (890, 0), (900, 1), (910, 1), (920, 0), (930, 0), (940, 0), (950, 1), (960, 0), (970, 0), (980, 0), (990, 0), (1000, 1), (1010, 1), (1020, 0), (1030, 1), (1040, 1), (1050, 0), (1060, 0), (1070, 1), (1080, 0), (1090, 0), (1100, 0), (1110, 0), (1120, 0), (1130, 0), (1140, 0), (1150, 1), (1160, 0), (1170, 0), (1180, 0), (1190, 0), (1200, 0), (1210, 0), (1220, 1), (1230, 0), (1240, 0), (1250, 0), (1260, 0), (1270, 0), (1280, 0), (1290, 0), (1300, 1), (1310, 0), (1320, 0), (1330, 0), (1340, 1), (1350, 0), (1360, 0), (1370, 0), (1380, 0), (1390, 1), (1400, 0), (1410, 1), (1420, 0), (1430, 0), (1440, 0), (1450, 0), (1460, 0), (1470, 1), (1480, 1), (1490, 0), (1500, 1), (1510, 0), (1520, 0), (1530, 0), (1540, 0), (1550, 0), (1560, 0), (1570, 0), (1580, 1), (1590, 1), (1600, 0), (1610, 1), (1620, 0), (1630, 0), (1640, 0), (1650, 0), (1660, 1), (1670, 0), (1680, 0), (1690, 1), (1700, 1), (1710, 0), (1720, 1), (1730, 0), (1740, 1), (1750, 1), (1760, 0), (1770, 0), (1780, 0), (1790, 0), (1800, 0), (1810, 0), (1820, 0), (1830, 0), (1840, 0), (1850, 0), (1860, 0), (1870, 0), (1880, 0), (1890, 1), (1900, 1), (1910, 0), (1920, 0), (1930, 1), (1940, 1), (1950, 0), (1960, 0), (1970, 1), (1980, 0), (1990, 0), (2000, 1), (2010, 0), (2020, 0), (2030, 0), (2040, 0), (2050, 1)]
VCSB0 CSB0 0 PWL (0n 1.8v 9.495n 1.8v 9.505n 0.0v 19.495n 0.0v 19.505n 0.0v 29.495n 0.0v 29.505n 0.0v 39.495n 0.0v 39.505n 0.0v 49.495n 0.0v 49.505n 1.8v 59.495n 1.8v 59.505n 0.0v 69.495n 0.0v 69.505n 1.8v 79.495n 1.8v 79.505n 1.8v 89.495n 1.8v 89.505n 0.0v 99.495n 0.0v 99.505n 0.0v 109.495n 0.0v 109.505n 0.0v 119.495n 0.0v 119.505n 0.0v 129.495n 0.0v 129.505n 0.0v 139.495n 0.0v 139.505n 1.8v 149.495n 1.8v 149.505n 0.0v 159.495n 0.0v 159.505n 0.0v 169.495n 0.0v 169.505n 1.8v 179.495n 1.8v 179.505n 0.0v 189.495n 0.0v 189.505n 1.8v 199.495n 1.8v 199.505n 0.0v 209.495n 0.0v 209.505n 1.8v 219.495n 1.8v 219.505n 1.8v 229.495n 1.8v 229.505n 0.0v 239.495n 0.0v 239.505n 0.0v 249.495n 0.0v 249.505n 1.8v 259.495n 1.8v 259.505n 1.8v 269.495n 1.8v 269.505n 1.8v 279.495n 1.8v 279.505n 0.0v 289.495n 0.0v 289.505n 0.0v 299.495n 0.0v 299.505n 0.0v 309.495n 0.0v 309.505n 1.8v 319.495n 1.8v 319.505n 1.8v 329.495n 1.8v 329.505n 0.0v 339.495n 0.0v 339.505n 0.0v 349.495n 0.0v 349.505n 0.0v 359.495n 0.0v 359.505n 0.0v 369.495n 0.0v 369.505n 0.0v 379.495n 0.0v 379.505n 0.0v 389.495n 0.0v 389.505n 0.0v 399.495n 0.0v 399.505n 0.0v 409.495n 0.0v 409.505n 1.8v 419.495n 1.8v 419.505n 0.0v 429.495n 0.0v 429.505n 0.0v 439.495n 0.0v 439.505n 1.8v 449.495n 1.8v 449.505n 1.8v 459.495n 1.8v 459.505n 0.0v 469.495n 0.0v 469.505n 0.0v 479.495n 0.0v 479.505n 1.8v 489.495n 1.8v 489.505n 0.0v 499.495n 0.0v 499.505n 0.0v 509.495n 0.0v 509.505n 1.8v 519.495n 1.8v 519.505n 1.8v 529.495n 1.8v 529.505n 0.0v 539.495n 0.0v 539.505n 0.0v 549.495n 0.0v 549.505n 0.0v 559.495n 0.0v 559.505n 0.0v 569.495n 0.0v 569.505n 1.8v 579.495n 1.8v 579.505n 0.0v 589.495n 0.0v 589.505n 0.0v 599.495n 0.0v 599.505n 0.0v 609.495n 0.0v 609.505n 0.0v 619.495n 0.0v 619.505n 1.8v 629.495n 1.8v 629.505n 0.0v 639.495n 0.0v 639.505n 0.0v 649.495n 0.0v 649.505n 1.8v 659.495n 1.8v 659.505n 0.0v 669.495n 0.0v 669.505n 0.0v 679.495n 0.0v 679.505n 0.0v 689.495n 0.0v 689.505n 0.0v 699.495n 0.0v 699.505n 0.0v 709.495n 0.0v 709.505n 1.8v 719.495n 1.8v 719.505n 0.0v 729.495n 0.0v 729.505n 1.8v 739.495n 1.8v 739.505n 0.0v 749.495n 0.0v 749.505n 1.8v 759.495n 1.8v 759.505n 0.0v 769.495n 0.0v 769.505n 1.8v 779.495n 1.8v 779.505n 0.0v 789.495n 0.0v 789.505n 0.0v 799.495n 0.0v 799.505n 1.8v 809.495n 1.8v 809.505n 0.0v 819.495n 0.0v 819.505n 0.0v 829.495n 0.0v 829.505n 1.8v 839.495n 1.8v 839.505n 0.0v 849.495n 0.0v 849.505n 0.0v 859.495n 0.0v 859.505n 0.0v 869.495n 0.0v 869.505n 0.0v 879.495n 0.0v 879.505n 0.0v 889.495n 0.0v 889.505n 0.0v 899.495n 0.0v 899.505n 1.8v 909.495n 1.8v 909.505n 1.8v 919.495n 1.8v 919.505n 0.0v 929.495n 0.0v 929.505n 0.0v 939.495n 0.0v 939.505n 0.0v 949.495n 0.0v 949.505n 1.8v 959.495n 1.8v 959.505n 0.0v 969.495n 0.0v 969.505n 0.0v 979.495n 0.0v 979.505n 0.0v 989.495n 0.0v 989.505n 0.0v 999.495n 0.0v 999.505n 1.8v 1009.495n 1.8v 1009.505n 1.8v 1019.495n 1.8v 1019.505n 0.0v 1029.495n 0.0v 1029.505n 1.8v 1039.495n 1.8v 1039.505n 1.8v 1049.495n 1.8v 1049.505n 0.0v 1059.495n 0.0v 1059.505n 0.0v 1069.495n 0.0v 1069.505n 1.8v 1079.495n 1.8v 1079.505n 0.0v 1089.495n 0.0v 1089.505n 0.0v 1099.495n 0.0v 1099.505n 0.0v 1109.495n 0.0v 1109.505n 0.0v 1119.495n 0.0v 1119.505n 0.0v 1129.495n 0.0v 1129.505n 0.0v 1139.495n 0.0v 1139.505n 0.0v 1149.495n 0.0v 1149.505n 1.8v 1159.495n 1.8v 1159.505n 0.0v 1169.495n 0.0v 1169.505n 0.0v 1179.495n 0.0v 1179.505n 0.0v 1189.495n 0.0v 1189.505n 0.0v 1199.495n 0.0v 1199.505n 0.0v 1209.495n 0.0v 1209.505n 0.0v 1219.495n 0.0v 1219.505n 1.8v 1229.495n 1.8v 1229.505n 0.0v 1239.495n 0.0v 1239.505n 0.0v 1249.495n 0.0v 1249.505n 0.0v 1259.495n 0.0v 1259.505n 0.0v 1269.495n 0.0v 1269.505n 0.0v 1279.495n 0.0v 1279.505n 0.0v 1289.495n 0.0v 1289.505n 0.0v 1299.495n 0.0v 1299.505n 1.8v 1309.495n 1.8v 1309.505n 0.0v 1319.495n 0.0v 1319.505n 0.0v 1329.495n 0.0v 1329.505n 0.0v 1339.495n 0.0v 1339.505n 1.8v 1349.495n 1.8v 1349.505n 0.0v 1359.495n 0.0v 1359.505n 0.0v 1369.495n 0.0v 1369.505n 0.0v 1379.495n 0.0v 1379.505n 0.0v 1389.495n 0.0v 1389.505n 1.8v 1399.495n 1.8v 1399.505n 0.0v 1409.495n 0.0v 1409.505n 1.8v 1419.495n 1.8v 1419.505n 0.0v 1429.495n 0.0v 1429.505n 0.0v 1439.495n 0.0v 1439.505n 0.0v 1449.495n 0.0v 1449.505n 0.0v 1459.495n 0.0v 1459.505n 0.0v 1469.495n 0.0v 1469.505n 1.8v 1479.495n 1.8v 1479.505n 1.8v 1489.495n 1.8v 1489.505n 0.0v 1499.495n 0.0v 1499.505n 1.8v 1509.495n 1.8v 1509.505n 0.0v 1519.495n 0.0v 1519.505n 0.0v 1529.495n 0.0v 1529.505n 0.0v 1539.495n 0.0v 1539.505n 0.0v 1549.495n 0.0v 1549.505n 0.0v 1559.495n 0.0v 1559.505n 0.0v 1569.495n 0.0v 1569.505n 0.0v 1579.495n 0.0v 1579.505n 1.8v 1589.495n 1.8v 1589.505n 1.8v 1599.495n 1.8v 1599.505n 0.0v 1609.495n 0.0v 1609.505n 1.8v 1619.495n 1.8v 1619.505n 0.0v 1629.495n 0.0v 1629.505n 0.0v 1639.495n 0.0v 1639.505n 0.0v 1649.495n 0.0v 1649.505n 0.0v 1659.495n 0.0v 1659.505n 1.8v 1669.495n 1.8v 1669.505n 0.0v 1679.495n 0.0v 1679.505n 0.0v 1689.495n 0.0v 1689.505n 1.8v 1699.495n 1.8v 1699.505n 1.8v 1709.495n 1.8v 1709.505n 0.0v 1719.495n 0.0v 1719.505n 1.8v 1729.495n 1.8v 1729.505n 0.0v 1739.495n 0.0v 1739.505n 1.8v 1749.495n 1.8v 1749.505n 1.8v 1759.495n 1.8v 1759.505n 0.0v 1769.495n 0.0v 1769.505n 0.0v 1779.495n 0.0v 1779.505n 0.0v 1789.495n 0.0v 1789.505n 0.0v 1799.495n 0.0v 1799.505n 0.0v 1809.495n 0.0v 1809.505n 0.0v 1819.495n 0.0v 1819.505n 0.0v 1829.495n 0.0v 1829.505n 0.0v 1839.495n 0.0v 1839.505n 0.0v 1849.495n 0.0v 1849.505n 0.0v 1859.495n 0.0v 1859.505n 0.0v 1869.495n 0.0v 1869.505n 0.0v 1879.495n 0.0v 1879.505n 0.0v 1889.495n 0.0v 1889.505n 1.8v 1899.495n 1.8v 1899.505n 1.8v 1909.495n 1.8v 1909.505n 0.0v 1919.495n 0.0v 1919.505n 0.0v 1929.495n 0.0v 1929.505n 1.8v 1939.495n 1.8v 1939.505n 1.8v 1949.495n 1.8v 1949.505n 0.0v 1959.495n 0.0v 1959.505n 0.0v 1969.495n 0.0v 1969.505n 1.8v 1979.495n 1.8v 1979.505n 0.0v 1989.495n 0.0v 1989.505n 0.0v 1999.495n 0.0v 1999.505n 1.8v 2009.495n 1.8v 2009.505n 0.0v 2019.495n 0.0v 2019.505n 0.0v 2029.495n 0.0v 2029.505n 0.0v 2039.495n 0.0v 2039.505n 0.0v 2049.495n 0.0v 2049.505n 1.8v )
* (time, data): [(0, 1), (10, 1), (20, 1), (30, 1), (40, 0), (50, 0), (60, 0), (70, 0), (80, 1), (90, 1), (100, 1), (110, 0), (120, 1), (130, 1), (140, 1), (150, 1), (160, 0), (170, 0), (180, 1), (190, 1), (200, 1), (210, 1), (220, 0), (230, 1), (240, 0), (250, 1), (260, 1), (270, 1), (280, 1), (290, 1), (300, 0), (310, 0), (320, 1), (330, 1), (340, 1), (350, 0), (360, 1), (370, 1), (380, 1), (390, 0), (400, 0), (410, 0), (420, 0), (430, 1), (440, 0), (450, 1), (460, 1), (470, 1), (480, 0), (490, 1), (500, 0), (510, 0), (520, 1), (530, 0), (540, 0), (550, 0), (560, 0), (570, 1), (580, 1), (590, 0), (600, 1), (610, 1), (620, 1), (630, 1), (640, 1), (650, 0), (660, 1), (670, 1), (680, 0), (690, 1), (700, 1), (710, 1), (720, 1), (730, 0), (740, 1), (750, 0), (760, 1), (770, 0), (780, 0), (790, 0), (800, 1), (810, 1), (820, 0), (830, 1), (840, 0), (850, 0), (860, 1), (870, 1), (880, 0), (890, 1), (900, 0), (910, 1), (920, 0), (930, 1), (940, 1), (950, 1), (960, 1), (970, 1), (980, 1), (990, 0), (1000, 1), (1010, 0), (1020, 0), (1030, 1), (1040, 0), (1050, 1), (1060, 1), (1070, 1), (1080, 1), (1090, 1), (1100, 1), (1110, 0), (1120, 1), (1130, 0), (1140, 1), (1150, 1), (1160, 1), (1170, 0), (1180, 0), (1190, 0), (1200, 0), (1210, 1), (1220, 0), (1230, 0), (1240, 0), (1250, 0), (1260, 1), (1270, 1), (1280, 1), (1290, 0), (1300, 1), (1310, 1), (1320, 1), (1330, 1), (1340, 0), (1350, 0), (1360, 1), (1370, 1), (1380, 1), (1390, 0), (1400, 0), (1410, 1), (1420, 1), (1430, 0), (1440, 0), (1450, 0), (1460, 1), (1470, 1), (1480, 1), (1490, 0), (1500, 1), (1510, 0), (1520, 0), (1530, 0), (1540, 1), (1550, 1), (1560, 0), (1570, 1), (1580, 1), (1590, 1), (1600, 1), (1610, 0), (1620, 1), (1630, 1), (1640, 0), (1650, 1), (1660, 0), (1670, 0), (1680, 0), (1690, 0), (1700, 1), (1710, 1), (1720, 0), (1730, 0), (1740, 0), (1750, 0), (1760, 0), (1770, 0), (1780, 1), (1790, 1), (1800, 0), (1810, 1), (1820, 1), (1830, 1), (1840, 0), (1850, 1), (1860, 0), (1870, 1), (1880, 0), (1890, 0), (1900, 1), (1910, 1), (1920, 0), (1930, 0), (1940, 1), (1950, 1), (1960, 1), (1970, 1), (1980, 0), (1990, 0), (2000, 0), (2010, 0), (2020, 0), (2030, 1), (2040, 1), (2050, 1)]
VCSB1 CSB1 0 PWL (0n 1.8v 9.495n 1.8v 9.505n 1.8v 19.495n 1.8v 19.505n 1.8v 29.495n 1.8v 29.505n 1.8v 39.495n 1.8v 39.505n 0.0v 49.495n 0.0v 49.505n 0.0v 59.495n 0.0v 59.505n 0.0v 69.495n 0.0v 69.505n 0.0v 79.495n 0.0v 79.505n 1.8v 89.495n 1.8v 89.505n 1.8v 99.495n 1.8v 99.505n 1.8v 109.495n 1.8v 109.505n 0.0v 119.495n 0.0v 119.505n 1.8v 129.495n 1.8v 129.505n 1.8v 139.495n 1.8v 139.505n 1.8v 149.495n 1.8v 149.505n 1.8v 159.495n 1.8v 159.505n 0.0v 169.495n 0.0v 169.505n 0.0v 179.495n 0.0v 179.505n 1.8v 189.495n 1.8v 189.505n 1.8v 199.495n 1.8v 199.505n 1.8v 209.495n 1.8v 209.505n 1.8v 219.495n 1.8v 219.505n 0.0v 229.495n 0.0v 229.505n 1.8v 239.495n 1.8v 239.505n 0.0v 249.495n 0.0v 249.505n 1.8v 259.495n 1.8v 259.505n 1.8v 269.495n 1.8v 269.505n 1.8v 279.495n 1.8v 279.505n 1.8v 289.495n 1.8v 289.505n 1.8v 299.495n 1.8v 299.505n 0.0v 309.495n 0.0v 309.505n 0.0v 319.495n 0.0v 319.505n 1.8v 329.495n 1.8v 329.505n 1.8v 339.495n 1.8v 339.505n 1.8v 349.495n 1.8v 349.505n 0.0v 359.495n 0.0v 359.505n 1.8v 369.495n 1.8v 369.505n 1.8v 379.495n 1.8v 379.505n 1.8v 389.495n 1.8v 389.505n 0.0v 399.495n 0.0v 399.505n 0.0v 409.495n 0.0v 409.505n 0.0v 419.495n 0.0v 419.505n 0.0v 429.495n 0.0v 429.505n 1.8v 439.495n 1.8v 439.505n 0.0v 449.495n 0.0v 449.505n 1.8v 459.495n 1.8v 459.505n 1.8v 469.495n 1.8v 469.505n 1.8v 479.495n 1.8v 479.505n 0.0v 489.495n 0.0v 489.505n 1.8v 499.495n 1.8v 499.505n 0.0v 509.495n 0.0v 509.505n 0.0v 519.495n 0.0v 519.505n 1.8v 529.495n 1.8v 529.505n 0.0v 539.495n 0.0v 539.505n 0.0v 549.495n 0.0v 549.505n 0.0v 559.495n 0.0v 559.505n 0.0v 569.495n 0.0v 569.505n 1.8v 579.495n 1.8v 579.505n 1.8v 589.495n 1.8v 589.505n 0.0v 599.495n 0.0v 599.505n 1.8v 609.495n 1.8v 609.505n 1.8v 619.495n 1.8v 619.505n 1.8v 629.495n 1.8v 629.505n 1.8v 639.495n 1.8v 639.505n 1.8v 649.495n 1.8v 649.505n 0.0v 659.495n 0.0v 659.505n 1.8v 669.495n 1.8v 669.505n 1.8v 679.495n 1.8v 679.505n 0.0v 689.495n 0.0v 689.505n 1.8v 699.495n 1.8v 699.505n 1.8v 709.495n 1.8v 709.505n 1.8v 719.495n 1.8v 719.505n 1.8v 729.495n 1.8v 729.505n 0.0v 739.495n 0.0v 739.505n 1.8v 749.495n 1.8v 749.505n 0.0v 759.495n 0.0v 759.505n 1.8v 769.495n 1.8v 769.505n 0.0v 779.495n 0.0v 779.505n 0.0v 789.495n 0.0v 789.505n 0.0v 799.495n 0.0v 799.505n 1.8v 809.495n 1.8v 809.505n 1.8v 819.495n 1.8v 819.505n 0.0v 829.495n 0.0v 829.505n 1.8v 839.495n 1.8v 839.505n 0.0v 849.495n 0.0v 849.505n 0.0v 859.495n 0.0v 859.505n 1.8v 869.495n 1.8v 869.505n 1.8v 879.495n 1.8v 879.505n 0.0v 889.495n 0.0v 889.505n 1.8v 899.495n 1.8v 899.505n 0.0v 909.495n 0.0v 909.505n 1.8v 919.495n 1.8v 919.505n 0.0v 929.495n 0.0v 929.505n 1.8v 939.495n 1.8v 939.505n 1.8v 949.495n 1.8v 949.505n 1.8v 959.495n 1.8v 959.505n 1.8v 969.495n 1.8v 969.505n 1.8v 979.495n 1.8v 979.505n 1.8v 989.495n 1.8v 989.505n 0.0v 999.495n 0.0v 999.505n 1.8v 1009.495n 1.8v 1009.505n 0.0v 1019.495n 0.0v 1019.505n 0.0v 1029.495n 0.0v 1029.505n 1.8v 1039.495n 1.8v 1039.505n 0.0v 1049.495n 0.0v 1049.505n 1.8v 1059.495n 1.8v 1059.505n 1.8v 1069.495n 1.8v 1069.505n 1.8v 1079.495n 1.8v 1079.505n 1.8v 1089.495n 1.8v 1089.505n 1.8v 1099.495n 1.8v 1099.505n 1.8v 1109.495n 1.8v 1109.505n 0.0v 1119.495n 0.0v 1119.505n 1.8v 1129.495n 1.8v 1129.505n 0.0v 1139.495n 0.0v 1139.505n 1.8v 1149.495n 1.8v 1149.505n 1.8v 1159.495n 1.8v 1159.505n 1.8v 1169.495n 1.8v 1169.505n 0.0v 1179.495n 0.0v 1179.505n 0.0v 1189.495n 0.0v 1189.505n 0.0v 1199.495n 0.0v 1199.505n 0.0v 1209.495n 0.0v 1209.505n 1.8v 1219.495n 1.8v 1219.505n 0.0v 1229.495n 0.0v 1229.505n 0.0v 1239.495n 0.0v 1239.505n 0.0v 1249.495n 0.0v 1249.505n 0.0v 1259.495n 0.0v 1259.505n 1.8v 1269.495n 1.8v 1269.505n 1.8v 1279.495n 1.8v 1279.505n 1.8v 1289.495n 1.8v 1289.505n 0.0v 1299.495n 0.0v 1299.505n 1.8v 1309.495n 1.8v 1309.505n 1.8v 1319.495n 1.8v 1319.505n 1.8v 1329.495n 1.8v 1329.505n 1.8v 1339.495n 1.8v 1339.505n 0.0v 1349.495n 0.0v 1349.505n 0.0v 1359.495n 0.0v 1359.505n 1.8v 1369.495n 1.8v 1369.505n 1.8v 1379.495n 1.8v 1379.505n 1.8v 1389.495n 1.8v 1389.505n 0.0v 1399.495n 0.0v 1399.505n 0.0v 1409.495n 0.0v 1409.505n 1.8v 1419.495n 1.8v 1419.505n 1.8v 1429.495n 1.8v 1429.505n 0.0v 1439.495n 0.0v 1439.505n 0.0v 1449.495n 0.0v 1449.505n 0.0v 1459.495n 0.0v 1459.505n 1.8v 1469.495n 1.8v 1469.505n 1.8v 1479.495n 1.8v 1479.505n 1.8v 1489.495n 1.8v 1489.505n 0.0v 1499.495n 0.0v 1499.505n 1.8v 1509.495n 1.8v 1509.505n 0.0v 1519.495n 0.0v 1519.505n 0.0v 1529.495n 0.0v 1529.505n 0.0v 1539.495n 0.0v 1539.505n 1.8v 1549.495n 1.8v 1549.505n 1.8v 1559.495n 1.8v 1559.505n 0.0v 1569.495n 0.0v 1569.505n 1.8v 1579.495n 1.8v 1579.505n 1.8v 1589.495n 1.8v 1589.505n 1.8v 1599.495n 1.8v 1599.505n 1.8v 1609.495n 1.8v 1609.505n 0.0v 1619.495n 0.0v 1619.505n 1.8v 1629.495n 1.8v 1629.505n 1.8v 1639.495n 1.8v 1639.505n 0.0v 1649.495n 0.0v 1649.505n 1.8v 1659.495n 1.8v 1659.505n 0.0v 1669.495n 0.0v 1669.505n 0.0v 1679.495n 0.0v 1679.505n 0.0v 1689.495n 0.0v 1689.505n 0.0v 1699.495n 0.0v 1699.505n 1.8v 1709.495n 1.8v 1709.505n 1.8v 1719.495n 1.8v 1719.505n 0.0v 1729.495n 0.0v 1729.505n 0.0v 1739.495n 0.0v 1739.505n 0.0v 1749.495n 0.0v 1749.505n 0.0v 1759.495n 0.0v 1759.505n 0.0v 1769.495n 0.0v 1769.505n 0.0v 1779.495n 0.0v 1779.505n 1.8v 1789.495n 1.8v 1789.505n 1.8v 1799.495n 1.8v 1799.505n 0.0v 1809.495n 0.0v 1809.505n 1.8v 1819.495n 1.8v 1819.505n 1.8v 1829.495n 1.8v 1829.505n 1.8v 1839.495n 1.8v 1839.505n 0.0v 1849.495n 0.0v 1849.505n 1.8v 1859.495n 1.8v 1859.505n 0.0v 1869.495n 0.0v 1869.505n 1.8v 1879.495n 1.8v 1879.505n 0.0v 1889.495n 0.0v 1889.505n 0.0v 1899.495n 0.0v 1899.505n 1.8v 1909.495n 1.8v 1909.505n 1.8v 1919.495n 1.8v 1919.505n 0.0v 1929.495n 0.0v 1929.505n 0.0v 1939.495n 0.0v 1939.505n 1.8v 1949.495n 1.8v 1949.505n 1.8v 1959.495n 1.8v 1959.505n 1.8v 1969.495n 1.8v 1969.505n 1.8v 1979.495n 1.8v 1979.505n 0.0v 1989.495n 0.0v 1989.505n 0.0v 1999.495n 0.0v 1999.505n 0.0v 2009.495n 0.0v 2009.505n 0.0v 2019.495n 0.0v 2019.505n 0.0v 2029.495n 0.0v 2029.505n 1.8v 2039.495n 1.8v 2039.505n 1.8v 2049.495n 1.8v 2049.505n 1.8v )
* (time, data): [(0, 1), (10, 0), (20, 0), (30, 0), (40, 1), (50, 1), (60, 1), (70, 1), (80, 1), (90, 0), (100, 0), (110, 1), (120, 0), (130, 1), (140, 1), (150, 1), (160, 1), (170, 1), (180, 0), (190, 1), (200, 0), (210, 1), (220, 1), (230, 0), (240, 0), (250, 1), (260, 1), (270, 1), (280, 1), (290, 0), (300, 0), (310, 1), (320, 1), (330, 0), (340, 1), (350, 1), (360, 0), (370, 0), (380, 1), (390, 1), (400, 1), (410, 1), (420, 1), (430, 1), (440, 1), (450, 1), (460, 0), (470, 0), (480, 1), (490, 1), (500, 1), (510, 1), (520, 1), (530, 1), (540, 1), (550, 1), (560, 0), (570, 1), (580, 1), (590, 1), (600, 1), (610, 1), (620, 1), (630, 1), (640, 0), (650, 1), (660, 0), (670, 1), (680, 0), (690, 1), (700, 0), (710, 1), (720, 1), (730, 1), (740, 0), (750, 1), (760, 0), (770, 1), (780, 1), (790, 1), (800, 1), (810, 0), (820, 1), (830, 1), (840, 1), (850, 1), (860, 0), (870, 0), (880, 1), (890, 1), (900, 1), (910, 1), (920, 1), (930, 0), (940, 0), (950, 1), (960, 0), (970, 1), (980, 1), (990, 1), (1000, 1), (1010, 1), (1020, 1), (1030, 1), (1040, 1), (1050, 0), (1060, 0), (1070, 1), (1080, 1), (1090, 0), (1100, 1), (1110, 1), (1120, 1), (1130, 1), (1140, 0), (1150, 1), (1160, 0), (1170, 1), (1180, 1), (1190, 1), (1200, 1), (1210, 1), (1220, 1), (1230, 1), (1240, 1), (1250, 0), (1260, 0), (1270, 1), (1280, 0), (1290, 1), (1300, 1), (1310, 1), (1320, 1), (1330, 0), (1340, 1), (1350, 1), (1360, 1), (1370, 0), (1380, 1), (1390, 1), (1400, 0), (1410, 1), (1420, 0), (1430, 0), (1440, 1), (1450, 1), (1460, 1), (1470, 1), (1480, 1), (1490, 0), (1500, 1), (1510, 1), (1520, 1), (1530, 1), (1540, 1), (1550, 0), (1560, 1), (1570, 0), (1580, 1), (1590, 1), (1600, 1), (1610, 1), (1620, 1), (1630, 1), (1640, 1), (1650, 0), (1660, 1), (1670, 1), (1680, 1), (1690, 1), (1700, 1), (1710, 1), (1720, 1), (1730, 1), (1740, 1), (1750, 1), (1760, 0), (1770, 1), (1780, 1), (1790, 0), (1800, 1), (1810, 1), (1820, 0), (1830, 1), (1840, 1), (1850, 0), (1860, 1), (1870, 1), (1880, 1), (1890, 1), (1900, 1), (1910, 0), (1920, 1), (1930, 1), (1940, 1), (1950, 1), (1960, 1), (1970, 1), (1980, 1), (1990, 1), (2000, 1), (2010, 1), (2020, 1), (2030, 1), (2040, 1), (2050, 1)]
VWEB0 WEB0 0 PWL (0n 1.8v 9.495n 1.8v 9.505n 0.0v 19.495n 0.0v 19.505n 0.0v 29.495n 0.0v 29.505n 0.0v 39.495n 0.0v 39.505n 1.8v 49.495n 1.8v 49.505n 1.8v 59.495n 1.8v 59.505n 1.8v 69.495n 1.8v 69.505n 1.8v 79.495n 1.8v 79.505n 1.8v 89.495n 1.8v 89.505n 0.0v 99.495n 0.0v 99.505n 0.0v 109.495n 0.0v 109.505n 1.8v 119.495n 1.8v 119.505n 0.0v 129.495n 0.0v 129.505n 1.8v 139.495n 1.8v 139.505n 1.8v 149.495n 1.8v 149.505n 1.8v 159.495n 1.8v 159.505n 1.8v 169.495n 1.8v 169.505n 1.8v 179.495n 1.8v 179.505n 0.0v 189.495n 0.0v 189.505n 1.8v 199.495n 1.8v 199.505n 0.0v 209.495n 0.0v 209.505n 1.8v 219.495n 1.8v 219.505n 1.8v 229.495n 1.8v 229.505n 0.0v 239.495n 0.0v 239.505n 0.0v 249.495n 0.0v 249.505n 1.8v 259.495n 1.8v 259.505n 1.8v 269.495n 1.8v 269.505n 1.8v 279.495n 1.8v 279.505n 1.8v 289.495n 1.8v 289.505n 0.0v 299.495n 0.0v 299.505n 0.0v 309.495n 0.0v 309.505n 1.8v 319.495n 1.8v 319.505n 1.8v 329.495n 1.8v 329.505n 0.0v 339.495n 0.0v 339.505n 1.8v 349.495n 1.8v 349.505n 1.8v 359.495n 1.8v 359.505n 0.0v 369.495n 0.0v 369.505n 0.0v 379.495n 0.0v 379.505n 1.8v 389.495n 1.8v 389.505n 1.8v 399.495n 1.8v 399.505n 1.8v 409.495n 1.8v 409.505n 1.8v 419.495n 1.8v 419.505n 1.8v 429.495n 1.8v 429.505n 1.8v 439.495n 1.8v 439.505n 1.8v 449.495n 1.8v 449.505n 1.8v 459.495n 1.8v 459.505n 0.0v 469.495n 0.0v 469.505n 0.0v 479.495n 0.0v 479.505n 1.8v 489.495n 1.8v 489.505n 1.8v 499.495n 1.8v 499.505n 1.8v 509.495n 1.8v 509.505n 1.8v 519.495n 1.8v 519.505n 1.8v 529.495n 1.8v 529.505n 1.8v 539.495n 1.8v 539.505n 1.8v 549.495n 1.8v 549.505n 1.8v 559.495n 1.8v 559.505n 0.0v 569.495n 0.0v 569.505n 1.8v 579.495n 1.8v 579.505n 1.8v 589.495n 1.8v 589.505n 1.8v 599.495n 1.8v 599.505n 1.8v 609.495n 1.8v 609.505n 1.8v 619.495n 1.8v 619.505n 1.8v 629.495n 1.8v 629.505n 1.8v 639.495n 1.8v 639.505n 0.0v 649.495n 0.0v 649.505n 1.8v 659.495n 1.8v 659.505n 0.0v 669.495n 0.0v 669.505n 1.8v 679.495n 1.8v 679.505n 0.0v 689.495n 0.0v 689.505n 1.8v 699.495n 1.8v 699.505n 0.0v 709.495n 0.0v 709.505n 1.8v 719.495n 1.8v 719.505n 1.8v 729.495n 1.8v 729.505n 1.8v 739.495n 1.8v 739.505n 0.0v 749.495n 0.0v 749.505n 1.8v 759.495n 1.8v 759.505n 0.0v 769.495n 0.0v 769.505n 1.8v 779.495n 1.8v 779.505n 1.8v 789.495n 1.8v 789.505n 1.8v 799.495n 1.8v 799.505n 1.8v 809.495n 1.8v 809.505n 0.0v 819.495n 0.0v 819.505n 1.8v 829.495n 1.8v 829.505n 1.8v 839.495n 1.8v 839.505n 1.8v 849.495n 1.8v 849.505n 1.8v 859.495n 1.8v 859.505n 0.0v 869.495n 0.0v 869.505n 0.0v 879.495n 0.0v 879.505n 1.8v 889.495n 1.8v 889.505n 1.8v 899.495n 1.8v 899.505n 1.8v 909.495n 1.8v 909.505n 1.8v 919.495n 1.8v 919.505n 1.8v 929.495n 1.8v 929.505n 0.0v 939.495n 0.0v 939.505n 0.0v 949.495n 0.0v 949.505n 1.8v 959.495n 1.8v 959.505n 0.0v 969.495n 0.0v 969.505n 1.8v 979.495n 1.8v 979.505n 1.8v 989.495n 1.8v 989.505n 1.8v 999.495n 1.8v 999.505n 1.8v 1009.495n 1.8v 1009.505n 1.8v 1019.495n 1.8v 1019.505n 1.8v 1029.495n 1.8v 1029.505n 1.8v 1039.495n 1.8v 1039.505n 1.8v 1049.495n 1.8v 1049.505n 0.0v 1059.495n 0.0v 1059.505n 0.0v 1069.495n 0.0v 1069.505n 1.8v 1079.495n 1.8v 1079.505n 1.8v 1089.495n 1.8v 1089.505n 0.0v 1099.495n 0.0v 1099.505n 1.8v 1109.495n 1.8v 1109.505n 1.8v 1119.495n 1.8v 1119.505n 1.8v 1129.495n 1.8v 1129.505n 1.8v 1139.495n 1.8v 1139.505n 0.0v 1149.495n 0.0v 1149.505n 1.8v 1159.495n 1.8v 1159.505n 0.0v 1169.495n 0.0v 1169.505n 1.8v 1179.495n 1.8v 1179.505n 1.8v 1189.495n 1.8v 1189.505n 1.8v 1199.495n 1.8v 1199.505n 1.8v 1209.495n 1.8v 1209.505n 1.8v 1219.495n 1.8v 1219.505n 1.8v 1229.495n 1.8v 1229.505n 1.8v 1239.495n 1.8v 1239.505n 1.8v 1249.495n 1.8v 1249.505n 0.0v 1259.495n 0.0v 1259.505n 0.0v 1269.495n 0.0v 1269.505n 1.8v 1279.495n 1.8v 1279.505n 0.0v 1289.495n 0.0v 1289.505n 1.8v 1299.495n 1.8v 1299.505n 1.8v 1309.495n 1.8v 1309.505n 1.8v 1319.495n 1.8v 1319.505n 1.8v 1329.495n 1.8v 1329.505n 0.0v 1339.495n 0.0v 1339.505n 1.8v 1349.495n 1.8v 1349.505n 1.8v 1359.495n 1.8v 1359.505n 1.8v 1369.495n 1.8v 1369.505n 0.0v 1379.495n 0.0v 1379.505n 1.8v 1389.495n 1.8v 1389.505n 1.8v 1399.495n 1.8v 1399.505n 0.0v 1409.495n 0.0v 1409.505n 1.8v 1419.495n 1.8v 1419.505n 0.0v 1429.495n 0.0v 1429.505n 0.0v 1439.495n 0.0v 1439.505n 1.8v 1449.495n 1.8v 1449.505n 1.8v 1459.495n 1.8v 1459.505n 1.8v 1469.495n 1.8v 1469.505n 1.8v 1479.495n 1.8v 1479.505n 1.8v 1489.495n 1.8v 1489.505n 0.0v 1499.495n 0.0v 1499.505n 1.8v 1509.495n 1.8v 1509.505n 1.8v 1519.495n 1.8v 1519.505n 1.8v 1529.495n 1.8v 1529.505n 1.8v 1539.495n 1.8v 1539.505n 1.8v 1549.495n 1.8v 1549.505n 0.0v 1559.495n 0.0v 1559.505n 1.8v 1569.495n 1.8v 1569.505n 0.0v 1579.495n 0.0v 1579.505n 1.8v 1589.495n 1.8v 1589.505n 1.8v 1599.495n 1.8v 1599.505n 1.8v 1609.495n 1.8v 1609.505n 1.8v 1619.495n 1.8v 1619.505n 1.8v 1629.495n 1.8v 1629.505n 1.8v 1639.495n 1.8v 1639.505n 1.8v 1649.495n 1.8v 1649.505n 0.0v 1659.495n 0.0v 1659.505n 1.8v 1669.495n 1.8v 1669.505n 1.8v 1679.495n 1.8v 1679.505n 1.8v 1689.495n 1.8v 1689.505n 1.8v 1699.495n 1.8v 1699.505n 1.8v 1709.495n 1.8v 1709.505n 1.8v 1719.495n 1.8v 1719.505n 1.8v 1729.495n 1.8v 1729.505n 1.8v 1739.495n 1.8v 1739.505n 1.8v 1749.495n 1.8v 1749.505n 1.8v 1759.495n 1.8v 1759.505n 0.0v 1769.495n 0.0v 1769.505n 1.8v 1779.495n 1.8v 1779.505n 1.8v 1789.495n 1.8v 1789.505n 0.0v 1799.495n 0.0v 1799.505n 1.8v 1809.495n 1.8v 1809.505n 1.8v 1819.495n 1.8v 1819.505n 0.0v 1829.495n 0.0v 1829.505n 1.8v 1839.495n 1.8v 1839.505n 1.8v 1849.495n 1.8v 1849.505n 0.0v 1859.495n 0.0v 1859.505n 1.8v 1869.495n 1.8v 1869.505n 1.8v 1879.495n 1.8v 1879.505n 1.8v 1889.495n 1.8v 1889.505n 1.8v 1899.495n 1.8v 1899.505n 1.8v 1909.495n 1.8v 1909.505n 0.0v 1919.495n 0.0v 1919.505n 1.8v 1929.495n 1.8v 1929.505n 1.8v 1939.495n 1.8v 1939.505n 1.8v 1949.495n 1.8v 1949.505n 1.8v 1959.495n 1.8v 1959.505n 1.8v 1969.495n 1.8v 1969.505n 1.8v 1979.495n 1.8v 1979.505n 1.8v 1989.495n 1.8v 1989.505n 1.8v 1999.495n 1.8v 1999.505n 1.8v 2009.495n 1.8v 2009.505n 1.8v 2019.495n 1.8v 2019.505n 1.8v 2029.495n 1.8v 2029.505n 1.8v 2039.495n 1.8v 2039.505n 1.8v 2049.495n 1.8v 2049.505n 1.8v )
* PULSE: period=10
Vclk0 clk0 0 PULSE (0 1.8 9.995n 0.01n 0.01n 4.99n 10n)
* PULSE: period=10
Vclk1 clk1 0 PULSE (0 1.8 9.995n 0.01n 0.01n 4.99n 10n)

 * Generation of dout measurements
* CHECK dout0_0 vdout0_0ck4 = 0 time = 50
* CHECK dout0_1 vdout0_1ck4 = 0 time = 50
* CHECK dout0_2 vdout0_2ck4 = 1.8 time = 50
* CHECK dout0_3 vdout0_3ck4 = 0 time = 50
* CHECK dout0_4 vdout0_4ck4 = 1.8 time = 50
* CHECK dout0_5 vdout0_5ck4 = 1.8 time = 50
* CHECK dout0_6 vdout0_6ck4 = 0 time = 50
* CHECK dout0_7 vdout0_7ck4 = 1.8 time = 50
* CHECK dout0_8 vdout0_8ck4 = 0 time = 50
* CHECK dout0_9 vdout0_9ck4 = 1.8 time = 50
* CHECK dout0_10 vdout0_10ck4 = 1.8 time = 50
* CHECK dout0_11 vdout0_11ck4 = 1.8 time = 50
* CHECK dout0_12 vdout0_12ck4 = 0 time = 50
* CHECK dout0_13 vdout0_13ck4 = 1.8 time = 50
* CHECK dout0_14 vdout0_14ck4 = 0 time = 50
* CHECK dout0_15 vdout0_15ck4 = 0 time = 50
* CHECK dout0_16 vdout0_16ck4 = 1.8 time = 50
* CHECK dout0_17 vdout0_17ck4 = 1.8 time = 50
* CHECK dout0_18 vdout0_18ck4 = 1.8 time = 50
* CHECK dout0_19 vdout0_19ck4 = 0 time = 50
* CHECK dout0_20 vdout0_20ck4 = 1.8 time = 50
* CHECK dout0_21 vdout0_21ck4 = 1.8 time = 50
* CHECK dout0_22 vdout0_22ck4 = 0 time = 50
* CHECK dout0_23 vdout0_23ck4 = 1.8 time = 50
* CHECK dout0_24 vdout0_24ck4 = 1.8 time = 50
* CHECK dout0_25 vdout0_25ck4 = 0 time = 50
* CHECK dout0_26 vdout0_26ck4 = 1.8 time = 50
* CHECK dout0_27 vdout0_27ck4 = 0 time = 50
* CHECK dout0_28 vdout0_28ck4 = 1.8 time = 50
* CHECK dout0_29 vdout0_29ck4 = 1.8 time = 50
* CHECK dout0_30 vdout0_30ck4 = 0 time = 50
* CHECK dout0_31 vdout0_31ck4 = 0 time = 50
* CHECK dout1_0 vdout1_0ck4 = 0 time = 50
* CHECK dout1_1 vdout1_1ck4 = 0 time = 50
* CHECK dout1_2 vdout1_2ck4 = 1.8 time = 50
* CHECK dout1_3 vdout1_3ck4 = 0 time = 50
* CHECK dout1_4 vdout1_4ck4 = 1.8 time = 50
* CHECK dout1_5 vdout1_5ck4 = 1.8 time = 50
* CHECK dout1_6 vdout1_6ck4 = 0 time = 50
* CHECK dout1_7 vdout1_7ck4 = 1.8 time = 50
* CHECK dout1_8 vdout1_8ck4 = 0 time = 50
* CHECK dout1_9 vdout1_9ck4 = 1.8 time = 50
* CHECK dout1_10 vdout1_10ck4 = 1.8 time = 50
* CHECK dout1_11 vdout1_11ck4 = 1.8 time = 50
* CHECK dout1_12 vdout1_12ck4 = 0 time = 50
* CHECK dout1_13 vdout1_13ck4 = 1.8 time = 50
* CHECK dout1_14 vdout1_14ck4 = 0 time = 50
* CHECK dout1_15 vdout1_15ck4 = 0 time = 50
* CHECK dout1_16 vdout1_16ck4 = 1.8 time = 50
* CHECK dout1_17 vdout1_17ck4 = 1.8 time = 50
* CHECK dout1_18 vdout1_18ck4 = 1.8 time = 50
* CHECK dout1_19 vdout1_19ck4 = 0 time = 50
* CHECK dout1_20 vdout1_20ck4 = 1.8 time = 50
* CHECK dout1_21 vdout1_21ck4 = 1.8 time = 50
* CHECK dout1_22 vdout1_22ck4 = 0 time = 50
* CHECK dout1_23 vdout1_23ck4 = 1.8 time = 50
* CHECK dout1_24 vdout1_24ck4 = 1.8 time = 50
* CHECK dout1_25 vdout1_25ck4 = 0 time = 50
* CHECK dout1_26 vdout1_26ck4 = 1.8 time = 50
* CHECK dout1_27 vdout1_27ck4 = 0 time = 50
* CHECK dout1_28 vdout1_28ck4 = 1.8 time = 50
* CHECK dout1_29 vdout1_29ck4 = 1.8 time = 50
* CHECK dout1_30 vdout1_30ck4 = 0 time = 50
* CHECK dout1_31 vdout1_31ck4 = 0 time = 50
* CHECK dout1_0 vdout1_0ck5 = 0 time = 60
* CHECK dout1_1 vdout1_1ck5 = 0 time = 60
* CHECK dout1_2 vdout1_2ck5 = 1.8 time = 60
* CHECK dout1_3 vdout1_3ck5 = 0 time = 60
* CHECK dout1_4 vdout1_4ck5 = 1.8 time = 60
* CHECK dout1_5 vdout1_5ck5 = 1.8 time = 60
* CHECK dout1_6 vdout1_6ck5 = 0 time = 60
* CHECK dout1_7 vdout1_7ck5 = 1.8 time = 60
* CHECK dout1_8 vdout1_8ck5 = 0 time = 60
* CHECK dout1_9 vdout1_9ck5 = 1.8 time = 60
* CHECK dout1_10 vdout1_10ck5 = 1.8 time = 60
* CHECK dout1_11 vdout1_11ck5 = 1.8 time = 60
* CHECK dout1_12 vdout1_12ck5 = 0 time = 60
* CHECK dout1_13 vdout1_13ck5 = 1.8 time = 60
* CHECK dout1_14 vdout1_14ck5 = 0 time = 60
* CHECK dout1_15 vdout1_15ck5 = 0 time = 60
* CHECK dout1_16 vdout1_16ck5 = 1.8 time = 60
* CHECK dout1_17 vdout1_17ck5 = 1.8 time = 60
* CHECK dout1_18 vdout1_18ck5 = 1.8 time = 60
* CHECK dout1_19 vdout1_19ck5 = 0 time = 60
* CHECK dout1_20 vdout1_20ck5 = 1.8 time = 60
* CHECK dout1_21 vdout1_21ck5 = 1.8 time = 60
* CHECK dout1_22 vdout1_22ck5 = 0 time = 60
* CHECK dout1_23 vdout1_23ck5 = 1.8 time = 60
* CHECK dout1_24 vdout1_24ck5 = 1.8 time = 60
* CHECK dout1_25 vdout1_25ck5 = 0 time = 60
* CHECK dout1_26 vdout1_26ck5 = 1.8 time = 60
* CHECK dout1_27 vdout1_27ck5 = 0 time = 60
* CHECK dout1_28 vdout1_28ck5 = 1.8 time = 60
* CHECK dout1_29 vdout1_29ck5 = 1.8 time = 60
* CHECK dout1_30 vdout1_30ck5 = 0 time = 60
* CHECK dout1_31 vdout1_31ck5 = 0 time = 60
* CHECK dout0_0 vdout0_0ck6 = 0 time = 70
* CHECK dout0_1 vdout0_1ck6 = 0 time = 70
* CHECK dout0_2 vdout0_2ck6 = 1.8 time = 70
* CHECK dout0_3 vdout0_3ck6 = 0 time = 70
* CHECK dout0_4 vdout0_4ck6 = 1.8 time = 70
* CHECK dout0_5 vdout0_5ck6 = 1.8 time = 70
* CHECK dout0_6 vdout0_6ck6 = 0 time = 70
* CHECK dout0_7 vdout0_7ck6 = 1.8 time = 70
* CHECK dout0_8 vdout0_8ck6 = 0 time = 70
* CHECK dout0_9 vdout0_9ck6 = 1.8 time = 70
* CHECK dout0_10 vdout0_10ck6 = 1.8 time = 70
* CHECK dout0_11 vdout0_11ck6 = 1.8 time = 70
* CHECK dout0_12 vdout0_12ck6 = 0 time = 70
* CHECK dout0_13 vdout0_13ck6 = 1.8 time = 70
* CHECK dout0_14 vdout0_14ck6 = 0 time = 70
* CHECK dout0_15 vdout0_15ck6 = 0 time = 70
* CHECK dout0_16 vdout0_16ck6 = 1.8 time = 70
* CHECK dout0_17 vdout0_17ck6 = 1.8 time = 70
* CHECK dout0_18 vdout0_18ck6 = 1.8 time = 70
* CHECK dout0_19 vdout0_19ck6 = 0 time = 70
* CHECK dout0_20 vdout0_20ck6 = 1.8 time = 70
* CHECK dout0_21 vdout0_21ck6 = 1.8 time = 70
* CHECK dout0_22 vdout0_22ck6 = 0 time = 70
* CHECK dout0_23 vdout0_23ck6 = 1.8 time = 70
* CHECK dout0_24 vdout0_24ck6 = 1.8 time = 70
* CHECK dout0_25 vdout0_25ck6 = 0 time = 70
* CHECK dout0_26 vdout0_26ck6 = 1.8 time = 70
* CHECK dout0_27 vdout0_27ck6 = 0 time = 70
* CHECK dout0_28 vdout0_28ck6 = 1.8 time = 70
* CHECK dout0_29 vdout0_29ck6 = 1.8 time = 70
* CHECK dout0_30 vdout0_30ck6 = 0 time = 70
* CHECK dout0_31 vdout0_31ck6 = 0 time = 70
* CHECK dout1_0 vdout1_0ck6 = 0 time = 70
* CHECK dout1_1 vdout1_1ck6 = 0 time = 70
* CHECK dout1_2 vdout1_2ck6 = 1.8 time = 70
* CHECK dout1_3 vdout1_3ck6 = 0 time = 70
* CHECK dout1_4 vdout1_4ck6 = 1.8 time = 70
* CHECK dout1_5 vdout1_5ck6 = 1.8 time = 70
* CHECK dout1_6 vdout1_6ck6 = 0 time = 70
* CHECK dout1_7 vdout1_7ck6 = 1.8 time = 70
* CHECK dout1_8 vdout1_8ck6 = 0 time = 70
* CHECK dout1_9 vdout1_9ck6 = 1.8 time = 70
* CHECK dout1_10 vdout1_10ck6 = 1.8 time = 70
* CHECK dout1_11 vdout1_11ck6 = 1.8 time = 70
* CHECK dout1_12 vdout1_12ck6 = 0 time = 70
* CHECK dout1_13 vdout1_13ck6 = 1.8 time = 70
* CHECK dout1_14 vdout1_14ck6 = 0 time = 70
* CHECK dout1_15 vdout1_15ck6 = 0 time = 70
* CHECK dout1_16 vdout1_16ck6 = 1.8 time = 70
* CHECK dout1_17 vdout1_17ck6 = 1.8 time = 70
* CHECK dout1_18 vdout1_18ck6 = 1.8 time = 70
* CHECK dout1_19 vdout1_19ck6 = 0 time = 70
* CHECK dout1_20 vdout1_20ck6 = 1.8 time = 70
* CHECK dout1_21 vdout1_21ck6 = 1.8 time = 70
* CHECK dout1_22 vdout1_22ck6 = 0 time = 70
* CHECK dout1_23 vdout1_23ck6 = 1.8 time = 70
* CHECK dout1_24 vdout1_24ck6 = 1.8 time = 70
* CHECK dout1_25 vdout1_25ck6 = 0 time = 70
* CHECK dout1_26 vdout1_26ck6 = 1.8 time = 70
* CHECK dout1_27 vdout1_27ck6 = 0 time = 70
* CHECK dout1_28 vdout1_28ck6 = 1.8 time = 70
* CHECK dout1_29 vdout1_29ck6 = 1.8 time = 70
* CHECK dout1_30 vdout1_30ck6 = 0 time = 70
* CHECK dout1_31 vdout1_31ck6 = 0 time = 70
* CHECK dout1_0 vdout1_0ck7 = 0 time = 80
* CHECK dout1_1 vdout1_1ck7 = 0 time = 80
* CHECK dout1_2 vdout1_2ck7 = 1.8 time = 80
* CHECK dout1_3 vdout1_3ck7 = 0 time = 80
* CHECK dout1_4 vdout1_4ck7 = 1.8 time = 80
* CHECK dout1_5 vdout1_5ck7 = 1.8 time = 80
* CHECK dout1_6 vdout1_6ck7 = 0 time = 80
* CHECK dout1_7 vdout1_7ck7 = 1.8 time = 80
* CHECK dout1_8 vdout1_8ck7 = 0 time = 80
* CHECK dout1_9 vdout1_9ck7 = 1.8 time = 80
* CHECK dout1_10 vdout1_10ck7 = 1.8 time = 80
* CHECK dout1_11 vdout1_11ck7 = 1.8 time = 80
* CHECK dout1_12 vdout1_12ck7 = 0 time = 80
* CHECK dout1_13 vdout1_13ck7 = 1.8 time = 80
* CHECK dout1_14 vdout1_14ck7 = 0 time = 80
* CHECK dout1_15 vdout1_15ck7 = 0 time = 80
* CHECK dout1_16 vdout1_16ck7 = 1.8 time = 80
* CHECK dout1_17 vdout1_17ck7 = 1.8 time = 80
* CHECK dout1_18 vdout1_18ck7 = 1.8 time = 80
* CHECK dout1_19 vdout1_19ck7 = 0 time = 80
* CHECK dout1_20 vdout1_20ck7 = 1.8 time = 80
* CHECK dout1_21 vdout1_21ck7 = 1.8 time = 80
* CHECK dout1_22 vdout1_22ck7 = 0 time = 80
* CHECK dout1_23 vdout1_23ck7 = 1.8 time = 80
* CHECK dout1_24 vdout1_24ck7 = 1.8 time = 80
* CHECK dout1_25 vdout1_25ck7 = 0 time = 80
* CHECK dout1_26 vdout1_26ck7 = 1.8 time = 80
* CHECK dout1_27 vdout1_27ck7 = 0 time = 80
* CHECK dout1_28 vdout1_28ck7 = 1.8 time = 80
* CHECK dout1_29 vdout1_29ck7 = 1.8 time = 80
* CHECK dout1_30 vdout1_30ck7 = 0 time = 80
* CHECK dout1_31 vdout1_31ck7 = 0 time = 80
* CHECK dout0_0 vdout0_0ck11 = 0 time = 120
* CHECK dout0_1 vdout0_1ck11 = 1.8 time = 120
* CHECK dout0_2 vdout0_2ck11 = 1.8 time = 120
* CHECK dout0_3 vdout0_3ck11 = 1.8 time = 120
* CHECK dout0_4 vdout0_4ck11 = 1.8 time = 120
* CHECK dout0_5 vdout0_5ck11 = 1.8 time = 120
* CHECK dout0_6 vdout0_6ck11 = 1.8 time = 120
* CHECK dout0_7 vdout0_7ck11 = 0 time = 120
* CHECK dout0_8 vdout0_8ck11 = 1.8 time = 120
* CHECK dout0_9 vdout0_9ck11 = 1.8 time = 120
* CHECK dout0_10 vdout0_10ck11 = 0 time = 120
* CHECK dout0_11 vdout0_11ck11 = 1.8 time = 120
* CHECK dout0_12 vdout0_12ck11 = 1.8 time = 120
* CHECK dout0_13 vdout0_13ck11 = 0 time = 120
* CHECK dout0_14 vdout0_14ck11 = 1.8 time = 120
* CHECK dout0_15 vdout0_15ck11 = 0 time = 120
* CHECK dout0_16 vdout0_16ck11 = 0 time = 120
* CHECK dout0_17 vdout0_17ck11 = 0 time = 120
* CHECK dout0_18 vdout0_18ck11 = 0 time = 120
* CHECK dout0_19 vdout0_19ck11 = 1.8 time = 120
* CHECK dout0_20 vdout0_20ck11 = 0 time = 120
* CHECK dout0_21 vdout0_21ck11 = 0 time = 120
* CHECK dout0_22 vdout0_22ck11 = 1.8 time = 120
* CHECK dout0_23 vdout0_23ck11 = 1.8 time = 120
* CHECK dout0_24 vdout0_24ck11 = 0 time = 120
* CHECK dout0_25 vdout0_25ck11 = 1.8 time = 120
* CHECK dout0_26 vdout0_26ck11 = 0 time = 120
* CHECK dout0_27 vdout0_27ck11 = 1.8 time = 120
* CHECK dout0_28 vdout0_28ck11 = 0 time = 120
* CHECK dout0_29 vdout0_29ck11 = 1.8 time = 120
* CHECK dout0_30 vdout0_30ck11 = 0 time = 120
* CHECK dout0_31 vdout0_31ck11 = 1.8 time = 120
* CHECK dout1_0 vdout1_0ck11 = 0 time = 120
* CHECK dout1_1 vdout1_1ck11 = 0 time = 120
* CHECK dout1_2 vdout1_2ck11 = 1.8 time = 120
* CHECK dout1_3 vdout1_3ck11 = 0 time = 120
* CHECK dout1_4 vdout1_4ck11 = 1.8 time = 120
* CHECK dout1_5 vdout1_5ck11 = 1.8 time = 120
* CHECK dout1_6 vdout1_6ck11 = 0 time = 120
* CHECK dout1_7 vdout1_7ck11 = 1.8 time = 120
* CHECK dout1_8 vdout1_8ck11 = 0 time = 120
* CHECK dout1_9 vdout1_9ck11 = 1.8 time = 120
* CHECK dout1_10 vdout1_10ck11 = 1.8 time = 120
* CHECK dout1_11 vdout1_11ck11 = 1.8 time = 120
* CHECK dout1_12 vdout1_12ck11 = 0 time = 120
* CHECK dout1_13 vdout1_13ck11 = 1.8 time = 120
* CHECK dout1_14 vdout1_14ck11 = 0 time = 120
* CHECK dout1_15 vdout1_15ck11 = 0 time = 120
* CHECK dout1_16 vdout1_16ck11 = 1.8 time = 120
* CHECK dout1_17 vdout1_17ck11 = 1.8 time = 120
* CHECK dout1_18 vdout1_18ck11 = 1.8 time = 120
* CHECK dout1_19 vdout1_19ck11 = 0 time = 120
* CHECK dout1_20 vdout1_20ck11 = 1.8 time = 120
* CHECK dout1_21 vdout1_21ck11 = 1.8 time = 120
* CHECK dout1_22 vdout1_22ck11 = 0 time = 120
* CHECK dout1_23 vdout1_23ck11 = 1.8 time = 120
* CHECK dout1_24 vdout1_24ck11 = 1.8 time = 120
* CHECK dout1_25 vdout1_25ck11 = 0 time = 120
* CHECK dout1_26 vdout1_26ck11 = 1.8 time = 120
* CHECK dout1_27 vdout1_27ck11 = 0 time = 120
* CHECK dout1_28 vdout1_28ck11 = 1.8 time = 120
* CHECK dout1_29 vdout1_29ck11 = 1.8 time = 120
* CHECK dout1_30 vdout1_30ck11 = 0 time = 120
* CHECK dout1_31 vdout1_31ck11 = 0 time = 120
* CHECK dout0_0 vdout0_0ck13 = 0 time = 140
* CHECK dout0_1 vdout0_1ck13 = 1.8 time = 140
* CHECK dout0_2 vdout0_2ck13 = 1.8 time = 140
* CHECK dout0_3 vdout0_3ck13 = 0 time = 140
* CHECK dout0_4 vdout0_4ck13 = 1.8 time = 140
* CHECK dout0_5 vdout0_5ck13 = 0 time = 140
* CHECK dout0_6 vdout0_6ck13 = 1.8 time = 140
* CHECK dout0_7 vdout0_7ck13 = 1.8 time = 140
* CHECK dout0_8 vdout0_8ck13 = 0 time = 140
* CHECK dout0_9 vdout0_9ck13 = 0 time = 140
* CHECK dout0_10 vdout0_10ck13 = 0 time = 140
* CHECK dout0_11 vdout0_11ck13 = 1.8 time = 140
* CHECK dout0_12 vdout0_12ck13 = 0 time = 140
* CHECK dout0_13 vdout0_13ck13 = 1.8 time = 140
* CHECK dout0_14 vdout0_14ck13 = 1.8 time = 140
* CHECK dout0_15 vdout0_15ck13 = 1.8 time = 140
* CHECK dout0_16 vdout0_16ck13 = 0 time = 140
* CHECK dout0_17 vdout0_17ck13 = 0 time = 140
* CHECK dout0_18 vdout0_18ck13 = 1.8 time = 140
* CHECK dout0_19 vdout0_19ck13 = 1.8 time = 140
* CHECK dout0_20 vdout0_20ck13 = 1.8 time = 140
* CHECK dout0_21 vdout0_21ck13 = 1.8 time = 140
* CHECK dout0_22 vdout0_22ck13 = 0 time = 140
* CHECK dout0_23 vdout0_23ck13 = 1.8 time = 140
* CHECK dout0_24 vdout0_24ck13 = 0 time = 140
* CHECK dout0_25 vdout0_25ck13 = 1.8 time = 140
* CHECK dout0_26 vdout0_26ck13 = 0 time = 140
* CHECK dout0_27 vdout0_27ck13 = 0 time = 140
* CHECK dout0_28 vdout0_28ck13 = 1.8 time = 140
* CHECK dout0_29 vdout0_29ck13 = 0 time = 140
* CHECK dout0_30 vdout0_30ck13 = 0 time = 140
* CHECK dout0_31 vdout0_31ck13 = 1.8 time = 140
* CHECK dout0_0 vdout0_0ck15 = 0 time = 160
* CHECK dout0_1 vdout0_1ck15 = 1.8 time = 160
* CHECK dout0_2 vdout0_2ck15 = 1.8 time = 160
* CHECK dout0_3 vdout0_3ck15 = 1.8 time = 160
* CHECK dout0_4 vdout0_4ck15 = 1.8 time = 160
* CHECK dout0_5 vdout0_5ck15 = 1.8 time = 160
* CHECK dout0_6 vdout0_6ck15 = 1.8 time = 160
* CHECK dout0_7 vdout0_7ck15 = 0 time = 160
* CHECK dout0_8 vdout0_8ck15 = 1.8 time = 160
* CHECK dout0_9 vdout0_9ck15 = 1.8 time = 160
* CHECK dout0_10 vdout0_10ck15 = 0 time = 160
* CHECK dout0_11 vdout0_11ck15 = 1.8 time = 160
* CHECK dout0_12 vdout0_12ck15 = 1.8 time = 160
* CHECK dout0_13 vdout0_13ck15 = 0 time = 160
* CHECK dout0_14 vdout0_14ck15 = 1.8 time = 160
* CHECK dout0_15 vdout0_15ck15 = 0 time = 160
* CHECK dout0_16 vdout0_16ck15 = 0 time = 160
* CHECK dout0_17 vdout0_17ck15 = 0 time = 160
* CHECK dout0_18 vdout0_18ck15 = 0 time = 160
* CHECK dout0_19 vdout0_19ck15 = 1.8 time = 160
* CHECK dout0_20 vdout0_20ck15 = 0 time = 160
* CHECK dout0_21 vdout0_21ck15 = 0 time = 160
* CHECK dout0_22 vdout0_22ck15 = 1.8 time = 160
* CHECK dout0_23 vdout0_23ck15 = 1.8 time = 160
* CHECK dout0_24 vdout0_24ck15 = 0 time = 160
* CHECK dout0_25 vdout0_25ck15 = 1.8 time = 160
* CHECK dout0_26 vdout0_26ck15 = 0 time = 160
* CHECK dout0_27 vdout0_27ck15 = 1.8 time = 160
* CHECK dout0_28 vdout0_28ck15 = 0 time = 160
* CHECK dout0_29 vdout0_29ck15 = 1.8 time = 160
* CHECK dout0_30 vdout0_30ck15 = 0 time = 160
* CHECK dout0_31 vdout0_31ck15 = 1.8 time = 160
* CHECK dout0_0 vdout0_0ck16 = 0 time = 170
* CHECK dout0_1 vdout0_1ck16 = 1.8 time = 170
* CHECK dout0_2 vdout0_2ck16 = 1.8 time = 170
* CHECK dout0_3 vdout0_3ck16 = 1.8 time = 170
* CHECK dout0_4 vdout0_4ck16 = 1.8 time = 170
* CHECK dout0_5 vdout0_5ck16 = 1.8 time = 170
* CHECK dout0_6 vdout0_6ck16 = 1.8 time = 170
* CHECK dout0_7 vdout0_7ck16 = 0 time = 170
* CHECK dout0_8 vdout0_8ck16 = 1.8 time = 170
* CHECK dout0_9 vdout0_9ck16 = 1.8 time = 170
* CHECK dout0_10 vdout0_10ck16 = 0 time = 170
* CHECK dout0_11 vdout0_11ck16 = 1.8 time = 170
* CHECK dout0_12 vdout0_12ck16 = 1.8 time = 170
* CHECK dout0_13 vdout0_13ck16 = 0 time = 170
* CHECK dout0_14 vdout0_14ck16 = 1.8 time = 170
* CHECK dout0_15 vdout0_15ck16 = 0 time = 170
* CHECK dout0_16 vdout0_16ck16 = 0 time = 170
* CHECK dout0_17 vdout0_17ck16 = 0 time = 170
* CHECK dout0_18 vdout0_18ck16 = 0 time = 170
* CHECK dout0_19 vdout0_19ck16 = 1.8 time = 170
* CHECK dout0_20 vdout0_20ck16 = 0 time = 170
* CHECK dout0_21 vdout0_21ck16 = 0 time = 170
* CHECK dout0_22 vdout0_22ck16 = 1.8 time = 170
* CHECK dout0_23 vdout0_23ck16 = 1.8 time = 170
* CHECK dout0_24 vdout0_24ck16 = 0 time = 170
* CHECK dout0_25 vdout0_25ck16 = 1.8 time = 170
* CHECK dout0_26 vdout0_26ck16 = 0 time = 170
* CHECK dout0_27 vdout0_27ck16 = 1.8 time = 170
* CHECK dout0_28 vdout0_28ck16 = 0 time = 170
* CHECK dout0_29 vdout0_29ck16 = 1.8 time = 170
* CHECK dout0_30 vdout0_30ck16 = 0 time = 170
* CHECK dout0_31 vdout0_31ck16 = 1.8 time = 170
* CHECK dout1_0 vdout1_0ck16 = 0 time = 170
* CHECK dout1_1 vdout1_1ck16 = 1.8 time = 170
* CHECK dout1_2 vdout1_2ck16 = 1.8 time = 170
* CHECK dout1_3 vdout1_3ck16 = 1.8 time = 170
* CHECK dout1_4 vdout1_4ck16 = 1.8 time = 170
* CHECK dout1_5 vdout1_5ck16 = 1.8 time = 170
* CHECK dout1_6 vdout1_6ck16 = 1.8 time = 170
* CHECK dout1_7 vdout1_7ck16 = 0 time = 170
* CHECK dout1_8 vdout1_8ck16 = 1.8 time = 170
* CHECK dout1_9 vdout1_9ck16 = 1.8 time = 170
* CHECK dout1_10 vdout1_10ck16 = 0 time = 170
* CHECK dout1_11 vdout1_11ck16 = 1.8 time = 170
* CHECK dout1_12 vdout1_12ck16 = 1.8 time = 170
* CHECK dout1_13 vdout1_13ck16 = 0 time = 170
* CHECK dout1_14 vdout1_14ck16 = 1.8 time = 170
* CHECK dout1_15 vdout1_15ck16 = 0 time = 170
* CHECK dout1_16 vdout1_16ck16 = 0 time = 170
* CHECK dout1_17 vdout1_17ck16 = 0 time = 170
* CHECK dout1_18 vdout1_18ck16 = 0 time = 170
* CHECK dout1_19 vdout1_19ck16 = 1.8 time = 170
* CHECK dout1_20 vdout1_20ck16 = 0 time = 170
* CHECK dout1_21 vdout1_21ck16 = 0 time = 170
* CHECK dout1_22 vdout1_22ck16 = 1.8 time = 170
* CHECK dout1_23 vdout1_23ck16 = 1.8 time = 170
* CHECK dout1_24 vdout1_24ck16 = 0 time = 170
* CHECK dout1_25 vdout1_25ck16 = 1.8 time = 170
* CHECK dout1_26 vdout1_26ck16 = 0 time = 170
* CHECK dout1_27 vdout1_27ck16 = 1.8 time = 170
* CHECK dout1_28 vdout1_28ck16 = 0 time = 170
* CHECK dout1_29 vdout1_29ck16 = 1.8 time = 170
* CHECK dout1_30 vdout1_30ck16 = 0 time = 170
* CHECK dout1_31 vdout1_31ck16 = 1.8 time = 170
* CHECK dout1_0 vdout1_0ck17 = 0 time = 180
* CHECK dout1_1 vdout1_1ck17 = 1.8 time = 180
* CHECK dout1_2 vdout1_2ck17 = 1.8 time = 180
* CHECK dout1_3 vdout1_3ck17 = 0 time = 180
* CHECK dout1_4 vdout1_4ck17 = 1.8 time = 180
* CHECK dout1_5 vdout1_5ck17 = 0 time = 180
* CHECK dout1_6 vdout1_6ck17 = 1.8 time = 180
* CHECK dout1_7 vdout1_7ck17 = 1.8 time = 180
* CHECK dout1_8 vdout1_8ck17 = 0 time = 180
* CHECK dout1_9 vdout1_9ck17 = 0 time = 180
* CHECK dout1_10 vdout1_10ck17 = 0 time = 180
* CHECK dout1_11 vdout1_11ck17 = 1.8 time = 180
* CHECK dout1_12 vdout1_12ck17 = 0 time = 180
* CHECK dout1_13 vdout1_13ck17 = 1.8 time = 180
* CHECK dout1_14 vdout1_14ck17 = 1.8 time = 180
* CHECK dout1_15 vdout1_15ck17 = 1.8 time = 180
* CHECK dout1_16 vdout1_16ck17 = 0 time = 180
* CHECK dout1_17 vdout1_17ck17 = 0 time = 180
* CHECK dout1_18 vdout1_18ck17 = 1.8 time = 180
* CHECK dout1_19 vdout1_19ck17 = 1.8 time = 180
* CHECK dout1_20 vdout1_20ck17 = 1.8 time = 180
* CHECK dout1_21 vdout1_21ck17 = 1.8 time = 180
* CHECK dout1_22 vdout1_22ck17 = 0 time = 180
* CHECK dout1_23 vdout1_23ck17 = 1.8 time = 180
* CHECK dout1_24 vdout1_24ck17 = 0 time = 180
* CHECK dout1_25 vdout1_25ck17 = 1.8 time = 180
* CHECK dout1_26 vdout1_26ck17 = 0 time = 180
* CHECK dout1_27 vdout1_27ck17 = 0 time = 180
* CHECK dout1_28 vdout1_28ck17 = 1.8 time = 180
* CHECK dout1_29 vdout1_29ck17 = 0 time = 180
* CHECK dout1_30 vdout1_30ck17 = 0 time = 180
* CHECK dout1_31 vdout1_31ck17 = 1.8 time = 180
* CHECK dout1_0 vdout1_0ck22 = 1.8 time = 230
* CHECK dout1_1 vdout1_1ck22 = 0 time = 230
* CHECK dout1_2 vdout1_2ck22 = 0 time = 230
* CHECK dout1_3 vdout1_3ck22 = 1.8 time = 230
* CHECK dout1_4 vdout1_4ck22 = 1.8 time = 230
* CHECK dout1_5 vdout1_5ck22 = 0 time = 230
* CHECK dout1_6 vdout1_6ck22 = 1.8 time = 230
* CHECK dout1_7 vdout1_7ck22 = 1.8 time = 230
* CHECK dout1_8 vdout1_8ck22 = 0 time = 230
* CHECK dout1_9 vdout1_9ck22 = 0 time = 230
* CHECK dout1_10 vdout1_10ck22 = 1.8 time = 230
* CHECK dout1_11 vdout1_11ck22 = 1.8 time = 230
* CHECK dout1_12 vdout1_12ck22 = 1.8 time = 230
* CHECK dout1_13 vdout1_13ck22 = 1.8 time = 230
* CHECK dout1_14 vdout1_14ck22 = 0 time = 230
* CHECK dout1_15 vdout1_15ck22 = 0 time = 230
* CHECK dout1_16 vdout1_16ck22 = 1.8 time = 230
* CHECK dout1_17 vdout1_17ck22 = 0 time = 230
* CHECK dout1_18 vdout1_18ck22 = 1.8 time = 230
* CHECK dout1_19 vdout1_19ck22 = 0 time = 230
* CHECK dout1_20 vdout1_20ck22 = 1.8 time = 230
* CHECK dout1_21 vdout1_21ck22 = 0 time = 230
* CHECK dout1_22 vdout1_22ck22 = 0 time = 230
* CHECK dout1_23 vdout1_23ck22 = 0 time = 230
* CHECK dout1_24 vdout1_24ck22 = 1.8 time = 230
* CHECK dout1_25 vdout1_25ck22 = 0 time = 230
* CHECK dout1_26 vdout1_26ck22 = 0 time = 230
* CHECK dout1_27 vdout1_27ck22 = 0 time = 230
* CHECK dout1_28 vdout1_28ck22 = 0 time = 230
* CHECK dout1_29 vdout1_29ck22 = 0 time = 230
* CHECK dout1_30 vdout1_30ck22 = 1.8 time = 230
* CHECK dout1_31 vdout1_31ck22 = 0 time = 230
* CHECK dout1_0 vdout1_0ck24 = 1.8 time = 250
* CHECK dout1_1 vdout1_1ck24 = 0 time = 250
* CHECK dout1_2 vdout1_2ck24 = 0 time = 250
* CHECK dout1_3 vdout1_3ck24 = 1.8 time = 250
* CHECK dout1_4 vdout1_4ck24 = 1.8 time = 250
* CHECK dout1_5 vdout1_5ck24 = 0 time = 250
* CHECK dout1_6 vdout1_6ck24 = 1.8 time = 250
* CHECK dout1_7 vdout1_7ck24 = 1.8 time = 250
* CHECK dout1_8 vdout1_8ck24 = 0 time = 250
* CHECK dout1_9 vdout1_9ck24 = 0 time = 250
* CHECK dout1_10 vdout1_10ck24 = 1.8 time = 250
* CHECK dout1_11 vdout1_11ck24 = 1.8 time = 250
* CHECK dout1_12 vdout1_12ck24 = 1.8 time = 250
* CHECK dout1_13 vdout1_13ck24 = 1.8 time = 250
* CHECK dout1_14 vdout1_14ck24 = 0 time = 250
* CHECK dout1_15 vdout1_15ck24 = 0 time = 250
* CHECK dout1_16 vdout1_16ck24 = 1.8 time = 250
* CHECK dout1_17 vdout1_17ck24 = 0 time = 250
* CHECK dout1_18 vdout1_18ck24 = 1.8 time = 250
* CHECK dout1_19 vdout1_19ck24 = 0 time = 250
* CHECK dout1_20 vdout1_20ck24 = 1.8 time = 250
* CHECK dout1_21 vdout1_21ck24 = 0 time = 250
* CHECK dout1_22 vdout1_22ck24 = 0 time = 250
* CHECK dout1_23 vdout1_23ck24 = 0 time = 250
* CHECK dout1_24 vdout1_24ck24 = 1.8 time = 250
* CHECK dout1_25 vdout1_25ck24 = 0 time = 250
* CHECK dout1_26 vdout1_26ck24 = 0 time = 250
* CHECK dout1_27 vdout1_27ck24 = 0 time = 250
* CHECK dout1_28 vdout1_28ck24 = 0 time = 250
* CHECK dout1_29 vdout1_29ck24 = 0 time = 250
* CHECK dout1_30 vdout1_30ck24 = 1.8 time = 250
* CHECK dout1_31 vdout1_31ck24 = 0 time = 250
* CHECK dout0_0 vdout0_0ck28 = 0 time = 290
* CHECK dout0_1 vdout0_1ck28 = 0 time = 290
* CHECK dout0_2 vdout0_2ck28 = 1.8 time = 290
* CHECK dout0_3 vdout0_3ck28 = 0 time = 290
* CHECK dout0_4 vdout0_4ck28 = 0 time = 290
* CHECK dout0_5 vdout0_5ck28 = 0 time = 290
* CHECK dout0_6 vdout0_6ck28 = 0 time = 290
* CHECK dout0_7 vdout0_7ck28 = 0 time = 290
* CHECK dout0_8 vdout0_8ck28 = 1.8 time = 290
* CHECK dout0_9 vdout0_9ck28 = 1.8 time = 290
* CHECK dout0_10 vdout0_10ck28 = 1.8 time = 290
* CHECK dout0_11 vdout0_11ck28 = 0 time = 290
* CHECK dout0_12 vdout0_12ck28 = 1.8 time = 290
* CHECK dout0_13 vdout0_13ck28 = 0 time = 290
* CHECK dout0_14 vdout0_14ck28 = 0 time = 290
* CHECK dout0_15 vdout0_15ck28 = 0 time = 290
* CHECK dout0_16 vdout0_16ck28 = 0 time = 290
* CHECK dout0_17 vdout0_17ck28 = 1.8 time = 290
* CHECK dout0_18 vdout0_18ck28 = 0 time = 290
* CHECK dout0_19 vdout0_19ck28 = 1.8 time = 290
* CHECK dout0_20 vdout0_20ck28 = 1.8 time = 290
* CHECK dout0_21 vdout0_21ck28 = 1.8 time = 290
* CHECK dout0_22 vdout0_22ck28 = 0 time = 290
* CHECK dout0_23 vdout0_23ck28 = 1.8 time = 290
* CHECK dout0_24 vdout0_24ck28 = 0 time = 290
* CHECK dout0_25 vdout0_25ck28 = 1.8 time = 290
* CHECK dout0_26 vdout0_26ck28 = 0 time = 290
* CHECK dout0_27 vdout0_27ck28 = 0 time = 290
* CHECK dout0_28 vdout0_28ck28 = 1.8 time = 290
* CHECK dout0_29 vdout0_29ck28 = 1.8 time = 290
* CHECK dout0_30 vdout0_30ck28 = 1.8 time = 290
* CHECK dout0_31 vdout0_31ck28 = 1.8 time = 290
* CHECK dout1_0 vdout1_0ck30 = 1.8 time = 310
* CHECK dout1_1 vdout1_1ck30 = 0 time = 310
* CHECK dout1_2 vdout1_2ck30 = 1.8 time = 310
* CHECK dout1_3 vdout1_3ck30 = 0 time = 310
* CHECK dout1_4 vdout1_4ck30 = 0 time = 310
* CHECK dout1_5 vdout1_5ck30 = 1.8 time = 310
* CHECK dout1_6 vdout1_6ck30 = 1.8 time = 310
* CHECK dout1_7 vdout1_7ck30 = 0 time = 310
* CHECK dout1_8 vdout1_8ck30 = 0 time = 310
* CHECK dout1_9 vdout1_9ck30 = 1.8 time = 310
* CHECK dout1_10 vdout1_10ck30 = 0 time = 310
* CHECK dout1_11 vdout1_11ck30 = 0 time = 310
* CHECK dout1_12 vdout1_12ck30 = 1.8 time = 310
* CHECK dout1_13 vdout1_13ck30 = 1.8 time = 310
* CHECK dout1_14 vdout1_14ck30 = 0 time = 310
* CHECK dout1_15 vdout1_15ck30 = 0 time = 310
* CHECK dout1_16 vdout1_16ck30 = 1.8 time = 310
* CHECK dout1_17 vdout1_17ck30 = 1.8 time = 310
* CHECK dout1_18 vdout1_18ck30 = 0 time = 310
* CHECK dout1_19 vdout1_19ck30 = 0 time = 310
* CHECK dout1_20 vdout1_20ck30 = 0 time = 310
* CHECK dout1_21 vdout1_21ck30 = 1.8 time = 310
* CHECK dout1_22 vdout1_22ck30 = 0 time = 310
* CHECK dout1_23 vdout1_23ck30 = 0 time = 310
* CHECK dout1_24 vdout1_24ck30 = 1.8 time = 310
* CHECK dout1_25 vdout1_25ck30 = 1.8 time = 310
* CHECK dout1_26 vdout1_26ck30 = 1.8 time = 310
* CHECK dout1_27 vdout1_27ck30 = 0 time = 310
* CHECK dout1_28 vdout1_28ck30 = 0 time = 310
* CHECK dout1_29 vdout1_29ck30 = 0 time = 310
* CHECK dout1_30 vdout1_30ck30 = 1.8 time = 310
* CHECK dout1_31 vdout1_31ck30 = 1.8 time = 310
* CHECK dout1_0 vdout1_0ck31 = 1.8 time = 320
* CHECK dout1_1 vdout1_1ck31 = 0 time = 320
* CHECK dout1_2 vdout1_2ck31 = 0 time = 320
* CHECK dout1_3 vdout1_3ck31 = 1.8 time = 320
* CHECK dout1_4 vdout1_4ck31 = 0 time = 320
* CHECK dout1_5 vdout1_5ck31 = 1.8 time = 320
* CHECK dout1_6 vdout1_6ck31 = 0 time = 320
* CHECK dout1_7 vdout1_7ck31 = 0 time = 320
* CHECK dout1_8 vdout1_8ck31 = 1.8 time = 320
* CHECK dout1_9 vdout1_9ck31 = 0 time = 320
* CHECK dout1_10 vdout1_10ck31 = 1.8 time = 320
* CHECK dout1_11 vdout1_11ck31 = 0 time = 320
* CHECK dout1_12 vdout1_12ck31 = 0 time = 320
* CHECK dout1_13 vdout1_13ck31 = 0 time = 320
* CHECK dout1_14 vdout1_14ck31 = 1.8 time = 320
* CHECK dout1_15 vdout1_15ck31 = 1.8 time = 320
* CHECK dout1_16 vdout1_16ck31 = 1.8 time = 320
* CHECK dout1_17 vdout1_17ck31 = 0 time = 320
* CHECK dout1_18 vdout1_18ck31 = 1.8 time = 320
* CHECK dout1_19 vdout1_19ck31 = 1.8 time = 320
* CHECK dout1_20 vdout1_20ck31 = 0 time = 320
* CHECK dout1_21 vdout1_21ck31 = 1.8 time = 320
* CHECK dout1_22 vdout1_22ck31 = 0 time = 320
* CHECK dout1_23 vdout1_23ck31 = 1.8 time = 320
* CHECK dout1_24 vdout1_24ck31 = 1.8 time = 320
* CHECK dout1_25 vdout1_25ck31 = 1.8 time = 320
* CHECK dout1_26 vdout1_26ck31 = 0 time = 320
* CHECK dout1_27 vdout1_27ck31 = 0 time = 320
* CHECK dout1_28 vdout1_28ck31 = 1.8 time = 320
* CHECK dout1_29 vdout1_29ck31 = 1.8 time = 320
* CHECK dout1_30 vdout1_30ck31 = 1.8 time = 320
* CHECK dout1_31 vdout1_31ck31 = 1.8 time = 320
* CHECK dout0_0 vdout0_0ck34 = 1.8 time = 350
* CHECK dout0_1 vdout0_1ck34 = 0 time = 350
* CHECK dout0_2 vdout0_2ck34 = 0 time = 350
* CHECK dout0_3 vdout0_3ck34 = 1.8 time = 350
* CHECK dout0_4 vdout0_4ck34 = 0 time = 350
* CHECK dout0_5 vdout0_5ck34 = 1.8 time = 350
* CHECK dout0_6 vdout0_6ck34 = 0 time = 350
* CHECK dout0_7 vdout0_7ck34 = 0 time = 350
* CHECK dout0_8 vdout0_8ck34 = 1.8 time = 350
* CHECK dout0_9 vdout0_9ck34 = 0 time = 350
* CHECK dout0_10 vdout0_10ck34 = 1.8 time = 350
* CHECK dout0_11 vdout0_11ck34 = 0 time = 350
* CHECK dout0_12 vdout0_12ck34 = 0 time = 350
* CHECK dout0_13 vdout0_13ck34 = 0 time = 350
* CHECK dout0_14 vdout0_14ck34 = 1.8 time = 350
* CHECK dout0_15 vdout0_15ck34 = 1.8 time = 350
* CHECK dout0_16 vdout0_16ck34 = 1.8 time = 350
* CHECK dout0_17 vdout0_17ck34 = 0 time = 350
* CHECK dout0_18 vdout0_18ck34 = 1.8 time = 350
* CHECK dout0_19 vdout0_19ck34 = 1.8 time = 350
* CHECK dout0_20 vdout0_20ck34 = 0 time = 350
* CHECK dout0_21 vdout0_21ck34 = 1.8 time = 350
* CHECK dout0_22 vdout0_22ck34 = 0 time = 350
* CHECK dout0_23 vdout0_23ck34 = 1.8 time = 350
* CHECK dout0_24 vdout0_24ck34 = 1.8 time = 350
* CHECK dout0_25 vdout0_25ck34 = 1.8 time = 350
* CHECK dout0_26 vdout0_26ck34 = 0 time = 350
* CHECK dout0_27 vdout0_27ck34 = 0 time = 350
* CHECK dout0_28 vdout0_28ck34 = 1.8 time = 350
* CHECK dout0_29 vdout0_29ck34 = 1.8 time = 350
* CHECK dout0_30 vdout0_30ck34 = 1.8 time = 350
* CHECK dout0_31 vdout0_31ck34 = 1.8 time = 350
* CHECK dout0_0 vdout0_0ck35 = 1.8 time = 360
* CHECK dout0_1 vdout0_1ck35 = 1.8 time = 360
* CHECK dout0_2 vdout0_2ck35 = 0 time = 360
* CHECK dout0_3 vdout0_3ck35 = 0 time = 360
* CHECK dout0_4 vdout0_4ck35 = 1.8 time = 360
* CHECK dout0_5 vdout0_5ck35 = 0 time = 360
* CHECK dout0_6 vdout0_6ck35 = 1.8 time = 360
* CHECK dout0_7 vdout0_7ck35 = 1.8 time = 360
* CHECK dout0_8 vdout0_8ck35 = 1.8 time = 360
* CHECK dout0_9 vdout0_9ck35 = 1.8 time = 360
* CHECK dout0_10 vdout0_10ck35 = 1.8 time = 360
* CHECK dout0_11 vdout0_11ck35 = 1.8 time = 360
* CHECK dout0_12 vdout0_12ck35 = 1.8 time = 360
* CHECK dout0_13 vdout0_13ck35 = 1.8 time = 360
* CHECK dout0_14 vdout0_14ck35 = 0 time = 360
* CHECK dout0_15 vdout0_15ck35 = 1.8 time = 360
* CHECK dout0_16 vdout0_16ck35 = 0 time = 360
* CHECK dout0_17 vdout0_17ck35 = 0 time = 360
* CHECK dout0_18 vdout0_18ck35 = 1.8 time = 360
* CHECK dout0_19 vdout0_19ck35 = 0 time = 360
* CHECK dout0_20 vdout0_20ck35 = 1.8 time = 360
* CHECK dout0_21 vdout0_21ck35 = 0 time = 360
* CHECK dout0_22 vdout0_22ck35 = 1.8 time = 360
* CHECK dout0_23 vdout0_23ck35 = 0 time = 360
* CHECK dout0_24 vdout0_24ck35 = 1.8 time = 360
* CHECK dout0_25 vdout0_25ck35 = 0 time = 360
* CHECK dout0_26 vdout0_26ck35 = 1.8 time = 360
* CHECK dout0_27 vdout0_27ck35 = 1.8 time = 360
* CHECK dout0_28 vdout0_28ck35 = 1.8 time = 360
* CHECK dout0_29 vdout0_29ck35 = 0 time = 360
* CHECK dout0_30 vdout0_30ck35 = 0 time = 360
* CHECK dout0_31 vdout0_31ck35 = 0 time = 360
* CHECK dout1_0 vdout1_0ck35 = 1.8 time = 360
* CHECK dout1_1 vdout1_1ck35 = 1.8 time = 360
* CHECK dout1_2 vdout1_2ck35 = 0 time = 360
* CHECK dout1_3 vdout1_3ck35 = 0 time = 360
* CHECK dout1_4 vdout1_4ck35 = 1.8 time = 360
* CHECK dout1_5 vdout1_5ck35 = 0 time = 360
* CHECK dout1_6 vdout1_6ck35 = 1.8 time = 360
* CHECK dout1_7 vdout1_7ck35 = 1.8 time = 360
* CHECK dout1_8 vdout1_8ck35 = 1.8 time = 360
* CHECK dout1_9 vdout1_9ck35 = 1.8 time = 360
* CHECK dout1_10 vdout1_10ck35 = 1.8 time = 360
* CHECK dout1_11 vdout1_11ck35 = 1.8 time = 360
* CHECK dout1_12 vdout1_12ck35 = 1.8 time = 360
* CHECK dout1_13 vdout1_13ck35 = 1.8 time = 360
* CHECK dout1_14 vdout1_14ck35 = 0 time = 360
* CHECK dout1_15 vdout1_15ck35 = 1.8 time = 360
* CHECK dout1_16 vdout1_16ck35 = 0 time = 360
* CHECK dout1_17 vdout1_17ck35 = 0 time = 360
* CHECK dout1_18 vdout1_18ck35 = 1.8 time = 360
* CHECK dout1_19 vdout1_19ck35 = 0 time = 360
* CHECK dout1_20 vdout1_20ck35 = 1.8 time = 360
* CHECK dout1_21 vdout1_21ck35 = 0 time = 360
* CHECK dout1_22 vdout1_22ck35 = 1.8 time = 360
* CHECK dout1_23 vdout1_23ck35 = 0 time = 360
* CHECK dout1_24 vdout1_24ck35 = 1.8 time = 360
* CHECK dout1_25 vdout1_25ck35 = 0 time = 360
* CHECK dout1_26 vdout1_26ck35 = 1.8 time = 360
* CHECK dout1_27 vdout1_27ck35 = 1.8 time = 360
* CHECK dout1_28 vdout1_28ck35 = 1.8 time = 360
* CHECK dout1_29 vdout1_29ck35 = 0 time = 360
* CHECK dout1_30 vdout1_30ck35 = 0 time = 360
* CHECK dout1_31 vdout1_31ck35 = 0 time = 360
* CHECK dout0_0 vdout0_0ck38 = 1.8 time = 390
* CHECK dout0_1 vdout0_1ck38 = 0 time = 390
* CHECK dout0_2 vdout0_2ck38 = 0 time = 390
* CHECK dout0_3 vdout0_3ck38 = 1.8 time = 390
* CHECK dout0_4 vdout0_4ck38 = 0 time = 390
* CHECK dout0_5 vdout0_5ck38 = 1.8 time = 390
* CHECK dout0_6 vdout0_6ck38 = 0 time = 390
* CHECK dout0_7 vdout0_7ck38 = 0 time = 390
* CHECK dout0_8 vdout0_8ck38 = 1.8 time = 390
* CHECK dout0_9 vdout0_9ck38 = 0 time = 390
* CHECK dout0_10 vdout0_10ck38 = 1.8 time = 390
* CHECK dout0_11 vdout0_11ck38 = 0 time = 390
* CHECK dout0_12 vdout0_12ck38 = 0 time = 390
* CHECK dout0_13 vdout0_13ck38 = 0 time = 390
* CHECK dout0_14 vdout0_14ck38 = 1.8 time = 390
* CHECK dout0_15 vdout0_15ck38 = 1.8 time = 390
* CHECK dout0_16 vdout0_16ck38 = 1.8 time = 390
* CHECK dout0_17 vdout0_17ck38 = 0 time = 390
* CHECK dout0_18 vdout0_18ck38 = 1.8 time = 390
* CHECK dout0_19 vdout0_19ck38 = 1.8 time = 390
* CHECK dout0_20 vdout0_20ck38 = 0 time = 390
* CHECK dout0_21 vdout0_21ck38 = 1.8 time = 390
* CHECK dout0_22 vdout0_22ck38 = 0 time = 390
* CHECK dout0_23 vdout0_23ck38 = 1.8 time = 390
* CHECK dout0_24 vdout0_24ck38 = 1.8 time = 390
* CHECK dout0_25 vdout0_25ck38 = 1.8 time = 390
* CHECK dout0_26 vdout0_26ck38 = 0 time = 390
* CHECK dout0_27 vdout0_27ck38 = 0 time = 390
* CHECK dout0_28 vdout0_28ck38 = 1.8 time = 390
* CHECK dout0_29 vdout0_29ck38 = 1.8 time = 390
* CHECK dout0_30 vdout0_30ck38 = 1.8 time = 390
* CHECK dout0_31 vdout0_31ck38 = 1.8 time = 390
* CHECK dout0_0 vdout0_0ck39 = 1.8 time = 400
* CHECK dout0_1 vdout0_1ck39 = 0 time = 400
* CHECK dout0_2 vdout0_2ck39 = 0 time = 400
* CHECK dout0_3 vdout0_3ck39 = 1.8 time = 400
* CHECK dout0_4 vdout0_4ck39 = 0 time = 400
* CHECK dout0_5 vdout0_5ck39 = 1.8 time = 400
* CHECK dout0_6 vdout0_6ck39 = 0 time = 400
* CHECK dout0_7 vdout0_7ck39 = 0 time = 400
* CHECK dout0_8 vdout0_8ck39 = 1.8 time = 400
* CHECK dout0_9 vdout0_9ck39 = 0 time = 400
* CHECK dout0_10 vdout0_10ck39 = 1.8 time = 400
* CHECK dout0_11 vdout0_11ck39 = 0 time = 400
* CHECK dout0_12 vdout0_12ck39 = 0 time = 400
* CHECK dout0_13 vdout0_13ck39 = 0 time = 400
* CHECK dout0_14 vdout0_14ck39 = 1.8 time = 400
* CHECK dout0_15 vdout0_15ck39 = 1.8 time = 400
* CHECK dout0_16 vdout0_16ck39 = 1.8 time = 400
* CHECK dout0_17 vdout0_17ck39 = 0 time = 400
* CHECK dout0_18 vdout0_18ck39 = 1.8 time = 400
* CHECK dout0_19 vdout0_19ck39 = 1.8 time = 400
* CHECK dout0_20 vdout0_20ck39 = 0 time = 400
* CHECK dout0_21 vdout0_21ck39 = 1.8 time = 400
* CHECK dout0_22 vdout0_22ck39 = 0 time = 400
* CHECK dout0_23 vdout0_23ck39 = 1.8 time = 400
* CHECK dout0_24 vdout0_24ck39 = 1.8 time = 400
* CHECK dout0_25 vdout0_25ck39 = 1.8 time = 400
* CHECK dout0_26 vdout0_26ck39 = 0 time = 400
* CHECK dout0_27 vdout0_27ck39 = 0 time = 400
* CHECK dout0_28 vdout0_28ck39 = 1.8 time = 400
* CHECK dout0_29 vdout0_29ck39 = 1.8 time = 400
* CHECK dout0_30 vdout0_30ck39 = 1.8 time = 400
* CHECK dout0_31 vdout0_31ck39 = 1.8 time = 400
* CHECK dout1_0 vdout1_0ck39 = 0 time = 400
* CHECK dout1_1 vdout1_1ck39 = 0 time = 400
* CHECK dout1_2 vdout1_2ck39 = 0 time = 400
* CHECK dout1_3 vdout1_3ck39 = 1.8 time = 400
* CHECK dout1_4 vdout1_4ck39 = 0 time = 400
* CHECK dout1_5 vdout1_5ck39 = 1.8 time = 400
* CHECK dout1_6 vdout1_6ck39 = 0 time = 400
* CHECK dout1_7 vdout1_7ck39 = 0 time = 400
* CHECK dout1_8 vdout1_8ck39 = 1.8 time = 400
* CHECK dout1_9 vdout1_9ck39 = 0 time = 400
* CHECK dout1_10 vdout1_10ck39 = 0 time = 400
* CHECK dout1_11 vdout1_11ck39 = 1.8 time = 400
* CHECK dout1_12 vdout1_12ck39 = 0 time = 400
* CHECK dout1_13 vdout1_13ck39 = 0 time = 400
* CHECK dout1_14 vdout1_14ck39 = 1.8 time = 400
* CHECK dout1_15 vdout1_15ck39 = 1.8 time = 400
* CHECK dout1_16 vdout1_16ck39 = 0 time = 400
* CHECK dout1_17 vdout1_17ck39 = 1.8 time = 400
* CHECK dout1_18 vdout1_18ck39 = 1.8 time = 400
* CHECK dout1_19 vdout1_19ck39 = 1.8 time = 400
* CHECK dout1_20 vdout1_20ck39 = 0 time = 400
* CHECK dout1_21 vdout1_21ck39 = 0 time = 400
* CHECK dout1_22 vdout1_22ck39 = 1.8 time = 400
* CHECK dout1_23 vdout1_23ck39 = 0 time = 400
* CHECK dout1_24 vdout1_24ck39 = 1.8 time = 400
* CHECK dout1_25 vdout1_25ck39 = 0 time = 400
* CHECK dout1_26 vdout1_26ck39 = 0 time = 400
* CHECK dout1_27 vdout1_27ck39 = 0 time = 400
* CHECK dout1_28 vdout1_28ck39 = 1.8 time = 400
* CHECK dout1_29 vdout1_29ck39 = 1.8 time = 400
* CHECK dout1_30 vdout1_30ck39 = 1.8 time = 400
* CHECK dout1_31 vdout1_31ck39 = 1.8 time = 400
* CHECK dout0_0 vdout0_0ck40 = 0 time = 410
* CHECK dout0_1 vdout0_1ck40 = 0 time = 410
* CHECK dout0_2 vdout0_2ck40 = 0 time = 410
* CHECK dout0_3 vdout0_3ck40 = 1.8 time = 410
* CHECK dout0_4 vdout0_4ck40 = 0 time = 410
* CHECK dout0_5 vdout0_5ck40 = 1.8 time = 410
* CHECK dout0_6 vdout0_6ck40 = 0 time = 410
* CHECK dout0_7 vdout0_7ck40 = 0 time = 410
* CHECK dout0_8 vdout0_8ck40 = 1.8 time = 410
* CHECK dout0_9 vdout0_9ck40 = 0 time = 410
* CHECK dout0_10 vdout0_10ck40 = 0 time = 410
* CHECK dout0_11 vdout0_11ck40 = 1.8 time = 410
* CHECK dout0_12 vdout0_12ck40 = 0 time = 410
* CHECK dout0_13 vdout0_13ck40 = 0 time = 410
* CHECK dout0_14 vdout0_14ck40 = 1.8 time = 410
* CHECK dout0_15 vdout0_15ck40 = 1.8 time = 410
* CHECK dout0_16 vdout0_16ck40 = 0 time = 410
* CHECK dout0_17 vdout0_17ck40 = 1.8 time = 410
* CHECK dout0_18 vdout0_18ck40 = 1.8 time = 410
* CHECK dout0_19 vdout0_19ck40 = 1.8 time = 410
* CHECK dout0_20 vdout0_20ck40 = 0 time = 410
* CHECK dout0_21 vdout0_21ck40 = 0 time = 410
* CHECK dout0_22 vdout0_22ck40 = 1.8 time = 410
* CHECK dout0_23 vdout0_23ck40 = 0 time = 410
* CHECK dout0_24 vdout0_24ck40 = 1.8 time = 410
* CHECK dout0_25 vdout0_25ck40 = 0 time = 410
* CHECK dout0_26 vdout0_26ck40 = 0 time = 410
* CHECK dout0_27 vdout0_27ck40 = 0 time = 410
* CHECK dout0_28 vdout0_28ck40 = 1.8 time = 410
* CHECK dout0_29 vdout0_29ck40 = 1.8 time = 410
* CHECK dout0_30 vdout0_30ck40 = 1.8 time = 410
* CHECK dout0_31 vdout0_31ck40 = 1.8 time = 410
* CHECK dout1_0 vdout1_0ck40 = 1.8 time = 410
* CHECK dout1_1 vdout1_1ck40 = 0 time = 410
* CHECK dout1_2 vdout1_2ck40 = 0 time = 410
* CHECK dout1_3 vdout1_3ck40 = 1.8 time = 410
* CHECK dout1_4 vdout1_4ck40 = 0 time = 410
* CHECK dout1_5 vdout1_5ck40 = 1.8 time = 410
* CHECK dout1_6 vdout1_6ck40 = 0 time = 410
* CHECK dout1_7 vdout1_7ck40 = 0 time = 410
* CHECK dout1_8 vdout1_8ck40 = 1.8 time = 410
* CHECK dout1_9 vdout1_9ck40 = 0 time = 410
* CHECK dout1_10 vdout1_10ck40 = 1.8 time = 410
* CHECK dout1_11 vdout1_11ck40 = 0 time = 410
* CHECK dout1_12 vdout1_12ck40 = 0 time = 410
* CHECK dout1_13 vdout1_13ck40 = 0 time = 410
* CHECK dout1_14 vdout1_14ck40 = 1.8 time = 410
* CHECK dout1_15 vdout1_15ck40 = 1.8 time = 410
* CHECK dout1_16 vdout1_16ck40 = 1.8 time = 410
* CHECK dout1_17 vdout1_17ck40 = 0 time = 410
* CHECK dout1_18 vdout1_18ck40 = 1.8 time = 410
* CHECK dout1_19 vdout1_19ck40 = 1.8 time = 410
* CHECK dout1_20 vdout1_20ck40 = 0 time = 410
* CHECK dout1_21 vdout1_21ck40 = 1.8 time = 410
* CHECK dout1_22 vdout1_22ck40 = 0 time = 410
* CHECK dout1_23 vdout1_23ck40 = 1.8 time = 410
* CHECK dout1_24 vdout1_24ck40 = 1.8 time = 410
* CHECK dout1_25 vdout1_25ck40 = 1.8 time = 410
* CHECK dout1_26 vdout1_26ck40 = 0 time = 410
* CHECK dout1_27 vdout1_27ck40 = 0 time = 410
* CHECK dout1_28 vdout1_28ck40 = 1.8 time = 410
* CHECK dout1_29 vdout1_29ck40 = 1.8 time = 410
* CHECK dout1_30 vdout1_30ck40 = 1.8 time = 410
* CHECK dout1_31 vdout1_31ck40 = 1.8 time = 410
* CHECK dout1_0 vdout1_0ck41 = 0 time = 420
* CHECK dout1_1 vdout1_1ck41 = 0 time = 420
* CHECK dout1_2 vdout1_2ck41 = 0 time = 420
* CHECK dout1_3 vdout1_3ck41 = 1.8 time = 420
* CHECK dout1_4 vdout1_4ck41 = 0 time = 420
* CHECK dout1_5 vdout1_5ck41 = 1.8 time = 420
* CHECK dout1_6 vdout1_6ck41 = 0 time = 420
* CHECK dout1_7 vdout1_7ck41 = 0 time = 420
* CHECK dout1_8 vdout1_8ck41 = 1.8 time = 420
* CHECK dout1_9 vdout1_9ck41 = 0 time = 420
* CHECK dout1_10 vdout1_10ck41 = 0 time = 420
* CHECK dout1_11 vdout1_11ck41 = 1.8 time = 420
* CHECK dout1_12 vdout1_12ck41 = 0 time = 420
* CHECK dout1_13 vdout1_13ck41 = 0 time = 420
* CHECK dout1_14 vdout1_14ck41 = 1.8 time = 420
* CHECK dout1_15 vdout1_15ck41 = 1.8 time = 420
* CHECK dout1_16 vdout1_16ck41 = 0 time = 420
* CHECK dout1_17 vdout1_17ck41 = 1.8 time = 420
* CHECK dout1_18 vdout1_18ck41 = 1.8 time = 420
* CHECK dout1_19 vdout1_19ck41 = 1.8 time = 420
* CHECK dout1_20 vdout1_20ck41 = 0 time = 420
* CHECK dout1_21 vdout1_21ck41 = 0 time = 420
* CHECK dout1_22 vdout1_22ck41 = 1.8 time = 420
* CHECK dout1_23 vdout1_23ck41 = 0 time = 420
* CHECK dout1_24 vdout1_24ck41 = 1.8 time = 420
* CHECK dout1_25 vdout1_25ck41 = 0 time = 420
* CHECK dout1_26 vdout1_26ck41 = 0 time = 420
* CHECK dout1_27 vdout1_27ck41 = 0 time = 420
* CHECK dout1_28 vdout1_28ck41 = 1.8 time = 420
* CHECK dout1_29 vdout1_29ck41 = 1.8 time = 420
* CHECK dout1_30 vdout1_30ck41 = 1.8 time = 420
* CHECK dout1_31 vdout1_31ck41 = 1.8 time = 420
* CHECK dout0_0 vdout0_0ck42 = 1.8 time = 430
* CHECK dout0_1 vdout0_1ck42 = 0 time = 430
* CHECK dout0_2 vdout0_2ck42 = 0 time = 430
* CHECK dout0_3 vdout0_3ck42 = 1.8 time = 430
* CHECK dout0_4 vdout0_4ck42 = 0 time = 430
* CHECK dout0_5 vdout0_5ck42 = 1.8 time = 430
* CHECK dout0_6 vdout0_6ck42 = 0 time = 430
* CHECK dout0_7 vdout0_7ck42 = 0 time = 430
* CHECK dout0_8 vdout0_8ck42 = 1.8 time = 430
* CHECK dout0_9 vdout0_9ck42 = 0 time = 430
* CHECK dout0_10 vdout0_10ck42 = 1.8 time = 430
* CHECK dout0_11 vdout0_11ck42 = 0 time = 430
* CHECK dout0_12 vdout0_12ck42 = 0 time = 430
* CHECK dout0_13 vdout0_13ck42 = 0 time = 430
* CHECK dout0_14 vdout0_14ck42 = 1.8 time = 430
* CHECK dout0_15 vdout0_15ck42 = 1.8 time = 430
* CHECK dout0_16 vdout0_16ck42 = 1.8 time = 430
* CHECK dout0_17 vdout0_17ck42 = 0 time = 430
* CHECK dout0_18 vdout0_18ck42 = 1.8 time = 430
* CHECK dout0_19 vdout0_19ck42 = 1.8 time = 430
* CHECK dout0_20 vdout0_20ck42 = 0 time = 430
* CHECK dout0_21 vdout0_21ck42 = 1.8 time = 430
* CHECK dout0_22 vdout0_22ck42 = 0 time = 430
* CHECK dout0_23 vdout0_23ck42 = 1.8 time = 430
* CHECK dout0_24 vdout0_24ck42 = 1.8 time = 430
* CHECK dout0_25 vdout0_25ck42 = 1.8 time = 430
* CHECK dout0_26 vdout0_26ck42 = 0 time = 430
* CHECK dout0_27 vdout0_27ck42 = 0 time = 430
* CHECK dout0_28 vdout0_28ck42 = 1.8 time = 430
* CHECK dout0_29 vdout0_29ck42 = 1.8 time = 430
* CHECK dout0_30 vdout0_30ck42 = 1.8 time = 430
* CHECK dout0_31 vdout0_31ck42 = 1.8 time = 430
* CHECK dout1_0 vdout1_0ck42 = 1.8 time = 430
* CHECK dout1_1 vdout1_1ck42 = 0 time = 430
* CHECK dout1_2 vdout1_2ck42 = 0 time = 430
* CHECK dout1_3 vdout1_3ck42 = 1.8 time = 430
* CHECK dout1_4 vdout1_4ck42 = 0 time = 430
* CHECK dout1_5 vdout1_5ck42 = 1.8 time = 430
* CHECK dout1_6 vdout1_6ck42 = 0 time = 430
* CHECK dout1_7 vdout1_7ck42 = 0 time = 430
* CHECK dout1_8 vdout1_8ck42 = 1.8 time = 430
* CHECK dout1_9 vdout1_9ck42 = 0 time = 430
* CHECK dout1_10 vdout1_10ck42 = 1.8 time = 430
* CHECK dout1_11 vdout1_11ck42 = 0 time = 430
* CHECK dout1_12 vdout1_12ck42 = 0 time = 430
* CHECK dout1_13 vdout1_13ck42 = 0 time = 430
* CHECK dout1_14 vdout1_14ck42 = 1.8 time = 430
* CHECK dout1_15 vdout1_15ck42 = 1.8 time = 430
* CHECK dout1_16 vdout1_16ck42 = 1.8 time = 430
* CHECK dout1_17 vdout1_17ck42 = 0 time = 430
* CHECK dout1_18 vdout1_18ck42 = 1.8 time = 430
* CHECK dout1_19 vdout1_19ck42 = 1.8 time = 430
* CHECK dout1_20 vdout1_20ck42 = 0 time = 430
* CHECK dout1_21 vdout1_21ck42 = 1.8 time = 430
* CHECK dout1_22 vdout1_22ck42 = 0 time = 430
* CHECK dout1_23 vdout1_23ck42 = 1.8 time = 430
* CHECK dout1_24 vdout1_24ck42 = 1.8 time = 430
* CHECK dout1_25 vdout1_25ck42 = 1.8 time = 430
* CHECK dout1_26 vdout1_26ck42 = 0 time = 430
* CHECK dout1_27 vdout1_27ck42 = 0 time = 430
* CHECK dout1_28 vdout1_28ck42 = 1.8 time = 430
* CHECK dout1_29 vdout1_29ck42 = 1.8 time = 430
* CHECK dout1_30 vdout1_30ck42 = 1.8 time = 430
* CHECK dout1_31 vdout1_31ck42 = 1.8 time = 430
* CHECK dout0_0 vdout0_0ck43 = 0 time = 440
* CHECK dout0_1 vdout0_1ck43 = 0 time = 440
* CHECK dout0_2 vdout0_2ck43 = 0 time = 440
* CHECK dout0_3 vdout0_3ck43 = 1.8 time = 440
* CHECK dout0_4 vdout0_4ck43 = 0 time = 440
* CHECK dout0_5 vdout0_5ck43 = 1.8 time = 440
* CHECK dout0_6 vdout0_6ck43 = 0 time = 440
* CHECK dout0_7 vdout0_7ck43 = 0 time = 440
* CHECK dout0_8 vdout0_8ck43 = 1.8 time = 440
* CHECK dout0_9 vdout0_9ck43 = 0 time = 440
* CHECK dout0_10 vdout0_10ck43 = 0 time = 440
* CHECK dout0_11 vdout0_11ck43 = 1.8 time = 440
* CHECK dout0_12 vdout0_12ck43 = 0 time = 440
* CHECK dout0_13 vdout0_13ck43 = 0 time = 440
* CHECK dout0_14 vdout0_14ck43 = 1.8 time = 440
* CHECK dout0_15 vdout0_15ck43 = 1.8 time = 440
* CHECK dout0_16 vdout0_16ck43 = 0 time = 440
* CHECK dout0_17 vdout0_17ck43 = 1.8 time = 440
* CHECK dout0_18 vdout0_18ck43 = 1.8 time = 440
* CHECK dout0_19 vdout0_19ck43 = 1.8 time = 440
* CHECK dout0_20 vdout0_20ck43 = 0 time = 440
* CHECK dout0_21 vdout0_21ck43 = 0 time = 440
* CHECK dout0_22 vdout0_22ck43 = 1.8 time = 440
* CHECK dout0_23 vdout0_23ck43 = 0 time = 440
* CHECK dout0_24 vdout0_24ck43 = 1.8 time = 440
* CHECK dout0_25 vdout0_25ck43 = 0 time = 440
* CHECK dout0_26 vdout0_26ck43 = 0 time = 440
* CHECK dout0_27 vdout0_27ck43 = 0 time = 440
* CHECK dout0_28 vdout0_28ck43 = 1.8 time = 440
* CHECK dout0_29 vdout0_29ck43 = 1.8 time = 440
* CHECK dout0_30 vdout0_30ck43 = 1.8 time = 440
* CHECK dout0_31 vdout0_31ck43 = 1.8 time = 440
* CHECK dout1_0 vdout1_0ck44 = 1.8 time = 450
* CHECK dout1_1 vdout1_1ck44 = 0 time = 450
* CHECK dout1_2 vdout1_2ck44 = 0 time = 450
* CHECK dout1_3 vdout1_3ck44 = 1.8 time = 450
* CHECK dout1_4 vdout1_4ck44 = 0 time = 450
* CHECK dout1_5 vdout1_5ck44 = 1.8 time = 450
* CHECK dout1_6 vdout1_6ck44 = 0 time = 450
* CHECK dout1_7 vdout1_7ck44 = 0 time = 450
* CHECK dout1_8 vdout1_8ck44 = 1.8 time = 450
* CHECK dout1_9 vdout1_9ck44 = 0 time = 450
* CHECK dout1_10 vdout1_10ck44 = 1.8 time = 450
* CHECK dout1_11 vdout1_11ck44 = 0 time = 450
* CHECK dout1_12 vdout1_12ck44 = 0 time = 450
* CHECK dout1_13 vdout1_13ck44 = 0 time = 450
* CHECK dout1_14 vdout1_14ck44 = 1.8 time = 450
* CHECK dout1_15 vdout1_15ck44 = 1.8 time = 450
* CHECK dout1_16 vdout1_16ck44 = 1.8 time = 450
* CHECK dout1_17 vdout1_17ck44 = 0 time = 450
* CHECK dout1_18 vdout1_18ck44 = 1.8 time = 450
* CHECK dout1_19 vdout1_19ck44 = 1.8 time = 450
* CHECK dout1_20 vdout1_20ck44 = 0 time = 450
* CHECK dout1_21 vdout1_21ck44 = 1.8 time = 450
* CHECK dout1_22 vdout1_22ck44 = 0 time = 450
* CHECK dout1_23 vdout1_23ck44 = 1.8 time = 450
* CHECK dout1_24 vdout1_24ck44 = 1.8 time = 450
* CHECK dout1_25 vdout1_25ck44 = 1.8 time = 450
* CHECK dout1_26 vdout1_26ck44 = 0 time = 450
* CHECK dout1_27 vdout1_27ck44 = 0 time = 450
* CHECK dout1_28 vdout1_28ck44 = 1.8 time = 450
* CHECK dout1_29 vdout1_29ck44 = 1.8 time = 450
* CHECK dout1_30 vdout1_30ck44 = 1.8 time = 450
* CHECK dout1_31 vdout1_31ck44 = 1.8 time = 450
* CHECK dout1_0 vdout1_0ck48 = 1.8 time = 490
* CHECK dout1_1 vdout1_1ck48 = 0 time = 490
* CHECK dout1_2 vdout1_2ck48 = 0 time = 490
* CHECK dout1_3 vdout1_3ck48 = 0 time = 490
* CHECK dout1_4 vdout1_4ck48 = 1.8 time = 490
* CHECK dout1_5 vdout1_5ck48 = 0 time = 490
* CHECK dout1_6 vdout1_6ck48 = 0 time = 490
* CHECK dout1_7 vdout1_7ck48 = 1.8 time = 490
* CHECK dout1_8 vdout1_8ck48 = 1.8 time = 490
* CHECK dout1_9 vdout1_9ck48 = 0 time = 490
* CHECK dout1_10 vdout1_10ck48 = 0 time = 490
* CHECK dout1_11 vdout1_11ck48 = 0 time = 490
* CHECK dout1_12 vdout1_12ck48 = 1.8 time = 490
* CHECK dout1_13 vdout1_13ck48 = 1.8 time = 490
* CHECK dout1_14 vdout1_14ck48 = 1.8 time = 490
* CHECK dout1_15 vdout1_15ck48 = 1.8 time = 490
* CHECK dout1_16 vdout1_16ck48 = 1.8 time = 490
* CHECK dout1_17 vdout1_17ck48 = 1.8 time = 490
* CHECK dout1_18 vdout1_18ck48 = 0 time = 490
* CHECK dout1_19 vdout1_19ck48 = 1.8 time = 490
* CHECK dout1_20 vdout1_20ck48 = 0 time = 490
* CHECK dout1_21 vdout1_21ck48 = 1.8 time = 490
* CHECK dout1_22 vdout1_22ck48 = 1.8 time = 490
* CHECK dout1_23 vdout1_23ck48 = 0 time = 490
* CHECK dout1_24 vdout1_24ck48 = 0 time = 490
* CHECK dout1_25 vdout1_25ck48 = 1.8 time = 490
* CHECK dout1_26 vdout1_26ck48 = 1.8 time = 490
* CHECK dout1_27 vdout1_27ck48 = 1.8 time = 490
* CHECK dout1_28 vdout1_28ck48 = 0 time = 490
* CHECK dout1_29 vdout1_29ck48 = 0 time = 490
* CHECK dout1_30 vdout1_30ck48 = 0 time = 490
* CHECK dout1_31 vdout1_31ck48 = 1.8 time = 490
* CHECK dout0_0 vdout0_0ck49 = 1.8 time = 500
* CHECK dout0_1 vdout0_1ck49 = 1.8 time = 500
* CHECK dout0_2 vdout0_2ck49 = 1.8 time = 500
* CHECK dout0_3 vdout0_3ck49 = 0 time = 500
* CHECK dout0_4 vdout0_4ck49 = 0 time = 500
* CHECK dout0_5 vdout0_5ck49 = 0 time = 500
* CHECK dout0_6 vdout0_6ck49 = 0 time = 500
* CHECK dout0_7 vdout0_7ck49 = 1.8 time = 500
* CHECK dout0_8 vdout0_8ck49 = 1.8 time = 500
* CHECK dout0_9 vdout0_9ck49 = 1.8 time = 500
* CHECK dout0_10 vdout0_10ck49 = 1.8 time = 500
* CHECK dout0_11 vdout0_11ck49 = 0 time = 500
* CHECK dout0_12 vdout0_12ck49 = 0 time = 500
* CHECK dout0_13 vdout0_13ck49 = 0 time = 500
* CHECK dout0_14 vdout0_14ck49 = 0 time = 500
* CHECK dout0_15 vdout0_15ck49 = 0 time = 500
* CHECK dout0_16 vdout0_16ck49 = 1.8 time = 500
* CHECK dout0_17 vdout0_17ck49 = 0 time = 500
* CHECK dout0_18 vdout0_18ck49 = 0 time = 500
* CHECK dout0_19 vdout0_19ck49 = 1.8 time = 500
* CHECK dout0_20 vdout0_20ck49 = 0 time = 500
* CHECK dout0_21 vdout0_21ck49 = 0 time = 500
* CHECK dout0_22 vdout0_22ck49 = 0 time = 500
* CHECK dout0_23 vdout0_23ck49 = 0 time = 500
* CHECK dout0_24 vdout0_24ck49 = 0 time = 500
* CHECK dout0_25 vdout0_25ck49 = 0 time = 500
* CHECK dout0_26 vdout0_26ck49 = 1.8 time = 500
* CHECK dout0_27 vdout0_27ck49 = 1.8 time = 500
* CHECK dout0_28 vdout0_28ck49 = 1.8 time = 500
* CHECK dout0_29 vdout0_29ck49 = 0 time = 500
* CHECK dout0_30 vdout0_30ck49 = 1.8 time = 500
* CHECK dout0_31 vdout0_31ck49 = 1.8 time = 500
* CHECK dout0_0 vdout0_0ck50 = 1.8 time = 510
* CHECK dout0_1 vdout0_1ck50 = 0 time = 510
* CHECK dout0_2 vdout0_2ck50 = 0 time = 510
* CHECK dout0_3 vdout0_3ck50 = 0 time = 510
* CHECK dout0_4 vdout0_4ck50 = 1.8 time = 510
* CHECK dout0_5 vdout0_5ck50 = 0 time = 510
* CHECK dout0_6 vdout0_6ck50 = 0 time = 510
* CHECK dout0_7 vdout0_7ck50 = 1.8 time = 510
* CHECK dout0_8 vdout0_8ck50 = 1.8 time = 510
* CHECK dout0_9 vdout0_9ck50 = 0 time = 510
* CHECK dout0_10 vdout0_10ck50 = 0 time = 510
* CHECK dout0_11 vdout0_11ck50 = 0 time = 510
* CHECK dout0_12 vdout0_12ck50 = 1.8 time = 510
* CHECK dout0_13 vdout0_13ck50 = 1.8 time = 510
* CHECK dout0_14 vdout0_14ck50 = 1.8 time = 510
* CHECK dout0_15 vdout0_15ck50 = 1.8 time = 510
* CHECK dout0_16 vdout0_16ck50 = 1.8 time = 510
* CHECK dout0_17 vdout0_17ck50 = 1.8 time = 510
* CHECK dout0_18 vdout0_18ck50 = 0 time = 510
* CHECK dout0_19 vdout0_19ck50 = 1.8 time = 510
* CHECK dout0_20 vdout0_20ck50 = 0 time = 510
* CHECK dout0_21 vdout0_21ck50 = 1.8 time = 510
* CHECK dout0_22 vdout0_22ck50 = 1.8 time = 510
* CHECK dout0_23 vdout0_23ck50 = 0 time = 510
* CHECK dout0_24 vdout0_24ck50 = 0 time = 510
* CHECK dout0_25 vdout0_25ck50 = 1.8 time = 510
* CHECK dout0_26 vdout0_26ck50 = 1.8 time = 510
* CHECK dout0_27 vdout0_27ck50 = 1.8 time = 510
* CHECK dout0_28 vdout0_28ck50 = 0 time = 510
* CHECK dout0_29 vdout0_29ck50 = 0 time = 510
* CHECK dout0_30 vdout0_30ck50 = 0 time = 510
* CHECK dout0_31 vdout0_31ck50 = 1.8 time = 510
* CHECK dout1_0 vdout1_0ck50 = 1.8 time = 510
* CHECK dout1_1 vdout1_1ck50 = 0 time = 510
* CHECK dout1_2 vdout1_2ck50 = 0 time = 510
* CHECK dout1_3 vdout1_3ck50 = 0 time = 510
* CHECK dout1_4 vdout1_4ck50 = 1.8 time = 510
* CHECK dout1_5 vdout1_5ck50 = 0 time = 510
* CHECK dout1_6 vdout1_6ck50 = 0 time = 510
* CHECK dout1_7 vdout1_7ck50 = 1.8 time = 510
* CHECK dout1_8 vdout1_8ck50 = 1.8 time = 510
* CHECK dout1_9 vdout1_9ck50 = 0 time = 510
* CHECK dout1_10 vdout1_10ck50 = 0 time = 510
* CHECK dout1_11 vdout1_11ck50 = 0 time = 510
* CHECK dout1_12 vdout1_12ck50 = 1.8 time = 510
* CHECK dout1_13 vdout1_13ck50 = 1.8 time = 510
* CHECK dout1_14 vdout1_14ck50 = 1.8 time = 510
* CHECK dout1_15 vdout1_15ck50 = 1.8 time = 510
* CHECK dout1_16 vdout1_16ck50 = 1.8 time = 510
* CHECK dout1_17 vdout1_17ck50 = 1.8 time = 510
* CHECK dout1_18 vdout1_18ck50 = 0 time = 510
* CHECK dout1_19 vdout1_19ck50 = 1.8 time = 510
* CHECK dout1_20 vdout1_20ck50 = 0 time = 510
* CHECK dout1_21 vdout1_21ck50 = 1.8 time = 510
* CHECK dout1_22 vdout1_22ck50 = 1.8 time = 510
* CHECK dout1_23 vdout1_23ck50 = 0 time = 510
* CHECK dout1_24 vdout1_24ck50 = 0 time = 510
* CHECK dout1_25 vdout1_25ck50 = 1.8 time = 510
* CHECK dout1_26 vdout1_26ck50 = 1.8 time = 510
* CHECK dout1_27 vdout1_27ck50 = 1.8 time = 510
* CHECK dout1_28 vdout1_28ck50 = 0 time = 510
* CHECK dout1_29 vdout1_29ck50 = 0 time = 510
* CHECK dout1_30 vdout1_30ck50 = 0 time = 510
* CHECK dout1_31 vdout1_31ck50 = 1.8 time = 510
* CHECK dout1_0 vdout1_0ck51 = 1.8 time = 520
* CHECK dout1_1 vdout1_1ck51 = 0 time = 520
* CHECK dout1_2 vdout1_2ck51 = 0 time = 520
* CHECK dout1_3 vdout1_3ck51 = 0 time = 520
* CHECK dout1_4 vdout1_4ck51 = 1.8 time = 520
* CHECK dout1_5 vdout1_5ck51 = 0 time = 520
* CHECK dout1_6 vdout1_6ck51 = 0 time = 520
* CHECK dout1_7 vdout1_7ck51 = 1.8 time = 520
* CHECK dout1_8 vdout1_8ck51 = 1.8 time = 520
* CHECK dout1_9 vdout1_9ck51 = 0 time = 520
* CHECK dout1_10 vdout1_10ck51 = 0 time = 520
* CHECK dout1_11 vdout1_11ck51 = 0 time = 520
* CHECK dout1_12 vdout1_12ck51 = 1.8 time = 520
* CHECK dout1_13 vdout1_13ck51 = 1.8 time = 520
* CHECK dout1_14 vdout1_14ck51 = 1.8 time = 520
* CHECK dout1_15 vdout1_15ck51 = 1.8 time = 520
* CHECK dout1_16 vdout1_16ck51 = 1.8 time = 520
* CHECK dout1_17 vdout1_17ck51 = 1.8 time = 520
* CHECK dout1_18 vdout1_18ck51 = 0 time = 520
* CHECK dout1_19 vdout1_19ck51 = 1.8 time = 520
* CHECK dout1_20 vdout1_20ck51 = 0 time = 520
* CHECK dout1_21 vdout1_21ck51 = 1.8 time = 520
* CHECK dout1_22 vdout1_22ck51 = 1.8 time = 520
* CHECK dout1_23 vdout1_23ck51 = 0 time = 520
* CHECK dout1_24 vdout1_24ck51 = 0 time = 520
* CHECK dout1_25 vdout1_25ck51 = 1.8 time = 520
* CHECK dout1_26 vdout1_26ck51 = 1.8 time = 520
* CHECK dout1_27 vdout1_27ck51 = 1.8 time = 520
* CHECK dout1_28 vdout1_28ck51 = 0 time = 520
* CHECK dout1_29 vdout1_29ck51 = 0 time = 520
* CHECK dout1_30 vdout1_30ck51 = 0 time = 520
* CHECK dout1_31 vdout1_31ck51 = 1.8 time = 520
* CHECK dout0_0 vdout0_0ck53 = 1.8 time = 540
* CHECK dout0_1 vdout0_1ck53 = 1.8 time = 540
* CHECK dout0_2 vdout0_2ck53 = 1.8 time = 540
* CHECK dout0_3 vdout0_3ck53 = 0 time = 540
* CHECK dout0_4 vdout0_4ck53 = 0 time = 540
* CHECK dout0_5 vdout0_5ck53 = 0 time = 540
* CHECK dout0_6 vdout0_6ck53 = 0 time = 540
* CHECK dout0_7 vdout0_7ck53 = 1.8 time = 540
* CHECK dout0_8 vdout0_8ck53 = 1.8 time = 540
* CHECK dout0_9 vdout0_9ck53 = 1.8 time = 540
* CHECK dout0_10 vdout0_10ck53 = 1.8 time = 540
* CHECK dout0_11 vdout0_11ck53 = 0 time = 540
* CHECK dout0_12 vdout0_12ck53 = 0 time = 540
* CHECK dout0_13 vdout0_13ck53 = 0 time = 540
* CHECK dout0_14 vdout0_14ck53 = 0 time = 540
* CHECK dout0_15 vdout0_15ck53 = 0 time = 540
* CHECK dout0_16 vdout0_16ck53 = 1.8 time = 540
* CHECK dout0_17 vdout0_17ck53 = 0 time = 540
* CHECK dout0_18 vdout0_18ck53 = 0 time = 540
* CHECK dout0_19 vdout0_19ck53 = 1.8 time = 540
* CHECK dout0_20 vdout0_20ck53 = 0 time = 540
* CHECK dout0_21 vdout0_21ck53 = 0 time = 540
* CHECK dout0_22 vdout0_22ck53 = 0 time = 540
* CHECK dout0_23 vdout0_23ck53 = 0 time = 540
* CHECK dout0_24 vdout0_24ck53 = 0 time = 540
* CHECK dout0_25 vdout0_25ck53 = 0 time = 540
* CHECK dout0_26 vdout0_26ck53 = 1.8 time = 540
* CHECK dout0_27 vdout0_27ck53 = 1.8 time = 540
* CHECK dout0_28 vdout0_28ck53 = 1.8 time = 540
* CHECK dout0_29 vdout0_29ck53 = 0 time = 540
* CHECK dout0_30 vdout0_30ck53 = 1.8 time = 540
* CHECK dout0_31 vdout0_31ck53 = 1.8 time = 540
* CHECK dout1_0 vdout1_0ck53 = 1.8 time = 540
* CHECK dout1_1 vdout1_1ck53 = 1.8 time = 540
* CHECK dout1_2 vdout1_2ck53 = 1.8 time = 540
* CHECK dout1_3 vdout1_3ck53 = 0 time = 540
* CHECK dout1_4 vdout1_4ck53 = 0 time = 540
* CHECK dout1_5 vdout1_5ck53 = 0 time = 540
* CHECK dout1_6 vdout1_6ck53 = 0 time = 540
* CHECK dout1_7 vdout1_7ck53 = 1.8 time = 540
* CHECK dout1_8 vdout1_8ck53 = 1.8 time = 540
* CHECK dout1_9 vdout1_9ck53 = 1.8 time = 540
* CHECK dout1_10 vdout1_10ck53 = 1.8 time = 540
* CHECK dout1_11 vdout1_11ck53 = 0 time = 540
* CHECK dout1_12 vdout1_12ck53 = 0 time = 540
* CHECK dout1_13 vdout1_13ck53 = 0 time = 540
* CHECK dout1_14 vdout1_14ck53 = 0 time = 540
* CHECK dout1_15 vdout1_15ck53 = 0 time = 540
* CHECK dout1_16 vdout1_16ck53 = 1.8 time = 540
* CHECK dout1_17 vdout1_17ck53 = 0 time = 540
* CHECK dout1_18 vdout1_18ck53 = 0 time = 540
* CHECK dout1_19 vdout1_19ck53 = 1.8 time = 540
* CHECK dout1_20 vdout1_20ck53 = 0 time = 540
* CHECK dout1_21 vdout1_21ck53 = 0 time = 540
* CHECK dout1_22 vdout1_22ck53 = 0 time = 540
* CHECK dout1_23 vdout1_23ck53 = 0 time = 540
* CHECK dout1_24 vdout1_24ck53 = 0 time = 540
* CHECK dout1_25 vdout1_25ck53 = 0 time = 540
* CHECK dout1_26 vdout1_26ck53 = 1.8 time = 540
* CHECK dout1_27 vdout1_27ck53 = 1.8 time = 540
* CHECK dout1_28 vdout1_28ck53 = 1.8 time = 540
* CHECK dout1_29 vdout1_29ck53 = 0 time = 540
* CHECK dout1_30 vdout1_30ck53 = 1.8 time = 540
* CHECK dout1_31 vdout1_31ck53 = 1.8 time = 540
* CHECK dout0_0 vdout0_0ck54 = 1.8 time = 550
* CHECK dout0_1 vdout0_1ck54 = 1.8 time = 550
* CHECK dout0_2 vdout0_2ck54 = 1.8 time = 550
* CHECK dout0_3 vdout0_3ck54 = 0 time = 550
* CHECK dout0_4 vdout0_4ck54 = 0 time = 550
* CHECK dout0_5 vdout0_5ck54 = 0 time = 550
* CHECK dout0_6 vdout0_6ck54 = 0 time = 550
* CHECK dout0_7 vdout0_7ck54 = 1.8 time = 550
* CHECK dout0_8 vdout0_8ck54 = 1.8 time = 550
* CHECK dout0_9 vdout0_9ck54 = 1.8 time = 550
* CHECK dout0_10 vdout0_10ck54 = 1.8 time = 550
* CHECK dout0_11 vdout0_11ck54 = 0 time = 550
* CHECK dout0_12 vdout0_12ck54 = 0 time = 550
* CHECK dout0_13 vdout0_13ck54 = 0 time = 550
* CHECK dout0_14 vdout0_14ck54 = 0 time = 550
* CHECK dout0_15 vdout0_15ck54 = 0 time = 550
* CHECK dout0_16 vdout0_16ck54 = 1.8 time = 550
* CHECK dout0_17 vdout0_17ck54 = 0 time = 550
* CHECK dout0_18 vdout0_18ck54 = 0 time = 550
* CHECK dout0_19 vdout0_19ck54 = 1.8 time = 550
* CHECK dout0_20 vdout0_20ck54 = 0 time = 550
* CHECK dout0_21 vdout0_21ck54 = 0 time = 550
* CHECK dout0_22 vdout0_22ck54 = 0 time = 550
* CHECK dout0_23 vdout0_23ck54 = 0 time = 550
* CHECK dout0_24 vdout0_24ck54 = 0 time = 550
* CHECK dout0_25 vdout0_25ck54 = 0 time = 550
* CHECK dout0_26 vdout0_26ck54 = 1.8 time = 550
* CHECK dout0_27 vdout0_27ck54 = 1.8 time = 550
* CHECK dout0_28 vdout0_28ck54 = 1.8 time = 550
* CHECK dout0_29 vdout0_29ck54 = 0 time = 550
* CHECK dout0_30 vdout0_30ck54 = 1.8 time = 550
* CHECK dout0_31 vdout0_31ck54 = 1.8 time = 550
* CHECK dout1_0 vdout1_0ck54 = 1.8 time = 550
* CHECK dout1_1 vdout1_1ck54 = 1.8 time = 550
* CHECK dout1_2 vdout1_2ck54 = 1.8 time = 550
* CHECK dout1_3 vdout1_3ck54 = 0 time = 550
* CHECK dout1_4 vdout1_4ck54 = 0 time = 550
* CHECK dout1_5 vdout1_5ck54 = 0 time = 550
* CHECK dout1_6 vdout1_6ck54 = 0 time = 550
* CHECK dout1_7 vdout1_7ck54 = 1.8 time = 550
* CHECK dout1_8 vdout1_8ck54 = 1.8 time = 550
* CHECK dout1_9 vdout1_9ck54 = 1.8 time = 550
* CHECK dout1_10 vdout1_10ck54 = 1.8 time = 550
* CHECK dout1_11 vdout1_11ck54 = 0 time = 550
* CHECK dout1_12 vdout1_12ck54 = 0 time = 550
* CHECK dout1_13 vdout1_13ck54 = 0 time = 550
* CHECK dout1_14 vdout1_14ck54 = 0 time = 550
* CHECK dout1_15 vdout1_15ck54 = 0 time = 550
* CHECK dout1_16 vdout1_16ck54 = 1.8 time = 550
* CHECK dout1_17 vdout1_17ck54 = 0 time = 550
* CHECK dout1_18 vdout1_18ck54 = 0 time = 550
* CHECK dout1_19 vdout1_19ck54 = 1.8 time = 550
* CHECK dout1_20 vdout1_20ck54 = 0 time = 550
* CHECK dout1_21 vdout1_21ck54 = 0 time = 550
* CHECK dout1_22 vdout1_22ck54 = 0 time = 550
* CHECK dout1_23 vdout1_23ck54 = 0 time = 550
* CHECK dout1_24 vdout1_24ck54 = 0 time = 550
* CHECK dout1_25 vdout1_25ck54 = 0 time = 550
* CHECK dout1_26 vdout1_26ck54 = 1.8 time = 550
* CHECK dout1_27 vdout1_27ck54 = 1.8 time = 550
* CHECK dout1_28 vdout1_28ck54 = 1.8 time = 550
* CHECK dout1_29 vdout1_29ck54 = 0 time = 550
* CHECK dout1_30 vdout1_30ck54 = 1.8 time = 550
* CHECK dout1_31 vdout1_31ck54 = 1.8 time = 550
* CHECK dout0_0 vdout0_0ck55 = 1.8 time = 560
* CHECK dout0_1 vdout0_1ck55 = 1.8 time = 560
* CHECK dout0_2 vdout0_2ck55 = 1.8 time = 560
* CHECK dout0_3 vdout0_3ck55 = 0 time = 560
* CHECK dout0_4 vdout0_4ck55 = 0 time = 560
* CHECK dout0_5 vdout0_5ck55 = 0 time = 560
* CHECK dout0_6 vdout0_6ck55 = 0 time = 560
* CHECK dout0_7 vdout0_7ck55 = 1.8 time = 560
* CHECK dout0_8 vdout0_8ck55 = 1.8 time = 560
* CHECK dout0_9 vdout0_9ck55 = 1.8 time = 560
* CHECK dout0_10 vdout0_10ck55 = 1.8 time = 560
* CHECK dout0_11 vdout0_11ck55 = 0 time = 560
* CHECK dout0_12 vdout0_12ck55 = 0 time = 560
* CHECK dout0_13 vdout0_13ck55 = 0 time = 560
* CHECK dout0_14 vdout0_14ck55 = 0 time = 560
* CHECK dout0_15 vdout0_15ck55 = 0 time = 560
* CHECK dout0_16 vdout0_16ck55 = 1.8 time = 560
* CHECK dout0_17 vdout0_17ck55 = 0 time = 560
* CHECK dout0_18 vdout0_18ck55 = 0 time = 560
* CHECK dout0_19 vdout0_19ck55 = 1.8 time = 560
* CHECK dout0_20 vdout0_20ck55 = 0 time = 560
* CHECK dout0_21 vdout0_21ck55 = 0 time = 560
* CHECK dout0_22 vdout0_22ck55 = 0 time = 560
* CHECK dout0_23 vdout0_23ck55 = 0 time = 560
* CHECK dout0_24 vdout0_24ck55 = 0 time = 560
* CHECK dout0_25 vdout0_25ck55 = 0 time = 560
* CHECK dout0_26 vdout0_26ck55 = 1.8 time = 560
* CHECK dout0_27 vdout0_27ck55 = 1.8 time = 560
* CHECK dout0_28 vdout0_28ck55 = 1.8 time = 560
* CHECK dout0_29 vdout0_29ck55 = 0 time = 560
* CHECK dout0_30 vdout0_30ck55 = 1.8 time = 560
* CHECK dout0_31 vdout0_31ck55 = 1.8 time = 560
* CHECK dout1_0 vdout1_0ck55 = 1.8 time = 560
* CHECK dout1_1 vdout1_1ck55 = 1.8 time = 560
* CHECK dout1_2 vdout1_2ck55 = 1.8 time = 560
* CHECK dout1_3 vdout1_3ck55 = 0 time = 560
* CHECK dout1_4 vdout1_4ck55 = 0 time = 560
* CHECK dout1_5 vdout1_5ck55 = 0 time = 560
* CHECK dout1_6 vdout1_6ck55 = 0 time = 560
* CHECK dout1_7 vdout1_7ck55 = 1.8 time = 560
* CHECK dout1_8 vdout1_8ck55 = 1.8 time = 560
* CHECK dout1_9 vdout1_9ck55 = 1.8 time = 560
* CHECK dout1_10 vdout1_10ck55 = 1.8 time = 560
* CHECK dout1_11 vdout1_11ck55 = 0 time = 560
* CHECK dout1_12 vdout1_12ck55 = 0 time = 560
* CHECK dout1_13 vdout1_13ck55 = 0 time = 560
* CHECK dout1_14 vdout1_14ck55 = 0 time = 560
* CHECK dout1_15 vdout1_15ck55 = 0 time = 560
* CHECK dout1_16 vdout1_16ck55 = 1.8 time = 560
* CHECK dout1_17 vdout1_17ck55 = 0 time = 560
* CHECK dout1_18 vdout1_18ck55 = 0 time = 560
* CHECK dout1_19 vdout1_19ck55 = 1.8 time = 560
* CHECK dout1_20 vdout1_20ck55 = 0 time = 560
* CHECK dout1_21 vdout1_21ck55 = 0 time = 560
* CHECK dout1_22 vdout1_22ck55 = 0 time = 560
* CHECK dout1_23 vdout1_23ck55 = 0 time = 560
* CHECK dout1_24 vdout1_24ck55 = 0 time = 560
* CHECK dout1_25 vdout1_25ck55 = 0 time = 560
* CHECK dout1_26 vdout1_26ck55 = 1.8 time = 560
* CHECK dout1_27 vdout1_27ck55 = 1.8 time = 560
* CHECK dout1_28 vdout1_28ck55 = 1.8 time = 560
* CHECK dout1_29 vdout1_29ck55 = 0 time = 560
* CHECK dout1_30 vdout1_30ck55 = 1.8 time = 560
* CHECK dout1_31 vdout1_31ck55 = 1.8 time = 560
* CHECK dout1_0 vdout1_0ck56 = 1.8 time = 570
* CHECK dout1_1 vdout1_1ck56 = 0 time = 570
* CHECK dout1_2 vdout1_2ck56 = 0 time = 570
* CHECK dout1_3 vdout1_3ck56 = 0 time = 570
* CHECK dout1_4 vdout1_4ck56 = 1.8 time = 570
* CHECK dout1_5 vdout1_5ck56 = 0 time = 570
* CHECK dout1_6 vdout1_6ck56 = 0 time = 570
* CHECK dout1_7 vdout1_7ck56 = 1.8 time = 570
* CHECK dout1_8 vdout1_8ck56 = 1.8 time = 570
* CHECK dout1_9 vdout1_9ck56 = 0 time = 570
* CHECK dout1_10 vdout1_10ck56 = 0 time = 570
* CHECK dout1_11 vdout1_11ck56 = 0 time = 570
* CHECK dout1_12 vdout1_12ck56 = 1.8 time = 570
* CHECK dout1_13 vdout1_13ck56 = 1.8 time = 570
* CHECK dout1_14 vdout1_14ck56 = 1.8 time = 570
* CHECK dout1_15 vdout1_15ck56 = 1.8 time = 570
* CHECK dout1_16 vdout1_16ck56 = 1.8 time = 570
* CHECK dout1_17 vdout1_17ck56 = 1.8 time = 570
* CHECK dout1_18 vdout1_18ck56 = 0 time = 570
* CHECK dout1_19 vdout1_19ck56 = 1.8 time = 570
* CHECK dout1_20 vdout1_20ck56 = 0 time = 570
* CHECK dout1_21 vdout1_21ck56 = 1.8 time = 570
* CHECK dout1_22 vdout1_22ck56 = 1.8 time = 570
* CHECK dout1_23 vdout1_23ck56 = 0 time = 570
* CHECK dout1_24 vdout1_24ck56 = 0 time = 570
* CHECK dout1_25 vdout1_25ck56 = 1.8 time = 570
* CHECK dout1_26 vdout1_26ck56 = 1.8 time = 570
* CHECK dout1_27 vdout1_27ck56 = 1.8 time = 570
* CHECK dout1_28 vdout1_28ck56 = 0 time = 570
* CHECK dout1_29 vdout1_29ck56 = 0 time = 570
* CHECK dout1_30 vdout1_30ck56 = 0 time = 570
* CHECK dout1_31 vdout1_31ck56 = 1.8 time = 570
* CHECK dout0_0 vdout0_0ck58 = 1.8 time = 590
* CHECK dout0_1 vdout0_1ck58 = 0 time = 590
* CHECK dout0_2 vdout0_2ck58 = 0 time = 590
* CHECK dout0_3 vdout0_3ck58 = 0 time = 590
* CHECK dout0_4 vdout0_4ck58 = 1.8 time = 590
* CHECK dout0_5 vdout0_5ck58 = 0 time = 590
* CHECK dout0_6 vdout0_6ck58 = 0 time = 590
* CHECK dout0_7 vdout0_7ck58 = 1.8 time = 590
* CHECK dout0_8 vdout0_8ck58 = 1.8 time = 590
* CHECK dout0_9 vdout0_9ck58 = 0 time = 590
* CHECK dout0_10 vdout0_10ck58 = 0 time = 590
* CHECK dout0_11 vdout0_11ck58 = 0 time = 590
* CHECK dout0_12 vdout0_12ck58 = 1.8 time = 590
* CHECK dout0_13 vdout0_13ck58 = 1.8 time = 590
* CHECK dout0_14 vdout0_14ck58 = 1.8 time = 590
* CHECK dout0_15 vdout0_15ck58 = 1.8 time = 590
* CHECK dout0_16 vdout0_16ck58 = 1.8 time = 590
* CHECK dout0_17 vdout0_17ck58 = 1.8 time = 590
* CHECK dout0_18 vdout0_18ck58 = 0 time = 590
* CHECK dout0_19 vdout0_19ck58 = 1.8 time = 590
* CHECK dout0_20 vdout0_20ck58 = 0 time = 590
* CHECK dout0_21 vdout0_21ck58 = 1.8 time = 590
* CHECK dout0_22 vdout0_22ck58 = 1.8 time = 590
* CHECK dout0_23 vdout0_23ck58 = 0 time = 590
* CHECK dout0_24 vdout0_24ck58 = 0 time = 590
* CHECK dout0_25 vdout0_25ck58 = 1.8 time = 590
* CHECK dout0_26 vdout0_26ck58 = 1.8 time = 590
* CHECK dout0_27 vdout0_27ck58 = 1.8 time = 590
* CHECK dout0_28 vdout0_28ck58 = 0 time = 590
* CHECK dout0_29 vdout0_29ck58 = 0 time = 590
* CHECK dout0_30 vdout0_30ck58 = 0 time = 590
* CHECK dout0_31 vdout0_31ck58 = 1.8 time = 590
* CHECK dout0_0 vdout0_0ck59 = 0 time = 600
* CHECK dout0_1 vdout0_1ck59 = 1.8 time = 600
* CHECK dout0_2 vdout0_2ck59 = 1.8 time = 600
* CHECK dout0_3 vdout0_3ck59 = 0 time = 600
* CHECK dout0_4 vdout0_4ck59 = 0 time = 600
* CHECK dout0_5 vdout0_5ck59 = 1.8 time = 600
* CHECK dout0_6 vdout0_6ck59 = 0 time = 600
* CHECK dout0_7 vdout0_7ck59 = 0 time = 600
* CHECK dout0_8 vdout0_8ck59 = 1.8 time = 600
* CHECK dout0_9 vdout0_9ck59 = 1.8 time = 600
* CHECK dout0_10 vdout0_10ck59 = 1.8 time = 600
* CHECK dout0_11 vdout0_11ck59 = 0 time = 600
* CHECK dout0_12 vdout0_12ck59 = 0 time = 600
* CHECK dout0_13 vdout0_13ck59 = 0 time = 600
* CHECK dout0_14 vdout0_14ck59 = 1.8 time = 600
* CHECK dout0_15 vdout0_15ck59 = 0 time = 600
* CHECK dout0_16 vdout0_16ck59 = 0 time = 600
* CHECK dout0_17 vdout0_17ck59 = 1.8 time = 600
* CHECK dout0_18 vdout0_18ck59 = 0 time = 600
* CHECK dout0_19 vdout0_19ck59 = 0 time = 600
* CHECK dout0_20 vdout0_20ck59 = 1.8 time = 600
* CHECK dout0_21 vdout0_21ck59 = 1.8 time = 600
* CHECK dout0_22 vdout0_22ck59 = 1.8 time = 600
* CHECK dout0_23 vdout0_23ck59 = 0 time = 600
* CHECK dout0_24 vdout0_24ck59 = 0 time = 600
* CHECK dout0_25 vdout0_25ck59 = 0 time = 600
* CHECK dout0_26 vdout0_26ck59 = 0 time = 600
* CHECK dout0_27 vdout0_27ck59 = 1.8 time = 600
* CHECK dout0_28 vdout0_28ck59 = 1.8 time = 600
* CHECK dout0_29 vdout0_29ck59 = 1.8 time = 600
* CHECK dout0_30 vdout0_30ck59 = 1.8 time = 600
* CHECK dout0_31 vdout0_31ck59 = 0 time = 600
* CHECK dout1_0 vdout1_0ck59 = 1.8 time = 600
* CHECK dout1_1 vdout1_1ck59 = 0 time = 600
* CHECK dout1_2 vdout1_2ck59 = 0 time = 600
* CHECK dout1_3 vdout1_3ck59 = 0 time = 600
* CHECK dout1_4 vdout1_4ck59 = 1.8 time = 600
* CHECK dout1_5 vdout1_5ck59 = 0 time = 600
* CHECK dout1_6 vdout1_6ck59 = 0 time = 600
* CHECK dout1_7 vdout1_7ck59 = 1.8 time = 600
* CHECK dout1_8 vdout1_8ck59 = 1.8 time = 600
* CHECK dout1_9 vdout1_9ck59 = 0 time = 600
* CHECK dout1_10 vdout1_10ck59 = 0 time = 600
* CHECK dout1_11 vdout1_11ck59 = 0 time = 600
* CHECK dout1_12 vdout1_12ck59 = 1.8 time = 600
* CHECK dout1_13 vdout1_13ck59 = 1.8 time = 600
* CHECK dout1_14 vdout1_14ck59 = 1.8 time = 600
* CHECK dout1_15 vdout1_15ck59 = 1.8 time = 600
* CHECK dout1_16 vdout1_16ck59 = 1.8 time = 600
* CHECK dout1_17 vdout1_17ck59 = 1.8 time = 600
* CHECK dout1_18 vdout1_18ck59 = 0 time = 600
* CHECK dout1_19 vdout1_19ck59 = 1.8 time = 600
* CHECK dout1_20 vdout1_20ck59 = 0 time = 600
* CHECK dout1_21 vdout1_21ck59 = 1.8 time = 600
* CHECK dout1_22 vdout1_22ck59 = 1.8 time = 600
* CHECK dout1_23 vdout1_23ck59 = 0 time = 600
* CHECK dout1_24 vdout1_24ck59 = 0 time = 600
* CHECK dout1_25 vdout1_25ck59 = 1.8 time = 600
* CHECK dout1_26 vdout1_26ck59 = 1.8 time = 600
* CHECK dout1_27 vdout1_27ck59 = 1.8 time = 600
* CHECK dout1_28 vdout1_28ck59 = 0 time = 600
* CHECK dout1_29 vdout1_29ck59 = 0 time = 600
* CHECK dout1_30 vdout1_30ck59 = 0 time = 600
* CHECK dout1_31 vdout1_31ck59 = 1.8 time = 600
* CHECK dout0_0 vdout0_0ck60 = 1.8 time = 610
* CHECK dout0_1 vdout0_1ck60 = 0 time = 610
* CHECK dout0_2 vdout0_2ck60 = 0 time = 610
* CHECK dout0_3 vdout0_3ck60 = 0 time = 610
* CHECK dout0_4 vdout0_4ck60 = 1.8 time = 610
* CHECK dout0_5 vdout0_5ck60 = 0 time = 610
* CHECK dout0_6 vdout0_6ck60 = 0 time = 610
* CHECK dout0_7 vdout0_7ck60 = 1.8 time = 610
* CHECK dout0_8 vdout0_8ck60 = 1.8 time = 610
* CHECK dout0_9 vdout0_9ck60 = 0 time = 610
* CHECK dout0_10 vdout0_10ck60 = 0 time = 610
* CHECK dout0_11 vdout0_11ck60 = 0 time = 610
* CHECK dout0_12 vdout0_12ck60 = 1.8 time = 610
* CHECK dout0_13 vdout0_13ck60 = 1.8 time = 610
* CHECK dout0_14 vdout0_14ck60 = 1.8 time = 610
* CHECK dout0_15 vdout0_15ck60 = 1.8 time = 610
* CHECK dout0_16 vdout0_16ck60 = 1.8 time = 610
* CHECK dout0_17 vdout0_17ck60 = 1.8 time = 610
* CHECK dout0_18 vdout0_18ck60 = 0 time = 610
* CHECK dout0_19 vdout0_19ck60 = 1.8 time = 610
* CHECK dout0_20 vdout0_20ck60 = 0 time = 610
* CHECK dout0_21 vdout0_21ck60 = 1.8 time = 610
* CHECK dout0_22 vdout0_22ck60 = 1.8 time = 610
* CHECK dout0_23 vdout0_23ck60 = 0 time = 610
* CHECK dout0_24 vdout0_24ck60 = 0 time = 610
* CHECK dout0_25 vdout0_25ck60 = 1.8 time = 610
* CHECK dout0_26 vdout0_26ck60 = 1.8 time = 610
* CHECK dout0_27 vdout0_27ck60 = 1.8 time = 610
* CHECK dout0_28 vdout0_28ck60 = 0 time = 610
* CHECK dout0_29 vdout0_29ck60 = 0 time = 610
* CHECK dout0_30 vdout0_30ck60 = 0 time = 610
* CHECK dout0_31 vdout0_31ck60 = 1.8 time = 610
* CHECK dout0_0 vdout0_0ck61 = 0 time = 620
* CHECK dout0_1 vdout0_1ck61 = 1.8 time = 620
* CHECK dout0_2 vdout0_2ck61 = 1.8 time = 620
* CHECK dout0_3 vdout0_3ck61 = 0 time = 620
* CHECK dout0_4 vdout0_4ck61 = 0 time = 620
* CHECK dout0_5 vdout0_5ck61 = 1.8 time = 620
* CHECK dout0_6 vdout0_6ck61 = 0 time = 620
* CHECK dout0_7 vdout0_7ck61 = 0 time = 620
* CHECK dout0_8 vdout0_8ck61 = 1.8 time = 620
* CHECK dout0_9 vdout0_9ck61 = 1.8 time = 620
* CHECK dout0_10 vdout0_10ck61 = 1.8 time = 620
* CHECK dout0_11 vdout0_11ck61 = 0 time = 620
* CHECK dout0_12 vdout0_12ck61 = 0 time = 620
* CHECK dout0_13 vdout0_13ck61 = 0 time = 620
* CHECK dout0_14 vdout0_14ck61 = 1.8 time = 620
* CHECK dout0_15 vdout0_15ck61 = 0 time = 620
* CHECK dout0_16 vdout0_16ck61 = 0 time = 620
* CHECK dout0_17 vdout0_17ck61 = 1.8 time = 620
* CHECK dout0_18 vdout0_18ck61 = 0 time = 620
* CHECK dout0_19 vdout0_19ck61 = 0 time = 620
* CHECK dout0_20 vdout0_20ck61 = 1.8 time = 620
* CHECK dout0_21 vdout0_21ck61 = 1.8 time = 620
* CHECK dout0_22 vdout0_22ck61 = 1.8 time = 620
* CHECK dout0_23 vdout0_23ck61 = 0 time = 620
* CHECK dout0_24 vdout0_24ck61 = 0 time = 620
* CHECK dout0_25 vdout0_25ck61 = 0 time = 620
* CHECK dout0_26 vdout0_26ck61 = 0 time = 620
* CHECK dout0_27 vdout0_27ck61 = 1.8 time = 620
* CHECK dout0_28 vdout0_28ck61 = 1.8 time = 620
* CHECK dout0_29 vdout0_29ck61 = 1.8 time = 620
* CHECK dout0_30 vdout0_30ck61 = 1.8 time = 620
* CHECK dout0_31 vdout0_31ck61 = 0 time = 620
* CHECK dout0_0 vdout0_0ck63 = 0 time = 640
* CHECK dout0_1 vdout0_1ck63 = 1.8 time = 640
* CHECK dout0_2 vdout0_2ck63 = 1.8 time = 640
* CHECK dout0_3 vdout0_3ck63 = 0 time = 640
* CHECK dout0_4 vdout0_4ck63 = 0 time = 640
* CHECK dout0_5 vdout0_5ck63 = 1.8 time = 640
* CHECK dout0_6 vdout0_6ck63 = 0 time = 640
* CHECK dout0_7 vdout0_7ck63 = 0 time = 640
* CHECK dout0_8 vdout0_8ck63 = 1.8 time = 640
* CHECK dout0_9 vdout0_9ck63 = 1.8 time = 640
* CHECK dout0_10 vdout0_10ck63 = 1.8 time = 640
* CHECK dout0_11 vdout0_11ck63 = 0 time = 640
* CHECK dout0_12 vdout0_12ck63 = 0 time = 640
* CHECK dout0_13 vdout0_13ck63 = 0 time = 640
* CHECK dout0_14 vdout0_14ck63 = 1.8 time = 640
* CHECK dout0_15 vdout0_15ck63 = 0 time = 640
* CHECK dout0_16 vdout0_16ck63 = 0 time = 640
* CHECK dout0_17 vdout0_17ck63 = 1.8 time = 640
* CHECK dout0_18 vdout0_18ck63 = 0 time = 640
* CHECK dout0_19 vdout0_19ck63 = 0 time = 640
* CHECK dout0_20 vdout0_20ck63 = 1.8 time = 640
* CHECK dout0_21 vdout0_21ck63 = 1.8 time = 640
* CHECK dout0_22 vdout0_22ck63 = 1.8 time = 640
* CHECK dout0_23 vdout0_23ck63 = 0 time = 640
* CHECK dout0_24 vdout0_24ck63 = 0 time = 640
* CHECK dout0_25 vdout0_25ck63 = 0 time = 640
* CHECK dout0_26 vdout0_26ck63 = 0 time = 640
* CHECK dout0_27 vdout0_27ck63 = 1.8 time = 640
* CHECK dout0_28 vdout0_28ck63 = 1.8 time = 640
* CHECK dout0_29 vdout0_29ck63 = 1.8 time = 640
* CHECK dout0_30 vdout0_30ck63 = 1.8 time = 640
* CHECK dout0_31 vdout0_31ck63 = 0 time = 640
* CHECK dout1_0 vdout1_0ck65 = 0 time = 660
* CHECK dout1_1 vdout1_1ck65 = 1.8 time = 660
* CHECK dout1_2 vdout1_2ck65 = 1.8 time = 660
* CHECK dout1_3 vdout1_3ck65 = 0 time = 660
* CHECK dout1_4 vdout1_4ck65 = 0 time = 660
* CHECK dout1_5 vdout1_5ck65 = 1.8 time = 660
* CHECK dout1_6 vdout1_6ck65 = 0 time = 660
* CHECK dout1_7 vdout1_7ck65 = 0 time = 660
* CHECK dout1_8 vdout1_8ck65 = 1.8 time = 660
* CHECK dout1_9 vdout1_9ck65 = 1.8 time = 660
* CHECK dout1_10 vdout1_10ck65 = 1.8 time = 660
* CHECK dout1_11 vdout1_11ck65 = 0 time = 660
* CHECK dout1_12 vdout1_12ck65 = 0 time = 660
* CHECK dout1_13 vdout1_13ck65 = 0 time = 660
* CHECK dout1_14 vdout1_14ck65 = 1.8 time = 660
* CHECK dout1_15 vdout1_15ck65 = 0 time = 660
* CHECK dout1_16 vdout1_16ck65 = 0 time = 660
* CHECK dout1_17 vdout1_17ck65 = 1.8 time = 660
* CHECK dout1_18 vdout1_18ck65 = 0 time = 660
* CHECK dout1_19 vdout1_19ck65 = 0 time = 660
* CHECK dout1_20 vdout1_20ck65 = 1.8 time = 660
* CHECK dout1_21 vdout1_21ck65 = 1.8 time = 660
* CHECK dout1_22 vdout1_22ck65 = 1.8 time = 660
* CHECK dout1_23 vdout1_23ck65 = 0 time = 660
* CHECK dout1_24 vdout1_24ck65 = 0 time = 660
* CHECK dout1_25 vdout1_25ck65 = 0 time = 660
* CHECK dout1_26 vdout1_26ck65 = 0 time = 660
* CHECK dout1_27 vdout1_27ck65 = 1.8 time = 660
* CHECK dout1_28 vdout1_28ck65 = 1.8 time = 660
* CHECK dout1_29 vdout1_29ck65 = 1.8 time = 660
* CHECK dout1_30 vdout1_30ck65 = 1.8 time = 660
* CHECK dout1_31 vdout1_31ck65 = 0 time = 660
* CHECK dout0_0 vdout0_0ck67 = 0 time = 680
* CHECK dout0_1 vdout0_1ck67 = 1.8 time = 680
* CHECK dout0_2 vdout0_2ck67 = 0 time = 680
* CHECK dout0_3 vdout0_3ck67 = 1.8 time = 680
* CHECK dout0_4 vdout0_4ck67 = 1.8 time = 680
* CHECK dout0_5 vdout0_5ck67 = 1.8 time = 680
* CHECK dout0_6 vdout0_6ck67 = 0 time = 680
* CHECK dout0_7 vdout0_7ck67 = 1.8 time = 680
* CHECK dout0_8 vdout0_8ck67 = 1.8 time = 680
* CHECK dout0_9 vdout0_9ck67 = 0 time = 680
* CHECK dout0_10 vdout0_10ck67 = 0 time = 680
* CHECK dout0_11 vdout0_11ck67 = 1.8 time = 680
* CHECK dout0_12 vdout0_12ck67 = 1.8 time = 680
* CHECK dout0_13 vdout0_13ck67 = 1.8 time = 680
* CHECK dout0_14 vdout0_14ck67 = 1.8 time = 680
* CHECK dout0_15 vdout0_15ck67 = 0 time = 680
* CHECK dout0_16 vdout0_16ck67 = 1.8 time = 680
* CHECK dout0_17 vdout0_17ck67 = 0 time = 680
* CHECK dout0_18 vdout0_18ck67 = 0 time = 680
* CHECK dout0_19 vdout0_19ck67 = 1.8 time = 680
* CHECK dout0_20 vdout0_20ck67 = 0 time = 680
* CHECK dout0_21 vdout0_21ck67 = 1.8 time = 680
* CHECK dout0_22 vdout0_22ck67 = 0 time = 680
* CHECK dout0_23 vdout0_23ck67 = 0 time = 680
* CHECK dout0_24 vdout0_24ck67 = 0 time = 680
* CHECK dout0_25 vdout0_25ck67 = 1.8 time = 680
* CHECK dout0_26 vdout0_26ck67 = 1.8 time = 680
* CHECK dout0_27 vdout0_27ck67 = 1.8 time = 680
* CHECK dout0_28 vdout0_28ck67 = 0 time = 680
* CHECK dout0_29 vdout0_29ck67 = 0 time = 680
* CHECK dout0_30 vdout0_30ck67 = 0 time = 680
* CHECK dout0_31 vdout0_31ck67 = 1.8 time = 680
* CHECK dout1_0 vdout1_0ck68 = 0 time = 690
* CHECK dout1_1 vdout1_1ck68 = 1.8 time = 690
* CHECK dout1_2 vdout1_2ck68 = 0 time = 690
* CHECK dout1_3 vdout1_3ck68 = 0 time = 690
* CHECK dout1_4 vdout1_4ck68 = 1.8 time = 690
* CHECK dout1_5 vdout1_5ck68 = 0 time = 690
* CHECK dout1_6 vdout1_6ck68 = 0 time = 690
* CHECK dout1_7 vdout1_7ck68 = 0 time = 690
* CHECK dout1_8 vdout1_8ck68 = 0 time = 690
* CHECK dout1_9 vdout1_9ck68 = 0 time = 690
* CHECK dout1_10 vdout1_10ck68 = 1.8 time = 690
* CHECK dout1_11 vdout1_11ck68 = 1.8 time = 690
* CHECK dout1_12 vdout1_12ck68 = 1.8 time = 690
* CHECK dout1_13 vdout1_13ck68 = 1.8 time = 690
* CHECK dout1_14 vdout1_14ck68 = 1.8 time = 690
* CHECK dout1_15 vdout1_15ck68 = 0 time = 690
* CHECK dout1_16 vdout1_16ck68 = 0 time = 690
* CHECK dout1_17 vdout1_17ck68 = 0 time = 690
* CHECK dout1_18 vdout1_18ck68 = 0 time = 690
* CHECK dout1_19 vdout1_19ck68 = 1.8 time = 690
* CHECK dout1_20 vdout1_20ck68 = 0 time = 690
* CHECK dout1_21 vdout1_21ck68 = 1.8 time = 690
* CHECK dout1_22 vdout1_22ck68 = 1.8 time = 690
* CHECK dout1_23 vdout1_23ck68 = 1.8 time = 690
* CHECK dout1_24 vdout1_24ck68 = 0 time = 690
* CHECK dout1_25 vdout1_25ck68 = 1.8 time = 690
* CHECK dout1_26 vdout1_26ck68 = 0 time = 690
* CHECK dout1_27 vdout1_27ck68 = 1.8 time = 690
* CHECK dout1_28 vdout1_28ck68 = 0 time = 690
* CHECK dout1_29 vdout1_29ck68 = 1.8 time = 690
* CHECK dout1_30 vdout1_30ck68 = 1.8 time = 690
* CHECK dout1_31 vdout1_31ck68 = 1.8 time = 690
* CHECK dout0_0 vdout0_0ck69 = 0 time = 700
* CHECK dout0_1 vdout0_1ck69 = 1.8 time = 700
* CHECK dout0_2 vdout0_2ck69 = 0 time = 700
* CHECK dout0_3 vdout0_3ck69 = 0 time = 700
* CHECK dout0_4 vdout0_4ck69 = 1.8 time = 700
* CHECK dout0_5 vdout0_5ck69 = 0 time = 700
* CHECK dout0_6 vdout0_6ck69 = 0 time = 700
* CHECK dout0_7 vdout0_7ck69 = 0 time = 700
* CHECK dout0_8 vdout0_8ck69 = 0 time = 700
* CHECK dout0_9 vdout0_9ck69 = 0 time = 700
* CHECK dout0_10 vdout0_10ck69 = 1.8 time = 700
* CHECK dout0_11 vdout0_11ck69 = 1.8 time = 700
* CHECK dout0_12 vdout0_12ck69 = 1.8 time = 700
* CHECK dout0_13 vdout0_13ck69 = 1.8 time = 700
* CHECK dout0_14 vdout0_14ck69 = 1.8 time = 700
* CHECK dout0_15 vdout0_15ck69 = 0 time = 700
* CHECK dout0_16 vdout0_16ck69 = 0 time = 700
* CHECK dout0_17 vdout0_17ck69 = 0 time = 700
* CHECK dout0_18 vdout0_18ck69 = 0 time = 700
* CHECK dout0_19 vdout0_19ck69 = 1.8 time = 700
* CHECK dout0_20 vdout0_20ck69 = 0 time = 700
* CHECK dout0_21 vdout0_21ck69 = 1.8 time = 700
* CHECK dout0_22 vdout0_22ck69 = 1.8 time = 700
* CHECK dout0_23 vdout0_23ck69 = 1.8 time = 700
* CHECK dout0_24 vdout0_24ck69 = 0 time = 700
* CHECK dout0_25 vdout0_25ck69 = 1.8 time = 700
* CHECK dout0_26 vdout0_26ck69 = 0 time = 700
* CHECK dout0_27 vdout0_27ck69 = 1.8 time = 700
* CHECK dout0_28 vdout0_28ck69 = 0 time = 700
* CHECK dout0_29 vdout0_29ck69 = 1.8 time = 700
* CHECK dout0_30 vdout0_30ck69 = 1.8 time = 700
* CHECK dout0_31 vdout0_31ck69 = 1.8 time = 700
* CHECK dout0_0 vdout0_0ck72 = 1.8 time = 730
* CHECK dout0_1 vdout0_1ck72 = 1.8 time = 730
* CHECK dout0_2 vdout0_2ck72 = 1.8 time = 730
* CHECK dout0_3 vdout0_3ck72 = 0 time = 730
* CHECK dout0_4 vdout0_4ck72 = 0 time = 730
* CHECK dout0_5 vdout0_5ck72 = 0 time = 730
* CHECK dout0_6 vdout0_6ck72 = 1.8 time = 730
* CHECK dout0_7 vdout0_7ck72 = 1.8 time = 730
* CHECK dout0_8 vdout0_8ck72 = 0 time = 730
* CHECK dout0_9 vdout0_9ck72 = 1.8 time = 730
* CHECK dout0_10 vdout0_10ck72 = 0 time = 730
* CHECK dout0_11 vdout0_11ck72 = 0 time = 730
* CHECK dout0_12 vdout0_12ck72 = 0 time = 730
* CHECK dout0_13 vdout0_13ck72 = 1.8 time = 730
* CHECK dout0_14 vdout0_14ck72 = 0 time = 730
* CHECK dout0_15 vdout0_15ck72 = 0 time = 730
* CHECK dout0_16 vdout0_16ck72 = 0 time = 730
* CHECK dout0_17 vdout0_17ck72 = 1.8 time = 730
* CHECK dout0_18 vdout0_18ck72 = 0 time = 730
* CHECK dout0_19 vdout0_19ck72 = 1.8 time = 730
* CHECK dout0_20 vdout0_20ck72 = 0 time = 730
* CHECK dout0_21 vdout0_21ck72 = 0 time = 730
* CHECK dout0_22 vdout0_22ck72 = 1.8 time = 730
* CHECK dout0_23 vdout0_23ck72 = 1.8 time = 730
* CHECK dout0_24 vdout0_24ck72 = 0 time = 730
* CHECK dout0_25 vdout0_25ck72 = 1.8 time = 730
* CHECK dout0_26 vdout0_26ck72 = 0 time = 730
* CHECK dout0_27 vdout0_27ck72 = 1.8 time = 730
* CHECK dout0_28 vdout0_28ck72 = 1.8 time = 730
* CHECK dout0_29 vdout0_29ck72 = 1.8 time = 730
* CHECK dout0_30 vdout0_30ck72 = 0 time = 730
* CHECK dout0_31 vdout0_31ck72 = 0 time = 730
* CHECK dout1_0 vdout1_0ck73 = 1.8 time = 740
* CHECK dout1_1 vdout1_1ck73 = 1.8 time = 740
* CHECK dout1_2 vdout1_2ck73 = 1.8 time = 740
* CHECK dout1_3 vdout1_3ck73 = 0 time = 740
* CHECK dout1_4 vdout1_4ck73 = 0 time = 740
* CHECK dout1_5 vdout1_5ck73 = 0 time = 740
* CHECK dout1_6 vdout1_6ck73 = 1.8 time = 740
* CHECK dout1_7 vdout1_7ck73 = 1.8 time = 740
* CHECK dout1_8 vdout1_8ck73 = 0 time = 740
* CHECK dout1_9 vdout1_9ck73 = 1.8 time = 740
* CHECK dout1_10 vdout1_10ck73 = 0 time = 740
* CHECK dout1_11 vdout1_11ck73 = 0 time = 740
* CHECK dout1_12 vdout1_12ck73 = 0 time = 740
* CHECK dout1_13 vdout1_13ck73 = 1.8 time = 740
* CHECK dout1_14 vdout1_14ck73 = 0 time = 740
* CHECK dout1_15 vdout1_15ck73 = 0 time = 740
* CHECK dout1_16 vdout1_16ck73 = 0 time = 740
* CHECK dout1_17 vdout1_17ck73 = 1.8 time = 740
* CHECK dout1_18 vdout1_18ck73 = 0 time = 740
* CHECK dout1_19 vdout1_19ck73 = 1.8 time = 740
* CHECK dout1_20 vdout1_20ck73 = 0 time = 740
* CHECK dout1_21 vdout1_21ck73 = 0 time = 740
* CHECK dout1_22 vdout1_22ck73 = 1.8 time = 740
* CHECK dout1_23 vdout1_23ck73 = 1.8 time = 740
* CHECK dout1_24 vdout1_24ck73 = 0 time = 740
* CHECK dout1_25 vdout1_25ck73 = 1.8 time = 740
* CHECK dout1_26 vdout1_26ck73 = 0 time = 740
* CHECK dout1_27 vdout1_27ck73 = 1.8 time = 740
* CHECK dout1_28 vdout1_28ck73 = 1.8 time = 740
* CHECK dout1_29 vdout1_29ck73 = 1.8 time = 740
* CHECK dout1_30 vdout1_30ck73 = 0 time = 740
* CHECK dout1_31 vdout1_31ck73 = 0 time = 740
* CHECK dout1_0 vdout1_0ck75 = 1.8 time = 760
* CHECK dout1_1 vdout1_1ck75 = 1.8 time = 760
* CHECK dout1_2 vdout1_2ck75 = 1.8 time = 760
* CHECK dout1_3 vdout1_3ck75 = 0 time = 760
* CHECK dout1_4 vdout1_4ck75 = 0 time = 760
* CHECK dout1_5 vdout1_5ck75 = 0 time = 760
* CHECK dout1_6 vdout1_6ck75 = 1.8 time = 760
* CHECK dout1_7 vdout1_7ck75 = 1.8 time = 760
* CHECK dout1_8 vdout1_8ck75 = 0 time = 760
* CHECK dout1_9 vdout1_9ck75 = 1.8 time = 760
* CHECK dout1_10 vdout1_10ck75 = 0 time = 760
* CHECK dout1_11 vdout1_11ck75 = 0 time = 760
* CHECK dout1_12 vdout1_12ck75 = 0 time = 760
* CHECK dout1_13 vdout1_13ck75 = 1.8 time = 760
* CHECK dout1_14 vdout1_14ck75 = 0 time = 760
* CHECK dout1_15 vdout1_15ck75 = 0 time = 760
* CHECK dout1_16 vdout1_16ck75 = 0 time = 760
* CHECK dout1_17 vdout1_17ck75 = 1.8 time = 760
* CHECK dout1_18 vdout1_18ck75 = 0 time = 760
* CHECK dout1_19 vdout1_19ck75 = 1.8 time = 760
* CHECK dout1_20 vdout1_20ck75 = 0 time = 760
* CHECK dout1_21 vdout1_21ck75 = 0 time = 760
* CHECK dout1_22 vdout1_22ck75 = 1.8 time = 760
* CHECK dout1_23 vdout1_23ck75 = 1.8 time = 760
* CHECK dout1_24 vdout1_24ck75 = 0 time = 760
* CHECK dout1_25 vdout1_25ck75 = 1.8 time = 760
* CHECK dout1_26 vdout1_26ck75 = 0 time = 760
* CHECK dout1_27 vdout1_27ck75 = 1.8 time = 760
* CHECK dout1_28 vdout1_28ck75 = 1.8 time = 760
* CHECK dout1_29 vdout1_29ck75 = 1.8 time = 760
* CHECK dout1_30 vdout1_30ck75 = 0 time = 760
* CHECK dout1_31 vdout1_31ck75 = 0 time = 760
* CHECK dout1_0 vdout1_0ck77 = 0 time = 780
* CHECK dout1_1 vdout1_1ck77 = 1.8 time = 780
* CHECK dout1_2 vdout1_2ck77 = 0 time = 780
* CHECK dout1_3 vdout1_3ck77 = 0 time = 780
* CHECK dout1_4 vdout1_4ck77 = 1.8 time = 780
* CHECK dout1_5 vdout1_5ck77 = 0 time = 780
* CHECK dout1_6 vdout1_6ck77 = 0 time = 780
* CHECK dout1_7 vdout1_7ck77 = 1.8 time = 780
* CHECK dout1_8 vdout1_8ck77 = 0 time = 780
* CHECK dout1_9 vdout1_9ck77 = 0 time = 780
* CHECK dout1_10 vdout1_10ck77 = 0 time = 780
* CHECK dout1_11 vdout1_11ck77 = 0 time = 780
* CHECK dout1_12 vdout1_12ck77 = 1.8 time = 780
* CHECK dout1_13 vdout1_13ck77 = 0 time = 780
* CHECK dout1_14 vdout1_14ck77 = 0 time = 780
* CHECK dout1_15 vdout1_15ck77 = 1.8 time = 780
* CHECK dout1_16 vdout1_16ck77 = 1.8 time = 780
* CHECK dout1_17 vdout1_17ck77 = 0 time = 780
* CHECK dout1_18 vdout1_18ck77 = 0 time = 780
* CHECK dout1_19 vdout1_19ck77 = 0 time = 780
* CHECK dout1_20 vdout1_20ck77 = 0 time = 780
* CHECK dout1_21 vdout1_21ck77 = 1.8 time = 780
* CHECK dout1_22 vdout1_22ck77 = 1.8 time = 780
* CHECK dout1_23 vdout1_23ck77 = 0 time = 780
* CHECK dout1_24 vdout1_24ck77 = 1.8 time = 780
* CHECK dout1_25 vdout1_25ck77 = 1.8 time = 780
* CHECK dout1_26 vdout1_26ck77 = 0 time = 780
* CHECK dout1_27 vdout1_27ck77 = 0 time = 780
* CHECK dout1_28 vdout1_28ck77 = 1.8 time = 780
* CHECK dout1_29 vdout1_29ck77 = 0 time = 780
* CHECK dout1_30 vdout1_30ck77 = 0 time = 780
* CHECK dout1_31 vdout1_31ck77 = 0 time = 780
* CHECK dout0_0 vdout0_0ck78 = 0 time = 790
* CHECK dout0_1 vdout0_1ck78 = 1.8 time = 790
* CHECK dout0_2 vdout0_2ck78 = 0 time = 790
* CHECK dout0_3 vdout0_3ck78 = 0 time = 790
* CHECK dout0_4 vdout0_4ck78 = 1.8 time = 790
* CHECK dout0_5 vdout0_5ck78 = 0 time = 790
* CHECK dout0_6 vdout0_6ck78 = 0 time = 790
* CHECK dout0_7 vdout0_7ck78 = 1.8 time = 790
* CHECK dout0_8 vdout0_8ck78 = 0 time = 790
* CHECK dout0_9 vdout0_9ck78 = 0 time = 790
* CHECK dout0_10 vdout0_10ck78 = 0 time = 790
* CHECK dout0_11 vdout0_11ck78 = 0 time = 790
* CHECK dout0_12 vdout0_12ck78 = 1.8 time = 790
* CHECK dout0_13 vdout0_13ck78 = 0 time = 790
* CHECK dout0_14 vdout0_14ck78 = 0 time = 790
* CHECK dout0_15 vdout0_15ck78 = 1.8 time = 790
* CHECK dout0_16 vdout0_16ck78 = 1.8 time = 790
* CHECK dout0_17 vdout0_17ck78 = 0 time = 790
* CHECK dout0_18 vdout0_18ck78 = 0 time = 790
* CHECK dout0_19 vdout0_19ck78 = 0 time = 790
* CHECK dout0_20 vdout0_20ck78 = 0 time = 790
* CHECK dout0_21 vdout0_21ck78 = 1.8 time = 790
* CHECK dout0_22 vdout0_22ck78 = 1.8 time = 790
* CHECK dout0_23 vdout0_23ck78 = 0 time = 790
* CHECK dout0_24 vdout0_24ck78 = 1.8 time = 790
* CHECK dout0_25 vdout0_25ck78 = 1.8 time = 790
* CHECK dout0_26 vdout0_26ck78 = 0 time = 790
* CHECK dout0_27 vdout0_27ck78 = 0 time = 790
* CHECK dout0_28 vdout0_28ck78 = 1.8 time = 790
* CHECK dout0_29 vdout0_29ck78 = 0 time = 790
* CHECK dout0_30 vdout0_30ck78 = 0 time = 790
* CHECK dout0_31 vdout0_31ck78 = 0 time = 790
* CHECK dout1_0 vdout1_0ck78 = 0 time = 790
* CHECK dout1_1 vdout1_1ck78 = 1.8 time = 790
* CHECK dout1_2 vdout1_2ck78 = 0 time = 790
* CHECK dout1_3 vdout1_3ck78 = 0 time = 790
* CHECK dout1_4 vdout1_4ck78 = 1.8 time = 790
* CHECK dout1_5 vdout1_5ck78 = 0 time = 790
* CHECK dout1_6 vdout1_6ck78 = 0 time = 790
* CHECK dout1_7 vdout1_7ck78 = 1.8 time = 790
* CHECK dout1_8 vdout1_8ck78 = 1.8 time = 790
* CHECK dout1_9 vdout1_9ck78 = 0 time = 790
* CHECK dout1_10 vdout1_10ck78 = 1.8 time = 790
* CHECK dout1_11 vdout1_11ck78 = 0 time = 790
* CHECK dout1_12 vdout1_12ck78 = 0 time = 790
* CHECK dout1_13 vdout1_13ck78 = 1.8 time = 790
* CHECK dout1_14 vdout1_14ck78 = 0 time = 790
* CHECK dout1_15 vdout1_15ck78 = 0 time = 790
* CHECK dout1_16 vdout1_16ck78 = 1.8 time = 790
* CHECK dout1_17 vdout1_17ck78 = 0 time = 790
* CHECK dout1_18 vdout1_18ck78 = 1.8 time = 790
* CHECK dout1_19 vdout1_19ck78 = 1.8 time = 790
* CHECK dout1_20 vdout1_20ck78 = 1.8 time = 790
* CHECK dout1_21 vdout1_21ck78 = 1.8 time = 790
* CHECK dout1_22 vdout1_22ck78 = 1.8 time = 790
* CHECK dout1_23 vdout1_23ck78 = 0 time = 790
* CHECK dout1_24 vdout1_24ck78 = 0 time = 790
* CHECK dout1_25 vdout1_25ck78 = 1.8 time = 790
* CHECK dout1_26 vdout1_26ck78 = 1.8 time = 790
* CHECK dout1_27 vdout1_27ck78 = 1.8 time = 790
* CHECK dout1_28 vdout1_28ck78 = 1.8 time = 790
* CHECK dout1_29 vdout1_29ck78 = 0 time = 790
* CHECK dout1_30 vdout1_30ck78 = 1.8 time = 790
* CHECK dout1_31 vdout1_31ck78 = 1.8 time = 790
* CHECK dout0_0 vdout0_0ck79 = 0 time = 800
* CHECK dout0_1 vdout0_1ck79 = 1.8 time = 800
* CHECK dout0_2 vdout0_2ck79 = 0 time = 800
* CHECK dout0_3 vdout0_3ck79 = 0 time = 800
* CHECK dout0_4 vdout0_4ck79 = 1.8 time = 800
* CHECK dout0_5 vdout0_5ck79 = 0 time = 800
* CHECK dout0_6 vdout0_6ck79 = 0 time = 800
* CHECK dout0_7 vdout0_7ck79 = 1.8 time = 800
* CHECK dout0_8 vdout0_8ck79 = 1.8 time = 800
* CHECK dout0_9 vdout0_9ck79 = 0 time = 800
* CHECK dout0_10 vdout0_10ck79 = 1.8 time = 800
* CHECK dout0_11 vdout0_11ck79 = 0 time = 800
* CHECK dout0_12 vdout0_12ck79 = 0 time = 800
* CHECK dout0_13 vdout0_13ck79 = 1.8 time = 800
* CHECK dout0_14 vdout0_14ck79 = 0 time = 800
* CHECK dout0_15 vdout0_15ck79 = 0 time = 800
* CHECK dout0_16 vdout0_16ck79 = 1.8 time = 800
* CHECK dout0_17 vdout0_17ck79 = 0 time = 800
* CHECK dout0_18 vdout0_18ck79 = 1.8 time = 800
* CHECK dout0_19 vdout0_19ck79 = 1.8 time = 800
* CHECK dout0_20 vdout0_20ck79 = 1.8 time = 800
* CHECK dout0_21 vdout0_21ck79 = 1.8 time = 800
* CHECK dout0_22 vdout0_22ck79 = 1.8 time = 800
* CHECK dout0_23 vdout0_23ck79 = 0 time = 800
* CHECK dout0_24 vdout0_24ck79 = 0 time = 800
* CHECK dout0_25 vdout0_25ck79 = 1.8 time = 800
* CHECK dout0_26 vdout0_26ck79 = 1.8 time = 800
* CHECK dout0_27 vdout0_27ck79 = 1.8 time = 800
* CHECK dout0_28 vdout0_28ck79 = 1.8 time = 800
* CHECK dout0_29 vdout0_29ck79 = 0 time = 800
* CHECK dout0_30 vdout0_30ck79 = 1.8 time = 800
* CHECK dout0_31 vdout0_31ck79 = 1.8 time = 800
* CHECK dout1_0 vdout1_0ck79 = 0 time = 800
* CHECK dout1_1 vdout1_1ck79 = 1.8 time = 800
* CHECK dout1_2 vdout1_2ck79 = 0 time = 800
* CHECK dout1_3 vdout1_3ck79 = 0 time = 800
* CHECK dout1_4 vdout1_4ck79 = 1.8 time = 800
* CHECK dout1_5 vdout1_5ck79 = 0 time = 800
* CHECK dout1_6 vdout1_6ck79 = 0 time = 800
* CHECK dout1_7 vdout1_7ck79 = 1.8 time = 800
* CHECK dout1_8 vdout1_8ck79 = 1.8 time = 800
* CHECK dout1_9 vdout1_9ck79 = 0 time = 800
* CHECK dout1_10 vdout1_10ck79 = 1.8 time = 800
* CHECK dout1_11 vdout1_11ck79 = 0 time = 800
* CHECK dout1_12 vdout1_12ck79 = 0 time = 800
* CHECK dout1_13 vdout1_13ck79 = 1.8 time = 800
* CHECK dout1_14 vdout1_14ck79 = 0 time = 800
* CHECK dout1_15 vdout1_15ck79 = 0 time = 800
* CHECK dout1_16 vdout1_16ck79 = 1.8 time = 800
* CHECK dout1_17 vdout1_17ck79 = 0 time = 800
* CHECK dout1_18 vdout1_18ck79 = 1.8 time = 800
* CHECK dout1_19 vdout1_19ck79 = 1.8 time = 800
* CHECK dout1_20 vdout1_20ck79 = 1.8 time = 800
* CHECK dout1_21 vdout1_21ck79 = 1.8 time = 800
* CHECK dout1_22 vdout1_22ck79 = 1.8 time = 800
* CHECK dout1_23 vdout1_23ck79 = 0 time = 800
* CHECK dout1_24 vdout1_24ck79 = 0 time = 800
* CHECK dout1_25 vdout1_25ck79 = 1.8 time = 800
* CHECK dout1_26 vdout1_26ck79 = 1.8 time = 800
* CHECK dout1_27 vdout1_27ck79 = 1.8 time = 800
* CHECK dout1_28 vdout1_28ck79 = 1.8 time = 800
* CHECK dout1_29 vdout1_29ck79 = 0 time = 800
* CHECK dout1_30 vdout1_30ck79 = 1.8 time = 800
* CHECK dout1_31 vdout1_31ck79 = 1.8 time = 800
* CHECK dout0_0 vdout0_0ck82 = 0 time = 830
* CHECK dout0_1 vdout0_1ck82 = 1.8 time = 830
* CHECK dout0_2 vdout0_2ck82 = 0 time = 830
* CHECK dout0_3 vdout0_3ck82 = 0 time = 830
* CHECK dout0_4 vdout0_4ck82 = 1.8 time = 830
* CHECK dout0_5 vdout0_5ck82 = 0 time = 830
* CHECK dout0_6 vdout0_6ck82 = 0 time = 830
* CHECK dout0_7 vdout0_7ck82 = 1.8 time = 830
* CHECK dout0_8 vdout0_8ck82 = 1.8 time = 830
* CHECK dout0_9 vdout0_9ck82 = 0 time = 830
* CHECK dout0_10 vdout0_10ck82 = 1.8 time = 830
* CHECK dout0_11 vdout0_11ck82 = 0 time = 830
* CHECK dout0_12 vdout0_12ck82 = 0 time = 830
* CHECK dout0_13 vdout0_13ck82 = 1.8 time = 830
* CHECK dout0_14 vdout0_14ck82 = 0 time = 830
* CHECK dout0_15 vdout0_15ck82 = 0 time = 830
* CHECK dout0_16 vdout0_16ck82 = 1.8 time = 830
* CHECK dout0_17 vdout0_17ck82 = 0 time = 830
* CHECK dout0_18 vdout0_18ck82 = 1.8 time = 830
* CHECK dout0_19 vdout0_19ck82 = 1.8 time = 830
* CHECK dout0_20 vdout0_20ck82 = 1.8 time = 830
* CHECK dout0_21 vdout0_21ck82 = 1.8 time = 830
* CHECK dout0_22 vdout0_22ck82 = 1.8 time = 830
* CHECK dout0_23 vdout0_23ck82 = 0 time = 830
* CHECK dout0_24 vdout0_24ck82 = 0 time = 830
* CHECK dout0_25 vdout0_25ck82 = 1.8 time = 830
* CHECK dout0_26 vdout0_26ck82 = 1.8 time = 830
* CHECK dout0_27 vdout0_27ck82 = 1.8 time = 830
* CHECK dout0_28 vdout0_28ck82 = 1.8 time = 830
* CHECK dout0_29 vdout0_29ck82 = 0 time = 830
* CHECK dout0_30 vdout0_30ck82 = 1.8 time = 830
* CHECK dout0_31 vdout0_31ck82 = 1.8 time = 830
* CHECK dout1_0 vdout1_0ck82 = 1.8 time = 830
* CHECK dout1_1 vdout1_1ck82 = 1.8 time = 830
* CHECK dout1_2 vdout1_2ck82 = 0 time = 830
* CHECK dout1_3 vdout1_3ck82 = 0 time = 830
* CHECK dout1_4 vdout1_4ck82 = 0 time = 830
* CHECK dout1_5 vdout1_5ck82 = 0 time = 830
* CHECK dout1_6 vdout1_6ck82 = 0 time = 830
* CHECK dout1_7 vdout1_7ck82 = 1.8 time = 830
* CHECK dout1_8 vdout1_8ck82 = 1.8 time = 830
* CHECK dout1_9 vdout1_9ck82 = 1.8 time = 830
* CHECK dout1_10 vdout1_10ck82 = 1.8 time = 830
* CHECK dout1_11 vdout1_11ck82 = 0 time = 830
* CHECK dout1_12 vdout1_12ck82 = 1.8 time = 830
* CHECK dout1_13 vdout1_13ck82 = 1.8 time = 830
* CHECK dout1_14 vdout1_14ck82 = 1.8 time = 830
* CHECK dout1_15 vdout1_15ck82 = 1.8 time = 830
* CHECK dout1_16 vdout1_16ck82 = 0 time = 830
* CHECK dout1_17 vdout1_17ck82 = 0 time = 830
* CHECK dout1_18 vdout1_18ck82 = 1.8 time = 830
* CHECK dout1_19 vdout1_19ck82 = 1.8 time = 830
* CHECK dout1_20 vdout1_20ck82 = 0 time = 830
* CHECK dout1_21 vdout1_21ck82 = 1.8 time = 830
* CHECK dout1_22 vdout1_22ck82 = 1.8 time = 830
* CHECK dout1_23 vdout1_23ck82 = 1.8 time = 830
* CHECK dout1_24 vdout1_24ck82 = 1.8 time = 830
* CHECK dout1_25 vdout1_25ck82 = 0 time = 830
* CHECK dout1_26 vdout1_26ck82 = 0 time = 830
* CHECK dout1_27 vdout1_27ck82 = 1.8 time = 830
* CHECK dout1_28 vdout1_28ck82 = 1.8 time = 830
* CHECK dout1_29 vdout1_29ck82 = 1.8 time = 830
* CHECK dout1_30 vdout1_30ck82 = 0 time = 830
* CHECK dout1_31 vdout1_31ck82 = 0 time = 830
* CHECK dout0_0 vdout0_0ck84 = 1.8 time = 850
* CHECK dout0_1 vdout0_1ck84 = 1.8 time = 850
* CHECK dout0_2 vdout0_2ck84 = 0 time = 850
* CHECK dout0_3 vdout0_3ck84 = 0 time = 850
* CHECK dout0_4 vdout0_4ck84 = 0 time = 850
* CHECK dout0_5 vdout0_5ck84 = 0 time = 850
* CHECK dout0_6 vdout0_6ck84 = 0 time = 850
* CHECK dout0_7 vdout0_7ck84 = 1.8 time = 850
* CHECK dout0_8 vdout0_8ck84 = 1.8 time = 850
* CHECK dout0_9 vdout0_9ck84 = 1.8 time = 850
* CHECK dout0_10 vdout0_10ck84 = 1.8 time = 850
* CHECK dout0_11 vdout0_11ck84 = 0 time = 850
* CHECK dout0_12 vdout0_12ck84 = 1.8 time = 850
* CHECK dout0_13 vdout0_13ck84 = 1.8 time = 850
* CHECK dout0_14 vdout0_14ck84 = 1.8 time = 850
* CHECK dout0_15 vdout0_15ck84 = 1.8 time = 850
* CHECK dout0_16 vdout0_16ck84 = 0 time = 850
* CHECK dout0_17 vdout0_17ck84 = 0 time = 850
* CHECK dout0_18 vdout0_18ck84 = 1.8 time = 850
* CHECK dout0_19 vdout0_19ck84 = 1.8 time = 850
* CHECK dout0_20 vdout0_20ck84 = 0 time = 850
* CHECK dout0_21 vdout0_21ck84 = 1.8 time = 850
* CHECK dout0_22 vdout0_22ck84 = 1.8 time = 850
* CHECK dout0_23 vdout0_23ck84 = 1.8 time = 850
* CHECK dout0_24 vdout0_24ck84 = 1.8 time = 850
* CHECK dout0_25 vdout0_25ck84 = 0 time = 850
* CHECK dout0_26 vdout0_26ck84 = 0 time = 850
* CHECK dout0_27 vdout0_27ck84 = 1.8 time = 850
* CHECK dout0_28 vdout0_28ck84 = 1.8 time = 850
* CHECK dout0_29 vdout0_29ck84 = 1.8 time = 850
* CHECK dout0_30 vdout0_30ck84 = 0 time = 850
* CHECK dout0_31 vdout0_31ck84 = 0 time = 850
* CHECK dout1_0 vdout1_0ck84 = 0 time = 850
* CHECK dout1_1 vdout1_1ck84 = 1.8 time = 850
* CHECK dout1_2 vdout1_2ck84 = 0 time = 850
* CHECK dout1_3 vdout1_3ck84 = 0 time = 850
* CHECK dout1_4 vdout1_4ck84 = 1.8 time = 850
* CHECK dout1_5 vdout1_5ck84 = 0 time = 850
* CHECK dout1_6 vdout1_6ck84 = 0 time = 850
* CHECK dout1_7 vdout1_7ck84 = 1.8 time = 850
* CHECK dout1_8 vdout1_8ck84 = 1.8 time = 850
* CHECK dout1_9 vdout1_9ck84 = 0 time = 850
* CHECK dout1_10 vdout1_10ck84 = 1.8 time = 850
* CHECK dout1_11 vdout1_11ck84 = 0 time = 850
* CHECK dout1_12 vdout1_12ck84 = 0 time = 850
* CHECK dout1_13 vdout1_13ck84 = 1.8 time = 850
* CHECK dout1_14 vdout1_14ck84 = 0 time = 850
* CHECK dout1_15 vdout1_15ck84 = 0 time = 850
* CHECK dout1_16 vdout1_16ck84 = 1.8 time = 850
* CHECK dout1_17 vdout1_17ck84 = 0 time = 850
* CHECK dout1_18 vdout1_18ck84 = 1.8 time = 850
* CHECK dout1_19 vdout1_19ck84 = 1.8 time = 850
* CHECK dout1_20 vdout1_20ck84 = 1.8 time = 850
* CHECK dout1_21 vdout1_21ck84 = 1.8 time = 850
* CHECK dout1_22 vdout1_22ck84 = 1.8 time = 850
* CHECK dout1_23 vdout1_23ck84 = 0 time = 850
* CHECK dout1_24 vdout1_24ck84 = 0 time = 850
* CHECK dout1_25 vdout1_25ck84 = 1.8 time = 850
* CHECK dout1_26 vdout1_26ck84 = 1.8 time = 850
* CHECK dout1_27 vdout1_27ck84 = 1.8 time = 850
* CHECK dout1_28 vdout1_28ck84 = 1.8 time = 850
* CHECK dout1_29 vdout1_29ck84 = 0 time = 850
* CHECK dout1_30 vdout1_30ck84 = 1.8 time = 850
* CHECK dout1_31 vdout1_31ck84 = 1.8 time = 850
* CHECK dout0_0 vdout0_0ck85 = 0 time = 860
* CHECK dout0_1 vdout0_1ck85 = 1.8 time = 860
* CHECK dout0_2 vdout0_2ck85 = 0 time = 860
* CHECK dout0_3 vdout0_3ck85 = 0 time = 860
* CHECK dout0_4 vdout0_4ck85 = 1.8 time = 860
* CHECK dout0_5 vdout0_5ck85 = 0 time = 860
* CHECK dout0_6 vdout0_6ck85 = 0 time = 860
* CHECK dout0_7 vdout0_7ck85 = 1.8 time = 860
* CHECK dout0_8 vdout0_8ck85 = 1.8 time = 860
* CHECK dout0_9 vdout0_9ck85 = 0 time = 860
* CHECK dout0_10 vdout0_10ck85 = 1.8 time = 860
* CHECK dout0_11 vdout0_11ck85 = 0 time = 860
* CHECK dout0_12 vdout0_12ck85 = 0 time = 860
* CHECK dout0_13 vdout0_13ck85 = 1.8 time = 860
* CHECK dout0_14 vdout0_14ck85 = 0 time = 860
* CHECK dout0_15 vdout0_15ck85 = 0 time = 860
* CHECK dout0_16 vdout0_16ck85 = 1.8 time = 860
* CHECK dout0_17 vdout0_17ck85 = 0 time = 860
* CHECK dout0_18 vdout0_18ck85 = 1.8 time = 860
* CHECK dout0_19 vdout0_19ck85 = 1.8 time = 860
* CHECK dout0_20 vdout0_20ck85 = 1.8 time = 860
* CHECK dout0_21 vdout0_21ck85 = 1.8 time = 860
* CHECK dout0_22 vdout0_22ck85 = 1.8 time = 860
* CHECK dout0_23 vdout0_23ck85 = 0 time = 860
* CHECK dout0_24 vdout0_24ck85 = 0 time = 860
* CHECK dout0_25 vdout0_25ck85 = 1.8 time = 860
* CHECK dout0_26 vdout0_26ck85 = 1.8 time = 860
* CHECK dout0_27 vdout0_27ck85 = 1.8 time = 860
* CHECK dout0_28 vdout0_28ck85 = 1.8 time = 860
* CHECK dout0_29 vdout0_29ck85 = 0 time = 860
* CHECK dout0_30 vdout0_30ck85 = 1.8 time = 860
* CHECK dout0_31 vdout0_31ck85 = 1.8 time = 860
* CHECK dout1_0 vdout1_0ck85 = 0 time = 860
* CHECK dout1_1 vdout1_1ck85 = 1.8 time = 860
* CHECK dout1_2 vdout1_2ck85 = 0 time = 860
* CHECK dout1_3 vdout1_3ck85 = 0 time = 860
* CHECK dout1_4 vdout1_4ck85 = 1.8 time = 860
* CHECK dout1_5 vdout1_5ck85 = 0 time = 860
* CHECK dout1_6 vdout1_6ck85 = 0 time = 860
* CHECK dout1_7 vdout1_7ck85 = 1.8 time = 860
* CHECK dout1_8 vdout1_8ck85 = 1.8 time = 860
* CHECK dout1_9 vdout1_9ck85 = 0 time = 860
* CHECK dout1_10 vdout1_10ck85 = 1.8 time = 860
* CHECK dout1_11 vdout1_11ck85 = 0 time = 860
* CHECK dout1_12 vdout1_12ck85 = 0 time = 860
* CHECK dout1_13 vdout1_13ck85 = 1.8 time = 860
* CHECK dout1_14 vdout1_14ck85 = 0 time = 860
* CHECK dout1_15 vdout1_15ck85 = 0 time = 860
* CHECK dout1_16 vdout1_16ck85 = 1.8 time = 860
* CHECK dout1_17 vdout1_17ck85 = 0 time = 860
* CHECK dout1_18 vdout1_18ck85 = 1.8 time = 860
* CHECK dout1_19 vdout1_19ck85 = 1.8 time = 860
* CHECK dout1_20 vdout1_20ck85 = 1.8 time = 860
* CHECK dout1_21 vdout1_21ck85 = 1.8 time = 860
* CHECK dout1_22 vdout1_22ck85 = 1.8 time = 860
* CHECK dout1_23 vdout1_23ck85 = 0 time = 860
* CHECK dout1_24 vdout1_24ck85 = 0 time = 860
* CHECK dout1_25 vdout1_25ck85 = 1.8 time = 860
* CHECK dout1_26 vdout1_26ck85 = 1.8 time = 860
* CHECK dout1_27 vdout1_27ck85 = 1.8 time = 860
* CHECK dout1_28 vdout1_28ck85 = 1.8 time = 860
* CHECK dout1_29 vdout1_29ck85 = 0 time = 860
* CHECK dout1_30 vdout1_30ck85 = 1.8 time = 860
* CHECK dout1_31 vdout1_31ck85 = 1.8 time = 860
* CHECK dout0_0 vdout0_0ck88 = 0 time = 890
* CHECK dout0_1 vdout0_1ck88 = 1.8 time = 890
* CHECK dout0_2 vdout0_2ck88 = 0 time = 890
* CHECK dout0_3 vdout0_3ck88 = 0 time = 890
* CHECK dout0_4 vdout0_4ck88 = 1.8 time = 890
* CHECK dout0_5 vdout0_5ck88 = 0 time = 890
* CHECK dout0_6 vdout0_6ck88 = 0 time = 890
* CHECK dout0_7 vdout0_7ck88 = 1.8 time = 890
* CHECK dout0_8 vdout0_8ck88 = 1.8 time = 890
* CHECK dout0_9 vdout0_9ck88 = 0 time = 890
* CHECK dout0_10 vdout0_10ck88 = 1.8 time = 890
* CHECK dout0_11 vdout0_11ck88 = 0 time = 890
* CHECK dout0_12 vdout0_12ck88 = 0 time = 890
* CHECK dout0_13 vdout0_13ck88 = 1.8 time = 890
* CHECK dout0_14 vdout0_14ck88 = 0 time = 890
* CHECK dout0_15 vdout0_15ck88 = 0 time = 890
* CHECK dout0_16 vdout0_16ck88 = 1.8 time = 890
* CHECK dout0_17 vdout0_17ck88 = 0 time = 890
* CHECK dout0_18 vdout0_18ck88 = 1.8 time = 890
* CHECK dout0_19 vdout0_19ck88 = 1.8 time = 890
* CHECK dout0_20 vdout0_20ck88 = 1.8 time = 890
* CHECK dout0_21 vdout0_21ck88 = 1.8 time = 890
* CHECK dout0_22 vdout0_22ck88 = 1.8 time = 890
* CHECK dout0_23 vdout0_23ck88 = 0 time = 890
* CHECK dout0_24 vdout0_24ck88 = 0 time = 890
* CHECK dout0_25 vdout0_25ck88 = 1.8 time = 890
* CHECK dout0_26 vdout0_26ck88 = 1.8 time = 890
* CHECK dout0_27 vdout0_27ck88 = 1.8 time = 890
* CHECK dout0_28 vdout0_28ck88 = 1.8 time = 890
* CHECK dout0_29 vdout0_29ck88 = 0 time = 890
* CHECK dout0_30 vdout0_30ck88 = 1.8 time = 890
* CHECK dout0_31 vdout0_31ck88 = 1.8 time = 890
* CHECK dout1_0 vdout1_0ck88 = 0 time = 890
* CHECK dout1_1 vdout1_1ck88 = 1.8 time = 890
* CHECK dout1_2 vdout1_2ck88 = 0 time = 890
* CHECK dout1_3 vdout1_3ck88 = 0 time = 890
* CHECK dout1_4 vdout1_4ck88 = 1.8 time = 890
* CHECK dout1_5 vdout1_5ck88 = 0 time = 890
* CHECK dout1_6 vdout1_6ck88 = 0 time = 890
* CHECK dout1_7 vdout1_7ck88 = 1.8 time = 890
* CHECK dout1_8 vdout1_8ck88 = 1.8 time = 890
* CHECK dout1_9 vdout1_9ck88 = 0 time = 890
* CHECK dout1_10 vdout1_10ck88 = 1.8 time = 890
* CHECK dout1_11 vdout1_11ck88 = 0 time = 890
* CHECK dout1_12 vdout1_12ck88 = 0 time = 890
* CHECK dout1_13 vdout1_13ck88 = 1.8 time = 890
* CHECK dout1_14 vdout1_14ck88 = 0 time = 890
* CHECK dout1_15 vdout1_15ck88 = 0 time = 890
* CHECK dout1_16 vdout1_16ck88 = 1.8 time = 890
* CHECK dout1_17 vdout1_17ck88 = 0 time = 890
* CHECK dout1_18 vdout1_18ck88 = 1.8 time = 890
* CHECK dout1_19 vdout1_19ck88 = 1.8 time = 890
* CHECK dout1_20 vdout1_20ck88 = 1.8 time = 890
* CHECK dout1_21 vdout1_21ck88 = 1.8 time = 890
* CHECK dout1_22 vdout1_22ck88 = 1.8 time = 890
* CHECK dout1_23 vdout1_23ck88 = 0 time = 890
* CHECK dout1_24 vdout1_24ck88 = 0 time = 890
* CHECK dout1_25 vdout1_25ck88 = 1.8 time = 890
* CHECK dout1_26 vdout1_26ck88 = 1.8 time = 890
* CHECK dout1_27 vdout1_27ck88 = 1.8 time = 890
* CHECK dout1_28 vdout1_28ck88 = 1.8 time = 890
* CHECK dout1_29 vdout1_29ck88 = 0 time = 890
* CHECK dout1_30 vdout1_30ck88 = 1.8 time = 890
* CHECK dout1_31 vdout1_31ck88 = 1.8 time = 890
* CHECK dout0_0 vdout0_0ck89 = 1.8 time = 900
* CHECK dout0_1 vdout0_1ck89 = 0 time = 900
* CHECK dout0_2 vdout0_2ck89 = 1.8 time = 900
* CHECK dout0_3 vdout0_3ck89 = 1.8 time = 900
* CHECK dout0_4 vdout0_4ck89 = 1.8 time = 900
* CHECK dout0_5 vdout0_5ck89 = 0 time = 900
* CHECK dout0_6 vdout0_6ck89 = 1.8 time = 900
* CHECK dout0_7 vdout0_7ck89 = 1.8 time = 900
* CHECK dout0_8 vdout0_8ck89 = 0 time = 900
* CHECK dout0_9 vdout0_9ck89 = 1.8 time = 900
* CHECK dout0_10 vdout0_10ck89 = 0 time = 900
* CHECK dout0_11 vdout0_11ck89 = 1.8 time = 900
* CHECK dout0_12 vdout0_12ck89 = 1.8 time = 900
* CHECK dout0_13 vdout0_13ck89 = 1.8 time = 900
* CHECK dout0_14 vdout0_14ck89 = 0 time = 900
* CHECK dout0_15 vdout0_15ck89 = 1.8 time = 900
* CHECK dout0_16 vdout0_16ck89 = 1.8 time = 900
* CHECK dout0_17 vdout0_17ck89 = 0 time = 900
* CHECK dout0_18 vdout0_18ck89 = 0 time = 900
* CHECK dout0_19 vdout0_19ck89 = 1.8 time = 900
* CHECK dout0_20 vdout0_20ck89 = 1.8 time = 900
* CHECK dout0_21 vdout0_21ck89 = 1.8 time = 900
* CHECK dout0_22 vdout0_22ck89 = 0 time = 900
* CHECK dout0_23 vdout0_23ck89 = 0 time = 900
* CHECK dout0_24 vdout0_24ck89 = 0 time = 900
* CHECK dout0_25 vdout0_25ck89 = 0 time = 900
* CHECK dout0_26 vdout0_26ck89 = 0 time = 900
* CHECK dout0_27 vdout0_27ck89 = 1.8 time = 900
* CHECK dout0_28 vdout0_28ck89 = 1.8 time = 900
* CHECK dout0_29 vdout0_29ck89 = 0 time = 900
* CHECK dout0_30 vdout0_30ck89 = 0 time = 900
* CHECK dout0_31 vdout0_31ck89 = 1.8 time = 900
* CHECK dout1_0 vdout1_0ck90 = 1.8 time = 910
* CHECK dout1_1 vdout1_1ck90 = 0 time = 910
* CHECK dout1_2 vdout1_2ck90 = 1.8 time = 910
* CHECK dout1_3 vdout1_3ck90 = 1.8 time = 910
* CHECK dout1_4 vdout1_4ck90 = 1.8 time = 910
* CHECK dout1_5 vdout1_5ck90 = 0 time = 910
* CHECK dout1_6 vdout1_6ck90 = 1.8 time = 910
* CHECK dout1_7 vdout1_7ck90 = 1.8 time = 910
* CHECK dout1_8 vdout1_8ck90 = 0 time = 910
* CHECK dout1_9 vdout1_9ck90 = 1.8 time = 910
* CHECK dout1_10 vdout1_10ck90 = 0 time = 910
* CHECK dout1_11 vdout1_11ck90 = 1.8 time = 910
* CHECK dout1_12 vdout1_12ck90 = 1.8 time = 910
* CHECK dout1_13 vdout1_13ck90 = 1.8 time = 910
* CHECK dout1_14 vdout1_14ck90 = 0 time = 910
* CHECK dout1_15 vdout1_15ck90 = 1.8 time = 910
* CHECK dout1_16 vdout1_16ck90 = 1.8 time = 910
* CHECK dout1_17 vdout1_17ck90 = 0 time = 910
* CHECK dout1_18 vdout1_18ck90 = 0 time = 910
* CHECK dout1_19 vdout1_19ck90 = 1.8 time = 910
* CHECK dout1_20 vdout1_20ck90 = 1.8 time = 910
* CHECK dout1_21 vdout1_21ck90 = 1.8 time = 910
* CHECK dout1_22 vdout1_22ck90 = 0 time = 910
* CHECK dout1_23 vdout1_23ck90 = 0 time = 910
* CHECK dout1_24 vdout1_24ck90 = 0 time = 910
* CHECK dout1_25 vdout1_25ck90 = 0 time = 910
* CHECK dout1_26 vdout1_26ck90 = 0 time = 910
* CHECK dout1_27 vdout1_27ck90 = 1.8 time = 910
* CHECK dout1_28 vdout1_28ck90 = 1.8 time = 910
* CHECK dout1_29 vdout1_29ck90 = 0 time = 910
* CHECK dout1_30 vdout1_30ck90 = 0 time = 910
* CHECK dout1_31 vdout1_31ck90 = 1.8 time = 910
* CHECK dout0_0 vdout0_0ck92 = 0 time = 930
* CHECK dout0_1 vdout0_1ck92 = 1.8 time = 930
* CHECK dout0_2 vdout0_2ck92 = 0 time = 930
* CHECK dout0_3 vdout0_3ck92 = 0 time = 930
* CHECK dout0_4 vdout0_4ck92 = 1.8 time = 930
* CHECK dout0_5 vdout0_5ck92 = 0 time = 930
* CHECK dout0_6 vdout0_6ck92 = 0 time = 930
* CHECK dout0_7 vdout0_7ck92 = 1.8 time = 930
* CHECK dout0_8 vdout0_8ck92 = 1.8 time = 930
* CHECK dout0_9 vdout0_9ck92 = 0 time = 930
* CHECK dout0_10 vdout0_10ck92 = 1.8 time = 930
* CHECK dout0_11 vdout0_11ck92 = 0 time = 930
* CHECK dout0_12 vdout0_12ck92 = 0 time = 930
* CHECK dout0_13 vdout0_13ck92 = 1.8 time = 930
* CHECK dout0_14 vdout0_14ck92 = 0 time = 930
* CHECK dout0_15 vdout0_15ck92 = 0 time = 930
* CHECK dout0_16 vdout0_16ck92 = 1.8 time = 930
* CHECK dout0_17 vdout0_17ck92 = 0 time = 930
* CHECK dout0_18 vdout0_18ck92 = 1.8 time = 930
* CHECK dout0_19 vdout0_19ck92 = 1.8 time = 930
* CHECK dout0_20 vdout0_20ck92 = 1.8 time = 930
* CHECK dout0_21 vdout0_21ck92 = 1.8 time = 930
* CHECK dout0_22 vdout0_22ck92 = 1.8 time = 930
* CHECK dout0_23 vdout0_23ck92 = 0 time = 930
* CHECK dout0_24 vdout0_24ck92 = 0 time = 930
* CHECK dout0_25 vdout0_25ck92 = 1.8 time = 930
* CHECK dout0_26 vdout0_26ck92 = 1.8 time = 930
* CHECK dout0_27 vdout0_27ck92 = 1.8 time = 930
* CHECK dout0_28 vdout0_28ck92 = 1.8 time = 930
* CHECK dout0_29 vdout0_29ck92 = 0 time = 930
* CHECK dout0_30 vdout0_30ck92 = 1.8 time = 930
* CHECK dout0_31 vdout0_31ck92 = 1.8 time = 930
* CHECK dout1_0 vdout1_0ck92 = 0 time = 930
* CHECK dout1_1 vdout1_1ck92 = 1.8 time = 930
* CHECK dout1_2 vdout1_2ck92 = 0 time = 930
* CHECK dout1_3 vdout1_3ck92 = 0 time = 930
* CHECK dout1_4 vdout1_4ck92 = 1.8 time = 930
* CHECK dout1_5 vdout1_5ck92 = 0 time = 930
* CHECK dout1_6 vdout1_6ck92 = 0 time = 930
* CHECK dout1_7 vdout1_7ck92 = 1.8 time = 930
* CHECK dout1_8 vdout1_8ck92 = 1.8 time = 930
* CHECK dout1_9 vdout1_9ck92 = 0 time = 930
* CHECK dout1_10 vdout1_10ck92 = 1.8 time = 930
* CHECK dout1_11 vdout1_11ck92 = 0 time = 930
* CHECK dout1_12 vdout1_12ck92 = 0 time = 930
* CHECK dout1_13 vdout1_13ck92 = 1.8 time = 930
* CHECK dout1_14 vdout1_14ck92 = 0 time = 930
* CHECK dout1_15 vdout1_15ck92 = 0 time = 930
* CHECK dout1_16 vdout1_16ck92 = 1.8 time = 930
* CHECK dout1_17 vdout1_17ck92 = 0 time = 930
* CHECK dout1_18 vdout1_18ck92 = 1.8 time = 930
* CHECK dout1_19 vdout1_19ck92 = 1.8 time = 930
* CHECK dout1_20 vdout1_20ck92 = 1.8 time = 930
* CHECK dout1_21 vdout1_21ck92 = 1.8 time = 930
* CHECK dout1_22 vdout1_22ck92 = 1.8 time = 930
* CHECK dout1_23 vdout1_23ck92 = 0 time = 930
* CHECK dout1_24 vdout1_24ck92 = 0 time = 930
* CHECK dout1_25 vdout1_25ck92 = 1.8 time = 930
* CHECK dout1_26 vdout1_26ck92 = 1.8 time = 930
* CHECK dout1_27 vdout1_27ck92 = 1.8 time = 930
* CHECK dout1_28 vdout1_28ck92 = 1.8 time = 930
* CHECK dout1_29 vdout1_29ck92 = 0 time = 930
* CHECK dout1_30 vdout1_30ck92 = 1.8 time = 930
* CHECK dout1_31 vdout1_31ck92 = 1.8 time = 930
* CHECK dout0_0 vdout0_0ck97 = 1.8 time = 980
* CHECK dout0_1 vdout0_1ck97 = 0 time = 980
* CHECK dout0_2 vdout0_2ck97 = 1.8 time = 980
* CHECK dout0_3 vdout0_3ck97 = 1.8 time = 980
* CHECK dout0_4 vdout0_4ck97 = 1.8 time = 980
* CHECK dout0_5 vdout0_5ck97 = 0 time = 980
* CHECK dout0_6 vdout0_6ck97 = 1.8 time = 980
* CHECK dout0_7 vdout0_7ck97 = 1.8 time = 980
* CHECK dout0_8 vdout0_8ck97 = 0 time = 980
* CHECK dout0_9 vdout0_9ck97 = 1.8 time = 980
* CHECK dout0_10 vdout0_10ck97 = 0 time = 980
* CHECK dout0_11 vdout0_11ck97 = 1.8 time = 980
* CHECK dout0_12 vdout0_12ck97 = 1.8 time = 980
* CHECK dout0_13 vdout0_13ck97 = 1.8 time = 980
* CHECK dout0_14 vdout0_14ck97 = 0 time = 980
* CHECK dout0_15 vdout0_15ck97 = 1.8 time = 980
* CHECK dout0_16 vdout0_16ck97 = 1.8 time = 980
* CHECK dout0_17 vdout0_17ck97 = 0 time = 980
* CHECK dout0_18 vdout0_18ck97 = 0 time = 980
* CHECK dout0_19 vdout0_19ck97 = 1.8 time = 980
* CHECK dout0_20 vdout0_20ck97 = 1.8 time = 980
* CHECK dout0_21 vdout0_21ck97 = 1.8 time = 980
* CHECK dout0_22 vdout0_22ck97 = 0 time = 980
* CHECK dout0_23 vdout0_23ck97 = 0 time = 980
* CHECK dout0_24 vdout0_24ck97 = 0 time = 980
* CHECK dout0_25 vdout0_25ck97 = 0 time = 980
* CHECK dout0_26 vdout0_26ck97 = 0 time = 980
* CHECK dout0_27 vdout0_27ck97 = 1.8 time = 980
* CHECK dout0_28 vdout0_28ck97 = 1.8 time = 980
* CHECK dout0_29 vdout0_29ck97 = 0 time = 980
* CHECK dout0_30 vdout0_30ck97 = 0 time = 980
* CHECK dout0_31 vdout0_31ck97 = 1.8 time = 980
* CHECK dout0_0 vdout0_0ck98 = 1.8 time = 990
* CHECK dout0_1 vdout0_1ck98 = 1.8 time = 990
* CHECK dout0_2 vdout0_2ck98 = 0 time = 990
* CHECK dout0_3 vdout0_3ck98 = 0 time = 990
* CHECK dout0_4 vdout0_4ck98 = 0 time = 990
* CHECK dout0_5 vdout0_5ck98 = 0 time = 990
* CHECK dout0_6 vdout0_6ck98 = 0 time = 990
* CHECK dout0_7 vdout0_7ck98 = 0 time = 990
* CHECK dout0_8 vdout0_8ck98 = 0 time = 990
* CHECK dout0_9 vdout0_9ck98 = 1.8 time = 990
* CHECK dout0_10 vdout0_10ck98 = 1.8 time = 990
* CHECK dout0_11 vdout0_11ck98 = 1.8 time = 990
* CHECK dout0_12 vdout0_12ck98 = 1.8 time = 990
* CHECK dout0_13 vdout0_13ck98 = 0 time = 990
* CHECK dout0_14 vdout0_14ck98 = 0 time = 990
* CHECK dout0_15 vdout0_15ck98 = 1.8 time = 990
* CHECK dout0_16 vdout0_16ck98 = 1.8 time = 990
* CHECK dout0_17 vdout0_17ck98 = 1.8 time = 990
* CHECK dout0_18 vdout0_18ck98 = 1.8 time = 990
* CHECK dout0_19 vdout0_19ck98 = 0 time = 990
* CHECK dout0_20 vdout0_20ck98 = 1.8 time = 990
* CHECK dout0_21 vdout0_21ck98 = 1.8 time = 990
* CHECK dout0_22 vdout0_22ck98 = 0 time = 990
* CHECK dout0_23 vdout0_23ck98 = 0 time = 990
* CHECK dout0_24 vdout0_24ck98 = 1.8 time = 990
* CHECK dout0_25 vdout0_25ck98 = 0 time = 990
* CHECK dout0_26 vdout0_26ck98 = 0 time = 990
* CHECK dout0_27 vdout0_27ck98 = 1.8 time = 990
* CHECK dout0_28 vdout0_28ck98 = 0 time = 990
* CHECK dout0_29 vdout0_29ck98 = 1.8 time = 990
* CHECK dout0_30 vdout0_30ck98 = 0 time = 990
* CHECK dout0_31 vdout0_31ck98 = 0 time = 990
* CHECK dout0_0 vdout0_0ck99 = 1.8 time = 1000
* CHECK dout0_1 vdout0_1ck99 = 1.8 time = 1000
* CHECK dout0_2 vdout0_2ck99 = 0 time = 1000
* CHECK dout0_3 vdout0_3ck99 = 0 time = 1000
* CHECK dout0_4 vdout0_4ck99 = 0 time = 1000
* CHECK dout0_5 vdout0_5ck99 = 0 time = 1000
* CHECK dout0_6 vdout0_6ck99 = 0 time = 1000
* CHECK dout0_7 vdout0_7ck99 = 0 time = 1000
* CHECK dout0_8 vdout0_8ck99 = 0 time = 1000
* CHECK dout0_9 vdout0_9ck99 = 1.8 time = 1000
* CHECK dout0_10 vdout0_10ck99 = 1.8 time = 1000
* CHECK dout0_11 vdout0_11ck99 = 1.8 time = 1000
* CHECK dout0_12 vdout0_12ck99 = 1.8 time = 1000
* CHECK dout0_13 vdout0_13ck99 = 0 time = 1000
* CHECK dout0_14 vdout0_14ck99 = 0 time = 1000
* CHECK dout0_15 vdout0_15ck99 = 1.8 time = 1000
* CHECK dout0_16 vdout0_16ck99 = 1.8 time = 1000
* CHECK dout0_17 vdout0_17ck99 = 1.8 time = 1000
* CHECK dout0_18 vdout0_18ck99 = 1.8 time = 1000
* CHECK dout0_19 vdout0_19ck99 = 0 time = 1000
* CHECK dout0_20 vdout0_20ck99 = 1.8 time = 1000
* CHECK dout0_21 vdout0_21ck99 = 1.8 time = 1000
* CHECK dout0_22 vdout0_22ck99 = 0 time = 1000
* CHECK dout0_23 vdout0_23ck99 = 0 time = 1000
* CHECK dout0_24 vdout0_24ck99 = 1.8 time = 1000
* CHECK dout0_25 vdout0_25ck99 = 0 time = 1000
* CHECK dout0_26 vdout0_26ck99 = 0 time = 1000
* CHECK dout0_27 vdout0_27ck99 = 1.8 time = 1000
* CHECK dout0_28 vdout0_28ck99 = 0 time = 1000
* CHECK dout0_29 vdout0_29ck99 = 1.8 time = 1000
* CHECK dout0_30 vdout0_30ck99 = 0 time = 1000
* CHECK dout0_31 vdout0_31ck99 = 0 time = 1000
* CHECK dout1_0 vdout1_0ck99 = 1.8 time = 1000
* CHECK dout1_1 vdout1_1ck99 = 0 time = 1000
* CHECK dout1_2 vdout1_2ck99 = 1.8 time = 1000
* CHECK dout1_3 vdout1_3ck99 = 1.8 time = 1000
* CHECK dout1_4 vdout1_4ck99 = 1.8 time = 1000
* CHECK dout1_5 vdout1_5ck99 = 0 time = 1000
* CHECK dout1_6 vdout1_6ck99 = 1.8 time = 1000
* CHECK dout1_7 vdout1_7ck99 = 1.8 time = 1000
* CHECK dout1_8 vdout1_8ck99 = 0 time = 1000
* CHECK dout1_9 vdout1_9ck99 = 1.8 time = 1000
* CHECK dout1_10 vdout1_10ck99 = 0 time = 1000
* CHECK dout1_11 vdout1_11ck99 = 1.8 time = 1000
* CHECK dout1_12 vdout1_12ck99 = 1.8 time = 1000
* CHECK dout1_13 vdout1_13ck99 = 1.8 time = 1000
* CHECK dout1_14 vdout1_14ck99 = 0 time = 1000
* CHECK dout1_15 vdout1_15ck99 = 1.8 time = 1000
* CHECK dout1_16 vdout1_16ck99 = 1.8 time = 1000
* CHECK dout1_17 vdout1_17ck99 = 0 time = 1000
* CHECK dout1_18 vdout1_18ck99 = 0 time = 1000
* CHECK dout1_19 vdout1_19ck99 = 1.8 time = 1000
* CHECK dout1_20 vdout1_20ck99 = 1.8 time = 1000
* CHECK dout1_21 vdout1_21ck99 = 1.8 time = 1000
* CHECK dout1_22 vdout1_22ck99 = 0 time = 1000
* CHECK dout1_23 vdout1_23ck99 = 0 time = 1000
* CHECK dout1_24 vdout1_24ck99 = 0 time = 1000
* CHECK dout1_25 vdout1_25ck99 = 0 time = 1000
* CHECK dout1_26 vdout1_26ck99 = 0 time = 1000
* CHECK dout1_27 vdout1_27ck99 = 1.8 time = 1000
* CHECK dout1_28 vdout1_28ck99 = 1.8 time = 1000
* CHECK dout1_29 vdout1_29ck99 = 0 time = 1000
* CHECK dout1_30 vdout1_30ck99 = 0 time = 1000
* CHECK dout1_31 vdout1_31ck99 = 1.8 time = 1000
* CHECK dout1_0 vdout1_0ck101 = 1.8 time = 1020
* CHECK dout1_1 vdout1_1ck101 = 0 time = 1020
* CHECK dout1_2 vdout1_2ck101 = 1.8 time = 1020
* CHECK dout1_3 vdout1_3ck101 = 1.8 time = 1020
* CHECK dout1_4 vdout1_4ck101 = 1.8 time = 1020
* CHECK dout1_5 vdout1_5ck101 = 0 time = 1020
* CHECK dout1_6 vdout1_6ck101 = 1.8 time = 1020
* CHECK dout1_7 vdout1_7ck101 = 1.8 time = 1020
* CHECK dout1_8 vdout1_8ck101 = 0 time = 1020
* CHECK dout1_9 vdout1_9ck101 = 1.8 time = 1020
* CHECK dout1_10 vdout1_10ck101 = 0 time = 1020
* CHECK dout1_11 vdout1_11ck101 = 1.8 time = 1020
* CHECK dout1_12 vdout1_12ck101 = 1.8 time = 1020
* CHECK dout1_13 vdout1_13ck101 = 1.8 time = 1020
* CHECK dout1_14 vdout1_14ck101 = 0 time = 1020
* CHECK dout1_15 vdout1_15ck101 = 1.8 time = 1020
* CHECK dout1_16 vdout1_16ck101 = 1.8 time = 1020
* CHECK dout1_17 vdout1_17ck101 = 0 time = 1020
* CHECK dout1_18 vdout1_18ck101 = 0 time = 1020
* CHECK dout1_19 vdout1_19ck101 = 1.8 time = 1020
* CHECK dout1_20 vdout1_20ck101 = 1.8 time = 1020
* CHECK dout1_21 vdout1_21ck101 = 1.8 time = 1020
* CHECK dout1_22 vdout1_22ck101 = 0 time = 1020
* CHECK dout1_23 vdout1_23ck101 = 0 time = 1020
* CHECK dout1_24 vdout1_24ck101 = 0 time = 1020
* CHECK dout1_25 vdout1_25ck101 = 0 time = 1020
* CHECK dout1_26 vdout1_26ck101 = 0 time = 1020
* CHECK dout1_27 vdout1_27ck101 = 1.8 time = 1020
* CHECK dout1_28 vdout1_28ck101 = 1.8 time = 1020
* CHECK dout1_29 vdout1_29ck101 = 0 time = 1020
* CHECK dout1_30 vdout1_30ck101 = 0 time = 1020
* CHECK dout1_31 vdout1_31ck101 = 1.8 time = 1020
* CHECK dout0_0 vdout0_0ck102 = 1.8 time = 1030
* CHECK dout0_1 vdout0_1ck102 = 1.8 time = 1030
* CHECK dout0_2 vdout0_2ck102 = 0 time = 1030
* CHECK dout0_3 vdout0_3ck102 = 0 time = 1030
* CHECK dout0_4 vdout0_4ck102 = 0 time = 1030
* CHECK dout0_5 vdout0_5ck102 = 0 time = 1030
* CHECK dout0_6 vdout0_6ck102 = 0 time = 1030
* CHECK dout0_7 vdout0_7ck102 = 0 time = 1030
* CHECK dout0_8 vdout0_8ck102 = 0 time = 1030
* CHECK dout0_9 vdout0_9ck102 = 1.8 time = 1030
* CHECK dout0_10 vdout0_10ck102 = 1.8 time = 1030
* CHECK dout0_11 vdout0_11ck102 = 1.8 time = 1030
* CHECK dout0_12 vdout0_12ck102 = 1.8 time = 1030
* CHECK dout0_13 vdout0_13ck102 = 0 time = 1030
* CHECK dout0_14 vdout0_14ck102 = 0 time = 1030
* CHECK dout0_15 vdout0_15ck102 = 1.8 time = 1030
* CHECK dout0_16 vdout0_16ck102 = 1.8 time = 1030
* CHECK dout0_17 vdout0_17ck102 = 1.8 time = 1030
* CHECK dout0_18 vdout0_18ck102 = 1.8 time = 1030
* CHECK dout0_19 vdout0_19ck102 = 0 time = 1030
* CHECK dout0_20 vdout0_20ck102 = 1.8 time = 1030
* CHECK dout0_21 vdout0_21ck102 = 1.8 time = 1030
* CHECK dout0_22 vdout0_22ck102 = 0 time = 1030
* CHECK dout0_23 vdout0_23ck102 = 0 time = 1030
* CHECK dout0_24 vdout0_24ck102 = 1.8 time = 1030
* CHECK dout0_25 vdout0_25ck102 = 0 time = 1030
* CHECK dout0_26 vdout0_26ck102 = 0 time = 1030
* CHECK dout0_27 vdout0_27ck102 = 1.8 time = 1030
* CHECK dout0_28 vdout0_28ck102 = 0 time = 1030
* CHECK dout0_29 vdout0_29ck102 = 1.8 time = 1030
* CHECK dout0_30 vdout0_30ck102 = 0 time = 1030
* CHECK dout0_31 vdout0_31ck102 = 0 time = 1030
* CHECK dout1_0 vdout1_0ck102 = 1.8 time = 1030
* CHECK dout1_1 vdout1_1ck102 = 1.8 time = 1030
* CHECK dout1_2 vdout1_2ck102 = 0 time = 1030
* CHECK dout1_3 vdout1_3ck102 = 0 time = 1030
* CHECK dout1_4 vdout1_4ck102 = 0 time = 1030
* CHECK dout1_5 vdout1_5ck102 = 0 time = 1030
* CHECK dout1_6 vdout1_6ck102 = 0 time = 1030
* CHECK dout1_7 vdout1_7ck102 = 0 time = 1030
* CHECK dout1_8 vdout1_8ck102 = 0 time = 1030
* CHECK dout1_9 vdout1_9ck102 = 1.8 time = 1030
* CHECK dout1_10 vdout1_10ck102 = 1.8 time = 1030
* CHECK dout1_11 vdout1_11ck102 = 1.8 time = 1030
* CHECK dout1_12 vdout1_12ck102 = 1.8 time = 1030
* CHECK dout1_13 vdout1_13ck102 = 0 time = 1030
* CHECK dout1_14 vdout1_14ck102 = 0 time = 1030
* CHECK dout1_15 vdout1_15ck102 = 1.8 time = 1030
* CHECK dout1_16 vdout1_16ck102 = 1.8 time = 1030
* CHECK dout1_17 vdout1_17ck102 = 1.8 time = 1030
* CHECK dout1_18 vdout1_18ck102 = 1.8 time = 1030
* CHECK dout1_19 vdout1_19ck102 = 0 time = 1030
* CHECK dout1_20 vdout1_20ck102 = 1.8 time = 1030
* CHECK dout1_21 vdout1_21ck102 = 1.8 time = 1030
* CHECK dout1_22 vdout1_22ck102 = 0 time = 1030
* CHECK dout1_23 vdout1_23ck102 = 0 time = 1030
* CHECK dout1_24 vdout1_24ck102 = 1.8 time = 1030
* CHECK dout1_25 vdout1_25ck102 = 0 time = 1030
* CHECK dout1_26 vdout1_26ck102 = 0 time = 1030
* CHECK dout1_27 vdout1_27ck102 = 1.8 time = 1030
* CHECK dout1_28 vdout1_28ck102 = 0 time = 1030
* CHECK dout1_29 vdout1_29ck102 = 1.8 time = 1030
* CHECK dout1_30 vdout1_30ck102 = 0 time = 1030
* CHECK dout1_31 vdout1_31ck102 = 0 time = 1030
* CHECK dout1_0 vdout1_0ck104 = 1.8 time = 1050
* CHECK dout1_1 vdout1_1ck104 = 1.8 time = 1050
* CHECK dout1_2 vdout1_2ck104 = 0 time = 1050
* CHECK dout1_3 vdout1_3ck104 = 0 time = 1050
* CHECK dout1_4 vdout1_4ck104 = 0 time = 1050
* CHECK dout1_5 vdout1_5ck104 = 0 time = 1050
* CHECK dout1_6 vdout1_6ck104 = 0 time = 1050
* CHECK dout1_7 vdout1_7ck104 = 0 time = 1050
* CHECK dout1_8 vdout1_8ck104 = 0 time = 1050
* CHECK dout1_9 vdout1_9ck104 = 1.8 time = 1050
* CHECK dout1_10 vdout1_10ck104 = 1.8 time = 1050
* CHECK dout1_11 vdout1_11ck104 = 1.8 time = 1050
* CHECK dout1_12 vdout1_12ck104 = 1.8 time = 1050
* CHECK dout1_13 vdout1_13ck104 = 0 time = 1050
* CHECK dout1_14 vdout1_14ck104 = 0 time = 1050
* CHECK dout1_15 vdout1_15ck104 = 1.8 time = 1050
* CHECK dout1_16 vdout1_16ck104 = 1.8 time = 1050
* CHECK dout1_17 vdout1_17ck104 = 1.8 time = 1050
* CHECK dout1_18 vdout1_18ck104 = 1.8 time = 1050
* CHECK dout1_19 vdout1_19ck104 = 0 time = 1050
* CHECK dout1_20 vdout1_20ck104 = 1.8 time = 1050
* CHECK dout1_21 vdout1_21ck104 = 1.8 time = 1050
* CHECK dout1_22 vdout1_22ck104 = 0 time = 1050
* CHECK dout1_23 vdout1_23ck104 = 0 time = 1050
* CHECK dout1_24 vdout1_24ck104 = 1.8 time = 1050
* CHECK dout1_25 vdout1_25ck104 = 0 time = 1050
* CHECK dout1_26 vdout1_26ck104 = 0 time = 1050
* CHECK dout1_27 vdout1_27ck104 = 1.8 time = 1050
* CHECK dout1_28 vdout1_28ck104 = 0 time = 1050
* CHECK dout1_29 vdout1_29ck104 = 1.8 time = 1050
* CHECK dout1_30 vdout1_30ck104 = 0 time = 1050
* CHECK dout1_31 vdout1_31ck104 = 0 time = 1050
* CHECK dout0_0 vdout0_0ck108 = 1.8 time = 1090
* CHECK dout0_1 vdout0_1ck108 = 1.8 time = 1090
* CHECK dout0_2 vdout0_2ck108 = 0 time = 1090
* CHECK dout0_3 vdout0_3ck108 = 0 time = 1090
* CHECK dout0_4 vdout0_4ck108 = 0 time = 1090
* CHECK dout0_5 vdout0_5ck108 = 0 time = 1090
* CHECK dout0_6 vdout0_6ck108 = 0 time = 1090
* CHECK dout0_7 vdout0_7ck108 = 0 time = 1090
* CHECK dout0_8 vdout0_8ck108 = 0 time = 1090
* CHECK dout0_9 vdout0_9ck108 = 1.8 time = 1090
* CHECK dout0_10 vdout0_10ck108 = 1.8 time = 1090
* CHECK dout0_11 vdout0_11ck108 = 1.8 time = 1090
* CHECK dout0_12 vdout0_12ck108 = 1.8 time = 1090
* CHECK dout0_13 vdout0_13ck108 = 0 time = 1090
* CHECK dout0_14 vdout0_14ck108 = 0 time = 1090
* CHECK dout0_15 vdout0_15ck108 = 1.8 time = 1090
* CHECK dout0_16 vdout0_16ck108 = 1.8 time = 1090
* CHECK dout0_17 vdout0_17ck108 = 1.8 time = 1090
* CHECK dout0_18 vdout0_18ck108 = 1.8 time = 1090
* CHECK dout0_19 vdout0_19ck108 = 0 time = 1090
* CHECK dout0_20 vdout0_20ck108 = 1.8 time = 1090
* CHECK dout0_21 vdout0_21ck108 = 1.8 time = 1090
* CHECK dout0_22 vdout0_22ck108 = 0 time = 1090
* CHECK dout0_23 vdout0_23ck108 = 0 time = 1090
* CHECK dout0_24 vdout0_24ck108 = 1.8 time = 1090
* CHECK dout0_25 vdout0_25ck108 = 0 time = 1090
* CHECK dout0_26 vdout0_26ck108 = 0 time = 1090
* CHECK dout0_27 vdout0_27ck108 = 1.8 time = 1090
* CHECK dout0_28 vdout0_28ck108 = 0 time = 1090
* CHECK dout0_29 vdout0_29ck108 = 1.8 time = 1090
* CHECK dout0_30 vdout0_30ck108 = 0 time = 1090
* CHECK dout0_31 vdout0_31ck108 = 0 time = 1090
* CHECK dout0_0 vdout0_0ck110 = 0 time = 1110
* CHECK dout0_1 vdout0_1ck110 = 0 time = 1110
* CHECK dout0_2 vdout0_2ck110 = 0 time = 1110
* CHECK dout0_3 vdout0_3ck110 = 1.8 time = 1110
* CHECK dout0_4 vdout0_4ck110 = 0 time = 1110
* CHECK dout0_5 vdout0_5ck110 = 1.8 time = 1110
* CHECK dout0_6 vdout0_6ck110 = 1.8 time = 1110
* CHECK dout0_7 vdout0_7ck110 = 0 time = 1110
* CHECK dout0_8 vdout0_8ck110 = 1.8 time = 1110
* CHECK dout0_9 vdout0_9ck110 = 0 time = 1110
* CHECK dout0_10 vdout0_10ck110 = 1.8 time = 1110
* CHECK dout0_11 vdout0_11ck110 = 0 time = 1110
* CHECK dout0_12 vdout0_12ck110 = 1.8 time = 1110
* CHECK dout0_13 vdout0_13ck110 = 0 time = 1110
* CHECK dout0_14 vdout0_14ck110 = 1.8 time = 1110
* CHECK dout0_15 vdout0_15ck110 = 0 time = 1110
* CHECK dout0_16 vdout0_16ck110 = 0 time = 1110
* CHECK dout0_17 vdout0_17ck110 = 1.8 time = 1110
* CHECK dout0_18 vdout0_18ck110 = 0 time = 1110
* CHECK dout0_19 vdout0_19ck110 = 0 time = 1110
* CHECK dout0_20 vdout0_20ck110 = 0 time = 1110
* CHECK dout0_21 vdout0_21ck110 = 0 time = 1110
* CHECK dout0_22 vdout0_22ck110 = 1.8 time = 1110
* CHECK dout0_23 vdout0_23ck110 = 1.8 time = 1110
* CHECK dout0_24 vdout0_24ck110 = 0 time = 1110
* CHECK dout0_25 vdout0_25ck110 = 0 time = 1110
* CHECK dout0_26 vdout0_26ck110 = 1.8 time = 1110
* CHECK dout0_27 vdout0_27ck110 = 1.8 time = 1110
* CHECK dout0_28 vdout0_28ck110 = 1.8 time = 1110
* CHECK dout0_29 vdout0_29ck110 = 1.8 time = 1110
* CHECK dout0_30 vdout0_30ck110 = 1.8 time = 1110
* CHECK dout0_31 vdout0_31ck110 = 0 time = 1110
* CHECK dout0_0 vdout0_0ck111 = 0 time = 1120
* CHECK dout0_1 vdout0_1ck111 = 0 time = 1120
* CHECK dout0_2 vdout0_2ck111 = 0 time = 1120
* CHECK dout0_3 vdout0_3ck111 = 1.8 time = 1120
* CHECK dout0_4 vdout0_4ck111 = 0 time = 1120
* CHECK dout0_5 vdout0_5ck111 = 1.8 time = 1120
* CHECK dout0_6 vdout0_6ck111 = 1.8 time = 1120
* CHECK dout0_7 vdout0_7ck111 = 0 time = 1120
* CHECK dout0_8 vdout0_8ck111 = 1.8 time = 1120
* CHECK dout0_9 vdout0_9ck111 = 0 time = 1120
* CHECK dout0_10 vdout0_10ck111 = 1.8 time = 1120
* CHECK dout0_11 vdout0_11ck111 = 0 time = 1120
* CHECK dout0_12 vdout0_12ck111 = 1.8 time = 1120
* CHECK dout0_13 vdout0_13ck111 = 0 time = 1120
* CHECK dout0_14 vdout0_14ck111 = 1.8 time = 1120
* CHECK dout0_15 vdout0_15ck111 = 0 time = 1120
* CHECK dout0_16 vdout0_16ck111 = 0 time = 1120
* CHECK dout0_17 vdout0_17ck111 = 1.8 time = 1120
* CHECK dout0_18 vdout0_18ck111 = 0 time = 1120
* CHECK dout0_19 vdout0_19ck111 = 0 time = 1120
* CHECK dout0_20 vdout0_20ck111 = 0 time = 1120
* CHECK dout0_21 vdout0_21ck111 = 0 time = 1120
* CHECK dout0_22 vdout0_22ck111 = 1.8 time = 1120
* CHECK dout0_23 vdout0_23ck111 = 1.8 time = 1120
* CHECK dout0_24 vdout0_24ck111 = 0 time = 1120
* CHECK dout0_25 vdout0_25ck111 = 0 time = 1120
* CHECK dout0_26 vdout0_26ck111 = 1.8 time = 1120
* CHECK dout0_27 vdout0_27ck111 = 1.8 time = 1120
* CHECK dout0_28 vdout0_28ck111 = 1.8 time = 1120
* CHECK dout0_29 vdout0_29ck111 = 1.8 time = 1120
* CHECK dout0_30 vdout0_30ck111 = 1.8 time = 1120
* CHECK dout0_31 vdout0_31ck111 = 0 time = 1120
* CHECK dout1_0 vdout1_0ck111 = 0 time = 1120
* CHECK dout1_1 vdout1_1ck111 = 0 time = 1120
* CHECK dout1_2 vdout1_2ck111 = 0 time = 1120
* CHECK dout1_3 vdout1_3ck111 = 1.8 time = 1120
* CHECK dout1_4 vdout1_4ck111 = 0 time = 1120
* CHECK dout1_5 vdout1_5ck111 = 1.8 time = 1120
* CHECK dout1_6 vdout1_6ck111 = 1.8 time = 1120
* CHECK dout1_7 vdout1_7ck111 = 0 time = 1120
* CHECK dout1_8 vdout1_8ck111 = 1.8 time = 1120
* CHECK dout1_9 vdout1_9ck111 = 0 time = 1120
* CHECK dout1_10 vdout1_10ck111 = 1.8 time = 1120
* CHECK dout1_11 vdout1_11ck111 = 0 time = 1120
* CHECK dout1_12 vdout1_12ck111 = 1.8 time = 1120
* CHECK dout1_13 vdout1_13ck111 = 0 time = 1120
* CHECK dout1_14 vdout1_14ck111 = 1.8 time = 1120
* CHECK dout1_15 vdout1_15ck111 = 0 time = 1120
* CHECK dout1_16 vdout1_16ck111 = 0 time = 1120
* CHECK dout1_17 vdout1_17ck111 = 1.8 time = 1120
* CHECK dout1_18 vdout1_18ck111 = 0 time = 1120
* CHECK dout1_19 vdout1_19ck111 = 0 time = 1120
* CHECK dout1_20 vdout1_20ck111 = 0 time = 1120
* CHECK dout1_21 vdout1_21ck111 = 0 time = 1120
* CHECK dout1_22 vdout1_22ck111 = 1.8 time = 1120
* CHECK dout1_23 vdout1_23ck111 = 1.8 time = 1120
* CHECK dout1_24 vdout1_24ck111 = 0 time = 1120
* CHECK dout1_25 vdout1_25ck111 = 0 time = 1120
* CHECK dout1_26 vdout1_26ck111 = 1.8 time = 1120
* CHECK dout1_27 vdout1_27ck111 = 1.8 time = 1120
* CHECK dout1_28 vdout1_28ck111 = 1.8 time = 1120
* CHECK dout1_29 vdout1_29ck111 = 1.8 time = 1120
* CHECK dout1_30 vdout1_30ck111 = 1.8 time = 1120
* CHECK dout1_31 vdout1_31ck111 = 0 time = 1120
* CHECK dout0_0 vdout0_0ck112 = 1.8 time = 1130
* CHECK dout0_1 vdout0_1ck112 = 0 time = 1130
* CHECK dout0_2 vdout0_2ck112 = 0 time = 1130
* CHECK dout0_3 vdout0_3ck112 = 0 time = 1130
* CHECK dout0_4 vdout0_4ck112 = 0 time = 1130
* CHECK dout0_5 vdout0_5ck112 = 1.8 time = 1130
* CHECK dout0_6 vdout0_6ck112 = 1.8 time = 1130
* CHECK dout0_7 vdout0_7ck112 = 1.8 time = 1130
* CHECK dout0_8 vdout0_8ck112 = 1.8 time = 1130
* CHECK dout0_9 vdout0_9ck112 = 0 time = 1130
* CHECK dout0_10 vdout0_10ck112 = 1.8 time = 1130
* CHECK dout0_11 vdout0_11ck112 = 1.8 time = 1130
* CHECK dout0_12 vdout0_12ck112 = 0 time = 1130
* CHECK dout0_13 vdout0_13ck112 = 0 time = 1130
* CHECK dout0_14 vdout0_14ck112 = 1.8 time = 1130
* CHECK dout0_15 vdout0_15ck112 = 0 time = 1130
* CHECK dout0_16 vdout0_16ck112 = 1.8 time = 1130
* CHECK dout0_17 vdout0_17ck112 = 1.8 time = 1130
* CHECK dout0_18 vdout0_18ck112 = 0 time = 1130
* CHECK dout0_19 vdout0_19ck112 = 1.8 time = 1130
* CHECK dout0_20 vdout0_20ck112 = 0 time = 1130
* CHECK dout0_21 vdout0_21ck112 = 0 time = 1130
* CHECK dout0_22 vdout0_22ck112 = 0 time = 1130
* CHECK dout0_23 vdout0_23ck112 = 1.8 time = 1130
* CHECK dout0_24 vdout0_24ck112 = 1.8 time = 1130
* CHECK dout0_25 vdout0_25ck112 = 0 time = 1130
* CHECK dout0_26 vdout0_26ck112 = 1.8 time = 1130
* CHECK dout0_27 vdout0_27ck112 = 0 time = 1130
* CHECK dout0_28 vdout0_28ck112 = 1.8 time = 1130
* CHECK dout0_29 vdout0_29ck112 = 1.8 time = 1130
* CHECK dout0_30 vdout0_30ck112 = 0 time = 1130
* CHECK dout0_31 vdout0_31ck112 = 1.8 time = 1130
* CHECK dout0_0 vdout0_0ck113 = 0 time = 1140
* CHECK dout0_1 vdout0_1ck113 = 0 time = 1140
* CHECK dout0_2 vdout0_2ck113 = 0 time = 1140
* CHECK dout0_3 vdout0_3ck113 = 1.8 time = 1140
* CHECK dout0_4 vdout0_4ck113 = 0 time = 1140
* CHECK dout0_5 vdout0_5ck113 = 1.8 time = 1140
* CHECK dout0_6 vdout0_6ck113 = 1.8 time = 1140
* CHECK dout0_7 vdout0_7ck113 = 0 time = 1140
* CHECK dout0_8 vdout0_8ck113 = 1.8 time = 1140
* CHECK dout0_9 vdout0_9ck113 = 0 time = 1140
* CHECK dout0_10 vdout0_10ck113 = 1.8 time = 1140
* CHECK dout0_11 vdout0_11ck113 = 0 time = 1140
* CHECK dout0_12 vdout0_12ck113 = 1.8 time = 1140
* CHECK dout0_13 vdout0_13ck113 = 0 time = 1140
* CHECK dout0_14 vdout0_14ck113 = 1.8 time = 1140
* CHECK dout0_15 vdout0_15ck113 = 0 time = 1140
* CHECK dout0_16 vdout0_16ck113 = 0 time = 1140
* CHECK dout0_17 vdout0_17ck113 = 1.8 time = 1140
* CHECK dout0_18 vdout0_18ck113 = 0 time = 1140
* CHECK dout0_19 vdout0_19ck113 = 0 time = 1140
* CHECK dout0_20 vdout0_20ck113 = 0 time = 1140
* CHECK dout0_21 vdout0_21ck113 = 0 time = 1140
* CHECK dout0_22 vdout0_22ck113 = 1.8 time = 1140
* CHECK dout0_23 vdout0_23ck113 = 1.8 time = 1140
* CHECK dout0_24 vdout0_24ck113 = 0 time = 1140
* CHECK dout0_25 vdout0_25ck113 = 0 time = 1140
* CHECK dout0_26 vdout0_26ck113 = 1.8 time = 1140
* CHECK dout0_27 vdout0_27ck113 = 1.8 time = 1140
* CHECK dout0_28 vdout0_28ck113 = 1.8 time = 1140
* CHECK dout0_29 vdout0_29ck113 = 1.8 time = 1140
* CHECK dout0_30 vdout0_30ck113 = 1.8 time = 1140
* CHECK dout0_31 vdout0_31ck113 = 0 time = 1140
* CHECK dout1_0 vdout1_0ck113 = 0 time = 1140
* CHECK dout1_1 vdout1_1ck113 = 0 time = 1140
* CHECK dout1_2 vdout1_2ck113 = 0 time = 1140
* CHECK dout1_3 vdout1_3ck113 = 1.8 time = 1140
* CHECK dout1_4 vdout1_4ck113 = 0 time = 1140
* CHECK dout1_5 vdout1_5ck113 = 1.8 time = 1140
* CHECK dout1_6 vdout1_6ck113 = 1.8 time = 1140
* CHECK dout1_7 vdout1_7ck113 = 0 time = 1140
* CHECK dout1_8 vdout1_8ck113 = 1.8 time = 1140
* CHECK dout1_9 vdout1_9ck113 = 0 time = 1140
* CHECK dout1_10 vdout1_10ck113 = 1.8 time = 1140
* CHECK dout1_11 vdout1_11ck113 = 0 time = 1140
* CHECK dout1_12 vdout1_12ck113 = 1.8 time = 1140
* CHECK dout1_13 vdout1_13ck113 = 0 time = 1140
* CHECK dout1_14 vdout1_14ck113 = 1.8 time = 1140
* CHECK dout1_15 vdout1_15ck113 = 0 time = 1140
* CHECK dout1_16 vdout1_16ck113 = 0 time = 1140
* CHECK dout1_17 vdout1_17ck113 = 1.8 time = 1140
* CHECK dout1_18 vdout1_18ck113 = 0 time = 1140
* CHECK dout1_19 vdout1_19ck113 = 0 time = 1140
* CHECK dout1_20 vdout1_20ck113 = 0 time = 1140
* CHECK dout1_21 vdout1_21ck113 = 0 time = 1140
* CHECK dout1_22 vdout1_22ck113 = 1.8 time = 1140
* CHECK dout1_23 vdout1_23ck113 = 1.8 time = 1140
* CHECK dout1_24 vdout1_24ck113 = 0 time = 1140
* CHECK dout1_25 vdout1_25ck113 = 0 time = 1140
* CHECK dout1_26 vdout1_26ck113 = 1.8 time = 1140
* CHECK dout1_27 vdout1_27ck113 = 1.8 time = 1140
* CHECK dout1_28 vdout1_28ck113 = 1.8 time = 1140
* CHECK dout1_29 vdout1_29ck113 = 1.8 time = 1140
* CHECK dout1_30 vdout1_30ck113 = 1.8 time = 1140
* CHECK dout1_31 vdout1_31ck113 = 0 time = 1140
* CHECK dout0_0 vdout0_0ck117 = 1.8 time = 1180
* CHECK dout0_1 vdout0_1ck117 = 0 time = 1180
* CHECK dout0_2 vdout0_2ck117 = 0 time = 1180
* CHECK dout0_3 vdout0_3ck117 = 0 time = 1180
* CHECK dout0_4 vdout0_4ck117 = 0 time = 1180
* CHECK dout0_5 vdout0_5ck117 = 1.8 time = 1180
* CHECK dout0_6 vdout0_6ck117 = 1.8 time = 1180
* CHECK dout0_7 vdout0_7ck117 = 1.8 time = 1180
* CHECK dout0_8 vdout0_8ck117 = 1.8 time = 1180
* CHECK dout0_9 vdout0_9ck117 = 0 time = 1180
* CHECK dout0_10 vdout0_10ck117 = 1.8 time = 1180
* CHECK dout0_11 vdout0_11ck117 = 1.8 time = 1180
* CHECK dout0_12 vdout0_12ck117 = 0 time = 1180
* CHECK dout0_13 vdout0_13ck117 = 0 time = 1180
* CHECK dout0_14 vdout0_14ck117 = 1.8 time = 1180
* CHECK dout0_15 vdout0_15ck117 = 0 time = 1180
* CHECK dout0_16 vdout0_16ck117 = 1.8 time = 1180
* CHECK dout0_17 vdout0_17ck117 = 1.8 time = 1180
* CHECK dout0_18 vdout0_18ck117 = 0 time = 1180
* CHECK dout0_19 vdout0_19ck117 = 1.8 time = 1180
* CHECK dout0_20 vdout0_20ck117 = 0 time = 1180
* CHECK dout0_21 vdout0_21ck117 = 0 time = 1180
* CHECK dout0_22 vdout0_22ck117 = 0 time = 1180
* CHECK dout0_23 vdout0_23ck117 = 1.8 time = 1180
* CHECK dout0_24 vdout0_24ck117 = 1.8 time = 1180
* CHECK dout0_25 vdout0_25ck117 = 0 time = 1180
* CHECK dout0_26 vdout0_26ck117 = 1.8 time = 1180
* CHECK dout0_27 vdout0_27ck117 = 0 time = 1180
* CHECK dout0_28 vdout0_28ck117 = 1.8 time = 1180
* CHECK dout0_29 vdout0_29ck117 = 1.8 time = 1180
* CHECK dout0_30 vdout0_30ck117 = 0 time = 1180
* CHECK dout0_31 vdout0_31ck117 = 1.8 time = 1180
* CHECK dout1_0 vdout1_0ck117 = 0 time = 1180
* CHECK dout1_1 vdout1_1ck117 = 1.8 time = 1180
* CHECK dout1_2 vdout1_2ck117 = 1.8 time = 1180
* CHECK dout1_3 vdout1_3ck117 = 0 time = 1180
* CHECK dout1_4 vdout1_4ck117 = 0 time = 1180
* CHECK dout1_5 vdout1_5ck117 = 1.8 time = 1180
* CHECK dout1_6 vdout1_6ck117 = 1.8 time = 1180
* CHECK dout1_7 vdout1_7ck117 = 1.8 time = 1180
* CHECK dout1_8 vdout1_8ck117 = 0 time = 1180
* CHECK dout1_9 vdout1_9ck117 = 1.8 time = 1180
* CHECK dout1_10 vdout1_10ck117 = 1.8 time = 1180
* CHECK dout1_11 vdout1_11ck117 = 1.8 time = 1180
* CHECK dout1_12 vdout1_12ck117 = 0 time = 1180
* CHECK dout1_13 vdout1_13ck117 = 1.8 time = 1180
* CHECK dout1_14 vdout1_14ck117 = 0 time = 1180
* CHECK dout1_15 vdout1_15ck117 = 0 time = 1180
* CHECK dout1_16 vdout1_16ck117 = 1.8 time = 1180
* CHECK dout1_17 vdout1_17ck117 = 0 time = 1180
* CHECK dout1_18 vdout1_18ck117 = 1.8 time = 1180
* CHECK dout1_19 vdout1_19ck117 = 1.8 time = 1180
* CHECK dout1_20 vdout1_20ck117 = 0 time = 1180
* CHECK dout1_21 vdout1_21ck117 = 0 time = 1180
* CHECK dout1_22 vdout1_22ck117 = 1.8 time = 1180
* CHECK dout1_23 vdout1_23ck117 = 1.8 time = 1180
* CHECK dout1_24 vdout1_24ck117 = 0 time = 1180
* CHECK dout1_25 vdout1_25ck117 = 1.8 time = 1180
* CHECK dout1_26 vdout1_26ck117 = 0 time = 1180
* CHECK dout1_27 vdout1_27ck117 = 1.8 time = 1180
* CHECK dout1_28 vdout1_28ck117 = 1.8 time = 1180
* CHECK dout1_29 vdout1_29ck117 = 0 time = 1180
* CHECK dout1_30 vdout1_30ck117 = 1.8 time = 1180
* CHECK dout1_31 vdout1_31ck117 = 0 time = 1180
* CHECK dout0_0 vdout0_0ck118 = 0 time = 1190
* CHECK dout0_1 vdout0_1ck118 = 1.8 time = 1190
* CHECK dout0_2 vdout0_2ck118 = 1.8 time = 1190
* CHECK dout0_3 vdout0_3ck118 = 0 time = 1190
* CHECK dout0_4 vdout0_4ck118 = 0 time = 1190
* CHECK dout0_5 vdout0_5ck118 = 1.8 time = 1190
* CHECK dout0_6 vdout0_6ck118 = 1.8 time = 1190
* CHECK dout0_7 vdout0_7ck118 = 1.8 time = 1190
* CHECK dout0_8 vdout0_8ck118 = 0 time = 1190
* CHECK dout0_9 vdout0_9ck118 = 1.8 time = 1190
* CHECK dout0_10 vdout0_10ck118 = 1.8 time = 1190
* CHECK dout0_11 vdout0_11ck118 = 1.8 time = 1190
* CHECK dout0_12 vdout0_12ck118 = 0 time = 1190
* CHECK dout0_13 vdout0_13ck118 = 1.8 time = 1190
* CHECK dout0_14 vdout0_14ck118 = 0 time = 1190
* CHECK dout0_15 vdout0_15ck118 = 0 time = 1190
* CHECK dout0_16 vdout0_16ck118 = 1.8 time = 1190
* CHECK dout0_17 vdout0_17ck118 = 0 time = 1190
* CHECK dout0_18 vdout0_18ck118 = 1.8 time = 1190
* CHECK dout0_19 vdout0_19ck118 = 1.8 time = 1190
* CHECK dout0_20 vdout0_20ck118 = 0 time = 1190
* CHECK dout0_21 vdout0_21ck118 = 0 time = 1190
* CHECK dout0_22 vdout0_22ck118 = 1.8 time = 1190
* CHECK dout0_23 vdout0_23ck118 = 1.8 time = 1190
* CHECK dout0_24 vdout0_24ck118 = 0 time = 1190
* CHECK dout0_25 vdout0_25ck118 = 1.8 time = 1190
* CHECK dout0_26 vdout0_26ck118 = 0 time = 1190
* CHECK dout0_27 vdout0_27ck118 = 1.8 time = 1190
* CHECK dout0_28 vdout0_28ck118 = 1.8 time = 1190
* CHECK dout0_29 vdout0_29ck118 = 0 time = 1190
* CHECK dout0_30 vdout0_30ck118 = 1.8 time = 1190
* CHECK dout0_31 vdout0_31ck118 = 0 time = 1190
* CHECK dout1_0 vdout1_0ck118 = 1.8 time = 1190
* CHECK dout1_1 vdout1_1ck118 = 0 time = 1190
* CHECK dout1_2 vdout1_2ck118 = 0 time = 1190
* CHECK dout1_3 vdout1_3ck118 = 0 time = 1190
* CHECK dout1_4 vdout1_4ck118 = 0 time = 1190
* CHECK dout1_5 vdout1_5ck118 = 1.8 time = 1190
* CHECK dout1_6 vdout1_6ck118 = 1.8 time = 1190
* CHECK dout1_7 vdout1_7ck118 = 1.8 time = 1190
* CHECK dout1_8 vdout1_8ck118 = 1.8 time = 1190
* CHECK dout1_9 vdout1_9ck118 = 0 time = 1190
* CHECK dout1_10 vdout1_10ck118 = 1.8 time = 1190
* CHECK dout1_11 vdout1_11ck118 = 1.8 time = 1190
* CHECK dout1_12 vdout1_12ck118 = 0 time = 1190
* CHECK dout1_13 vdout1_13ck118 = 0 time = 1190
* CHECK dout1_14 vdout1_14ck118 = 1.8 time = 1190
* CHECK dout1_15 vdout1_15ck118 = 0 time = 1190
* CHECK dout1_16 vdout1_16ck118 = 1.8 time = 1190
* CHECK dout1_17 vdout1_17ck118 = 1.8 time = 1190
* CHECK dout1_18 vdout1_18ck118 = 0 time = 1190
* CHECK dout1_19 vdout1_19ck118 = 1.8 time = 1190
* CHECK dout1_20 vdout1_20ck118 = 0 time = 1190
* CHECK dout1_21 vdout1_21ck118 = 0 time = 1190
* CHECK dout1_22 vdout1_22ck118 = 0 time = 1190
* CHECK dout1_23 vdout1_23ck118 = 1.8 time = 1190
* CHECK dout1_24 vdout1_24ck118 = 1.8 time = 1190
* CHECK dout1_25 vdout1_25ck118 = 0 time = 1190
* CHECK dout1_26 vdout1_26ck118 = 1.8 time = 1190
* CHECK dout1_27 vdout1_27ck118 = 0 time = 1190
* CHECK dout1_28 vdout1_28ck118 = 1.8 time = 1190
* CHECK dout1_29 vdout1_29ck118 = 1.8 time = 1190
* CHECK dout1_30 vdout1_30ck118 = 0 time = 1190
* CHECK dout1_31 vdout1_31ck118 = 1.8 time = 1190
* CHECK dout0_0 vdout0_0ck119 = 1.8 time = 1200
* CHECK dout0_1 vdout0_1ck119 = 0 time = 1200
* CHECK dout0_2 vdout0_2ck119 = 0 time = 1200
* CHECK dout0_3 vdout0_3ck119 = 0 time = 1200
* CHECK dout0_4 vdout0_4ck119 = 0 time = 1200
* CHECK dout0_5 vdout0_5ck119 = 1.8 time = 1200
* CHECK dout0_6 vdout0_6ck119 = 1.8 time = 1200
* CHECK dout0_7 vdout0_7ck119 = 1.8 time = 1200
* CHECK dout0_8 vdout0_8ck119 = 1.8 time = 1200
* CHECK dout0_9 vdout0_9ck119 = 0 time = 1200
* CHECK dout0_10 vdout0_10ck119 = 1.8 time = 1200
* CHECK dout0_11 vdout0_11ck119 = 1.8 time = 1200
* CHECK dout0_12 vdout0_12ck119 = 0 time = 1200
* CHECK dout0_13 vdout0_13ck119 = 0 time = 1200
* CHECK dout0_14 vdout0_14ck119 = 1.8 time = 1200
* CHECK dout0_15 vdout0_15ck119 = 0 time = 1200
* CHECK dout0_16 vdout0_16ck119 = 1.8 time = 1200
* CHECK dout0_17 vdout0_17ck119 = 1.8 time = 1200
* CHECK dout0_18 vdout0_18ck119 = 0 time = 1200
* CHECK dout0_19 vdout0_19ck119 = 1.8 time = 1200
* CHECK dout0_20 vdout0_20ck119 = 0 time = 1200
* CHECK dout0_21 vdout0_21ck119 = 0 time = 1200
* CHECK dout0_22 vdout0_22ck119 = 0 time = 1200
* CHECK dout0_23 vdout0_23ck119 = 1.8 time = 1200
* CHECK dout0_24 vdout0_24ck119 = 1.8 time = 1200
* CHECK dout0_25 vdout0_25ck119 = 0 time = 1200
* CHECK dout0_26 vdout0_26ck119 = 1.8 time = 1200
* CHECK dout0_27 vdout0_27ck119 = 0 time = 1200
* CHECK dout0_28 vdout0_28ck119 = 1.8 time = 1200
* CHECK dout0_29 vdout0_29ck119 = 1.8 time = 1200
* CHECK dout0_30 vdout0_30ck119 = 0 time = 1200
* CHECK dout0_31 vdout0_31ck119 = 1.8 time = 1200
* CHECK dout1_0 vdout1_0ck119 = 1.8 time = 1200
* CHECK dout1_1 vdout1_1ck119 = 0 time = 1200
* CHECK dout1_2 vdout1_2ck119 = 0 time = 1200
* CHECK dout1_3 vdout1_3ck119 = 0 time = 1200
* CHECK dout1_4 vdout1_4ck119 = 0 time = 1200
* CHECK dout1_5 vdout1_5ck119 = 1.8 time = 1200
* CHECK dout1_6 vdout1_6ck119 = 1.8 time = 1200
* CHECK dout1_7 vdout1_7ck119 = 1.8 time = 1200
* CHECK dout1_8 vdout1_8ck119 = 1.8 time = 1200
* CHECK dout1_9 vdout1_9ck119 = 0 time = 1200
* CHECK dout1_10 vdout1_10ck119 = 1.8 time = 1200
* CHECK dout1_11 vdout1_11ck119 = 1.8 time = 1200
* CHECK dout1_12 vdout1_12ck119 = 0 time = 1200
* CHECK dout1_13 vdout1_13ck119 = 0 time = 1200
* CHECK dout1_14 vdout1_14ck119 = 1.8 time = 1200
* CHECK dout1_15 vdout1_15ck119 = 0 time = 1200
* CHECK dout1_16 vdout1_16ck119 = 1.8 time = 1200
* CHECK dout1_17 vdout1_17ck119 = 1.8 time = 1200
* CHECK dout1_18 vdout1_18ck119 = 0 time = 1200
* CHECK dout1_19 vdout1_19ck119 = 1.8 time = 1200
* CHECK dout1_20 vdout1_20ck119 = 0 time = 1200
* CHECK dout1_21 vdout1_21ck119 = 0 time = 1200
* CHECK dout1_22 vdout1_22ck119 = 0 time = 1200
* CHECK dout1_23 vdout1_23ck119 = 1.8 time = 1200
* CHECK dout1_24 vdout1_24ck119 = 1.8 time = 1200
* CHECK dout1_25 vdout1_25ck119 = 0 time = 1200
* CHECK dout1_26 vdout1_26ck119 = 1.8 time = 1200
* CHECK dout1_27 vdout1_27ck119 = 0 time = 1200
* CHECK dout1_28 vdout1_28ck119 = 1.8 time = 1200
* CHECK dout1_29 vdout1_29ck119 = 1.8 time = 1200
* CHECK dout1_30 vdout1_30ck119 = 0 time = 1200
* CHECK dout1_31 vdout1_31ck119 = 1.8 time = 1200
* CHECK dout0_0 vdout0_0ck120 = 1.8 time = 1210
* CHECK dout0_1 vdout0_1ck120 = 0 time = 1210
* CHECK dout0_2 vdout0_2ck120 = 0 time = 1210
* CHECK dout0_3 vdout0_3ck120 = 0 time = 1210
* CHECK dout0_4 vdout0_4ck120 = 0 time = 1210
* CHECK dout0_5 vdout0_5ck120 = 1.8 time = 1210
* CHECK dout0_6 vdout0_6ck120 = 1.8 time = 1210
* CHECK dout0_7 vdout0_7ck120 = 1.8 time = 1210
* CHECK dout0_8 vdout0_8ck120 = 1.8 time = 1210
* CHECK dout0_9 vdout0_9ck120 = 0 time = 1210
* CHECK dout0_10 vdout0_10ck120 = 1.8 time = 1210
* CHECK dout0_11 vdout0_11ck120 = 1.8 time = 1210
* CHECK dout0_12 vdout0_12ck120 = 0 time = 1210
* CHECK dout0_13 vdout0_13ck120 = 0 time = 1210
* CHECK dout0_14 vdout0_14ck120 = 1.8 time = 1210
* CHECK dout0_15 vdout0_15ck120 = 0 time = 1210
* CHECK dout0_16 vdout0_16ck120 = 1.8 time = 1210
* CHECK dout0_17 vdout0_17ck120 = 1.8 time = 1210
* CHECK dout0_18 vdout0_18ck120 = 0 time = 1210
* CHECK dout0_19 vdout0_19ck120 = 1.8 time = 1210
* CHECK dout0_20 vdout0_20ck120 = 0 time = 1210
* CHECK dout0_21 vdout0_21ck120 = 0 time = 1210
* CHECK dout0_22 vdout0_22ck120 = 0 time = 1210
* CHECK dout0_23 vdout0_23ck120 = 1.8 time = 1210
* CHECK dout0_24 vdout0_24ck120 = 1.8 time = 1210
* CHECK dout0_25 vdout0_25ck120 = 0 time = 1210
* CHECK dout0_26 vdout0_26ck120 = 1.8 time = 1210
* CHECK dout0_27 vdout0_27ck120 = 0 time = 1210
* CHECK dout0_28 vdout0_28ck120 = 1.8 time = 1210
* CHECK dout0_29 vdout0_29ck120 = 1.8 time = 1210
* CHECK dout0_30 vdout0_30ck120 = 0 time = 1210
* CHECK dout0_31 vdout0_31ck120 = 1.8 time = 1210
* CHECK dout1_0 vdout1_0ck120 = 1.8 time = 1210
* CHECK dout1_1 vdout1_1ck120 = 0 time = 1210
* CHECK dout1_2 vdout1_2ck120 = 0 time = 1210
* CHECK dout1_3 vdout1_3ck120 = 0 time = 1210
* CHECK dout1_4 vdout1_4ck120 = 0 time = 1210
* CHECK dout1_5 vdout1_5ck120 = 1.8 time = 1210
* CHECK dout1_6 vdout1_6ck120 = 1.8 time = 1210
* CHECK dout1_7 vdout1_7ck120 = 1.8 time = 1210
* CHECK dout1_8 vdout1_8ck120 = 1.8 time = 1210
* CHECK dout1_9 vdout1_9ck120 = 0 time = 1210
* CHECK dout1_10 vdout1_10ck120 = 1.8 time = 1210
* CHECK dout1_11 vdout1_11ck120 = 1.8 time = 1210
* CHECK dout1_12 vdout1_12ck120 = 0 time = 1210
* CHECK dout1_13 vdout1_13ck120 = 0 time = 1210
* CHECK dout1_14 vdout1_14ck120 = 1.8 time = 1210
* CHECK dout1_15 vdout1_15ck120 = 0 time = 1210
* CHECK dout1_16 vdout1_16ck120 = 1.8 time = 1210
* CHECK dout1_17 vdout1_17ck120 = 1.8 time = 1210
* CHECK dout1_18 vdout1_18ck120 = 0 time = 1210
* CHECK dout1_19 vdout1_19ck120 = 1.8 time = 1210
* CHECK dout1_20 vdout1_20ck120 = 0 time = 1210
* CHECK dout1_21 vdout1_21ck120 = 0 time = 1210
* CHECK dout1_22 vdout1_22ck120 = 0 time = 1210
* CHECK dout1_23 vdout1_23ck120 = 1.8 time = 1210
* CHECK dout1_24 vdout1_24ck120 = 1.8 time = 1210
* CHECK dout1_25 vdout1_25ck120 = 0 time = 1210
* CHECK dout1_26 vdout1_26ck120 = 1.8 time = 1210
* CHECK dout1_27 vdout1_27ck120 = 0 time = 1210
* CHECK dout1_28 vdout1_28ck120 = 1.8 time = 1210
* CHECK dout1_29 vdout1_29ck120 = 1.8 time = 1210
* CHECK dout1_30 vdout1_30ck120 = 0 time = 1210
* CHECK dout1_31 vdout1_31ck120 = 1.8 time = 1210
* CHECK dout0_0 vdout0_0ck121 = 1.8 time = 1220
* CHECK dout0_1 vdout0_1ck121 = 0 time = 1220
* CHECK dout0_2 vdout0_2ck121 = 0 time = 1220
* CHECK dout0_3 vdout0_3ck121 = 0 time = 1220
* CHECK dout0_4 vdout0_4ck121 = 0 time = 1220
* CHECK dout0_5 vdout0_5ck121 = 1.8 time = 1220
* CHECK dout0_6 vdout0_6ck121 = 1.8 time = 1220
* CHECK dout0_7 vdout0_7ck121 = 1.8 time = 1220
* CHECK dout0_8 vdout0_8ck121 = 1.8 time = 1220
* CHECK dout0_9 vdout0_9ck121 = 0 time = 1220
* CHECK dout0_10 vdout0_10ck121 = 1.8 time = 1220
* CHECK dout0_11 vdout0_11ck121 = 1.8 time = 1220
* CHECK dout0_12 vdout0_12ck121 = 0 time = 1220
* CHECK dout0_13 vdout0_13ck121 = 0 time = 1220
* CHECK dout0_14 vdout0_14ck121 = 1.8 time = 1220
* CHECK dout0_15 vdout0_15ck121 = 0 time = 1220
* CHECK dout0_16 vdout0_16ck121 = 1.8 time = 1220
* CHECK dout0_17 vdout0_17ck121 = 1.8 time = 1220
* CHECK dout0_18 vdout0_18ck121 = 0 time = 1220
* CHECK dout0_19 vdout0_19ck121 = 1.8 time = 1220
* CHECK dout0_20 vdout0_20ck121 = 0 time = 1220
* CHECK dout0_21 vdout0_21ck121 = 0 time = 1220
* CHECK dout0_22 vdout0_22ck121 = 0 time = 1220
* CHECK dout0_23 vdout0_23ck121 = 1.8 time = 1220
* CHECK dout0_24 vdout0_24ck121 = 1.8 time = 1220
* CHECK dout0_25 vdout0_25ck121 = 0 time = 1220
* CHECK dout0_26 vdout0_26ck121 = 1.8 time = 1220
* CHECK dout0_27 vdout0_27ck121 = 0 time = 1220
* CHECK dout0_28 vdout0_28ck121 = 1.8 time = 1220
* CHECK dout0_29 vdout0_29ck121 = 1.8 time = 1220
* CHECK dout0_30 vdout0_30ck121 = 0 time = 1220
* CHECK dout0_31 vdout0_31ck121 = 1.8 time = 1220
* CHECK dout1_0 vdout1_0ck122 = 0 time = 1230
* CHECK dout1_1 vdout1_1ck122 = 1.8 time = 1230
* CHECK dout1_2 vdout1_2ck122 = 1.8 time = 1230
* CHECK dout1_3 vdout1_3ck122 = 0 time = 1230
* CHECK dout1_4 vdout1_4ck122 = 0 time = 1230
* CHECK dout1_5 vdout1_5ck122 = 1.8 time = 1230
* CHECK dout1_6 vdout1_6ck122 = 1.8 time = 1230
* CHECK dout1_7 vdout1_7ck122 = 1.8 time = 1230
* CHECK dout1_8 vdout1_8ck122 = 0 time = 1230
* CHECK dout1_9 vdout1_9ck122 = 1.8 time = 1230
* CHECK dout1_10 vdout1_10ck122 = 1.8 time = 1230
* CHECK dout1_11 vdout1_11ck122 = 1.8 time = 1230
* CHECK dout1_12 vdout1_12ck122 = 0 time = 1230
* CHECK dout1_13 vdout1_13ck122 = 1.8 time = 1230
* CHECK dout1_14 vdout1_14ck122 = 0 time = 1230
* CHECK dout1_15 vdout1_15ck122 = 0 time = 1230
* CHECK dout1_16 vdout1_16ck122 = 1.8 time = 1230
* CHECK dout1_17 vdout1_17ck122 = 0 time = 1230
* CHECK dout1_18 vdout1_18ck122 = 1.8 time = 1230
* CHECK dout1_19 vdout1_19ck122 = 1.8 time = 1230
* CHECK dout1_20 vdout1_20ck122 = 0 time = 1230
* CHECK dout1_21 vdout1_21ck122 = 0 time = 1230
* CHECK dout1_22 vdout1_22ck122 = 1.8 time = 1230
* CHECK dout1_23 vdout1_23ck122 = 1.8 time = 1230
* CHECK dout1_24 vdout1_24ck122 = 0 time = 1230
* CHECK dout1_25 vdout1_25ck122 = 1.8 time = 1230
* CHECK dout1_26 vdout1_26ck122 = 0 time = 1230
* CHECK dout1_27 vdout1_27ck122 = 1.8 time = 1230
* CHECK dout1_28 vdout1_28ck122 = 1.8 time = 1230
* CHECK dout1_29 vdout1_29ck122 = 0 time = 1230
* CHECK dout1_30 vdout1_30ck122 = 1.8 time = 1230
* CHECK dout1_31 vdout1_31ck122 = 0 time = 1230
* CHECK dout0_0 vdout0_0ck123 = 0 time = 1240
* CHECK dout0_1 vdout0_1ck123 = 1.8 time = 1240
* CHECK dout0_2 vdout0_2ck123 = 1.8 time = 1240
* CHECK dout0_3 vdout0_3ck123 = 0 time = 1240
* CHECK dout0_4 vdout0_4ck123 = 0 time = 1240
* CHECK dout0_5 vdout0_5ck123 = 1.8 time = 1240
* CHECK dout0_6 vdout0_6ck123 = 1.8 time = 1240
* CHECK dout0_7 vdout0_7ck123 = 1.8 time = 1240
* CHECK dout0_8 vdout0_8ck123 = 0 time = 1240
* CHECK dout0_9 vdout0_9ck123 = 1.8 time = 1240
* CHECK dout0_10 vdout0_10ck123 = 1.8 time = 1240
* CHECK dout0_11 vdout0_11ck123 = 1.8 time = 1240
* CHECK dout0_12 vdout0_12ck123 = 0 time = 1240
* CHECK dout0_13 vdout0_13ck123 = 1.8 time = 1240
* CHECK dout0_14 vdout0_14ck123 = 0 time = 1240
* CHECK dout0_15 vdout0_15ck123 = 0 time = 1240
* CHECK dout0_16 vdout0_16ck123 = 1.8 time = 1240
* CHECK dout0_17 vdout0_17ck123 = 0 time = 1240
* CHECK dout0_18 vdout0_18ck123 = 1.8 time = 1240
* CHECK dout0_19 vdout0_19ck123 = 1.8 time = 1240
* CHECK dout0_20 vdout0_20ck123 = 0 time = 1240
* CHECK dout0_21 vdout0_21ck123 = 0 time = 1240
* CHECK dout0_22 vdout0_22ck123 = 1.8 time = 1240
* CHECK dout0_23 vdout0_23ck123 = 1.8 time = 1240
* CHECK dout0_24 vdout0_24ck123 = 0 time = 1240
* CHECK dout0_25 vdout0_25ck123 = 1.8 time = 1240
* CHECK dout0_26 vdout0_26ck123 = 0 time = 1240
* CHECK dout0_27 vdout0_27ck123 = 1.8 time = 1240
* CHECK dout0_28 vdout0_28ck123 = 1.8 time = 1240
* CHECK dout0_29 vdout0_29ck123 = 0 time = 1240
* CHECK dout0_30 vdout0_30ck123 = 1.8 time = 1240
* CHECK dout0_31 vdout0_31ck123 = 0 time = 1240
* CHECK dout1_0 vdout1_0ck123 = 0 time = 1240
* CHECK dout1_1 vdout1_1ck123 = 1.8 time = 1240
* CHECK dout1_2 vdout1_2ck123 = 1.8 time = 1240
* CHECK dout1_3 vdout1_3ck123 = 0 time = 1240
* CHECK dout1_4 vdout1_4ck123 = 0 time = 1240
* CHECK dout1_5 vdout1_5ck123 = 1.8 time = 1240
* CHECK dout1_6 vdout1_6ck123 = 1.8 time = 1240
* CHECK dout1_7 vdout1_7ck123 = 1.8 time = 1240
* CHECK dout1_8 vdout1_8ck123 = 0 time = 1240
* CHECK dout1_9 vdout1_9ck123 = 1.8 time = 1240
* CHECK dout1_10 vdout1_10ck123 = 1.8 time = 1240
* CHECK dout1_11 vdout1_11ck123 = 1.8 time = 1240
* CHECK dout1_12 vdout1_12ck123 = 0 time = 1240
* CHECK dout1_13 vdout1_13ck123 = 1.8 time = 1240
* CHECK dout1_14 vdout1_14ck123 = 0 time = 1240
* CHECK dout1_15 vdout1_15ck123 = 0 time = 1240
* CHECK dout1_16 vdout1_16ck123 = 1.8 time = 1240
* CHECK dout1_17 vdout1_17ck123 = 0 time = 1240
* CHECK dout1_18 vdout1_18ck123 = 1.8 time = 1240
* CHECK dout1_19 vdout1_19ck123 = 1.8 time = 1240
* CHECK dout1_20 vdout1_20ck123 = 0 time = 1240
* CHECK dout1_21 vdout1_21ck123 = 0 time = 1240
* CHECK dout1_22 vdout1_22ck123 = 1.8 time = 1240
* CHECK dout1_23 vdout1_23ck123 = 1.8 time = 1240
* CHECK dout1_24 vdout1_24ck123 = 0 time = 1240
* CHECK dout1_25 vdout1_25ck123 = 1.8 time = 1240
* CHECK dout1_26 vdout1_26ck123 = 0 time = 1240
* CHECK dout1_27 vdout1_27ck123 = 1.8 time = 1240
* CHECK dout1_28 vdout1_28ck123 = 1.8 time = 1240
* CHECK dout1_29 vdout1_29ck123 = 0 time = 1240
* CHECK dout1_30 vdout1_30ck123 = 1.8 time = 1240
* CHECK dout1_31 vdout1_31ck123 = 0 time = 1240
* CHECK dout0_0 vdout0_0ck124 = 0 time = 1250
* CHECK dout0_1 vdout0_1ck124 = 1.8 time = 1250
* CHECK dout0_2 vdout0_2ck124 = 1.8 time = 1250
* CHECK dout0_3 vdout0_3ck124 = 0 time = 1250
* CHECK dout0_4 vdout0_4ck124 = 0 time = 1250
* CHECK dout0_5 vdout0_5ck124 = 1.8 time = 1250
* CHECK dout0_6 vdout0_6ck124 = 1.8 time = 1250
* CHECK dout0_7 vdout0_7ck124 = 1.8 time = 1250
* CHECK dout0_8 vdout0_8ck124 = 0 time = 1250
* CHECK dout0_9 vdout0_9ck124 = 1.8 time = 1250
* CHECK dout0_10 vdout0_10ck124 = 1.8 time = 1250
* CHECK dout0_11 vdout0_11ck124 = 1.8 time = 1250
* CHECK dout0_12 vdout0_12ck124 = 0 time = 1250
* CHECK dout0_13 vdout0_13ck124 = 1.8 time = 1250
* CHECK dout0_14 vdout0_14ck124 = 0 time = 1250
* CHECK dout0_15 vdout0_15ck124 = 0 time = 1250
* CHECK dout0_16 vdout0_16ck124 = 1.8 time = 1250
* CHECK dout0_17 vdout0_17ck124 = 0 time = 1250
* CHECK dout0_18 vdout0_18ck124 = 1.8 time = 1250
* CHECK dout0_19 vdout0_19ck124 = 1.8 time = 1250
* CHECK dout0_20 vdout0_20ck124 = 0 time = 1250
* CHECK dout0_21 vdout0_21ck124 = 0 time = 1250
* CHECK dout0_22 vdout0_22ck124 = 1.8 time = 1250
* CHECK dout0_23 vdout0_23ck124 = 1.8 time = 1250
* CHECK dout0_24 vdout0_24ck124 = 0 time = 1250
* CHECK dout0_25 vdout0_25ck124 = 1.8 time = 1250
* CHECK dout0_26 vdout0_26ck124 = 0 time = 1250
* CHECK dout0_27 vdout0_27ck124 = 1.8 time = 1250
* CHECK dout0_28 vdout0_28ck124 = 1.8 time = 1250
* CHECK dout0_29 vdout0_29ck124 = 0 time = 1250
* CHECK dout0_30 vdout0_30ck124 = 1.8 time = 1250
* CHECK dout0_31 vdout0_31ck124 = 0 time = 1250
* CHECK dout1_0 vdout1_0ck124 = 1.8 time = 1250
* CHECK dout1_1 vdout1_1ck124 = 0 time = 1250
* CHECK dout1_2 vdout1_2ck124 = 0 time = 1250
* CHECK dout1_3 vdout1_3ck124 = 0 time = 1250
* CHECK dout1_4 vdout1_4ck124 = 0 time = 1250
* CHECK dout1_5 vdout1_5ck124 = 1.8 time = 1250
* CHECK dout1_6 vdout1_6ck124 = 1.8 time = 1250
* CHECK dout1_7 vdout1_7ck124 = 1.8 time = 1250
* CHECK dout1_8 vdout1_8ck124 = 1.8 time = 1250
* CHECK dout1_9 vdout1_9ck124 = 0 time = 1250
* CHECK dout1_10 vdout1_10ck124 = 1.8 time = 1250
* CHECK dout1_11 vdout1_11ck124 = 1.8 time = 1250
* CHECK dout1_12 vdout1_12ck124 = 0 time = 1250
* CHECK dout1_13 vdout1_13ck124 = 0 time = 1250
* CHECK dout1_14 vdout1_14ck124 = 1.8 time = 1250
* CHECK dout1_15 vdout1_15ck124 = 0 time = 1250
* CHECK dout1_16 vdout1_16ck124 = 1.8 time = 1250
* CHECK dout1_17 vdout1_17ck124 = 1.8 time = 1250
* CHECK dout1_18 vdout1_18ck124 = 0 time = 1250
* CHECK dout1_19 vdout1_19ck124 = 1.8 time = 1250
* CHECK dout1_20 vdout1_20ck124 = 0 time = 1250
* CHECK dout1_21 vdout1_21ck124 = 0 time = 1250
* CHECK dout1_22 vdout1_22ck124 = 0 time = 1250
* CHECK dout1_23 vdout1_23ck124 = 1.8 time = 1250
* CHECK dout1_24 vdout1_24ck124 = 1.8 time = 1250
* CHECK dout1_25 vdout1_25ck124 = 0 time = 1250
* CHECK dout1_26 vdout1_26ck124 = 1.8 time = 1250
* CHECK dout1_27 vdout1_27ck124 = 0 time = 1250
* CHECK dout1_28 vdout1_28ck124 = 1.8 time = 1250
* CHECK dout1_29 vdout1_29ck124 = 1.8 time = 1250
* CHECK dout1_30 vdout1_30ck124 = 0 time = 1250
* CHECK dout1_31 vdout1_31ck124 = 1.8 time = 1250
* CHECK dout1_0 vdout1_0ck125 = 1.8 time = 1260
* CHECK dout1_1 vdout1_1ck125 = 0 time = 1260
* CHECK dout1_2 vdout1_2ck125 = 0 time = 1260
* CHECK dout1_3 vdout1_3ck125 = 0 time = 1260
* CHECK dout1_4 vdout1_4ck125 = 0 time = 1260
* CHECK dout1_5 vdout1_5ck125 = 1.8 time = 1260
* CHECK dout1_6 vdout1_6ck125 = 1.8 time = 1260
* CHECK dout1_7 vdout1_7ck125 = 1.8 time = 1260
* CHECK dout1_8 vdout1_8ck125 = 1.8 time = 1260
* CHECK dout1_9 vdout1_9ck125 = 0 time = 1260
* CHECK dout1_10 vdout1_10ck125 = 1.8 time = 1260
* CHECK dout1_11 vdout1_11ck125 = 1.8 time = 1260
* CHECK dout1_12 vdout1_12ck125 = 0 time = 1260
* CHECK dout1_13 vdout1_13ck125 = 0 time = 1260
* CHECK dout1_14 vdout1_14ck125 = 1.8 time = 1260
* CHECK dout1_15 vdout1_15ck125 = 0 time = 1260
* CHECK dout1_16 vdout1_16ck125 = 1.8 time = 1260
* CHECK dout1_17 vdout1_17ck125 = 1.8 time = 1260
* CHECK dout1_18 vdout1_18ck125 = 0 time = 1260
* CHECK dout1_19 vdout1_19ck125 = 1.8 time = 1260
* CHECK dout1_20 vdout1_20ck125 = 0 time = 1260
* CHECK dout1_21 vdout1_21ck125 = 0 time = 1260
* CHECK dout1_22 vdout1_22ck125 = 0 time = 1260
* CHECK dout1_23 vdout1_23ck125 = 1.8 time = 1260
* CHECK dout1_24 vdout1_24ck125 = 1.8 time = 1260
* CHECK dout1_25 vdout1_25ck125 = 0 time = 1260
* CHECK dout1_26 vdout1_26ck125 = 1.8 time = 1260
* CHECK dout1_27 vdout1_27ck125 = 0 time = 1260
* CHECK dout1_28 vdout1_28ck125 = 1.8 time = 1260
* CHECK dout1_29 vdout1_29ck125 = 1.8 time = 1260
* CHECK dout1_30 vdout1_30ck125 = 0 time = 1260
* CHECK dout1_31 vdout1_31ck125 = 1.8 time = 1260
* CHECK dout0_0 vdout0_0ck127 = 1.8 time = 1280
* CHECK dout0_1 vdout0_1ck127 = 1.8 time = 1280
* CHECK dout0_2 vdout0_2ck127 = 1.8 time = 1280
* CHECK dout0_3 vdout0_3ck127 = 1.8 time = 1280
* CHECK dout0_4 vdout0_4ck127 = 0 time = 1280
* CHECK dout0_5 vdout0_5ck127 = 1.8 time = 1280
* CHECK dout0_6 vdout0_6ck127 = 0 time = 1280
* CHECK dout0_7 vdout0_7ck127 = 0 time = 1280
* CHECK dout0_8 vdout0_8ck127 = 0 time = 1280
* CHECK dout0_9 vdout0_9ck127 = 1.8 time = 1280
* CHECK dout0_10 vdout0_10ck127 = 1.8 time = 1280
* CHECK dout0_11 vdout0_11ck127 = 1.8 time = 1280
* CHECK dout0_12 vdout0_12ck127 = 0 time = 1280
* CHECK dout0_13 vdout0_13ck127 = 0 time = 1280
* CHECK dout0_14 vdout0_14ck127 = 1.8 time = 1280
* CHECK dout0_15 vdout0_15ck127 = 0 time = 1280
* CHECK dout0_16 vdout0_16ck127 = 0 time = 1280
* CHECK dout0_17 vdout0_17ck127 = 0 time = 1280
* CHECK dout0_18 vdout0_18ck127 = 1.8 time = 1280
* CHECK dout0_19 vdout0_19ck127 = 1.8 time = 1280
* CHECK dout0_20 vdout0_20ck127 = 1.8 time = 1280
* CHECK dout0_21 vdout0_21ck127 = 1.8 time = 1280
* CHECK dout0_22 vdout0_22ck127 = 1.8 time = 1280
* CHECK dout0_23 vdout0_23ck127 = 0 time = 1280
* CHECK dout0_24 vdout0_24ck127 = 0 time = 1280
* CHECK dout0_25 vdout0_25ck127 = 0 time = 1280
* CHECK dout0_26 vdout0_26ck127 = 1.8 time = 1280
* CHECK dout0_27 vdout0_27ck127 = 0 time = 1280
* CHECK dout0_28 vdout0_28ck127 = 1.8 time = 1280
* CHECK dout0_29 vdout0_29ck127 = 0 time = 1280
* CHECK dout0_30 vdout0_30ck127 = 1.8 time = 1280
* CHECK dout0_31 vdout0_31ck127 = 0 time = 1280
* CHECK dout0_0 vdout0_0ck129 = 1.8 time = 1300
* CHECK dout0_1 vdout0_1ck129 = 1.8 time = 1300
* CHECK dout0_2 vdout0_2ck129 = 1.8 time = 1300
* CHECK dout0_3 vdout0_3ck129 = 1.8 time = 1300
* CHECK dout0_4 vdout0_4ck129 = 0 time = 1300
* CHECK dout0_5 vdout0_5ck129 = 1.8 time = 1300
* CHECK dout0_6 vdout0_6ck129 = 0 time = 1300
* CHECK dout0_7 vdout0_7ck129 = 0 time = 1300
* CHECK dout0_8 vdout0_8ck129 = 0 time = 1300
* CHECK dout0_9 vdout0_9ck129 = 1.8 time = 1300
* CHECK dout0_10 vdout0_10ck129 = 1.8 time = 1300
* CHECK dout0_11 vdout0_11ck129 = 1.8 time = 1300
* CHECK dout0_12 vdout0_12ck129 = 0 time = 1300
* CHECK dout0_13 vdout0_13ck129 = 0 time = 1300
* CHECK dout0_14 vdout0_14ck129 = 1.8 time = 1300
* CHECK dout0_15 vdout0_15ck129 = 0 time = 1300
* CHECK dout0_16 vdout0_16ck129 = 0 time = 1300
* CHECK dout0_17 vdout0_17ck129 = 0 time = 1300
* CHECK dout0_18 vdout0_18ck129 = 1.8 time = 1300
* CHECK dout0_19 vdout0_19ck129 = 1.8 time = 1300
* CHECK dout0_20 vdout0_20ck129 = 1.8 time = 1300
* CHECK dout0_21 vdout0_21ck129 = 1.8 time = 1300
* CHECK dout0_22 vdout0_22ck129 = 1.8 time = 1300
* CHECK dout0_23 vdout0_23ck129 = 0 time = 1300
* CHECK dout0_24 vdout0_24ck129 = 0 time = 1300
* CHECK dout0_25 vdout0_25ck129 = 0 time = 1300
* CHECK dout0_26 vdout0_26ck129 = 1.8 time = 1300
* CHECK dout0_27 vdout0_27ck129 = 0 time = 1300
* CHECK dout0_28 vdout0_28ck129 = 1.8 time = 1300
* CHECK dout0_29 vdout0_29ck129 = 0 time = 1300
* CHECK dout0_30 vdout0_30ck129 = 1.8 time = 1300
* CHECK dout0_31 vdout0_31ck129 = 0 time = 1300
* CHECK dout1_0 vdout1_0ck129 = 1.8 time = 1300
* CHECK dout1_1 vdout1_1ck129 = 0 time = 1300
* CHECK dout1_2 vdout1_2ck129 = 1.8 time = 1300
* CHECK dout1_3 vdout1_3ck129 = 0 time = 1300
* CHECK dout1_4 vdout1_4ck129 = 1.8 time = 1300
* CHECK dout1_5 vdout1_5ck129 = 0 time = 1300
* CHECK dout1_6 vdout1_6ck129 = 1.8 time = 1300
* CHECK dout1_7 vdout1_7ck129 = 1.8 time = 1300
* CHECK dout1_8 vdout1_8ck129 = 1.8 time = 1300
* CHECK dout1_9 vdout1_9ck129 = 0 time = 1300
* CHECK dout1_10 vdout1_10ck129 = 1.8 time = 1300
* CHECK dout1_11 vdout1_11ck129 = 1.8 time = 1300
* CHECK dout1_12 vdout1_12ck129 = 1.8 time = 1300
* CHECK dout1_13 vdout1_13ck129 = 1.8 time = 1300
* CHECK dout1_14 vdout1_14ck129 = 0 time = 1300
* CHECK dout1_15 vdout1_15ck129 = 1.8 time = 1300
* CHECK dout1_16 vdout1_16ck129 = 1.8 time = 1300
* CHECK dout1_17 vdout1_17ck129 = 0 time = 1300
* CHECK dout1_18 vdout1_18ck129 = 0 time = 1300
* CHECK dout1_19 vdout1_19ck129 = 1.8 time = 1300
* CHECK dout1_20 vdout1_20ck129 = 1.8 time = 1300
* CHECK dout1_21 vdout1_21ck129 = 0 time = 1300
* CHECK dout1_22 vdout1_22ck129 = 0 time = 1300
* CHECK dout1_23 vdout1_23ck129 = 0 time = 1300
* CHECK dout1_24 vdout1_24ck129 = 0 time = 1300
* CHECK dout1_25 vdout1_25ck129 = 0 time = 1300
* CHECK dout1_26 vdout1_26ck129 = 1.8 time = 1300
* CHECK dout1_27 vdout1_27ck129 = 0 time = 1300
* CHECK dout1_28 vdout1_28ck129 = 0 time = 1300
* CHECK dout1_29 vdout1_29ck129 = 0 time = 1300
* CHECK dout1_30 vdout1_30ck129 = 1.8 time = 1300
* CHECK dout1_31 vdout1_31ck129 = 0 time = 1300
* CHECK dout0_0 vdout0_0ck131 = 1.8 time = 1320
* CHECK dout0_1 vdout0_1ck131 = 1.8 time = 1320
* CHECK dout0_2 vdout0_2ck131 = 1.8 time = 1320
* CHECK dout0_3 vdout0_3ck131 = 1.8 time = 1320
* CHECK dout0_4 vdout0_4ck131 = 0 time = 1320
* CHECK dout0_5 vdout0_5ck131 = 1.8 time = 1320
* CHECK dout0_6 vdout0_6ck131 = 0 time = 1320
* CHECK dout0_7 vdout0_7ck131 = 0 time = 1320
* CHECK dout0_8 vdout0_8ck131 = 0 time = 1320
* CHECK dout0_9 vdout0_9ck131 = 1.8 time = 1320
* CHECK dout0_10 vdout0_10ck131 = 1.8 time = 1320
* CHECK dout0_11 vdout0_11ck131 = 1.8 time = 1320
* CHECK dout0_12 vdout0_12ck131 = 0 time = 1320
* CHECK dout0_13 vdout0_13ck131 = 0 time = 1320
* CHECK dout0_14 vdout0_14ck131 = 1.8 time = 1320
* CHECK dout0_15 vdout0_15ck131 = 0 time = 1320
* CHECK dout0_16 vdout0_16ck131 = 0 time = 1320
* CHECK dout0_17 vdout0_17ck131 = 0 time = 1320
* CHECK dout0_18 vdout0_18ck131 = 1.8 time = 1320
* CHECK dout0_19 vdout0_19ck131 = 1.8 time = 1320
* CHECK dout0_20 vdout0_20ck131 = 1.8 time = 1320
* CHECK dout0_21 vdout0_21ck131 = 1.8 time = 1320
* CHECK dout0_22 vdout0_22ck131 = 1.8 time = 1320
* CHECK dout0_23 vdout0_23ck131 = 0 time = 1320
* CHECK dout0_24 vdout0_24ck131 = 0 time = 1320
* CHECK dout0_25 vdout0_25ck131 = 0 time = 1320
* CHECK dout0_26 vdout0_26ck131 = 1.8 time = 1320
* CHECK dout0_27 vdout0_27ck131 = 0 time = 1320
* CHECK dout0_28 vdout0_28ck131 = 1.8 time = 1320
* CHECK dout0_29 vdout0_29ck131 = 0 time = 1320
* CHECK dout0_30 vdout0_30ck131 = 1.8 time = 1320
* CHECK dout0_31 vdout0_31ck131 = 0 time = 1320
* CHECK dout0_0 vdout0_0ck132 = 1.8 time = 1330
* CHECK dout0_1 vdout0_1ck132 = 0 time = 1330
* CHECK dout0_2 vdout0_2ck132 = 1.8 time = 1330
* CHECK dout0_3 vdout0_3ck132 = 0 time = 1330
* CHECK dout0_4 vdout0_4ck132 = 1.8 time = 1330
* CHECK dout0_5 vdout0_5ck132 = 0 time = 1330
* CHECK dout0_6 vdout0_6ck132 = 1.8 time = 1330
* CHECK dout0_7 vdout0_7ck132 = 1.8 time = 1330
* CHECK dout0_8 vdout0_8ck132 = 1.8 time = 1330
* CHECK dout0_9 vdout0_9ck132 = 0 time = 1330
* CHECK dout0_10 vdout0_10ck132 = 1.8 time = 1330
* CHECK dout0_11 vdout0_11ck132 = 1.8 time = 1330
* CHECK dout0_12 vdout0_12ck132 = 1.8 time = 1330
* CHECK dout0_13 vdout0_13ck132 = 1.8 time = 1330
* CHECK dout0_14 vdout0_14ck132 = 0 time = 1330
* CHECK dout0_15 vdout0_15ck132 = 1.8 time = 1330
* CHECK dout0_16 vdout0_16ck132 = 1.8 time = 1330
* CHECK dout0_17 vdout0_17ck132 = 0 time = 1330
* CHECK dout0_18 vdout0_18ck132 = 0 time = 1330
* CHECK dout0_19 vdout0_19ck132 = 1.8 time = 1330
* CHECK dout0_20 vdout0_20ck132 = 1.8 time = 1330
* CHECK dout0_21 vdout0_21ck132 = 0 time = 1330
* CHECK dout0_22 vdout0_22ck132 = 0 time = 1330
* CHECK dout0_23 vdout0_23ck132 = 0 time = 1330
* CHECK dout0_24 vdout0_24ck132 = 0 time = 1330
* CHECK dout0_25 vdout0_25ck132 = 0 time = 1330
* CHECK dout0_26 vdout0_26ck132 = 1.8 time = 1330
* CHECK dout0_27 vdout0_27ck132 = 0 time = 1330
* CHECK dout0_28 vdout0_28ck132 = 0 time = 1330
* CHECK dout0_29 vdout0_29ck132 = 0 time = 1330
* CHECK dout0_30 vdout0_30ck132 = 1.8 time = 1330
* CHECK dout0_31 vdout0_31ck132 = 0 time = 1330
* CHECK dout1_0 vdout1_0ck134 = 0 time = 1350
* CHECK dout1_1 vdout1_1ck134 = 0 time = 1350
* CHECK dout1_2 vdout1_2ck134 = 0 time = 1350
* CHECK dout1_3 vdout1_3ck134 = 0 time = 1350
* CHECK dout1_4 vdout1_4ck134 = 1.8 time = 1350
* CHECK dout1_5 vdout1_5ck134 = 0 time = 1350
* CHECK dout1_6 vdout1_6ck134 = 1.8 time = 1350
* CHECK dout1_7 vdout1_7ck134 = 1.8 time = 1350
* CHECK dout1_8 vdout1_8ck134 = 1.8 time = 1350
* CHECK dout1_9 vdout1_9ck134 = 0 time = 1350
* CHECK dout1_10 vdout1_10ck134 = 1.8 time = 1350
* CHECK dout1_11 vdout1_11ck134 = 0 time = 1350
* CHECK dout1_12 vdout1_12ck134 = 1.8 time = 1350
* CHECK dout1_13 vdout1_13ck134 = 1.8 time = 1350
* CHECK dout1_14 vdout1_14ck134 = 0 time = 1350
* CHECK dout1_15 vdout1_15ck134 = 1.8 time = 1350
* CHECK dout1_16 vdout1_16ck134 = 0 time = 1350
* CHECK dout1_17 vdout1_17ck134 = 0 time = 1350
* CHECK dout1_18 vdout1_18ck134 = 1.8 time = 1350
* CHECK dout1_19 vdout1_19ck134 = 0 time = 1350
* CHECK dout1_20 vdout1_20ck134 = 0 time = 1350
* CHECK dout1_21 vdout1_21ck134 = 0 time = 1350
* CHECK dout1_22 vdout1_22ck134 = 0 time = 1350
* CHECK dout1_23 vdout1_23ck134 = 0 time = 1350
* CHECK dout1_24 vdout1_24ck134 = 0 time = 1350
* CHECK dout1_25 vdout1_25ck134 = 1.8 time = 1350
* CHECK dout1_26 vdout1_26ck134 = 0 time = 1350
* CHECK dout1_27 vdout1_27ck134 = 1.8 time = 1350
* CHECK dout1_28 vdout1_28ck134 = 0 time = 1350
* CHECK dout1_29 vdout1_29ck134 = 1.8 time = 1350
* CHECK dout1_30 vdout1_30ck134 = 0 time = 1350
* CHECK dout1_31 vdout1_31ck134 = 0 time = 1350
* CHECK dout0_0 vdout0_0ck135 = 1.8 time = 1360
* CHECK dout0_1 vdout0_1ck135 = 0 time = 1360
* CHECK dout0_2 vdout0_2ck135 = 1.8 time = 1360
* CHECK dout0_3 vdout0_3ck135 = 0 time = 1360
* CHECK dout0_4 vdout0_4ck135 = 1.8 time = 1360
* CHECK dout0_5 vdout0_5ck135 = 0 time = 1360
* CHECK dout0_6 vdout0_6ck135 = 1.8 time = 1360
* CHECK dout0_7 vdout0_7ck135 = 1.8 time = 1360
* CHECK dout0_8 vdout0_8ck135 = 1.8 time = 1360
* CHECK dout0_9 vdout0_9ck135 = 0 time = 1360
* CHECK dout0_10 vdout0_10ck135 = 1.8 time = 1360
* CHECK dout0_11 vdout0_11ck135 = 1.8 time = 1360
* CHECK dout0_12 vdout0_12ck135 = 1.8 time = 1360
* CHECK dout0_13 vdout0_13ck135 = 1.8 time = 1360
* CHECK dout0_14 vdout0_14ck135 = 0 time = 1360
* CHECK dout0_15 vdout0_15ck135 = 1.8 time = 1360
* CHECK dout0_16 vdout0_16ck135 = 1.8 time = 1360
* CHECK dout0_17 vdout0_17ck135 = 0 time = 1360
* CHECK dout0_18 vdout0_18ck135 = 0 time = 1360
* CHECK dout0_19 vdout0_19ck135 = 1.8 time = 1360
* CHECK dout0_20 vdout0_20ck135 = 1.8 time = 1360
* CHECK dout0_21 vdout0_21ck135 = 0 time = 1360
* CHECK dout0_22 vdout0_22ck135 = 0 time = 1360
* CHECK dout0_23 vdout0_23ck135 = 0 time = 1360
* CHECK dout0_24 vdout0_24ck135 = 0 time = 1360
* CHECK dout0_25 vdout0_25ck135 = 0 time = 1360
* CHECK dout0_26 vdout0_26ck135 = 1.8 time = 1360
* CHECK dout0_27 vdout0_27ck135 = 0 time = 1360
* CHECK dout0_28 vdout0_28ck135 = 0 time = 1360
* CHECK dout0_29 vdout0_29ck135 = 0 time = 1360
* CHECK dout0_30 vdout0_30ck135 = 1.8 time = 1360
* CHECK dout0_31 vdout0_31ck135 = 0 time = 1360
* CHECK dout1_0 vdout1_0ck135 = 1.8 time = 1360
* CHECK dout1_1 vdout1_1ck135 = 0 time = 1360
* CHECK dout1_2 vdout1_2ck135 = 1.8 time = 1360
* CHECK dout1_3 vdout1_3ck135 = 0 time = 1360
* CHECK dout1_4 vdout1_4ck135 = 1.8 time = 1360
* CHECK dout1_5 vdout1_5ck135 = 0 time = 1360
* CHECK dout1_6 vdout1_6ck135 = 1.8 time = 1360
* CHECK dout1_7 vdout1_7ck135 = 1.8 time = 1360
* CHECK dout1_8 vdout1_8ck135 = 1.8 time = 1360
* CHECK dout1_9 vdout1_9ck135 = 0 time = 1360
* CHECK dout1_10 vdout1_10ck135 = 1.8 time = 1360
* CHECK dout1_11 vdout1_11ck135 = 1.8 time = 1360
* CHECK dout1_12 vdout1_12ck135 = 1.8 time = 1360
* CHECK dout1_13 vdout1_13ck135 = 1.8 time = 1360
* CHECK dout1_14 vdout1_14ck135 = 0 time = 1360
* CHECK dout1_15 vdout1_15ck135 = 1.8 time = 1360
* CHECK dout1_16 vdout1_16ck135 = 1.8 time = 1360
* CHECK dout1_17 vdout1_17ck135 = 0 time = 1360
* CHECK dout1_18 vdout1_18ck135 = 0 time = 1360
* CHECK dout1_19 vdout1_19ck135 = 1.8 time = 1360
* CHECK dout1_20 vdout1_20ck135 = 1.8 time = 1360
* CHECK dout1_21 vdout1_21ck135 = 0 time = 1360
* CHECK dout1_22 vdout1_22ck135 = 0 time = 1360
* CHECK dout1_23 vdout1_23ck135 = 0 time = 1360
* CHECK dout1_24 vdout1_24ck135 = 0 time = 1360
* CHECK dout1_25 vdout1_25ck135 = 0 time = 1360
* CHECK dout1_26 vdout1_26ck135 = 1.8 time = 1360
* CHECK dout1_27 vdout1_27ck135 = 0 time = 1360
* CHECK dout1_28 vdout1_28ck135 = 0 time = 1360
* CHECK dout1_29 vdout1_29ck135 = 0 time = 1360
* CHECK dout1_30 vdout1_30ck135 = 1.8 time = 1360
* CHECK dout1_31 vdout1_31ck135 = 0 time = 1360
* CHECK dout0_0 vdout0_0ck136 = 1.8 time = 1370
* CHECK dout0_1 vdout0_1ck136 = 0 time = 1370
* CHECK dout0_2 vdout0_2ck136 = 1.8 time = 1370
* CHECK dout0_3 vdout0_3ck136 = 0 time = 1370
* CHECK dout0_4 vdout0_4ck136 = 1.8 time = 1370
* CHECK dout0_5 vdout0_5ck136 = 0 time = 1370
* CHECK dout0_6 vdout0_6ck136 = 1.8 time = 1370
* CHECK dout0_7 vdout0_7ck136 = 1.8 time = 1370
* CHECK dout0_8 vdout0_8ck136 = 1.8 time = 1370
* CHECK dout0_9 vdout0_9ck136 = 0 time = 1370
* CHECK dout0_10 vdout0_10ck136 = 1.8 time = 1370
* CHECK dout0_11 vdout0_11ck136 = 1.8 time = 1370
* CHECK dout0_12 vdout0_12ck136 = 1.8 time = 1370
* CHECK dout0_13 vdout0_13ck136 = 1.8 time = 1370
* CHECK dout0_14 vdout0_14ck136 = 0 time = 1370
* CHECK dout0_15 vdout0_15ck136 = 1.8 time = 1370
* CHECK dout0_16 vdout0_16ck136 = 1.8 time = 1370
* CHECK dout0_17 vdout0_17ck136 = 0 time = 1370
* CHECK dout0_18 vdout0_18ck136 = 0 time = 1370
* CHECK dout0_19 vdout0_19ck136 = 1.8 time = 1370
* CHECK dout0_20 vdout0_20ck136 = 1.8 time = 1370
* CHECK dout0_21 vdout0_21ck136 = 0 time = 1370
* CHECK dout0_22 vdout0_22ck136 = 0 time = 1370
* CHECK dout0_23 vdout0_23ck136 = 0 time = 1370
* CHECK dout0_24 vdout0_24ck136 = 0 time = 1370
* CHECK dout0_25 vdout0_25ck136 = 0 time = 1370
* CHECK dout0_26 vdout0_26ck136 = 1.8 time = 1370
* CHECK dout0_27 vdout0_27ck136 = 0 time = 1370
* CHECK dout0_28 vdout0_28ck136 = 0 time = 1370
* CHECK dout0_29 vdout0_29ck136 = 0 time = 1370
* CHECK dout0_30 vdout0_30ck136 = 1.8 time = 1370
* CHECK dout0_31 vdout0_31ck136 = 0 time = 1370
* CHECK dout0_0 vdout0_0ck138 = 1.8 time = 1390
* CHECK dout0_1 vdout0_1ck138 = 0 time = 1390
* CHECK dout0_2 vdout0_2ck138 = 1.8 time = 1390
* CHECK dout0_3 vdout0_3ck138 = 0 time = 1390
* CHECK dout0_4 vdout0_4ck138 = 0 time = 1390
* CHECK dout0_5 vdout0_5ck138 = 1.8 time = 1390
* CHECK dout0_6 vdout0_6ck138 = 0 time = 1390
* CHECK dout0_7 vdout0_7ck138 = 0 time = 1390
* CHECK dout0_8 vdout0_8ck138 = 1.8 time = 1390
* CHECK dout0_9 vdout0_9ck138 = 0 time = 1390
* CHECK dout0_10 vdout0_10ck138 = 0 time = 1390
* CHECK dout0_11 vdout0_11ck138 = 1.8 time = 1390
* CHECK dout0_12 vdout0_12ck138 = 0 time = 1390
* CHECK dout0_13 vdout0_13ck138 = 0 time = 1390
* CHECK dout0_14 vdout0_14ck138 = 0 time = 1390
* CHECK dout0_15 vdout0_15ck138 = 0 time = 1390
* CHECK dout0_16 vdout0_16ck138 = 1.8 time = 1390
* CHECK dout0_17 vdout0_17ck138 = 0 time = 1390
* CHECK dout0_18 vdout0_18ck138 = 1.8 time = 1390
* CHECK dout0_19 vdout0_19ck138 = 1.8 time = 1390
* CHECK dout0_20 vdout0_20ck138 = 1.8 time = 1390
* CHECK dout0_21 vdout0_21ck138 = 1.8 time = 1390
* CHECK dout0_22 vdout0_22ck138 = 0 time = 1390
* CHECK dout0_23 vdout0_23ck138 = 1.8 time = 1390
* CHECK dout0_24 vdout0_24ck138 = 1.8 time = 1390
* CHECK dout0_25 vdout0_25ck138 = 1.8 time = 1390
* CHECK dout0_26 vdout0_26ck138 = 0 time = 1390
* CHECK dout0_27 vdout0_27ck138 = 0 time = 1390
* CHECK dout0_28 vdout0_28ck138 = 1.8 time = 1390
* CHECK dout0_29 vdout0_29ck138 = 1.8 time = 1390
* CHECK dout0_30 vdout0_30ck138 = 1.8 time = 1390
* CHECK dout0_31 vdout0_31ck138 = 0 time = 1390
* CHECK dout1_0 vdout1_0ck139 = 1.8 time = 1400
* CHECK dout1_1 vdout1_1ck139 = 0 time = 1400
* CHECK dout1_2 vdout1_2ck139 = 1.8 time = 1400
* CHECK dout1_3 vdout1_3ck139 = 0 time = 1400
* CHECK dout1_4 vdout1_4ck139 = 0 time = 1400
* CHECK dout1_5 vdout1_5ck139 = 1.8 time = 1400
* CHECK dout1_6 vdout1_6ck139 = 0 time = 1400
* CHECK dout1_7 vdout1_7ck139 = 0 time = 1400
* CHECK dout1_8 vdout1_8ck139 = 1.8 time = 1400
* CHECK dout1_9 vdout1_9ck139 = 0 time = 1400
* CHECK dout1_10 vdout1_10ck139 = 0 time = 1400
* CHECK dout1_11 vdout1_11ck139 = 1.8 time = 1400
* CHECK dout1_12 vdout1_12ck139 = 0 time = 1400
* CHECK dout1_13 vdout1_13ck139 = 0 time = 1400
* CHECK dout1_14 vdout1_14ck139 = 0 time = 1400
* CHECK dout1_15 vdout1_15ck139 = 0 time = 1400
* CHECK dout1_16 vdout1_16ck139 = 1.8 time = 1400
* CHECK dout1_17 vdout1_17ck139 = 0 time = 1400
* CHECK dout1_18 vdout1_18ck139 = 1.8 time = 1400
* CHECK dout1_19 vdout1_19ck139 = 1.8 time = 1400
* CHECK dout1_20 vdout1_20ck139 = 1.8 time = 1400
* CHECK dout1_21 vdout1_21ck139 = 1.8 time = 1400
* CHECK dout1_22 vdout1_22ck139 = 0 time = 1400
* CHECK dout1_23 vdout1_23ck139 = 1.8 time = 1400
* CHECK dout1_24 vdout1_24ck139 = 1.8 time = 1400
* CHECK dout1_25 vdout1_25ck139 = 1.8 time = 1400
* CHECK dout1_26 vdout1_26ck139 = 0 time = 1400
* CHECK dout1_27 vdout1_27ck139 = 0 time = 1400
* CHECK dout1_28 vdout1_28ck139 = 1.8 time = 1400
* CHECK dout1_29 vdout1_29ck139 = 1.8 time = 1400
* CHECK dout1_30 vdout1_30ck139 = 1.8 time = 1400
* CHECK dout1_31 vdout1_31ck139 = 0 time = 1400
* CHECK dout1_0 vdout1_0ck140 = 1.8 time = 1410
* CHECK dout1_1 vdout1_1ck140 = 0 time = 1410
* CHECK dout1_2 vdout1_2ck140 = 1.8 time = 1410
* CHECK dout1_3 vdout1_3ck140 = 0 time = 1410
* CHECK dout1_4 vdout1_4ck140 = 0 time = 1410
* CHECK dout1_5 vdout1_5ck140 = 1.8 time = 1410
* CHECK dout1_6 vdout1_6ck140 = 0 time = 1410
* CHECK dout1_7 vdout1_7ck140 = 0 time = 1410
* CHECK dout1_8 vdout1_8ck140 = 1.8 time = 1410
* CHECK dout1_9 vdout1_9ck140 = 0 time = 1410
* CHECK dout1_10 vdout1_10ck140 = 0 time = 1410
* CHECK dout1_11 vdout1_11ck140 = 1.8 time = 1410
* CHECK dout1_12 vdout1_12ck140 = 0 time = 1410
* CHECK dout1_13 vdout1_13ck140 = 0 time = 1410
* CHECK dout1_14 vdout1_14ck140 = 0 time = 1410
* CHECK dout1_15 vdout1_15ck140 = 0 time = 1410
* CHECK dout1_16 vdout1_16ck140 = 1.8 time = 1410
* CHECK dout1_17 vdout1_17ck140 = 0 time = 1410
* CHECK dout1_18 vdout1_18ck140 = 1.8 time = 1410
* CHECK dout1_19 vdout1_19ck140 = 1.8 time = 1410
* CHECK dout1_20 vdout1_20ck140 = 1.8 time = 1410
* CHECK dout1_21 vdout1_21ck140 = 1.8 time = 1410
* CHECK dout1_22 vdout1_22ck140 = 0 time = 1410
* CHECK dout1_23 vdout1_23ck140 = 1.8 time = 1410
* CHECK dout1_24 vdout1_24ck140 = 1.8 time = 1410
* CHECK dout1_25 vdout1_25ck140 = 1.8 time = 1410
* CHECK dout1_26 vdout1_26ck140 = 0 time = 1410
* CHECK dout1_27 vdout1_27ck140 = 0 time = 1410
* CHECK dout1_28 vdout1_28ck140 = 1.8 time = 1410
* CHECK dout1_29 vdout1_29ck140 = 1.8 time = 1410
* CHECK dout1_30 vdout1_30ck140 = 1.8 time = 1410
* CHECK dout1_31 vdout1_31ck140 = 0 time = 1410
* CHECK dout1_0 vdout1_0ck143 = 0 time = 1440
* CHECK dout1_1 vdout1_1ck143 = 0 time = 1440
* CHECK dout1_2 vdout1_2ck143 = 1.8 time = 1440
* CHECK dout1_3 vdout1_3ck143 = 1.8 time = 1440
* CHECK dout1_4 vdout1_4ck143 = 0 time = 1440
* CHECK dout1_5 vdout1_5ck143 = 0 time = 1440
* CHECK dout1_6 vdout1_6ck143 = 0 time = 1440
* CHECK dout1_7 vdout1_7ck143 = 0 time = 1440
* CHECK dout1_8 vdout1_8ck143 = 0 time = 1440
* CHECK dout1_9 vdout1_9ck143 = 0 time = 1440
* CHECK dout1_10 vdout1_10ck143 = 1.8 time = 1440
* CHECK dout1_11 vdout1_11ck143 = 0 time = 1440
* CHECK dout1_12 vdout1_12ck143 = 1.8 time = 1440
* CHECK dout1_13 vdout1_13ck143 = 1.8 time = 1440
* CHECK dout1_14 vdout1_14ck143 = 1.8 time = 1440
* CHECK dout1_15 vdout1_15ck143 = 0 time = 1440
* CHECK dout1_16 vdout1_16ck143 = 0 time = 1440
* CHECK dout1_17 vdout1_17ck143 = 0 time = 1440
* CHECK dout1_18 vdout1_18ck143 = 0 time = 1440
* CHECK dout1_19 vdout1_19ck143 = 1.8 time = 1440
* CHECK dout1_20 vdout1_20ck143 = 0 time = 1440
* CHECK dout1_21 vdout1_21ck143 = 0 time = 1440
* CHECK dout1_22 vdout1_22ck143 = 1.8 time = 1440
* CHECK dout1_23 vdout1_23ck143 = 0 time = 1440
* CHECK dout1_24 vdout1_24ck143 = 0 time = 1440
* CHECK dout1_25 vdout1_25ck143 = 1.8 time = 1440
* CHECK dout1_26 vdout1_26ck143 = 0 time = 1440
* CHECK dout1_27 vdout1_27ck143 = 1.8 time = 1440
* CHECK dout1_28 vdout1_28ck143 = 0 time = 1440
* CHECK dout1_29 vdout1_29ck143 = 1.8 time = 1440
* CHECK dout1_30 vdout1_30ck143 = 1.8 time = 1440
* CHECK dout1_31 vdout1_31ck143 = 0 time = 1440
* CHECK dout0_0 vdout0_0ck144 = 1.8 time = 1450
* CHECK dout0_1 vdout0_1ck144 = 0 time = 1450
* CHECK dout0_2 vdout0_2ck144 = 0 time = 1450
* CHECK dout0_3 vdout0_3ck144 = 0 time = 1450
* CHECK dout0_4 vdout0_4ck144 = 0 time = 1450
* CHECK dout0_5 vdout0_5ck144 = 0 time = 1450
* CHECK dout0_6 vdout0_6ck144 = 0 time = 1450
* CHECK dout0_7 vdout0_7ck144 = 0 time = 1450
* CHECK dout0_8 vdout0_8ck144 = 1.8 time = 1450
* CHECK dout0_9 vdout0_9ck144 = 0 time = 1450
* CHECK dout0_10 vdout0_10ck144 = 0 time = 1450
* CHECK dout0_11 vdout0_11ck144 = 0 time = 1450
* CHECK dout0_12 vdout0_12ck144 = 0 time = 1450
* CHECK dout0_13 vdout0_13ck144 = 1.8 time = 1450
* CHECK dout0_14 vdout0_14ck144 = 0 time = 1450
* CHECK dout0_15 vdout0_15ck144 = 0 time = 1450
* CHECK dout0_16 vdout0_16ck144 = 0 time = 1450
* CHECK dout0_17 vdout0_17ck144 = 1.8 time = 1450
* CHECK dout0_18 vdout0_18ck144 = 1.8 time = 1450
* CHECK dout0_19 vdout0_19ck144 = 0 time = 1450
* CHECK dout0_20 vdout0_20ck144 = 1.8 time = 1450
* CHECK dout0_21 vdout0_21ck144 = 0 time = 1450
* CHECK dout0_22 vdout0_22ck144 = 0 time = 1450
* CHECK dout0_23 vdout0_23ck144 = 1.8 time = 1450
* CHECK dout0_24 vdout0_24ck144 = 1.8 time = 1450
* CHECK dout0_25 vdout0_25ck144 = 1.8 time = 1450
* CHECK dout0_26 vdout0_26ck144 = 1.8 time = 1450
* CHECK dout0_27 vdout0_27ck144 = 0 time = 1450
* CHECK dout0_28 vdout0_28ck144 = 0 time = 1450
* CHECK dout0_29 vdout0_29ck144 = 0 time = 1450
* CHECK dout0_30 vdout0_30ck144 = 0 time = 1450
* CHECK dout0_31 vdout0_31ck144 = 1.8 time = 1450
* CHECK dout1_0 vdout1_0ck144 = 0 time = 1450
* CHECK dout1_1 vdout1_1ck144 = 0 time = 1450
* CHECK dout1_2 vdout1_2ck144 = 1.8 time = 1450
* CHECK dout1_3 vdout1_3ck144 = 1.8 time = 1450
* CHECK dout1_4 vdout1_4ck144 = 0 time = 1450
* CHECK dout1_5 vdout1_5ck144 = 0 time = 1450
* CHECK dout1_6 vdout1_6ck144 = 0 time = 1450
* CHECK dout1_7 vdout1_7ck144 = 0 time = 1450
* CHECK dout1_8 vdout1_8ck144 = 0 time = 1450
* CHECK dout1_9 vdout1_9ck144 = 0 time = 1450
* CHECK dout1_10 vdout1_10ck144 = 1.8 time = 1450
* CHECK dout1_11 vdout1_11ck144 = 0 time = 1450
* CHECK dout1_12 vdout1_12ck144 = 1.8 time = 1450
* CHECK dout1_13 vdout1_13ck144 = 1.8 time = 1450
* CHECK dout1_14 vdout1_14ck144 = 1.8 time = 1450
* CHECK dout1_15 vdout1_15ck144 = 0 time = 1450
* CHECK dout1_16 vdout1_16ck144 = 0 time = 1450
* CHECK dout1_17 vdout1_17ck144 = 0 time = 1450
* CHECK dout1_18 vdout1_18ck144 = 0 time = 1450
* CHECK dout1_19 vdout1_19ck144 = 1.8 time = 1450
* CHECK dout1_20 vdout1_20ck144 = 0 time = 1450
* CHECK dout1_21 vdout1_21ck144 = 0 time = 1450
* CHECK dout1_22 vdout1_22ck144 = 1.8 time = 1450
* CHECK dout1_23 vdout1_23ck144 = 0 time = 1450
* CHECK dout1_24 vdout1_24ck144 = 0 time = 1450
* CHECK dout1_25 vdout1_25ck144 = 1.8 time = 1450
* CHECK dout1_26 vdout1_26ck144 = 0 time = 1450
* CHECK dout1_27 vdout1_27ck144 = 1.8 time = 1450
* CHECK dout1_28 vdout1_28ck144 = 0 time = 1450
* CHECK dout1_29 vdout1_29ck144 = 1.8 time = 1450
* CHECK dout1_30 vdout1_30ck144 = 1.8 time = 1450
* CHECK dout1_31 vdout1_31ck144 = 0 time = 1450
* CHECK dout0_0 vdout0_0ck145 = 1.8 time = 1460
* CHECK dout0_1 vdout0_1ck145 = 0 time = 1460
* CHECK dout0_2 vdout0_2ck145 = 0 time = 1460
* CHECK dout0_3 vdout0_3ck145 = 0 time = 1460
* CHECK dout0_4 vdout0_4ck145 = 0 time = 1460
* CHECK dout0_5 vdout0_5ck145 = 0 time = 1460
* CHECK dout0_6 vdout0_6ck145 = 0 time = 1460
* CHECK dout0_7 vdout0_7ck145 = 0 time = 1460
* CHECK dout0_8 vdout0_8ck145 = 1.8 time = 1460
* CHECK dout0_9 vdout0_9ck145 = 0 time = 1460
* CHECK dout0_10 vdout0_10ck145 = 0 time = 1460
* CHECK dout0_11 vdout0_11ck145 = 0 time = 1460
* CHECK dout0_12 vdout0_12ck145 = 0 time = 1460
* CHECK dout0_13 vdout0_13ck145 = 1.8 time = 1460
* CHECK dout0_14 vdout0_14ck145 = 0 time = 1460
* CHECK dout0_15 vdout0_15ck145 = 0 time = 1460
* CHECK dout0_16 vdout0_16ck145 = 0 time = 1460
* CHECK dout0_17 vdout0_17ck145 = 1.8 time = 1460
* CHECK dout0_18 vdout0_18ck145 = 1.8 time = 1460
* CHECK dout0_19 vdout0_19ck145 = 0 time = 1460
* CHECK dout0_20 vdout0_20ck145 = 1.8 time = 1460
* CHECK dout0_21 vdout0_21ck145 = 0 time = 1460
* CHECK dout0_22 vdout0_22ck145 = 0 time = 1460
* CHECK dout0_23 vdout0_23ck145 = 1.8 time = 1460
* CHECK dout0_24 vdout0_24ck145 = 1.8 time = 1460
* CHECK dout0_25 vdout0_25ck145 = 1.8 time = 1460
* CHECK dout0_26 vdout0_26ck145 = 1.8 time = 1460
* CHECK dout0_27 vdout0_27ck145 = 0 time = 1460
* CHECK dout0_28 vdout0_28ck145 = 0 time = 1460
* CHECK dout0_29 vdout0_29ck145 = 0 time = 1460
* CHECK dout0_30 vdout0_30ck145 = 0 time = 1460
* CHECK dout0_31 vdout0_31ck145 = 1.8 time = 1460
* CHECK dout1_0 vdout1_0ck145 = 0 time = 1460
* CHECK dout1_1 vdout1_1ck145 = 0 time = 1460
* CHECK dout1_2 vdout1_2ck145 = 1.8 time = 1460
* CHECK dout1_3 vdout1_3ck145 = 1.8 time = 1460
* CHECK dout1_4 vdout1_4ck145 = 0 time = 1460
* CHECK dout1_5 vdout1_5ck145 = 0 time = 1460
* CHECK dout1_6 vdout1_6ck145 = 0 time = 1460
* CHECK dout1_7 vdout1_7ck145 = 0 time = 1460
* CHECK dout1_8 vdout1_8ck145 = 0 time = 1460
* CHECK dout1_9 vdout1_9ck145 = 0 time = 1460
* CHECK dout1_10 vdout1_10ck145 = 1.8 time = 1460
* CHECK dout1_11 vdout1_11ck145 = 0 time = 1460
* CHECK dout1_12 vdout1_12ck145 = 1.8 time = 1460
* CHECK dout1_13 vdout1_13ck145 = 1.8 time = 1460
* CHECK dout1_14 vdout1_14ck145 = 1.8 time = 1460
* CHECK dout1_15 vdout1_15ck145 = 0 time = 1460
* CHECK dout1_16 vdout1_16ck145 = 0 time = 1460
* CHECK dout1_17 vdout1_17ck145 = 0 time = 1460
* CHECK dout1_18 vdout1_18ck145 = 0 time = 1460
* CHECK dout1_19 vdout1_19ck145 = 1.8 time = 1460
* CHECK dout1_20 vdout1_20ck145 = 0 time = 1460
* CHECK dout1_21 vdout1_21ck145 = 0 time = 1460
* CHECK dout1_22 vdout1_22ck145 = 1.8 time = 1460
* CHECK dout1_23 vdout1_23ck145 = 0 time = 1460
* CHECK dout1_24 vdout1_24ck145 = 0 time = 1460
* CHECK dout1_25 vdout1_25ck145 = 1.8 time = 1460
* CHECK dout1_26 vdout1_26ck145 = 0 time = 1460
* CHECK dout1_27 vdout1_27ck145 = 1.8 time = 1460
* CHECK dout1_28 vdout1_28ck145 = 0 time = 1460
* CHECK dout1_29 vdout1_29ck145 = 1.8 time = 1460
* CHECK dout1_30 vdout1_30ck145 = 1.8 time = 1460
* CHECK dout1_31 vdout1_31ck145 = 0 time = 1460
* CHECK dout0_0 vdout0_0ck146 = 1.8 time = 1470
* CHECK dout0_1 vdout0_1ck146 = 0 time = 1470
* CHECK dout0_2 vdout0_2ck146 = 0 time = 1470
* CHECK dout0_3 vdout0_3ck146 = 0 time = 1470
* CHECK dout0_4 vdout0_4ck146 = 0 time = 1470
* CHECK dout0_5 vdout0_5ck146 = 0 time = 1470
* CHECK dout0_6 vdout0_6ck146 = 0 time = 1470
* CHECK dout0_7 vdout0_7ck146 = 0 time = 1470
* CHECK dout0_8 vdout0_8ck146 = 1.8 time = 1470
* CHECK dout0_9 vdout0_9ck146 = 0 time = 1470
* CHECK dout0_10 vdout0_10ck146 = 0 time = 1470
* CHECK dout0_11 vdout0_11ck146 = 0 time = 1470
* CHECK dout0_12 vdout0_12ck146 = 0 time = 1470
* CHECK dout0_13 vdout0_13ck146 = 1.8 time = 1470
* CHECK dout0_14 vdout0_14ck146 = 0 time = 1470
* CHECK dout0_15 vdout0_15ck146 = 0 time = 1470
* CHECK dout0_16 vdout0_16ck146 = 0 time = 1470
* CHECK dout0_17 vdout0_17ck146 = 1.8 time = 1470
* CHECK dout0_18 vdout0_18ck146 = 1.8 time = 1470
* CHECK dout0_19 vdout0_19ck146 = 0 time = 1470
* CHECK dout0_20 vdout0_20ck146 = 1.8 time = 1470
* CHECK dout0_21 vdout0_21ck146 = 0 time = 1470
* CHECK dout0_22 vdout0_22ck146 = 0 time = 1470
* CHECK dout0_23 vdout0_23ck146 = 1.8 time = 1470
* CHECK dout0_24 vdout0_24ck146 = 1.8 time = 1470
* CHECK dout0_25 vdout0_25ck146 = 1.8 time = 1470
* CHECK dout0_26 vdout0_26ck146 = 1.8 time = 1470
* CHECK dout0_27 vdout0_27ck146 = 0 time = 1470
* CHECK dout0_28 vdout0_28ck146 = 0 time = 1470
* CHECK dout0_29 vdout0_29ck146 = 0 time = 1470
* CHECK dout0_30 vdout0_30ck146 = 0 time = 1470
* CHECK dout0_31 vdout0_31ck146 = 1.8 time = 1470
* CHECK dout1_0 vdout1_0ck149 = 0 time = 1500
* CHECK dout1_1 vdout1_1ck149 = 0 time = 1500
* CHECK dout1_2 vdout1_2ck149 = 1.8 time = 1500
* CHECK dout1_3 vdout1_3ck149 = 1.8 time = 1500
* CHECK dout1_4 vdout1_4ck149 = 0 time = 1500
* CHECK dout1_5 vdout1_5ck149 = 0 time = 1500
* CHECK dout1_6 vdout1_6ck149 = 0 time = 1500
* CHECK dout1_7 vdout1_7ck149 = 0 time = 1500
* CHECK dout1_8 vdout1_8ck149 = 0 time = 1500
* CHECK dout1_9 vdout1_9ck149 = 0 time = 1500
* CHECK dout1_10 vdout1_10ck149 = 1.8 time = 1500
* CHECK dout1_11 vdout1_11ck149 = 0 time = 1500
* CHECK dout1_12 vdout1_12ck149 = 1.8 time = 1500
* CHECK dout1_13 vdout1_13ck149 = 1.8 time = 1500
* CHECK dout1_14 vdout1_14ck149 = 1.8 time = 1500
* CHECK dout1_15 vdout1_15ck149 = 0 time = 1500
* CHECK dout1_16 vdout1_16ck149 = 0 time = 1500
* CHECK dout1_17 vdout1_17ck149 = 0 time = 1500
* CHECK dout1_18 vdout1_18ck149 = 0 time = 1500
* CHECK dout1_19 vdout1_19ck149 = 1.8 time = 1500
* CHECK dout1_20 vdout1_20ck149 = 0 time = 1500
* CHECK dout1_21 vdout1_21ck149 = 0 time = 1500
* CHECK dout1_22 vdout1_22ck149 = 1.8 time = 1500
* CHECK dout1_23 vdout1_23ck149 = 0 time = 1500
* CHECK dout1_24 vdout1_24ck149 = 0 time = 1500
* CHECK dout1_25 vdout1_25ck149 = 1.8 time = 1500
* CHECK dout1_26 vdout1_26ck149 = 0 time = 1500
* CHECK dout1_27 vdout1_27ck149 = 1.8 time = 1500
* CHECK dout1_28 vdout1_28ck149 = 0 time = 1500
* CHECK dout1_29 vdout1_29ck149 = 1.8 time = 1500
* CHECK dout1_30 vdout1_30ck149 = 1.8 time = 1500
* CHECK dout1_31 vdout1_31ck149 = 0 time = 1500
* CHECK dout0_0 vdout0_0ck151 = 0 time = 1520
* CHECK dout0_1 vdout0_1ck151 = 0 time = 1520
* CHECK dout0_2 vdout0_2ck151 = 1.8 time = 1520
* CHECK dout0_3 vdout0_3ck151 = 1.8 time = 1520
* CHECK dout0_4 vdout0_4ck151 = 0 time = 1520
* CHECK dout0_5 vdout0_5ck151 = 0 time = 1520
* CHECK dout0_6 vdout0_6ck151 = 0 time = 1520
* CHECK dout0_7 vdout0_7ck151 = 0 time = 1520
* CHECK dout0_8 vdout0_8ck151 = 0 time = 1520
* CHECK dout0_9 vdout0_9ck151 = 0 time = 1520
* CHECK dout0_10 vdout0_10ck151 = 1.8 time = 1520
* CHECK dout0_11 vdout0_11ck151 = 0 time = 1520
* CHECK dout0_12 vdout0_12ck151 = 1.8 time = 1520
* CHECK dout0_13 vdout0_13ck151 = 1.8 time = 1520
* CHECK dout0_14 vdout0_14ck151 = 1.8 time = 1520
* CHECK dout0_15 vdout0_15ck151 = 0 time = 1520
* CHECK dout0_16 vdout0_16ck151 = 0 time = 1520
* CHECK dout0_17 vdout0_17ck151 = 0 time = 1520
* CHECK dout0_18 vdout0_18ck151 = 0 time = 1520
* CHECK dout0_19 vdout0_19ck151 = 1.8 time = 1520
* CHECK dout0_20 vdout0_20ck151 = 0 time = 1520
* CHECK dout0_21 vdout0_21ck151 = 0 time = 1520
* CHECK dout0_22 vdout0_22ck151 = 1.8 time = 1520
* CHECK dout0_23 vdout0_23ck151 = 0 time = 1520
* CHECK dout0_24 vdout0_24ck151 = 0 time = 1520
* CHECK dout0_25 vdout0_25ck151 = 1.8 time = 1520
* CHECK dout0_26 vdout0_26ck151 = 0 time = 1520
* CHECK dout0_27 vdout0_27ck151 = 1.8 time = 1520
* CHECK dout0_28 vdout0_28ck151 = 0 time = 1520
* CHECK dout0_29 vdout0_29ck151 = 1.8 time = 1520
* CHECK dout0_30 vdout0_30ck151 = 1.8 time = 1520
* CHECK dout0_31 vdout0_31ck151 = 0 time = 1520
* CHECK dout1_0 vdout1_0ck151 = 0 time = 1520
* CHECK dout1_1 vdout1_1ck151 = 0 time = 1520
* CHECK dout1_2 vdout1_2ck151 = 1.8 time = 1520
* CHECK dout1_3 vdout1_3ck151 = 1.8 time = 1520
* CHECK dout1_4 vdout1_4ck151 = 0 time = 1520
* CHECK dout1_5 vdout1_5ck151 = 0 time = 1520
* CHECK dout1_6 vdout1_6ck151 = 0 time = 1520
* CHECK dout1_7 vdout1_7ck151 = 0 time = 1520
* CHECK dout1_8 vdout1_8ck151 = 0 time = 1520
* CHECK dout1_9 vdout1_9ck151 = 0 time = 1520
* CHECK dout1_10 vdout1_10ck151 = 1.8 time = 1520
* CHECK dout1_11 vdout1_11ck151 = 0 time = 1520
* CHECK dout1_12 vdout1_12ck151 = 1.8 time = 1520
* CHECK dout1_13 vdout1_13ck151 = 1.8 time = 1520
* CHECK dout1_14 vdout1_14ck151 = 1.8 time = 1520
* CHECK dout1_15 vdout1_15ck151 = 0 time = 1520
* CHECK dout1_16 vdout1_16ck151 = 0 time = 1520
* CHECK dout1_17 vdout1_17ck151 = 0 time = 1520
* CHECK dout1_18 vdout1_18ck151 = 0 time = 1520
* CHECK dout1_19 vdout1_19ck151 = 1.8 time = 1520
* CHECK dout1_20 vdout1_20ck151 = 0 time = 1520
* CHECK dout1_21 vdout1_21ck151 = 0 time = 1520
* CHECK dout1_22 vdout1_22ck151 = 1.8 time = 1520
* CHECK dout1_23 vdout1_23ck151 = 0 time = 1520
* CHECK dout1_24 vdout1_24ck151 = 0 time = 1520
* CHECK dout1_25 vdout1_25ck151 = 1.8 time = 1520
* CHECK dout1_26 vdout1_26ck151 = 0 time = 1520
* CHECK dout1_27 vdout1_27ck151 = 1.8 time = 1520
* CHECK dout1_28 vdout1_28ck151 = 0 time = 1520
* CHECK dout1_29 vdout1_29ck151 = 1.8 time = 1520
* CHECK dout1_30 vdout1_30ck151 = 1.8 time = 1520
* CHECK dout1_31 vdout1_31ck151 = 0 time = 1520
* CHECK dout0_0 vdout0_0ck152 = 0 time = 1530
* CHECK dout0_1 vdout0_1ck152 = 0 time = 1530
* CHECK dout0_2 vdout0_2ck152 = 1.8 time = 1530
* CHECK dout0_3 vdout0_3ck152 = 0 time = 1530
* CHECK dout0_4 vdout0_4ck152 = 0 time = 1530
* CHECK dout0_5 vdout0_5ck152 = 0 time = 1530
* CHECK dout0_6 vdout0_6ck152 = 1.8 time = 1530
* CHECK dout0_7 vdout0_7ck152 = 0 time = 1530
* CHECK dout0_8 vdout0_8ck152 = 0 time = 1530
* CHECK dout0_9 vdout0_9ck152 = 1.8 time = 1530
* CHECK dout0_10 vdout0_10ck152 = 1.8 time = 1530
* CHECK dout0_11 vdout0_11ck152 = 0 time = 1530
* CHECK dout0_12 vdout0_12ck152 = 0 time = 1530
* CHECK dout0_13 vdout0_13ck152 = 0 time = 1530
* CHECK dout0_14 vdout0_14ck152 = 1.8 time = 1530
* CHECK dout0_15 vdout0_15ck152 = 0 time = 1530
* CHECK dout0_16 vdout0_16ck152 = 1.8 time = 1530
* CHECK dout0_17 vdout0_17ck152 = 1.8 time = 1530
* CHECK dout0_18 vdout0_18ck152 = 1.8 time = 1530
* CHECK dout0_19 vdout0_19ck152 = 1.8 time = 1530
* CHECK dout0_20 vdout0_20ck152 = 1.8 time = 1530
* CHECK dout0_21 vdout0_21ck152 = 0 time = 1530
* CHECK dout0_22 vdout0_22ck152 = 1.8 time = 1530
* CHECK dout0_23 vdout0_23ck152 = 1.8 time = 1530
* CHECK dout0_24 vdout0_24ck152 = 1.8 time = 1530
* CHECK dout0_25 vdout0_25ck152 = 1.8 time = 1530
* CHECK dout0_26 vdout0_26ck152 = 0 time = 1530
* CHECK dout0_27 vdout0_27ck152 = 0 time = 1530
* CHECK dout0_28 vdout0_28ck152 = 0 time = 1530
* CHECK dout0_29 vdout0_29ck152 = 1.8 time = 1530
* CHECK dout0_30 vdout0_30ck152 = 1.8 time = 1530
* CHECK dout0_31 vdout0_31ck152 = 0 time = 1530
* CHECK dout1_0 vdout1_0ck152 = 0 time = 1530
* CHECK dout1_1 vdout1_1ck152 = 0 time = 1530
* CHECK dout1_2 vdout1_2ck152 = 1.8 time = 1530
* CHECK dout1_3 vdout1_3ck152 = 1.8 time = 1530
* CHECK dout1_4 vdout1_4ck152 = 0 time = 1530
* CHECK dout1_5 vdout1_5ck152 = 0 time = 1530
* CHECK dout1_6 vdout1_6ck152 = 0 time = 1530
* CHECK dout1_7 vdout1_7ck152 = 0 time = 1530
* CHECK dout1_8 vdout1_8ck152 = 0 time = 1530
* CHECK dout1_9 vdout1_9ck152 = 0 time = 1530
* CHECK dout1_10 vdout1_10ck152 = 1.8 time = 1530
* CHECK dout1_11 vdout1_11ck152 = 0 time = 1530
* CHECK dout1_12 vdout1_12ck152 = 1.8 time = 1530
* CHECK dout1_13 vdout1_13ck152 = 1.8 time = 1530
* CHECK dout1_14 vdout1_14ck152 = 1.8 time = 1530
* CHECK dout1_15 vdout1_15ck152 = 0 time = 1530
* CHECK dout1_16 vdout1_16ck152 = 0 time = 1530
* CHECK dout1_17 vdout1_17ck152 = 0 time = 1530
* CHECK dout1_18 vdout1_18ck152 = 0 time = 1530
* CHECK dout1_19 vdout1_19ck152 = 1.8 time = 1530
* CHECK dout1_20 vdout1_20ck152 = 0 time = 1530
* CHECK dout1_21 vdout1_21ck152 = 0 time = 1530
* CHECK dout1_22 vdout1_22ck152 = 1.8 time = 1530
* CHECK dout1_23 vdout1_23ck152 = 0 time = 1530
* CHECK dout1_24 vdout1_24ck152 = 0 time = 1530
* CHECK dout1_25 vdout1_25ck152 = 1.8 time = 1530
* CHECK dout1_26 vdout1_26ck152 = 0 time = 1530
* CHECK dout1_27 vdout1_27ck152 = 1.8 time = 1530
* CHECK dout1_28 vdout1_28ck152 = 0 time = 1530
* CHECK dout1_29 vdout1_29ck152 = 1.8 time = 1530
* CHECK dout1_30 vdout1_30ck152 = 1.8 time = 1530
* CHECK dout1_31 vdout1_31ck152 = 0 time = 1530
* CHECK dout0_0 vdout0_0ck153 = 0 time = 1540
* CHECK dout0_1 vdout0_1ck153 = 0 time = 1540
* CHECK dout0_2 vdout0_2ck153 = 1.8 time = 1540
* CHECK dout0_3 vdout0_3ck153 = 0 time = 1540
* CHECK dout0_4 vdout0_4ck153 = 0 time = 1540
* CHECK dout0_5 vdout0_5ck153 = 0 time = 1540
* CHECK dout0_6 vdout0_6ck153 = 1.8 time = 1540
* CHECK dout0_7 vdout0_7ck153 = 0 time = 1540
* CHECK dout0_8 vdout0_8ck153 = 0 time = 1540
* CHECK dout0_9 vdout0_9ck153 = 1.8 time = 1540
* CHECK dout0_10 vdout0_10ck153 = 1.8 time = 1540
* CHECK dout0_11 vdout0_11ck153 = 0 time = 1540
* CHECK dout0_12 vdout0_12ck153 = 0 time = 1540
* CHECK dout0_13 vdout0_13ck153 = 0 time = 1540
* CHECK dout0_14 vdout0_14ck153 = 1.8 time = 1540
* CHECK dout0_15 vdout0_15ck153 = 0 time = 1540
* CHECK dout0_16 vdout0_16ck153 = 1.8 time = 1540
* CHECK dout0_17 vdout0_17ck153 = 1.8 time = 1540
* CHECK dout0_18 vdout0_18ck153 = 1.8 time = 1540
* CHECK dout0_19 vdout0_19ck153 = 1.8 time = 1540
* CHECK dout0_20 vdout0_20ck153 = 1.8 time = 1540
* CHECK dout0_21 vdout0_21ck153 = 0 time = 1540
* CHECK dout0_22 vdout0_22ck153 = 1.8 time = 1540
* CHECK dout0_23 vdout0_23ck153 = 1.8 time = 1540
* CHECK dout0_24 vdout0_24ck153 = 1.8 time = 1540
* CHECK dout0_25 vdout0_25ck153 = 1.8 time = 1540
* CHECK dout0_26 vdout0_26ck153 = 0 time = 1540
* CHECK dout0_27 vdout0_27ck153 = 0 time = 1540
* CHECK dout0_28 vdout0_28ck153 = 0 time = 1540
* CHECK dout0_29 vdout0_29ck153 = 1.8 time = 1540
* CHECK dout0_30 vdout0_30ck153 = 1.8 time = 1540
* CHECK dout0_31 vdout0_31ck153 = 0 time = 1540
* CHECK dout1_0 vdout1_0ck153 = 0 time = 1540
* CHECK dout1_1 vdout1_1ck153 = 0 time = 1540
* CHECK dout1_2 vdout1_2ck153 = 1.8 time = 1540
* CHECK dout1_3 vdout1_3ck153 = 1.8 time = 1540
* CHECK dout1_4 vdout1_4ck153 = 0 time = 1540
* CHECK dout1_5 vdout1_5ck153 = 0 time = 1540
* CHECK dout1_6 vdout1_6ck153 = 0 time = 1540
* CHECK dout1_7 vdout1_7ck153 = 0 time = 1540
* CHECK dout1_8 vdout1_8ck153 = 0 time = 1540
* CHECK dout1_9 vdout1_9ck153 = 0 time = 1540
* CHECK dout1_10 vdout1_10ck153 = 1.8 time = 1540
* CHECK dout1_11 vdout1_11ck153 = 0 time = 1540
* CHECK dout1_12 vdout1_12ck153 = 1.8 time = 1540
* CHECK dout1_13 vdout1_13ck153 = 1.8 time = 1540
* CHECK dout1_14 vdout1_14ck153 = 1.8 time = 1540
* CHECK dout1_15 vdout1_15ck153 = 0 time = 1540
* CHECK dout1_16 vdout1_16ck153 = 0 time = 1540
* CHECK dout1_17 vdout1_17ck153 = 0 time = 1540
* CHECK dout1_18 vdout1_18ck153 = 0 time = 1540
* CHECK dout1_19 vdout1_19ck153 = 1.8 time = 1540
* CHECK dout1_20 vdout1_20ck153 = 0 time = 1540
* CHECK dout1_21 vdout1_21ck153 = 0 time = 1540
* CHECK dout1_22 vdout1_22ck153 = 1.8 time = 1540
* CHECK dout1_23 vdout1_23ck153 = 0 time = 1540
* CHECK dout1_24 vdout1_24ck153 = 0 time = 1540
* CHECK dout1_25 vdout1_25ck153 = 1.8 time = 1540
* CHECK dout1_26 vdout1_26ck153 = 0 time = 1540
* CHECK dout1_27 vdout1_27ck153 = 1.8 time = 1540
* CHECK dout1_28 vdout1_28ck153 = 0 time = 1540
* CHECK dout1_29 vdout1_29ck153 = 1.8 time = 1540
* CHECK dout1_30 vdout1_30ck153 = 1.8 time = 1540
* CHECK dout1_31 vdout1_31ck153 = 0 time = 1540
* CHECK dout0_0 vdout0_0ck154 = 0 time = 1550
* CHECK dout0_1 vdout0_1ck154 = 0 time = 1550
* CHECK dout0_2 vdout0_2ck154 = 1.8 time = 1550
* CHECK dout0_3 vdout0_3ck154 = 0 time = 1550
* CHECK dout0_4 vdout0_4ck154 = 0 time = 1550
* CHECK dout0_5 vdout0_5ck154 = 0 time = 1550
* CHECK dout0_6 vdout0_6ck154 = 1.8 time = 1550
* CHECK dout0_7 vdout0_7ck154 = 0 time = 1550
* CHECK dout0_8 vdout0_8ck154 = 0 time = 1550
* CHECK dout0_9 vdout0_9ck154 = 1.8 time = 1550
* CHECK dout0_10 vdout0_10ck154 = 1.8 time = 1550
* CHECK dout0_11 vdout0_11ck154 = 0 time = 1550
* CHECK dout0_12 vdout0_12ck154 = 0 time = 1550
* CHECK dout0_13 vdout0_13ck154 = 0 time = 1550
* CHECK dout0_14 vdout0_14ck154 = 1.8 time = 1550
* CHECK dout0_15 vdout0_15ck154 = 0 time = 1550
* CHECK dout0_16 vdout0_16ck154 = 1.8 time = 1550
* CHECK dout0_17 vdout0_17ck154 = 1.8 time = 1550
* CHECK dout0_18 vdout0_18ck154 = 1.8 time = 1550
* CHECK dout0_19 vdout0_19ck154 = 1.8 time = 1550
* CHECK dout0_20 vdout0_20ck154 = 1.8 time = 1550
* CHECK dout0_21 vdout0_21ck154 = 0 time = 1550
* CHECK dout0_22 vdout0_22ck154 = 1.8 time = 1550
* CHECK dout0_23 vdout0_23ck154 = 1.8 time = 1550
* CHECK dout0_24 vdout0_24ck154 = 1.8 time = 1550
* CHECK dout0_25 vdout0_25ck154 = 1.8 time = 1550
* CHECK dout0_26 vdout0_26ck154 = 0 time = 1550
* CHECK dout0_27 vdout0_27ck154 = 0 time = 1550
* CHECK dout0_28 vdout0_28ck154 = 0 time = 1550
* CHECK dout0_29 vdout0_29ck154 = 1.8 time = 1550
* CHECK dout0_30 vdout0_30ck154 = 1.8 time = 1550
* CHECK dout0_31 vdout0_31ck154 = 0 time = 1550
* CHECK dout0_0 vdout0_0ck156 = 1.8 time = 1570
* CHECK dout0_1 vdout0_1ck156 = 0 time = 1570
* CHECK dout0_2 vdout0_2ck156 = 1.8 time = 1570
* CHECK dout0_3 vdout0_3ck156 = 0 time = 1570
* CHECK dout0_4 vdout0_4ck156 = 1.8 time = 1570
* CHECK dout0_5 vdout0_5ck156 = 1.8 time = 1570
* CHECK dout0_6 vdout0_6ck156 = 0 time = 1570
* CHECK dout0_7 vdout0_7ck156 = 1.8 time = 1570
* CHECK dout0_8 vdout0_8ck156 = 1.8 time = 1570
* CHECK dout0_9 vdout0_9ck156 = 1.8 time = 1570
* CHECK dout0_10 vdout0_10ck156 = 1.8 time = 1570
* CHECK dout0_11 vdout0_11ck156 = 1.8 time = 1570
* CHECK dout0_12 vdout0_12ck156 = 0 time = 1570
* CHECK dout0_13 vdout0_13ck156 = 0 time = 1570
* CHECK dout0_14 vdout0_14ck156 = 1.8 time = 1570
* CHECK dout0_15 vdout0_15ck156 = 1.8 time = 1570
* CHECK dout0_16 vdout0_16ck156 = 1.8 time = 1570
* CHECK dout0_17 vdout0_17ck156 = 1.8 time = 1570
* CHECK dout0_18 vdout0_18ck156 = 0 time = 1570
* CHECK dout0_19 vdout0_19ck156 = 0 time = 1570
* CHECK dout0_20 vdout0_20ck156 = 0 time = 1570
* CHECK dout0_21 vdout0_21ck156 = 0 time = 1570
* CHECK dout0_22 vdout0_22ck156 = 1.8 time = 1570
* CHECK dout0_23 vdout0_23ck156 = 0 time = 1570
* CHECK dout0_24 vdout0_24ck156 = 0 time = 1570
* CHECK dout0_25 vdout0_25ck156 = 0 time = 1570
* CHECK dout0_26 vdout0_26ck156 = 1.8 time = 1570
* CHECK dout0_27 vdout0_27ck156 = 1.8 time = 1570
* CHECK dout0_28 vdout0_28ck156 = 0 time = 1570
* CHECK dout0_29 vdout0_29ck156 = 0 time = 1570
* CHECK dout0_30 vdout0_30ck156 = 1.8 time = 1570
* CHECK dout0_31 vdout0_31ck156 = 1.8 time = 1570
* CHECK dout1_0 vdout1_0ck156 = 0 time = 1570
* CHECK dout1_1 vdout1_1ck156 = 0 time = 1570
* CHECK dout1_2 vdout1_2ck156 = 1.8 time = 1570
* CHECK dout1_3 vdout1_3ck156 = 0 time = 1570
* CHECK dout1_4 vdout1_4ck156 = 0 time = 1570
* CHECK dout1_5 vdout1_5ck156 = 0 time = 1570
* CHECK dout1_6 vdout1_6ck156 = 1.8 time = 1570
* CHECK dout1_7 vdout1_7ck156 = 0 time = 1570
* CHECK dout1_8 vdout1_8ck156 = 0 time = 1570
* CHECK dout1_9 vdout1_9ck156 = 1.8 time = 1570
* CHECK dout1_10 vdout1_10ck156 = 1.8 time = 1570
* CHECK dout1_11 vdout1_11ck156 = 0 time = 1570
* CHECK dout1_12 vdout1_12ck156 = 0 time = 1570
* CHECK dout1_13 vdout1_13ck156 = 0 time = 1570
* CHECK dout1_14 vdout1_14ck156 = 1.8 time = 1570
* CHECK dout1_15 vdout1_15ck156 = 0 time = 1570
* CHECK dout1_16 vdout1_16ck156 = 1.8 time = 1570
* CHECK dout1_17 vdout1_17ck156 = 1.8 time = 1570
* CHECK dout1_18 vdout1_18ck156 = 1.8 time = 1570
* CHECK dout1_19 vdout1_19ck156 = 1.8 time = 1570
* CHECK dout1_20 vdout1_20ck156 = 1.8 time = 1570
* CHECK dout1_21 vdout1_21ck156 = 0 time = 1570
* CHECK dout1_22 vdout1_22ck156 = 1.8 time = 1570
* CHECK dout1_23 vdout1_23ck156 = 1.8 time = 1570
* CHECK dout1_24 vdout1_24ck156 = 1.8 time = 1570
* CHECK dout1_25 vdout1_25ck156 = 1.8 time = 1570
* CHECK dout1_26 vdout1_26ck156 = 0 time = 1570
* CHECK dout1_27 vdout1_27ck156 = 0 time = 1570
* CHECK dout1_28 vdout1_28ck156 = 0 time = 1570
* CHECK dout1_29 vdout1_29ck156 = 1.8 time = 1570
* CHECK dout1_30 vdout1_30ck156 = 1.8 time = 1570
* CHECK dout1_31 vdout1_31ck156 = 0 time = 1570
* CHECK dout0_0 vdout0_0ck160 = 0 time = 1610
* CHECK dout0_1 vdout0_1ck160 = 0 time = 1610
* CHECK dout0_2 vdout0_2ck160 = 1.8 time = 1610
* CHECK dout0_3 vdout0_3ck160 = 0 time = 1610
* CHECK dout0_4 vdout0_4ck160 = 1.8 time = 1610
* CHECK dout0_5 vdout0_5ck160 = 1.8 time = 1610
* CHECK dout0_6 vdout0_6ck160 = 0 time = 1610
* CHECK dout0_7 vdout0_7ck160 = 1.8 time = 1610
* CHECK dout0_8 vdout0_8ck160 = 1.8 time = 1610
* CHECK dout0_9 vdout0_9ck160 = 1.8 time = 1610
* CHECK dout0_10 vdout0_10ck160 = 1.8 time = 1610
* CHECK dout0_11 vdout0_11ck160 = 1.8 time = 1610
* CHECK dout0_12 vdout0_12ck160 = 0 time = 1610
* CHECK dout0_13 vdout0_13ck160 = 0 time = 1610
* CHECK dout0_14 vdout0_14ck160 = 1.8 time = 1610
* CHECK dout0_15 vdout0_15ck160 = 1.8 time = 1610
* CHECK dout0_16 vdout0_16ck160 = 1.8 time = 1610
* CHECK dout0_17 vdout0_17ck160 = 1.8 time = 1610
* CHECK dout0_18 vdout0_18ck160 = 0 time = 1610
* CHECK dout0_19 vdout0_19ck160 = 1.8 time = 1610
* CHECK dout0_20 vdout0_20ck160 = 0 time = 1610
* CHECK dout0_21 vdout0_21ck160 = 0 time = 1610
* CHECK dout0_22 vdout0_22ck160 = 1.8 time = 1610
* CHECK dout0_23 vdout0_23ck160 = 0 time = 1610
* CHECK dout0_24 vdout0_24ck160 = 1.8 time = 1610
* CHECK dout0_25 vdout0_25ck160 = 1.8 time = 1610
* CHECK dout0_26 vdout0_26ck160 = 0 time = 1610
* CHECK dout0_27 vdout0_27ck160 = 1.8 time = 1610
* CHECK dout0_28 vdout0_28ck160 = 0 time = 1610
* CHECK dout0_29 vdout0_29ck160 = 0 time = 1610
* CHECK dout0_30 vdout0_30ck160 = 1.8 time = 1610
* CHECK dout0_31 vdout0_31ck160 = 0 time = 1610
* CHECK dout1_0 vdout1_0ck161 = 0 time = 1620
* CHECK dout1_1 vdout1_1ck161 = 0 time = 1620
* CHECK dout1_2 vdout1_2ck161 = 1.8 time = 1620
* CHECK dout1_3 vdout1_3ck161 = 0 time = 1620
* CHECK dout1_4 vdout1_4ck161 = 1.8 time = 1620
* CHECK dout1_5 vdout1_5ck161 = 1.8 time = 1620
* CHECK dout1_6 vdout1_6ck161 = 0 time = 1620
* CHECK dout1_7 vdout1_7ck161 = 1.8 time = 1620
* CHECK dout1_8 vdout1_8ck161 = 1.8 time = 1620
* CHECK dout1_9 vdout1_9ck161 = 1.8 time = 1620
* CHECK dout1_10 vdout1_10ck161 = 1.8 time = 1620
* CHECK dout1_11 vdout1_11ck161 = 1.8 time = 1620
* CHECK dout1_12 vdout1_12ck161 = 0 time = 1620
* CHECK dout1_13 vdout1_13ck161 = 0 time = 1620
* CHECK dout1_14 vdout1_14ck161 = 1.8 time = 1620
* CHECK dout1_15 vdout1_15ck161 = 1.8 time = 1620
* CHECK dout1_16 vdout1_16ck161 = 1.8 time = 1620
* CHECK dout1_17 vdout1_17ck161 = 1.8 time = 1620
* CHECK dout1_18 vdout1_18ck161 = 0 time = 1620
* CHECK dout1_19 vdout1_19ck161 = 1.8 time = 1620
* CHECK dout1_20 vdout1_20ck161 = 0 time = 1620
* CHECK dout1_21 vdout1_21ck161 = 0 time = 1620
* CHECK dout1_22 vdout1_22ck161 = 1.8 time = 1620
* CHECK dout1_23 vdout1_23ck161 = 0 time = 1620
* CHECK dout1_24 vdout1_24ck161 = 1.8 time = 1620
* CHECK dout1_25 vdout1_25ck161 = 1.8 time = 1620
* CHECK dout1_26 vdout1_26ck161 = 0 time = 1620
* CHECK dout1_27 vdout1_27ck161 = 1.8 time = 1620
* CHECK dout1_28 vdout1_28ck161 = 0 time = 1620
* CHECK dout1_29 vdout1_29ck161 = 0 time = 1620
* CHECK dout1_30 vdout1_30ck161 = 1.8 time = 1620
* CHECK dout1_31 vdout1_31ck161 = 0 time = 1620
* CHECK dout0_0 vdout0_0ck162 = 0 time = 1630
* CHECK dout0_1 vdout0_1ck162 = 0 time = 1630
* CHECK dout0_2 vdout0_2ck162 = 1.8 time = 1630
* CHECK dout0_3 vdout0_3ck162 = 0 time = 1630
* CHECK dout0_4 vdout0_4ck162 = 0 time = 1630
* CHECK dout0_5 vdout0_5ck162 = 0 time = 1630
* CHECK dout0_6 vdout0_6ck162 = 1.8 time = 1630
* CHECK dout0_7 vdout0_7ck162 = 0 time = 1630
* CHECK dout0_8 vdout0_8ck162 = 0 time = 1630
* CHECK dout0_9 vdout0_9ck162 = 1.8 time = 1630
* CHECK dout0_10 vdout0_10ck162 = 1.8 time = 1630
* CHECK dout0_11 vdout0_11ck162 = 0 time = 1630
* CHECK dout0_12 vdout0_12ck162 = 0 time = 1630
* CHECK dout0_13 vdout0_13ck162 = 0 time = 1630
* CHECK dout0_14 vdout0_14ck162 = 1.8 time = 1630
* CHECK dout0_15 vdout0_15ck162 = 0 time = 1630
* CHECK dout0_16 vdout0_16ck162 = 1.8 time = 1630
* CHECK dout0_17 vdout0_17ck162 = 1.8 time = 1630
* CHECK dout0_18 vdout0_18ck162 = 1.8 time = 1630
* CHECK dout0_19 vdout0_19ck162 = 1.8 time = 1630
* CHECK dout0_20 vdout0_20ck162 = 1.8 time = 1630
* CHECK dout0_21 vdout0_21ck162 = 0 time = 1630
* CHECK dout0_22 vdout0_22ck162 = 1.8 time = 1630
* CHECK dout0_23 vdout0_23ck162 = 1.8 time = 1630
* CHECK dout0_24 vdout0_24ck162 = 1.8 time = 1630
* CHECK dout0_25 vdout0_25ck162 = 1.8 time = 1630
* CHECK dout0_26 vdout0_26ck162 = 0 time = 1630
* CHECK dout0_27 vdout0_27ck162 = 0 time = 1630
* CHECK dout0_28 vdout0_28ck162 = 0 time = 1630
* CHECK dout0_29 vdout0_29ck162 = 1.8 time = 1630
* CHECK dout0_30 vdout0_30ck162 = 1.8 time = 1630
* CHECK dout0_31 vdout0_31ck162 = 0 time = 1630
* CHECK dout0_0 vdout0_0ck163 = 0 time = 1640
* CHECK dout0_1 vdout0_1ck163 = 0 time = 1640
* CHECK dout0_2 vdout0_2ck163 = 1.8 time = 1640
* CHECK dout0_3 vdout0_3ck163 = 0 time = 1640
* CHECK dout0_4 vdout0_4ck163 = 1.8 time = 1640
* CHECK dout0_5 vdout0_5ck163 = 1.8 time = 1640
* CHECK dout0_6 vdout0_6ck163 = 0 time = 1640
* CHECK dout0_7 vdout0_7ck163 = 1.8 time = 1640
* CHECK dout0_8 vdout0_8ck163 = 1.8 time = 1640
* CHECK dout0_9 vdout0_9ck163 = 1.8 time = 1640
* CHECK dout0_10 vdout0_10ck163 = 1.8 time = 1640
* CHECK dout0_11 vdout0_11ck163 = 1.8 time = 1640
* CHECK dout0_12 vdout0_12ck163 = 0 time = 1640
* CHECK dout0_13 vdout0_13ck163 = 0 time = 1640
* CHECK dout0_14 vdout0_14ck163 = 1.8 time = 1640
* CHECK dout0_15 vdout0_15ck163 = 1.8 time = 1640
* CHECK dout0_16 vdout0_16ck163 = 1.8 time = 1640
* CHECK dout0_17 vdout0_17ck163 = 1.8 time = 1640
* CHECK dout0_18 vdout0_18ck163 = 0 time = 1640
* CHECK dout0_19 vdout0_19ck163 = 1.8 time = 1640
* CHECK dout0_20 vdout0_20ck163 = 0 time = 1640
* CHECK dout0_21 vdout0_21ck163 = 0 time = 1640
* CHECK dout0_22 vdout0_22ck163 = 1.8 time = 1640
* CHECK dout0_23 vdout0_23ck163 = 0 time = 1640
* CHECK dout0_24 vdout0_24ck163 = 1.8 time = 1640
* CHECK dout0_25 vdout0_25ck163 = 1.8 time = 1640
* CHECK dout0_26 vdout0_26ck163 = 0 time = 1640
* CHECK dout0_27 vdout0_27ck163 = 1.8 time = 1640
* CHECK dout0_28 vdout0_28ck163 = 0 time = 1640
* CHECK dout0_29 vdout0_29ck163 = 0 time = 1640
* CHECK dout0_30 vdout0_30ck163 = 1.8 time = 1640
* CHECK dout0_31 vdout0_31ck163 = 0 time = 1640
* CHECK dout0_0 vdout0_0ck164 = 0 time = 1650
* CHECK dout0_1 vdout0_1ck164 = 0 time = 1650
* CHECK dout0_2 vdout0_2ck164 = 1.8 time = 1650
* CHECK dout0_3 vdout0_3ck164 = 0 time = 1650
* CHECK dout0_4 vdout0_4ck164 = 1.8 time = 1650
* CHECK dout0_5 vdout0_5ck164 = 1.8 time = 1650
* CHECK dout0_6 vdout0_6ck164 = 0 time = 1650
* CHECK dout0_7 vdout0_7ck164 = 1.8 time = 1650
* CHECK dout0_8 vdout0_8ck164 = 1.8 time = 1650
* CHECK dout0_9 vdout0_9ck164 = 1.8 time = 1650
* CHECK dout0_10 vdout0_10ck164 = 1.8 time = 1650
* CHECK dout0_11 vdout0_11ck164 = 1.8 time = 1650
* CHECK dout0_12 vdout0_12ck164 = 0 time = 1650
* CHECK dout0_13 vdout0_13ck164 = 0 time = 1650
* CHECK dout0_14 vdout0_14ck164 = 1.8 time = 1650
* CHECK dout0_15 vdout0_15ck164 = 1.8 time = 1650
* CHECK dout0_16 vdout0_16ck164 = 1.8 time = 1650
* CHECK dout0_17 vdout0_17ck164 = 1.8 time = 1650
* CHECK dout0_18 vdout0_18ck164 = 0 time = 1650
* CHECK dout0_19 vdout0_19ck164 = 1.8 time = 1650
* CHECK dout0_20 vdout0_20ck164 = 0 time = 1650
* CHECK dout0_21 vdout0_21ck164 = 0 time = 1650
* CHECK dout0_22 vdout0_22ck164 = 1.8 time = 1650
* CHECK dout0_23 vdout0_23ck164 = 0 time = 1650
* CHECK dout0_24 vdout0_24ck164 = 1.8 time = 1650
* CHECK dout0_25 vdout0_25ck164 = 1.8 time = 1650
* CHECK dout0_26 vdout0_26ck164 = 0 time = 1650
* CHECK dout0_27 vdout0_27ck164 = 1.8 time = 1650
* CHECK dout0_28 vdout0_28ck164 = 0 time = 1650
* CHECK dout0_29 vdout0_29ck164 = 0 time = 1650
* CHECK dout0_30 vdout0_30ck164 = 1.8 time = 1650
* CHECK dout0_31 vdout0_31ck164 = 0 time = 1650
* CHECK dout1_0 vdout1_0ck164 = 0 time = 1650
* CHECK dout1_1 vdout1_1ck164 = 0 time = 1650
* CHECK dout1_2 vdout1_2ck164 = 1.8 time = 1650
* CHECK dout1_3 vdout1_3ck164 = 0 time = 1650
* CHECK dout1_4 vdout1_4ck164 = 0 time = 1650
* CHECK dout1_5 vdout1_5ck164 = 0 time = 1650
* CHECK dout1_6 vdout1_6ck164 = 1.8 time = 1650
* CHECK dout1_7 vdout1_7ck164 = 0 time = 1650
* CHECK dout1_8 vdout1_8ck164 = 0 time = 1650
* CHECK dout1_9 vdout1_9ck164 = 1.8 time = 1650
* CHECK dout1_10 vdout1_10ck164 = 1.8 time = 1650
* CHECK dout1_11 vdout1_11ck164 = 0 time = 1650
* CHECK dout1_12 vdout1_12ck164 = 0 time = 1650
* CHECK dout1_13 vdout1_13ck164 = 0 time = 1650
* CHECK dout1_14 vdout1_14ck164 = 1.8 time = 1650
* CHECK dout1_15 vdout1_15ck164 = 0 time = 1650
* CHECK dout1_16 vdout1_16ck164 = 1.8 time = 1650
* CHECK dout1_17 vdout1_17ck164 = 1.8 time = 1650
* CHECK dout1_18 vdout1_18ck164 = 1.8 time = 1650
* CHECK dout1_19 vdout1_19ck164 = 1.8 time = 1650
* CHECK dout1_20 vdout1_20ck164 = 1.8 time = 1650
* CHECK dout1_21 vdout1_21ck164 = 0 time = 1650
* CHECK dout1_22 vdout1_22ck164 = 1.8 time = 1650
* CHECK dout1_23 vdout1_23ck164 = 1.8 time = 1650
* CHECK dout1_24 vdout1_24ck164 = 1.8 time = 1650
* CHECK dout1_25 vdout1_25ck164 = 1.8 time = 1650
* CHECK dout1_26 vdout1_26ck164 = 0 time = 1650
* CHECK dout1_27 vdout1_27ck164 = 0 time = 1650
* CHECK dout1_28 vdout1_28ck164 = 0 time = 1650
* CHECK dout1_29 vdout1_29ck164 = 1.8 time = 1650
* CHECK dout1_30 vdout1_30ck164 = 1.8 time = 1650
* CHECK dout1_31 vdout1_31ck164 = 0 time = 1650
* CHECK dout1_0 vdout1_0ck166 = 0 time = 1670
* CHECK dout1_1 vdout1_1ck166 = 0 time = 1670
* CHECK dout1_2 vdout1_2ck166 = 0 time = 1670
* CHECK dout1_3 vdout1_3ck166 = 0 time = 1670
* CHECK dout1_4 vdout1_4ck166 = 0 time = 1670
* CHECK dout1_5 vdout1_5ck166 = 1.8 time = 1670
* CHECK dout1_6 vdout1_6ck166 = 0 time = 1670
* CHECK dout1_7 vdout1_7ck166 = 1.8 time = 1670
* CHECK dout1_8 vdout1_8ck166 = 0 time = 1670
* CHECK dout1_9 vdout1_9ck166 = 1.8 time = 1670
* CHECK dout1_10 vdout1_10ck166 = 0 time = 1670
* CHECK dout1_11 vdout1_11ck166 = 0 time = 1670
* CHECK dout1_12 vdout1_12ck166 = 1.8 time = 1670
* CHECK dout1_13 vdout1_13ck166 = 0 time = 1670
* CHECK dout1_14 vdout1_14ck166 = 0 time = 1670
* CHECK dout1_15 vdout1_15ck166 = 0 time = 1670
* CHECK dout1_16 vdout1_16ck166 = 0 time = 1670
* CHECK dout1_17 vdout1_17ck166 = 0 time = 1670
* CHECK dout1_18 vdout1_18ck166 = 0 time = 1670
* CHECK dout1_19 vdout1_19ck166 = 1.8 time = 1670
* CHECK dout1_20 vdout1_20ck166 = 1.8 time = 1670
* CHECK dout1_21 vdout1_21ck166 = 0 time = 1670
* CHECK dout1_22 vdout1_22ck166 = 1.8 time = 1670
* CHECK dout1_23 vdout1_23ck166 = 0 time = 1670
* CHECK dout1_24 vdout1_24ck166 = 1.8 time = 1670
* CHECK dout1_25 vdout1_25ck166 = 1.8 time = 1670
* CHECK dout1_26 vdout1_26ck166 = 0 time = 1670
* CHECK dout1_27 vdout1_27ck166 = 1.8 time = 1670
* CHECK dout1_28 vdout1_28ck166 = 1.8 time = 1670
* CHECK dout1_29 vdout1_29ck166 = 1.8 time = 1670
* CHECK dout1_30 vdout1_30ck166 = 1.8 time = 1670
* CHECK dout1_31 vdout1_31ck166 = 0 time = 1670
* CHECK dout0_0 vdout0_0ck167 = 0 time = 1680
* CHECK dout0_1 vdout0_1ck167 = 0 time = 1680
* CHECK dout0_2 vdout0_2ck167 = 1.8 time = 1680
* CHECK dout0_3 vdout0_3ck167 = 0 time = 1680
* CHECK dout0_4 vdout0_4ck167 = 1.8 time = 1680
* CHECK dout0_5 vdout0_5ck167 = 1.8 time = 1680
* CHECK dout0_6 vdout0_6ck167 = 0 time = 1680
* CHECK dout0_7 vdout0_7ck167 = 1.8 time = 1680
* CHECK dout0_8 vdout0_8ck167 = 1.8 time = 1680
* CHECK dout0_9 vdout0_9ck167 = 1.8 time = 1680
* CHECK dout0_10 vdout0_10ck167 = 1.8 time = 1680
* CHECK dout0_11 vdout0_11ck167 = 1.8 time = 1680
* CHECK dout0_12 vdout0_12ck167 = 0 time = 1680
* CHECK dout0_13 vdout0_13ck167 = 0 time = 1680
* CHECK dout0_14 vdout0_14ck167 = 1.8 time = 1680
* CHECK dout0_15 vdout0_15ck167 = 1.8 time = 1680
* CHECK dout0_16 vdout0_16ck167 = 1.8 time = 1680
* CHECK dout0_17 vdout0_17ck167 = 1.8 time = 1680
* CHECK dout0_18 vdout0_18ck167 = 0 time = 1680
* CHECK dout0_19 vdout0_19ck167 = 1.8 time = 1680
* CHECK dout0_20 vdout0_20ck167 = 0 time = 1680
* CHECK dout0_21 vdout0_21ck167 = 0 time = 1680
* CHECK dout0_22 vdout0_22ck167 = 1.8 time = 1680
* CHECK dout0_23 vdout0_23ck167 = 0 time = 1680
* CHECK dout0_24 vdout0_24ck167 = 1.8 time = 1680
* CHECK dout0_25 vdout0_25ck167 = 1.8 time = 1680
* CHECK dout0_26 vdout0_26ck167 = 0 time = 1680
* CHECK dout0_27 vdout0_27ck167 = 1.8 time = 1680
* CHECK dout0_28 vdout0_28ck167 = 0 time = 1680
* CHECK dout0_29 vdout0_29ck167 = 0 time = 1680
* CHECK dout0_30 vdout0_30ck167 = 1.8 time = 1680
* CHECK dout0_31 vdout0_31ck167 = 0 time = 1680
* CHECK dout1_0 vdout1_0ck167 = 0 time = 1680
* CHECK dout1_1 vdout1_1ck167 = 0 time = 1680
* CHECK dout1_2 vdout1_2ck167 = 1.8 time = 1680
* CHECK dout1_3 vdout1_3ck167 = 0 time = 1680
* CHECK dout1_4 vdout1_4ck167 = 1.8 time = 1680
* CHECK dout1_5 vdout1_5ck167 = 1.8 time = 1680
* CHECK dout1_6 vdout1_6ck167 = 0 time = 1680
* CHECK dout1_7 vdout1_7ck167 = 1.8 time = 1680
* CHECK dout1_8 vdout1_8ck167 = 1.8 time = 1680
* CHECK dout1_9 vdout1_9ck167 = 1.8 time = 1680
* CHECK dout1_10 vdout1_10ck167 = 1.8 time = 1680
* CHECK dout1_11 vdout1_11ck167 = 1.8 time = 1680
* CHECK dout1_12 vdout1_12ck167 = 0 time = 1680
* CHECK dout1_13 vdout1_13ck167 = 0 time = 1680
* CHECK dout1_14 vdout1_14ck167 = 1.8 time = 1680
* CHECK dout1_15 vdout1_15ck167 = 1.8 time = 1680
* CHECK dout1_16 vdout1_16ck167 = 1.8 time = 1680
* CHECK dout1_17 vdout1_17ck167 = 1.8 time = 1680
* CHECK dout1_18 vdout1_18ck167 = 0 time = 1680
* CHECK dout1_19 vdout1_19ck167 = 1.8 time = 1680
* CHECK dout1_20 vdout1_20ck167 = 0 time = 1680
* CHECK dout1_21 vdout1_21ck167 = 0 time = 1680
* CHECK dout1_22 vdout1_22ck167 = 1.8 time = 1680
* CHECK dout1_23 vdout1_23ck167 = 0 time = 1680
* CHECK dout1_24 vdout1_24ck167 = 1.8 time = 1680
* CHECK dout1_25 vdout1_25ck167 = 1.8 time = 1680
* CHECK dout1_26 vdout1_26ck167 = 0 time = 1680
* CHECK dout1_27 vdout1_27ck167 = 1.8 time = 1680
* CHECK dout1_28 vdout1_28ck167 = 0 time = 1680
* CHECK dout1_29 vdout1_29ck167 = 0 time = 1680
* CHECK dout1_30 vdout1_30ck167 = 1.8 time = 1680
* CHECK dout1_31 vdout1_31ck167 = 0 time = 1680
* CHECK dout0_0 vdout0_0ck168 = 0 time = 1690
* CHECK dout0_1 vdout0_1ck168 = 0 time = 1690
* CHECK dout0_2 vdout0_2ck168 = 0 time = 1690
* CHECK dout0_3 vdout0_3ck168 = 0 time = 1690
* CHECK dout0_4 vdout0_4ck168 = 0 time = 1690
* CHECK dout0_5 vdout0_5ck168 = 1.8 time = 1690
* CHECK dout0_6 vdout0_6ck168 = 0 time = 1690
* CHECK dout0_7 vdout0_7ck168 = 1.8 time = 1690
* CHECK dout0_8 vdout0_8ck168 = 0 time = 1690
* CHECK dout0_9 vdout0_9ck168 = 1.8 time = 1690
* CHECK dout0_10 vdout0_10ck168 = 0 time = 1690
* CHECK dout0_11 vdout0_11ck168 = 0 time = 1690
* CHECK dout0_12 vdout0_12ck168 = 1.8 time = 1690
* CHECK dout0_13 vdout0_13ck168 = 0 time = 1690
* CHECK dout0_14 vdout0_14ck168 = 0 time = 1690
* CHECK dout0_15 vdout0_15ck168 = 0 time = 1690
* CHECK dout0_16 vdout0_16ck168 = 0 time = 1690
* CHECK dout0_17 vdout0_17ck168 = 0 time = 1690
* CHECK dout0_18 vdout0_18ck168 = 0 time = 1690
* CHECK dout0_19 vdout0_19ck168 = 1.8 time = 1690
* CHECK dout0_20 vdout0_20ck168 = 1.8 time = 1690
* CHECK dout0_21 vdout0_21ck168 = 0 time = 1690
* CHECK dout0_22 vdout0_22ck168 = 1.8 time = 1690
* CHECK dout0_23 vdout0_23ck168 = 0 time = 1690
* CHECK dout0_24 vdout0_24ck168 = 1.8 time = 1690
* CHECK dout0_25 vdout0_25ck168 = 1.8 time = 1690
* CHECK dout0_26 vdout0_26ck168 = 0 time = 1690
* CHECK dout0_27 vdout0_27ck168 = 1.8 time = 1690
* CHECK dout0_28 vdout0_28ck168 = 1.8 time = 1690
* CHECK dout0_29 vdout0_29ck168 = 1.8 time = 1690
* CHECK dout0_30 vdout0_30ck168 = 1.8 time = 1690
* CHECK dout0_31 vdout0_31ck168 = 0 time = 1690
* CHECK dout1_0 vdout1_0ck168 = 0 time = 1690
* CHECK dout1_1 vdout1_1ck168 = 0 time = 1690
* CHECK dout1_2 vdout1_2ck168 = 0 time = 1690
* CHECK dout1_3 vdout1_3ck168 = 0 time = 1690
* CHECK dout1_4 vdout1_4ck168 = 0 time = 1690
* CHECK dout1_5 vdout1_5ck168 = 1.8 time = 1690
* CHECK dout1_6 vdout1_6ck168 = 0 time = 1690
* CHECK dout1_7 vdout1_7ck168 = 1.8 time = 1690
* CHECK dout1_8 vdout1_8ck168 = 0 time = 1690
* CHECK dout1_9 vdout1_9ck168 = 1.8 time = 1690
* CHECK dout1_10 vdout1_10ck168 = 0 time = 1690
* CHECK dout1_11 vdout1_11ck168 = 0 time = 1690
* CHECK dout1_12 vdout1_12ck168 = 1.8 time = 1690
* CHECK dout1_13 vdout1_13ck168 = 0 time = 1690
* CHECK dout1_14 vdout1_14ck168 = 0 time = 1690
* CHECK dout1_15 vdout1_15ck168 = 0 time = 1690
* CHECK dout1_16 vdout1_16ck168 = 0 time = 1690
* CHECK dout1_17 vdout1_17ck168 = 0 time = 1690
* CHECK dout1_18 vdout1_18ck168 = 0 time = 1690
* CHECK dout1_19 vdout1_19ck168 = 1.8 time = 1690
* CHECK dout1_20 vdout1_20ck168 = 1.8 time = 1690
* CHECK dout1_21 vdout1_21ck168 = 0 time = 1690
* CHECK dout1_22 vdout1_22ck168 = 1.8 time = 1690
* CHECK dout1_23 vdout1_23ck168 = 0 time = 1690
* CHECK dout1_24 vdout1_24ck168 = 1.8 time = 1690
* CHECK dout1_25 vdout1_25ck168 = 1.8 time = 1690
* CHECK dout1_26 vdout1_26ck168 = 0 time = 1690
* CHECK dout1_27 vdout1_27ck168 = 1.8 time = 1690
* CHECK dout1_28 vdout1_28ck168 = 1.8 time = 1690
* CHECK dout1_29 vdout1_29ck168 = 1.8 time = 1690
* CHECK dout1_30 vdout1_30ck168 = 1.8 time = 1690
* CHECK dout1_31 vdout1_31ck168 = 0 time = 1690
* CHECK dout1_0 vdout1_0ck169 = 0 time = 1700
* CHECK dout1_1 vdout1_1ck169 = 0 time = 1700
* CHECK dout1_2 vdout1_2ck169 = 0 time = 1700
* CHECK dout1_3 vdout1_3ck169 = 0 time = 1700
* CHECK dout1_4 vdout1_4ck169 = 0 time = 1700
* CHECK dout1_5 vdout1_5ck169 = 1.8 time = 1700
* CHECK dout1_6 vdout1_6ck169 = 0 time = 1700
* CHECK dout1_7 vdout1_7ck169 = 1.8 time = 1700
* CHECK dout1_8 vdout1_8ck169 = 0 time = 1700
* CHECK dout1_9 vdout1_9ck169 = 1.8 time = 1700
* CHECK dout1_10 vdout1_10ck169 = 0 time = 1700
* CHECK dout1_11 vdout1_11ck169 = 0 time = 1700
* CHECK dout1_12 vdout1_12ck169 = 1.8 time = 1700
* CHECK dout1_13 vdout1_13ck169 = 0 time = 1700
* CHECK dout1_14 vdout1_14ck169 = 0 time = 1700
* CHECK dout1_15 vdout1_15ck169 = 0 time = 1700
* CHECK dout1_16 vdout1_16ck169 = 0 time = 1700
* CHECK dout1_17 vdout1_17ck169 = 0 time = 1700
* CHECK dout1_18 vdout1_18ck169 = 0 time = 1700
* CHECK dout1_19 vdout1_19ck169 = 1.8 time = 1700
* CHECK dout1_20 vdout1_20ck169 = 1.8 time = 1700
* CHECK dout1_21 vdout1_21ck169 = 0 time = 1700
* CHECK dout1_22 vdout1_22ck169 = 1.8 time = 1700
* CHECK dout1_23 vdout1_23ck169 = 0 time = 1700
* CHECK dout1_24 vdout1_24ck169 = 1.8 time = 1700
* CHECK dout1_25 vdout1_25ck169 = 1.8 time = 1700
* CHECK dout1_26 vdout1_26ck169 = 0 time = 1700
* CHECK dout1_27 vdout1_27ck169 = 1.8 time = 1700
* CHECK dout1_28 vdout1_28ck169 = 1.8 time = 1700
* CHECK dout1_29 vdout1_29ck169 = 1.8 time = 1700
* CHECK dout1_30 vdout1_30ck169 = 1.8 time = 1700
* CHECK dout1_31 vdout1_31ck169 = 0 time = 1700
* CHECK dout0_0 vdout0_0ck171 = 0 time = 1720
* CHECK dout0_1 vdout0_1ck171 = 0 time = 1720
* CHECK dout0_2 vdout0_2ck171 = 0 time = 1720
* CHECK dout0_3 vdout0_3ck171 = 0 time = 1720
* CHECK dout0_4 vdout0_4ck171 = 0 time = 1720
* CHECK dout0_5 vdout0_5ck171 = 1.8 time = 1720
* CHECK dout0_6 vdout0_6ck171 = 0 time = 1720
* CHECK dout0_7 vdout0_7ck171 = 1.8 time = 1720
* CHECK dout0_8 vdout0_8ck171 = 0 time = 1720
* CHECK dout0_9 vdout0_9ck171 = 1.8 time = 1720
* CHECK dout0_10 vdout0_10ck171 = 0 time = 1720
* CHECK dout0_11 vdout0_11ck171 = 0 time = 1720
* CHECK dout0_12 vdout0_12ck171 = 1.8 time = 1720
* CHECK dout0_13 vdout0_13ck171 = 0 time = 1720
* CHECK dout0_14 vdout0_14ck171 = 0 time = 1720
* CHECK dout0_15 vdout0_15ck171 = 0 time = 1720
* CHECK dout0_16 vdout0_16ck171 = 0 time = 1720
* CHECK dout0_17 vdout0_17ck171 = 0 time = 1720
* CHECK dout0_18 vdout0_18ck171 = 0 time = 1720
* CHECK dout0_19 vdout0_19ck171 = 1.8 time = 1720
* CHECK dout0_20 vdout0_20ck171 = 1.8 time = 1720
* CHECK dout0_21 vdout0_21ck171 = 0 time = 1720
* CHECK dout0_22 vdout0_22ck171 = 1.8 time = 1720
* CHECK dout0_23 vdout0_23ck171 = 0 time = 1720
* CHECK dout0_24 vdout0_24ck171 = 1.8 time = 1720
* CHECK dout0_25 vdout0_25ck171 = 1.8 time = 1720
* CHECK dout0_26 vdout0_26ck171 = 0 time = 1720
* CHECK dout0_27 vdout0_27ck171 = 1.8 time = 1720
* CHECK dout0_28 vdout0_28ck171 = 1.8 time = 1720
* CHECK dout0_29 vdout0_29ck171 = 1.8 time = 1720
* CHECK dout0_30 vdout0_30ck171 = 1.8 time = 1720
* CHECK dout0_31 vdout0_31ck171 = 0 time = 1720
* CHECK dout1_0 vdout1_0ck172 = 0 time = 1730
* CHECK dout1_1 vdout1_1ck172 = 0 time = 1730
* CHECK dout1_2 vdout1_2ck172 = 1.8 time = 1730
* CHECK dout1_3 vdout1_3ck172 = 0 time = 1730
* CHECK dout1_4 vdout1_4ck172 = 1.8 time = 1730
* CHECK dout1_5 vdout1_5ck172 = 1.8 time = 1730
* CHECK dout1_6 vdout1_6ck172 = 0 time = 1730
* CHECK dout1_7 vdout1_7ck172 = 1.8 time = 1730
* CHECK dout1_8 vdout1_8ck172 = 1.8 time = 1730
* CHECK dout1_9 vdout1_9ck172 = 1.8 time = 1730
* CHECK dout1_10 vdout1_10ck172 = 1.8 time = 1730
* CHECK dout1_11 vdout1_11ck172 = 1.8 time = 1730
* CHECK dout1_12 vdout1_12ck172 = 0 time = 1730
* CHECK dout1_13 vdout1_13ck172 = 0 time = 1730
* CHECK dout1_14 vdout1_14ck172 = 1.8 time = 1730
* CHECK dout1_15 vdout1_15ck172 = 1.8 time = 1730
* CHECK dout1_16 vdout1_16ck172 = 1.8 time = 1730
* CHECK dout1_17 vdout1_17ck172 = 1.8 time = 1730
* CHECK dout1_18 vdout1_18ck172 = 0 time = 1730
* CHECK dout1_19 vdout1_19ck172 = 1.8 time = 1730
* CHECK dout1_20 vdout1_20ck172 = 0 time = 1730
* CHECK dout1_21 vdout1_21ck172 = 0 time = 1730
* CHECK dout1_22 vdout1_22ck172 = 1.8 time = 1730
* CHECK dout1_23 vdout1_23ck172 = 0 time = 1730
* CHECK dout1_24 vdout1_24ck172 = 1.8 time = 1730
* CHECK dout1_25 vdout1_25ck172 = 1.8 time = 1730
* CHECK dout1_26 vdout1_26ck172 = 0 time = 1730
* CHECK dout1_27 vdout1_27ck172 = 1.8 time = 1730
* CHECK dout1_28 vdout1_28ck172 = 0 time = 1730
* CHECK dout1_29 vdout1_29ck172 = 0 time = 1730
* CHECK dout1_30 vdout1_30ck172 = 1.8 time = 1730
* CHECK dout1_31 vdout1_31ck172 = 0 time = 1730
* CHECK dout0_0 vdout0_0ck173 = 0 time = 1740
* CHECK dout0_1 vdout0_1ck173 = 0 time = 1740
* CHECK dout0_2 vdout0_2ck173 = 1.8 time = 1740
* CHECK dout0_3 vdout0_3ck173 = 0 time = 1740
* CHECK dout0_4 vdout0_4ck173 = 1.8 time = 1740
* CHECK dout0_5 vdout0_5ck173 = 1.8 time = 1740
* CHECK dout0_6 vdout0_6ck173 = 0 time = 1740
* CHECK dout0_7 vdout0_7ck173 = 1.8 time = 1740
* CHECK dout0_8 vdout0_8ck173 = 1.8 time = 1740
* CHECK dout0_9 vdout0_9ck173 = 1.8 time = 1740
* CHECK dout0_10 vdout0_10ck173 = 1.8 time = 1740
* CHECK dout0_11 vdout0_11ck173 = 1.8 time = 1740
* CHECK dout0_12 vdout0_12ck173 = 0 time = 1740
* CHECK dout0_13 vdout0_13ck173 = 0 time = 1740
* CHECK dout0_14 vdout0_14ck173 = 1.8 time = 1740
* CHECK dout0_15 vdout0_15ck173 = 1.8 time = 1740
* CHECK dout0_16 vdout0_16ck173 = 1.8 time = 1740
* CHECK dout0_17 vdout0_17ck173 = 1.8 time = 1740
* CHECK dout0_18 vdout0_18ck173 = 0 time = 1740
* CHECK dout0_19 vdout0_19ck173 = 1.8 time = 1740
* CHECK dout0_20 vdout0_20ck173 = 0 time = 1740
* CHECK dout0_21 vdout0_21ck173 = 0 time = 1740
* CHECK dout0_22 vdout0_22ck173 = 1.8 time = 1740
* CHECK dout0_23 vdout0_23ck173 = 0 time = 1740
* CHECK dout0_24 vdout0_24ck173 = 1.8 time = 1740
* CHECK dout0_25 vdout0_25ck173 = 1.8 time = 1740
* CHECK dout0_26 vdout0_26ck173 = 0 time = 1740
* CHECK dout0_27 vdout0_27ck173 = 1.8 time = 1740
* CHECK dout0_28 vdout0_28ck173 = 0 time = 1740
* CHECK dout0_29 vdout0_29ck173 = 0 time = 1740
* CHECK dout0_30 vdout0_30ck173 = 1.8 time = 1740
* CHECK dout0_31 vdout0_31ck173 = 0 time = 1740
* CHECK dout1_0 vdout1_0ck173 = 0 time = 1740
* CHECK dout1_1 vdout1_1ck173 = 0 time = 1740
* CHECK dout1_2 vdout1_2ck173 = 0 time = 1740
* CHECK dout1_3 vdout1_3ck173 = 0 time = 1740
* CHECK dout1_4 vdout1_4ck173 = 0 time = 1740
* CHECK dout1_5 vdout1_5ck173 = 1.8 time = 1740
* CHECK dout1_6 vdout1_6ck173 = 0 time = 1740
* CHECK dout1_7 vdout1_7ck173 = 1.8 time = 1740
* CHECK dout1_8 vdout1_8ck173 = 0 time = 1740
* CHECK dout1_9 vdout1_9ck173 = 1.8 time = 1740
* CHECK dout1_10 vdout1_10ck173 = 0 time = 1740
* CHECK dout1_11 vdout1_11ck173 = 0 time = 1740
* CHECK dout1_12 vdout1_12ck173 = 1.8 time = 1740
* CHECK dout1_13 vdout1_13ck173 = 0 time = 1740
* CHECK dout1_14 vdout1_14ck173 = 0 time = 1740
* CHECK dout1_15 vdout1_15ck173 = 0 time = 1740
* CHECK dout1_16 vdout1_16ck173 = 0 time = 1740
* CHECK dout1_17 vdout1_17ck173 = 0 time = 1740
* CHECK dout1_18 vdout1_18ck173 = 0 time = 1740
* CHECK dout1_19 vdout1_19ck173 = 1.8 time = 1740
* CHECK dout1_20 vdout1_20ck173 = 1.8 time = 1740
* CHECK dout1_21 vdout1_21ck173 = 0 time = 1740
* CHECK dout1_22 vdout1_22ck173 = 1.8 time = 1740
* CHECK dout1_23 vdout1_23ck173 = 0 time = 1740
* CHECK dout1_24 vdout1_24ck173 = 1.8 time = 1740
* CHECK dout1_25 vdout1_25ck173 = 1.8 time = 1740
* CHECK dout1_26 vdout1_26ck173 = 0 time = 1740
* CHECK dout1_27 vdout1_27ck173 = 1.8 time = 1740
* CHECK dout1_28 vdout1_28ck173 = 1.8 time = 1740
* CHECK dout1_29 vdout1_29ck173 = 1.8 time = 1740
* CHECK dout1_30 vdout1_30ck173 = 1.8 time = 1740
* CHECK dout1_31 vdout1_31ck173 = 0 time = 1740
* CHECK dout1_0 vdout1_0ck174 = 0 time = 1750
* CHECK dout1_1 vdout1_1ck174 = 0 time = 1750
* CHECK dout1_2 vdout1_2ck174 = 0 time = 1750
* CHECK dout1_3 vdout1_3ck174 = 0 time = 1750
* CHECK dout1_4 vdout1_4ck174 = 0 time = 1750
* CHECK dout1_5 vdout1_5ck174 = 1.8 time = 1750
* CHECK dout1_6 vdout1_6ck174 = 0 time = 1750
* CHECK dout1_7 vdout1_7ck174 = 1.8 time = 1750
* CHECK dout1_8 vdout1_8ck174 = 0 time = 1750
* CHECK dout1_9 vdout1_9ck174 = 1.8 time = 1750
* CHECK dout1_10 vdout1_10ck174 = 0 time = 1750
* CHECK dout1_11 vdout1_11ck174 = 0 time = 1750
* CHECK dout1_12 vdout1_12ck174 = 1.8 time = 1750
* CHECK dout1_13 vdout1_13ck174 = 0 time = 1750
* CHECK dout1_14 vdout1_14ck174 = 0 time = 1750
* CHECK dout1_15 vdout1_15ck174 = 0 time = 1750
* CHECK dout1_16 vdout1_16ck174 = 0 time = 1750
* CHECK dout1_17 vdout1_17ck174 = 0 time = 1750
* CHECK dout1_18 vdout1_18ck174 = 0 time = 1750
* CHECK dout1_19 vdout1_19ck174 = 1.8 time = 1750
* CHECK dout1_20 vdout1_20ck174 = 1.8 time = 1750
* CHECK dout1_21 vdout1_21ck174 = 0 time = 1750
* CHECK dout1_22 vdout1_22ck174 = 1.8 time = 1750
* CHECK dout1_23 vdout1_23ck174 = 0 time = 1750
* CHECK dout1_24 vdout1_24ck174 = 1.8 time = 1750
* CHECK dout1_25 vdout1_25ck174 = 1.8 time = 1750
* CHECK dout1_26 vdout1_26ck174 = 0 time = 1750
* CHECK dout1_27 vdout1_27ck174 = 1.8 time = 1750
* CHECK dout1_28 vdout1_28ck174 = 1.8 time = 1750
* CHECK dout1_29 vdout1_29ck174 = 1.8 time = 1750
* CHECK dout1_30 vdout1_30ck174 = 1.8 time = 1750
* CHECK dout1_31 vdout1_31ck174 = 0 time = 1750
* CHECK dout1_0 vdout1_0ck175 = 0 time = 1760
* CHECK dout1_1 vdout1_1ck175 = 0 time = 1760
* CHECK dout1_2 vdout1_2ck175 = 1.8 time = 1760
* CHECK dout1_3 vdout1_3ck175 = 0 time = 1760
* CHECK dout1_4 vdout1_4ck175 = 1.8 time = 1760
* CHECK dout1_5 vdout1_5ck175 = 1.8 time = 1760
* CHECK dout1_6 vdout1_6ck175 = 0 time = 1760
* CHECK dout1_7 vdout1_7ck175 = 1.8 time = 1760
* CHECK dout1_8 vdout1_8ck175 = 1.8 time = 1760
* CHECK dout1_9 vdout1_9ck175 = 1.8 time = 1760
* CHECK dout1_10 vdout1_10ck175 = 1.8 time = 1760
* CHECK dout1_11 vdout1_11ck175 = 1.8 time = 1760
* CHECK dout1_12 vdout1_12ck175 = 0 time = 1760
* CHECK dout1_13 vdout1_13ck175 = 0 time = 1760
* CHECK dout1_14 vdout1_14ck175 = 1.8 time = 1760
* CHECK dout1_15 vdout1_15ck175 = 1.8 time = 1760
* CHECK dout1_16 vdout1_16ck175 = 1.8 time = 1760
* CHECK dout1_17 vdout1_17ck175 = 1.8 time = 1760
* CHECK dout1_18 vdout1_18ck175 = 0 time = 1760
* CHECK dout1_19 vdout1_19ck175 = 1.8 time = 1760
* CHECK dout1_20 vdout1_20ck175 = 0 time = 1760
* CHECK dout1_21 vdout1_21ck175 = 0 time = 1760
* CHECK dout1_22 vdout1_22ck175 = 1.8 time = 1760
* CHECK dout1_23 vdout1_23ck175 = 0 time = 1760
* CHECK dout1_24 vdout1_24ck175 = 1.8 time = 1760
* CHECK dout1_25 vdout1_25ck175 = 1.8 time = 1760
* CHECK dout1_26 vdout1_26ck175 = 0 time = 1760
* CHECK dout1_27 vdout1_27ck175 = 1.8 time = 1760
* CHECK dout1_28 vdout1_28ck175 = 0 time = 1760
* CHECK dout1_29 vdout1_29ck175 = 0 time = 1760
* CHECK dout1_30 vdout1_30ck175 = 1.8 time = 1760
* CHECK dout1_31 vdout1_31ck175 = 0 time = 1760
* CHECK dout1_0 vdout1_0ck176 = 0 time = 1770
* CHECK dout1_1 vdout1_1ck176 = 0 time = 1770
* CHECK dout1_2 vdout1_2ck176 = 0 time = 1770
* CHECK dout1_3 vdout1_3ck176 = 0 time = 1770
* CHECK dout1_4 vdout1_4ck176 = 0 time = 1770
* CHECK dout1_5 vdout1_5ck176 = 1.8 time = 1770
* CHECK dout1_6 vdout1_6ck176 = 0 time = 1770
* CHECK dout1_7 vdout1_7ck176 = 1.8 time = 1770
* CHECK dout1_8 vdout1_8ck176 = 0 time = 1770
* CHECK dout1_9 vdout1_9ck176 = 1.8 time = 1770
* CHECK dout1_10 vdout1_10ck176 = 0 time = 1770
* CHECK dout1_11 vdout1_11ck176 = 0 time = 1770
* CHECK dout1_12 vdout1_12ck176 = 1.8 time = 1770
* CHECK dout1_13 vdout1_13ck176 = 0 time = 1770
* CHECK dout1_14 vdout1_14ck176 = 0 time = 1770
* CHECK dout1_15 vdout1_15ck176 = 0 time = 1770
* CHECK dout1_16 vdout1_16ck176 = 0 time = 1770
* CHECK dout1_17 vdout1_17ck176 = 0 time = 1770
* CHECK dout1_18 vdout1_18ck176 = 0 time = 1770
* CHECK dout1_19 vdout1_19ck176 = 1.8 time = 1770
* CHECK dout1_20 vdout1_20ck176 = 1.8 time = 1770
* CHECK dout1_21 vdout1_21ck176 = 0 time = 1770
* CHECK dout1_22 vdout1_22ck176 = 1.8 time = 1770
* CHECK dout1_23 vdout1_23ck176 = 0 time = 1770
* CHECK dout1_24 vdout1_24ck176 = 1.8 time = 1770
* CHECK dout1_25 vdout1_25ck176 = 1.8 time = 1770
* CHECK dout1_26 vdout1_26ck176 = 0 time = 1770
* CHECK dout1_27 vdout1_27ck176 = 1.8 time = 1770
* CHECK dout1_28 vdout1_28ck176 = 1.8 time = 1770
* CHECK dout1_29 vdout1_29ck176 = 1.8 time = 1770
* CHECK dout1_30 vdout1_30ck176 = 1.8 time = 1770
* CHECK dout1_31 vdout1_31ck176 = 0 time = 1770
* CHECK dout0_0 vdout0_0ck177 = 0 time = 1780
* CHECK dout0_1 vdout0_1ck177 = 0 time = 1780
* CHECK dout0_2 vdout0_2ck177 = 0 time = 1780
* CHECK dout0_3 vdout0_3ck177 = 0 time = 1780
* CHECK dout0_4 vdout0_4ck177 = 0 time = 1780
* CHECK dout0_5 vdout0_5ck177 = 1.8 time = 1780
* CHECK dout0_6 vdout0_6ck177 = 0 time = 1780
* CHECK dout0_7 vdout0_7ck177 = 1.8 time = 1780
* CHECK dout0_8 vdout0_8ck177 = 0 time = 1780
* CHECK dout0_9 vdout0_9ck177 = 1.8 time = 1780
* CHECK dout0_10 vdout0_10ck177 = 0 time = 1780
* CHECK dout0_11 vdout0_11ck177 = 0 time = 1780
* CHECK dout0_12 vdout0_12ck177 = 1.8 time = 1780
* CHECK dout0_13 vdout0_13ck177 = 0 time = 1780
* CHECK dout0_14 vdout0_14ck177 = 0 time = 1780
* CHECK dout0_15 vdout0_15ck177 = 0 time = 1780
* CHECK dout0_16 vdout0_16ck177 = 0 time = 1780
* CHECK dout0_17 vdout0_17ck177 = 0 time = 1780
* CHECK dout0_18 vdout0_18ck177 = 0 time = 1780
* CHECK dout0_19 vdout0_19ck177 = 1.8 time = 1780
* CHECK dout0_20 vdout0_20ck177 = 1.8 time = 1780
* CHECK dout0_21 vdout0_21ck177 = 0 time = 1780
* CHECK dout0_22 vdout0_22ck177 = 1.8 time = 1780
* CHECK dout0_23 vdout0_23ck177 = 0 time = 1780
* CHECK dout0_24 vdout0_24ck177 = 1.8 time = 1780
* CHECK dout0_25 vdout0_25ck177 = 1.8 time = 1780
* CHECK dout0_26 vdout0_26ck177 = 0 time = 1780
* CHECK dout0_27 vdout0_27ck177 = 1.8 time = 1780
* CHECK dout0_28 vdout0_28ck177 = 1.8 time = 1780
* CHECK dout0_29 vdout0_29ck177 = 1.8 time = 1780
* CHECK dout0_30 vdout0_30ck177 = 1.8 time = 1780
* CHECK dout0_31 vdout0_31ck177 = 0 time = 1780
* CHECK dout1_0 vdout1_0ck177 = 0 time = 1780
* CHECK dout1_1 vdout1_1ck177 = 0 time = 1780
* CHECK dout1_2 vdout1_2ck177 = 0 time = 1780
* CHECK dout1_3 vdout1_3ck177 = 0 time = 1780
* CHECK dout1_4 vdout1_4ck177 = 0 time = 1780
* CHECK dout1_5 vdout1_5ck177 = 1.8 time = 1780
* CHECK dout1_6 vdout1_6ck177 = 0 time = 1780
* CHECK dout1_7 vdout1_7ck177 = 1.8 time = 1780
* CHECK dout1_8 vdout1_8ck177 = 0 time = 1780
* CHECK dout1_9 vdout1_9ck177 = 1.8 time = 1780
* CHECK dout1_10 vdout1_10ck177 = 0 time = 1780
* CHECK dout1_11 vdout1_11ck177 = 0 time = 1780
* CHECK dout1_12 vdout1_12ck177 = 1.8 time = 1780
* CHECK dout1_13 vdout1_13ck177 = 0 time = 1780
* CHECK dout1_14 vdout1_14ck177 = 0 time = 1780
* CHECK dout1_15 vdout1_15ck177 = 0 time = 1780
* CHECK dout1_16 vdout1_16ck177 = 0 time = 1780
* CHECK dout1_17 vdout1_17ck177 = 0 time = 1780
* CHECK dout1_18 vdout1_18ck177 = 0 time = 1780
* CHECK dout1_19 vdout1_19ck177 = 1.8 time = 1780
* CHECK dout1_20 vdout1_20ck177 = 1.8 time = 1780
* CHECK dout1_21 vdout1_21ck177 = 0 time = 1780
* CHECK dout1_22 vdout1_22ck177 = 1.8 time = 1780
* CHECK dout1_23 vdout1_23ck177 = 0 time = 1780
* CHECK dout1_24 vdout1_24ck177 = 1.8 time = 1780
* CHECK dout1_25 vdout1_25ck177 = 1.8 time = 1780
* CHECK dout1_26 vdout1_26ck177 = 0 time = 1780
* CHECK dout1_27 vdout1_27ck177 = 1.8 time = 1780
* CHECK dout1_28 vdout1_28ck177 = 1.8 time = 1780
* CHECK dout1_29 vdout1_29ck177 = 1.8 time = 1780
* CHECK dout1_30 vdout1_30ck177 = 1.8 time = 1780
* CHECK dout1_31 vdout1_31ck177 = 0 time = 1780
* CHECK dout0_0 vdout0_0ck178 = 0 time = 1790
* CHECK dout0_1 vdout0_1ck178 = 0 time = 1790
* CHECK dout0_2 vdout0_2ck178 = 0 time = 1790
* CHECK dout0_3 vdout0_3ck178 = 0 time = 1790
* CHECK dout0_4 vdout0_4ck178 = 0 time = 1790
* CHECK dout0_5 vdout0_5ck178 = 1.8 time = 1790
* CHECK dout0_6 vdout0_6ck178 = 0 time = 1790
* CHECK dout0_7 vdout0_7ck178 = 1.8 time = 1790
* CHECK dout0_8 vdout0_8ck178 = 0 time = 1790
* CHECK dout0_9 vdout0_9ck178 = 1.8 time = 1790
* CHECK dout0_10 vdout0_10ck178 = 0 time = 1790
* CHECK dout0_11 vdout0_11ck178 = 0 time = 1790
* CHECK dout0_12 vdout0_12ck178 = 1.8 time = 1790
* CHECK dout0_13 vdout0_13ck178 = 0 time = 1790
* CHECK dout0_14 vdout0_14ck178 = 0 time = 1790
* CHECK dout0_15 vdout0_15ck178 = 0 time = 1790
* CHECK dout0_16 vdout0_16ck178 = 0 time = 1790
* CHECK dout0_17 vdout0_17ck178 = 0 time = 1790
* CHECK dout0_18 vdout0_18ck178 = 0 time = 1790
* CHECK dout0_19 vdout0_19ck178 = 1.8 time = 1790
* CHECK dout0_20 vdout0_20ck178 = 1.8 time = 1790
* CHECK dout0_21 vdout0_21ck178 = 0 time = 1790
* CHECK dout0_22 vdout0_22ck178 = 1.8 time = 1790
* CHECK dout0_23 vdout0_23ck178 = 0 time = 1790
* CHECK dout0_24 vdout0_24ck178 = 1.8 time = 1790
* CHECK dout0_25 vdout0_25ck178 = 1.8 time = 1790
* CHECK dout0_26 vdout0_26ck178 = 0 time = 1790
* CHECK dout0_27 vdout0_27ck178 = 1.8 time = 1790
* CHECK dout0_28 vdout0_28ck178 = 1.8 time = 1790
* CHECK dout0_29 vdout0_29ck178 = 1.8 time = 1790
* CHECK dout0_30 vdout0_30ck178 = 1.8 time = 1790
* CHECK dout0_31 vdout0_31ck178 = 0 time = 1790
* CHECK dout0_0 vdout0_0ck180 = 0 time = 1810
* CHECK dout0_1 vdout0_1ck180 = 1.8 time = 1810
* CHECK dout0_2 vdout0_2ck180 = 1.8 time = 1810
* CHECK dout0_3 vdout0_3ck180 = 0 time = 1810
* CHECK dout0_4 vdout0_4ck180 = 1.8 time = 1810
* CHECK dout0_5 vdout0_5ck180 = 0 time = 1810
* CHECK dout0_6 vdout0_6ck180 = 0 time = 1810
* CHECK dout0_7 vdout0_7ck180 = 1.8 time = 1810
* CHECK dout0_8 vdout0_8ck180 = 0 time = 1810
* CHECK dout0_9 vdout0_9ck180 = 1.8 time = 1810
* CHECK dout0_10 vdout0_10ck180 = 0 time = 1810
* CHECK dout0_11 vdout0_11ck180 = 0 time = 1810
* CHECK dout0_12 vdout0_12ck180 = 0 time = 1810
* CHECK dout0_13 vdout0_13ck180 = 0 time = 1810
* CHECK dout0_14 vdout0_14ck180 = 1.8 time = 1810
* CHECK dout0_15 vdout0_15ck180 = 1.8 time = 1810
* CHECK dout0_16 vdout0_16ck180 = 1.8 time = 1810
* CHECK dout0_17 vdout0_17ck180 = 1.8 time = 1810
* CHECK dout0_18 vdout0_18ck180 = 1.8 time = 1810
* CHECK dout0_19 vdout0_19ck180 = 1.8 time = 1810
* CHECK dout0_20 vdout0_20ck180 = 1.8 time = 1810
* CHECK dout0_21 vdout0_21ck180 = 1.8 time = 1810
* CHECK dout0_22 vdout0_22ck180 = 1.8 time = 1810
* CHECK dout0_23 vdout0_23ck180 = 1.8 time = 1810
* CHECK dout0_24 vdout0_24ck180 = 0 time = 1810
* CHECK dout0_25 vdout0_25ck180 = 1.8 time = 1810
* CHECK dout0_26 vdout0_26ck180 = 0 time = 1810
* CHECK dout0_27 vdout0_27ck180 = 0 time = 1810
* CHECK dout0_28 vdout0_28ck180 = 1.8 time = 1810
* CHECK dout0_29 vdout0_29ck180 = 0 time = 1810
* CHECK dout0_30 vdout0_30ck180 = 0 time = 1810
* CHECK dout0_31 vdout0_31ck180 = 0 time = 1810
* CHECK dout1_0 vdout1_0ck180 = 0 time = 1810
* CHECK dout1_1 vdout1_1ck180 = 0 time = 1810
* CHECK dout1_2 vdout1_2ck180 = 0 time = 1810
* CHECK dout1_3 vdout1_3ck180 = 0 time = 1810
* CHECK dout1_4 vdout1_4ck180 = 0 time = 1810
* CHECK dout1_5 vdout1_5ck180 = 1.8 time = 1810
* CHECK dout1_6 vdout1_6ck180 = 0 time = 1810
* CHECK dout1_7 vdout1_7ck180 = 1.8 time = 1810
* CHECK dout1_8 vdout1_8ck180 = 0 time = 1810
* CHECK dout1_9 vdout1_9ck180 = 1.8 time = 1810
* CHECK dout1_10 vdout1_10ck180 = 0 time = 1810
* CHECK dout1_11 vdout1_11ck180 = 0 time = 1810
* CHECK dout1_12 vdout1_12ck180 = 1.8 time = 1810
* CHECK dout1_13 vdout1_13ck180 = 0 time = 1810
* CHECK dout1_14 vdout1_14ck180 = 0 time = 1810
* CHECK dout1_15 vdout1_15ck180 = 0 time = 1810
* CHECK dout1_16 vdout1_16ck180 = 0 time = 1810
* CHECK dout1_17 vdout1_17ck180 = 0 time = 1810
* CHECK dout1_18 vdout1_18ck180 = 0 time = 1810
* CHECK dout1_19 vdout1_19ck180 = 1.8 time = 1810
* CHECK dout1_20 vdout1_20ck180 = 1.8 time = 1810
* CHECK dout1_21 vdout1_21ck180 = 0 time = 1810
* CHECK dout1_22 vdout1_22ck180 = 1.8 time = 1810
* CHECK dout1_23 vdout1_23ck180 = 0 time = 1810
* CHECK dout1_24 vdout1_24ck180 = 1.8 time = 1810
* CHECK dout1_25 vdout1_25ck180 = 1.8 time = 1810
* CHECK dout1_26 vdout1_26ck180 = 0 time = 1810
* CHECK dout1_27 vdout1_27ck180 = 1.8 time = 1810
* CHECK dout1_28 vdout1_28ck180 = 1.8 time = 1810
* CHECK dout1_29 vdout1_29ck180 = 1.8 time = 1810
* CHECK dout1_30 vdout1_30ck180 = 1.8 time = 1810
* CHECK dout1_31 vdout1_31ck180 = 0 time = 1810
* CHECK dout0_0 vdout0_0ck181 = 0 time = 1820
* CHECK dout0_1 vdout0_1ck181 = 1.8 time = 1820
* CHECK dout0_2 vdout0_2ck181 = 1.8 time = 1820
* CHECK dout0_3 vdout0_3ck181 = 0 time = 1820
* CHECK dout0_4 vdout0_4ck181 = 1.8 time = 1820
* CHECK dout0_5 vdout0_5ck181 = 0 time = 1820
* CHECK dout0_6 vdout0_6ck181 = 0 time = 1820
* CHECK dout0_7 vdout0_7ck181 = 1.8 time = 1820
* CHECK dout0_8 vdout0_8ck181 = 0 time = 1820
* CHECK dout0_9 vdout0_9ck181 = 1.8 time = 1820
* CHECK dout0_10 vdout0_10ck181 = 0 time = 1820
* CHECK dout0_11 vdout0_11ck181 = 0 time = 1820
* CHECK dout0_12 vdout0_12ck181 = 0 time = 1820
* CHECK dout0_13 vdout0_13ck181 = 0 time = 1820
* CHECK dout0_14 vdout0_14ck181 = 1.8 time = 1820
* CHECK dout0_15 vdout0_15ck181 = 1.8 time = 1820
* CHECK dout0_16 vdout0_16ck181 = 1.8 time = 1820
* CHECK dout0_17 vdout0_17ck181 = 1.8 time = 1820
* CHECK dout0_18 vdout0_18ck181 = 1.8 time = 1820
* CHECK dout0_19 vdout0_19ck181 = 1.8 time = 1820
* CHECK dout0_20 vdout0_20ck181 = 1.8 time = 1820
* CHECK dout0_21 vdout0_21ck181 = 1.8 time = 1820
* CHECK dout0_22 vdout0_22ck181 = 1.8 time = 1820
* CHECK dout0_23 vdout0_23ck181 = 1.8 time = 1820
* CHECK dout0_24 vdout0_24ck181 = 0 time = 1820
* CHECK dout0_25 vdout0_25ck181 = 1.8 time = 1820
* CHECK dout0_26 vdout0_26ck181 = 0 time = 1820
* CHECK dout0_27 vdout0_27ck181 = 0 time = 1820
* CHECK dout0_28 vdout0_28ck181 = 1.8 time = 1820
* CHECK dout0_29 vdout0_29ck181 = 0 time = 1820
* CHECK dout0_30 vdout0_30ck181 = 0 time = 1820
* CHECK dout0_31 vdout0_31ck181 = 0 time = 1820
* CHECK dout0_0 vdout0_0ck183 = 0 time = 1840
* CHECK dout0_1 vdout0_1ck183 = 1.8 time = 1840
* CHECK dout0_2 vdout0_2ck183 = 1.8 time = 1840
* CHECK dout0_3 vdout0_3ck183 = 0 time = 1840
* CHECK dout0_4 vdout0_4ck183 = 1.8 time = 1840
* CHECK dout0_5 vdout0_5ck183 = 0 time = 1840
* CHECK dout0_6 vdout0_6ck183 = 0 time = 1840
* CHECK dout0_7 vdout0_7ck183 = 1.8 time = 1840
* CHECK dout0_8 vdout0_8ck183 = 0 time = 1840
* CHECK dout0_9 vdout0_9ck183 = 1.8 time = 1840
* CHECK dout0_10 vdout0_10ck183 = 0 time = 1840
* CHECK dout0_11 vdout0_11ck183 = 0 time = 1840
* CHECK dout0_12 vdout0_12ck183 = 0 time = 1840
* CHECK dout0_13 vdout0_13ck183 = 0 time = 1840
* CHECK dout0_14 vdout0_14ck183 = 1.8 time = 1840
* CHECK dout0_15 vdout0_15ck183 = 1.8 time = 1840
* CHECK dout0_16 vdout0_16ck183 = 1.8 time = 1840
* CHECK dout0_17 vdout0_17ck183 = 1.8 time = 1840
* CHECK dout0_18 vdout0_18ck183 = 1.8 time = 1840
* CHECK dout0_19 vdout0_19ck183 = 1.8 time = 1840
* CHECK dout0_20 vdout0_20ck183 = 1.8 time = 1840
* CHECK dout0_21 vdout0_21ck183 = 1.8 time = 1840
* CHECK dout0_22 vdout0_22ck183 = 1.8 time = 1840
* CHECK dout0_23 vdout0_23ck183 = 1.8 time = 1840
* CHECK dout0_24 vdout0_24ck183 = 0 time = 1840
* CHECK dout0_25 vdout0_25ck183 = 1.8 time = 1840
* CHECK dout0_26 vdout0_26ck183 = 0 time = 1840
* CHECK dout0_27 vdout0_27ck183 = 0 time = 1840
* CHECK dout0_28 vdout0_28ck183 = 1.8 time = 1840
* CHECK dout0_29 vdout0_29ck183 = 0 time = 1840
* CHECK dout0_30 vdout0_30ck183 = 0 time = 1840
* CHECK dout0_31 vdout0_31ck183 = 0 time = 1840
* CHECK dout0_0 vdout0_0ck184 = 0 time = 1850
* CHECK dout0_1 vdout0_1ck184 = 1.8 time = 1850
* CHECK dout0_2 vdout0_2ck184 = 1.8 time = 1850
* CHECK dout0_3 vdout0_3ck184 = 0 time = 1850
* CHECK dout0_4 vdout0_4ck184 = 1.8 time = 1850
* CHECK dout0_5 vdout0_5ck184 = 0 time = 1850
* CHECK dout0_6 vdout0_6ck184 = 0 time = 1850
* CHECK dout0_7 vdout0_7ck184 = 1.8 time = 1850
* CHECK dout0_8 vdout0_8ck184 = 0 time = 1850
* CHECK dout0_9 vdout0_9ck184 = 1.8 time = 1850
* CHECK dout0_10 vdout0_10ck184 = 0 time = 1850
* CHECK dout0_11 vdout0_11ck184 = 0 time = 1850
* CHECK dout0_12 vdout0_12ck184 = 0 time = 1850
* CHECK dout0_13 vdout0_13ck184 = 0 time = 1850
* CHECK dout0_14 vdout0_14ck184 = 1.8 time = 1850
* CHECK dout0_15 vdout0_15ck184 = 1.8 time = 1850
* CHECK dout0_16 vdout0_16ck184 = 1.8 time = 1850
* CHECK dout0_17 vdout0_17ck184 = 1.8 time = 1850
* CHECK dout0_18 vdout0_18ck184 = 1.8 time = 1850
* CHECK dout0_19 vdout0_19ck184 = 1.8 time = 1850
* CHECK dout0_20 vdout0_20ck184 = 1.8 time = 1850
* CHECK dout0_21 vdout0_21ck184 = 1.8 time = 1850
* CHECK dout0_22 vdout0_22ck184 = 1.8 time = 1850
* CHECK dout0_23 vdout0_23ck184 = 1.8 time = 1850
* CHECK dout0_24 vdout0_24ck184 = 0 time = 1850
* CHECK dout0_25 vdout0_25ck184 = 1.8 time = 1850
* CHECK dout0_26 vdout0_26ck184 = 0 time = 1850
* CHECK dout0_27 vdout0_27ck184 = 0 time = 1850
* CHECK dout0_28 vdout0_28ck184 = 1.8 time = 1850
* CHECK dout0_29 vdout0_29ck184 = 0 time = 1850
* CHECK dout0_30 vdout0_30ck184 = 0 time = 1850
* CHECK dout0_31 vdout0_31ck184 = 0 time = 1850
* CHECK dout1_0 vdout1_0ck184 = 0 time = 1850
* CHECK dout1_1 vdout1_1ck184 = 1.8 time = 1850
* CHECK dout1_2 vdout1_2ck184 = 1.8 time = 1850
* CHECK dout1_3 vdout1_3ck184 = 0 time = 1850
* CHECK dout1_4 vdout1_4ck184 = 1.8 time = 1850
* CHECK dout1_5 vdout1_5ck184 = 0 time = 1850
* CHECK dout1_6 vdout1_6ck184 = 0 time = 1850
* CHECK dout1_7 vdout1_7ck184 = 1.8 time = 1850
* CHECK dout1_8 vdout1_8ck184 = 0 time = 1850
* CHECK dout1_9 vdout1_9ck184 = 1.8 time = 1850
* CHECK dout1_10 vdout1_10ck184 = 0 time = 1850
* CHECK dout1_11 vdout1_11ck184 = 0 time = 1850
* CHECK dout1_12 vdout1_12ck184 = 0 time = 1850
* CHECK dout1_13 vdout1_13ck184 = 0 time = 1850
* CHECK dout1_14 vdout1_14ck184 = 1.8 time = 1850
* CHECK dout1_15 vdout1_15ck184 = 1.8 time = 1850
* CHECK dout1_16 vdout1_16ck184 = 1.8 time = 1850
* CHECK dout1_17 vdout1_17ck184 = 1.8 time = 1850
* CHECK dout1_18 vdout1_18ck184 = 1.8 time = 1850
* CHECK dout1_19 vdout1_19ck184 = 1.8 time = 1850
* CHECK dout1_20 vdout1_20ck184 = 1.8 time = 1850
* CHECK dout1_21 vdout1_21ck184 = 1.8 time = 1850
* CHECK dout1_22 vdout1_22ck184 = 1.8 time = 1850
* CHECK dout1_23 vdout1_23ck184 = 1.8 time = 1850
* CHECK dout1_24 vdout1_24ck184 = 0 time = 1850
* CHECK dout1_25 vdout1_25ck184 = 1.8 time = 1850
* CHECK dout1_26 vdout1_26ck184 = 0 time = 1850
* CHECK dout1_27 vdout1_27ck184 = 0 time = 1850
* CHECK dout1_28 vdout1_28ck184 = 1.8 time = 1850
* CHECK dout1_29 vdout1_29ck184 = 0 time = 1850
* CHECK dout1_30 vdout1_30ck184 = 0 time = 1850
* CHECK dout1_31 vdout1_31ck184 = 0 time = 1850
* CHECK dout0_0 vdout0_0ck186 = 0 time = 1870
* CHECK dout0_1 vdout0_1ck186 = 1.8 time = 1870
* CHECK dout0_2 vdout0_2ck186 = 1.8 time = 1870
* CHECK dout0_3 vdout0_3ck186 = 0 time = 1870
* CHECK dout0_4 vdout0_4ck186 = 1.8 time = 1870
* CHECK dout0_5 vdout0_5ck186 = 0 time = 1870
* CHECK dout0_6 vdout0_6ck186 = 0 time = 1870
* CHECK dout0_7 vdout0_7ck186 = 1.8 time = 1870
* CHECK dout0_8 vdout0_8ck186 = 0 time = 1870
* CHECK dout0_9 vdout0_9ck186 = 1.8 time = 1870
* CHECK dout0_10 vdout0_10ck186 = 0 time = 1870
* CHECK dout0_11 vdout0_11ck186 = 0 time = 1870
* CHECK dout0_12 vdout0_12ck186 = 0 time = 1870
* CHECK dout0_13 vdout0_13ck186 = 0 time = 1870
* CHECK dout0_14 vdout0_14ck186 = 1.8 time = 1870
* CHECK dout0_15 vdout0_15ck186 = 1.8 time = 1870
* CHECK dout0_16 vdout0_16ck186 = 1.8 time = 1870
* CHECK dout0_17 vdout0_17ck186 = 1.8 time = 1870
* CHECK dout0_18 vdout0_18ck186 = 1.8 time = 1870
* CHECK dout0_19 vdout0_19ck186 = 1.8 time = 1870
* CHECK dout0_20 vdout0_20ck186 = 1.8 time = 1870
* CHECK dout0_21 vdout0_21ck186 = 1.8 time = 1870
* CHECK dout0_22 vdout0_22ck186 = 1.8 time = 1870
* CHECK dout0_23 vdout0_23ck186 = 1.8 time = 1870
* CHECK dout0_24 vdout0_24ck186 = 0 time = 1870
* CHECK dout0_25 vdout0_25ck186 = 1.8 time = 1870
* CHECK dout0_26 vdout0_26ck186 = 0 time = 1870
* CHECK dout0_27 vdout0_27ck186 = 0 time = 1870
* CHECK dout0_28 vdout0_28ck186 = 1.8 time = 1870
* CHECK dout0_29 vdout0_29ck186 = 0 time = 1870
* CHECK dout0_30 vdout0_30ck186 = 0 time = 1870
* CHECK dout0_31 vdout0_31ck186 = 0 time = 1870
* CHECK dout1_0 vdout1_0ck186 = 1.8 time = 1870
* CHECK dout1_1 vdout1_1ck186 = 1.8 time = 1870
* CHECK dout1_2 vdout1_2ck186 = 0 time = 1870
* CHECK dout1_3 vdout1_3ck186 = 1.8 time = 1870
* CHECK dout1_4 vdout1_4ck186 = 0 time = 1870
* CHECK dout1_5 vdout1_5ck186 = 1.8 time = 1870
* CHECK dout1_6 vdout1_6ck186 = 1.8 time = 1870
* CHECK dout1_7 vdout1_7ck186 = 1.8 time = 1870
* CHECK dout1_8 vdout1_8ck186 = 1.8 time = 1870
* CHECK dout1_9 vdout1_9ck186 = 0 time = 1870
* CHECK dout1_10 vdout1_10ck186 = 0 time = 1870
* CHECK dout1_11 vdout1_11ck186 = 0 time = 1870
* CHECK dout1_12 vdout1_12ck186 = 0 time = 1870
* CHECK dout1_13 vdout1_13ck186 = 0 time = 1870
* CHECK dout1_14 vdout1_14ck186 = 1.8 time = 1870
* CHECK dout1_15 vdout1_15ck186 = 1.8 time = 1870
* CHECK dout1_16 vdout1_16ck186 = 0 time = 1870
* CHECK dout1_17 vdout1_17ck186 = 1.8 time = 1870
* CHECK dout1_18 vdout1_18ck186 = 1.8 time = 1870
* CHECK dout1_19 vdout1_19ck186 = 1.8 time = 1870
* CHECK dout1_20 vdout1_20ck186 = 1.8 time = 1870
* CHECK dout1_21 vdout1_21ck186 = 1.8 time = 1870
* CHECK dout1_22 vdout1_22ck186 = 0 time = 1870
* CHECK dout1_23 vdout1_23ck186 = 1.8 time = 1870
* CHECK dout1_24 vdout1_24ck186 = 0 time = 1870
* CHECK dout1_25 vdout1_25ck186 = 1.8 time = 1870
* CHECK dout1_26 vdout1_26ck186 = 1.8 time = 1870
* CHECK dout1_27 vdout1_27ck186 = 1.8 time = 1870
* CHECK dout1_28 vdout1_28ck186 = 0 time = 1870
* CHECK dout1_29 vdout1_29ck186 = 1.8 time = 1870
* CHECK dout1_30 vdout1_30ck186 = 0 time = 1870
* CHECK dout1_31 vdout1_31ck186 = 1.8 time = 1870
* CHECK dout0_0 vdout0_0ck187 = 0 time = 1880
* CHECK dout0_1 vdout0_1ck187 = 1.8 time = 1880
* CHECK dout0_2 vdout0_2ck187 = 1.8 time = 1880
* CHECK dout0_3 vdout0_3ck187 = 0 time = 1880
* CHECK dout0_4 vdout0_4ck187 = 1.8 time = 1880
* CHECK dout0_5 vdout0_5ck187 = 0 time = 1880
* CHECK dout0_6 vdout0_6ck187 = 0 time = 1880
* CHECK dout0_7 vdout0_7ck187 = 1.8 time = 1880
* CHECK dout0_8 vdout0_8ck187 = 0 time = 1880
* CHECK dout0_9 vdout0_9ck187 = 1.8 time = 1880
* CHECK dout0_10 vdout0_10ck187 = 0 time = 1880
* CHECK dout0_11 vdout0_11ck187 = 0 time = 1880
* CHECK dout0_12 vdout0_12ck187 = 0 time = 1880
* CHECK dout0_13 vdout0_13ck187 = 0 time = 1880
* CHECK dout0_14 vdout0_14ck187 = 1.8 time = 1880
* CHECK dout0_15 vdout0_15ck187 = 1.8 time = 1880
* CHECK dout0_16 vdout0_16ck187 = 1.8 time = 1880
* CHECK dout0_17 vdout0_17ck187 = 1.8 time = 1880
* CHECK dout0_18 vdout0_18ck187 = 1.8 time = 1880
* CHECK dout0_19 vdout0_19ck187 = 1.8 time = 1880
* CHECK dout0_20 vdout0_20ck187 = 1.8 time = 1880
* CHECK dout0_21 vdout0_21ck187 = 1.8 time = 1880
* CHECK dout0_22 vdout0_22ck187 = 1.8 time = 1880
* CHECK dout0_23 vdout0_23ck187 = 1.8 time = 1880
* CHECK dout0_24 vdout0_24ck187 = 0 time = 1880
* CHECK dout0_25 vdout0_25ck187 = 1.8 time = 1880
* CHECK dout0_26 vdout0_26ck187 = 0 time = 1880
* CHECK dout0_27 vdout0_27ck187 = 0 time = 1880
* CHECK dout0_28 vdout0_28ck187 = 1.8 time = 1880
* CHECK dout0_29 vdout0_29ck187 = 0 time = 1880
* CHECK dout0_30 vdout0_30ck187 = 0 time = 1880
* CHECK dout0_31 vdout0_31ck187 = 0 time = 1880
* CHECK dout0_0 vdout0_0ck188 = 0 time = 1890
* CHECK dout0_1 vdout0_1ck188 = 1.8 time = 1890
* CHECK dout0_2 vdout0_2ck188 = 1.8 time = 1890
* CHECK dout0_3 vdout0_3ck188 = 0 time = 1890
* CHECK dout0_4 vdout0_4ck188 = 1.8 time = 1890
* CHECK dout0_5 vdout0_5ck188 = 0 time = 1890
* CHECK dout0_6 vdout0_6ck188 = 0 time = 1890
* CHECK dout0_7 vdout0_7ck188 = 1.8 time = 1890
* CHECK dout0_8 vdout0_8ck188 = 0 time = 1890
* CHECK dout0_9 vdout0_9ck188 = 1.8 time = 1890
* CHECK dout0_10 vdout0_10ck188 = 0 time = 1890
* CHECK dout0_11 vdout0_11ck188 = 0 time = 1890
* CHECK dout0_12 vdout0_12ck188 = 0 time = 1890
* CHECK dout0_13 vdout0_13ck188 = 0 time = 1890
* CHECK dout0_14 vdout0_14ck188 = 1.8 time = 1890
* CHECK dout0_15 vdout0_15ck188 = 1.8 time = 1890
* CHECK dout0_16 vdout0_16ck188 = 1.8 time = 1890
* CHECK dout0_17 vdout0_17ck188 = 1.8 time = 1890
* CHECK dout0_18 vdout0_18ck188 = 1.8 time = 1890
* CHECK dout0_19 vdout0_19ck188 = 1.8 time = 1890
* CHECK dout0_20 vdout0_20ck188 = 1.8 time = 1890
* CHECK dout0_21 vdout0_21ck188 = 1.8 time = 1890
* CHECK dout0_22 vdout0_22ck188 = 1.8 time = 1890
* CHECK dout0_23 vdout0_23ck188 = 1.8 time = 1890
* CHECK dout0_24 vdout0_24ck188 = 0 time = 1890
* CHECK dout0_25 vdout0_25ck188 = 1.8 time = 1890
* CHECK dout0_26 vdout0_26ck188 = 0 time = 1890
* CHECK dout0_27 vdout0_27ck188 = 0 time = 1890
* CHECK dout0_28 vdout0_28ck188 = 1.8 time = 1890
* CHECK dout0_29 vdout0_29ck188 = 0 time = 1890
* CHECK dout0_30 vdout0_30ck188 = 0 time = 1890
* CHECK dout0_31 vdout0_31ck188 = 0 time = 1890
* CHECK dout1_0 vdout1_0ck188 = 1.8 time = 1890
* CHECK dout1_1 vdout1_1ck188 = 1.8 time = 1890
* CHECK dout1_2 vdout1_2ck188 = 0 time = 1890
* CHECK dout1_3 vdout1_3ck188 = 1.8 time = 1890
* CHECK dout1_4 vdout1_4ck188 = 0 time = 1890
* CHECK dout1_5 vdout1_5ck188 = 1.8 time = 1890
* CHECK dout1_6 vdout1_6ck188 = 1.8 time = 1890
* CHECK dout1_7 vdout1_7ck188 = 1.8 time = 1890
* CHECK dout1_8 vdout1_8ck188 = 1.8 time = 1890
* CHECK dout1_9 vdout1_9ck188 = 0 time = 1890
* CHECK dout1_10 vdout1_10ck188 = 0 time = 1890
* CHECK dout1_11 vdout1_11ck188 = 0 time = 1890
* CHECK dout1_12 vdout1_12ck188 = 0 time = 1890
* CHECK dout1_13 vdout1_13ck188 = 0 time = 1890
* CHECK dout1_14 vdout1_14ck188 = 1.8 time = 1890
* CHECK dout1_15 vdout1_15ck188 = 1.8 time = 1890
* CHECK dout1_16 vdout1_16ck188 = 0 time = 1890
* CHECK dout1_17 vdout1_17ck188 = 1.8 time = 1890
* CHECK dout1_18 vdout1_18ck188 = 1.8 time = 1890
* CHECK dout1_19 vdout1_19ck188 = 1.8 time = 1890
* CHECK dout1_20 vdout1_20ck188 = 1.8 time = 1890
* CHECK dout1_21 vdout1_21ck188 = 1.8 time = 1890
* CHECK dout1_22 vdout1_22ck188 = 0 time = 1890
* CHECK dout1_23 vdout1_23ck188 = 1.8 time = 1890
* CHECK dout1_24 vdout1_24ck188 = 0 time = 1890
* CHECK dout1_25 vdout1_25ck188 = 1.8 time = 1890
* CHECK dout1_26 vdout1_26ck188 = 1.8 time = 1890
* CHECK dout1_27 vdout1_27ck188 = 1.8 time = 1890
* CHECK dout1_28 vdout1_28ck188 = 0 time = 1890
* CHECK dout1_29 vdout1_29ck188 = 1.8 time = 1890
* CHECK dout1_30 vdout1_30ck188 = 0 time = 1890
* CHECK dout1_31 vdout1_31ck188 = 1.8 time = 1890
* CHECK dout1_0 vdout1_0ck189 = 1.8 time = 1900
* CHECK dout1_1 vdout1_1ck189 = 1.8 time = 1900
* CHECK dout1_2 vdout1_2ck189 = 0 time = 1900
* CHECK dout1_3 vdout1_3ck189 = 1.8 time = 1900
* CHECK dout1_4 vdout1_4ck189 = 0 time = 1900
* CHECK dout1_5 vdout1_5ck189 = 1.8 time = 1900
* CHECK dout1_6 vdout1_6ck189 = 1.8 time = 1900
* CHECK dout1_7 vdout1_7ck189 = 1.8 time = 1900
* CHECK dout1_8 vdout1_8ck189 = 1.8 time = 1900
* CHECK dout1_9 vdout1_9ck189 = 0 time = 1900
* CHECK dout1_10 vdout1_10ck189 = 0 time = 1900
* CHECK dout1_11 vdout1_11ck189 = 0 time = 1900
* CHECK dout1_12 vdout1_12ck189 = 0 time = 1900
* CHECK dout1_13 vdout1_13ck189 = 0 time = 1900
* CHECK dout1_14 vdout1_14ck189 = 1.8 time = 1900
* CHECK dout1_15 vdout1_15ck189 = 1.8 time = 1900
* CHECK dout1_16 vdout1_16ck189 = 0 time = 1900
* CHECK dout1_17 vdout1_17ck189 = 1.8 time = 1900
* CHECK dout1_18 vdout1_18ck189 = 1.8 time = 1900
* CHECK dout1_19 vdout1_19ck189 = 1.8 time = 1900
* CHECK dout1_20 vdout1_20ck189 = 1.8 time = 1900
* CHECK dout1_21 vdout1_21ck189 = 1.8 time = 1900
* CHECK dout1_22 vdout1_22ck189 = 0 time = 1900
* CHECK dout1_23 vdout1_23ck189 = 1.8 time = 1900
* CHECK dout1_24 vdout1_24ck189 = 0 time = 1900
* CHECK dout1_25 vdout1_25ck189 = 1.8 time = 1900
* CHECK dout1_26 vdout1_26ck189 = 1.8 time = 1900
* CHECK dout1_27 vdout1_27ck189 = 1.8 time = 1900
* CHECK dout1_28 vdout1_28ck189 = 0 time = 1900
* CHECK dout1_29 vdout1_29ck189 = 1.8 time = 1900
* CHECK dout1_30 vdout1_30ck189 = 0 time = 1900
* CHECK dout1_31 vdout1_31ck189 = 1.8 time = 1900
* CHECK dout0_0 vdout0_0ck192 = 0 time = 1930
* CHECK dout0_1 vdout0_1ck192 = 0 time = 1930
* CHECK dout0_2 vdout0_2ck192 = 1.8 time = 1930
* CHECK dout0_3 vdout0_3ck192 = 1.8 time = 1930
* CHECK dout0_4 vdout0_4ck192 = 1.8 time = 1930
* CHECK dout0_5 vdout0_5ck192 = 1.8 time = 1930
* CHECK dout0_6 vdout0_6ck192 = 1.8 time = 1930
* CHECK dout0_7 vdout0_7ck192 = 0 time = 1930
* CHECK dout0_8 vdout0_8ck192 = 0 time = 1930
* CHECK dout0_9 vdout0_9ck192 = 0 time = 1930
* CHECK dout0_10 vdout0_10ck192 = 0 time = 1930
* CHECK dout0_11 vdout0_11ck192 = 0 time = 1930
* CHECK dout0_12 vdout0_12ck192 = 1.8 time = 1930
* CHECK dout0_13 vdout0_13ck192 = 1.8 time = 1930
* CHECK dout0_14 vdout0_14ck192 = 0 time = 1930
* CHECK dout0_15 vdout0_15ck192 = 1.8 time = 1930
* CHECK dout0_16 vdout0_16ck192 = 1.8 time = 1930
* CHECK dout0_17 vdout0_17ck192 = 0 time = 1930
* CHECK dout0_18 vdout0_18ck192 = 0 time = 1930
* CHECK dout0_19 vdout0_19ck192 = 0 time = 1930
* CHECK dout0_20 vdout0_20ck192 = 0 time = 1930
* CHECK dout0_21 vdout0_21ck192 = 1.8 time = 1930
* CHECK dout0_22 vdout0_22ck192 = 1.8 time = 1930
* CHECK dout0_23 vdout0_23ck192 = 1.8 time = 1930
* CHECK dout0_24 vdout0_24ck192 = 1.8 time = 1930
* CHECK dout0_25 vdout0_25ck192 = 1.8 time = 1930
* CHECK dout0_26 vdout0_26ck192 = 1.8 time = 1930
* CHECK dout0_27 vdout0_27ck192 = 0 time = 1930
* CHECK dout0_28 vdout0_28ck192 = 0 time = 1930
* CHECK dout0_29 vdout0_29ck192 = 1.8 time = 1930
* CHECK dout0_30 vdout0_30ck192 = 0 time = 1930
* CHECK dout0_31 vdout0_31ck192 = 1.8 time = 1930
* CHECK dout1_0 vdout1_0ck192 = 0 time = 1930
* CHECK dout1_1 vdout1_1ck192 = 0 time = 1930
* CHECK dout1_2 vdout1_2ck192 = 1.8 time = 1930
* CHECK dout1_3 vdout1_3ck192 = 1.8 time = 1930
* CHECK dout1_4 vdout1_4ck192 = 1.8 time = 1930
* CHECK dout1_5 vdout1_5ck192 = 1.8 time = 1930
* CHECK dout1_6 vdout1_6ck192 = 1.8 time = 1930
* CHECK dout1_7 vdout1_7ck192 = 0 time = 1930
* CHECK dout1_8 vdout1_8ck192 = 0 time = 1930
* CHECK dout1_9 vdout1_9ck192 = 0 time = 1930
* CHECK dout1_10 vdout1_10ck192 = 0 time = 1930
* CHECK dout1_11 vdout1_11ck192 = 0 time = 1930
* CHECK dout1_12 vdout1_12ck192 = 1.8 time = 1930
* CHECK dout1_13 vdout1_13ck192 = 1.8 time = 1930
* CHECK dout1_14 vdout1_14ck192 = 0 time = 1930
* CHECK dout1_15 vdout1_15ck192 = 1.8 time = 1930
* CHECK dout1_16 vdout1_16ck192 = 1.8 time = 1930
* CHECK dout1_17 vdout1_17ck192 = 0 time = 1930
* CHECK dout1_18 vdout1_18ck192 = 0 time = 1930
* CHECK dout1_19 vdout1_19ck192 = 0 time = 1930
* CHECK dout1_20 vdout1_20ck192 = 0 time = 1930
* CHECK dout1_21 vdout1_21ck192 = 1.8 time = 1930
* CHECK dout1_22 vdout1_22ck192 = 1.8 time = 1930
* CHECK dout1_23 vdout1_23ck192 = 1.8 time = 1930
* CHECK dout1_24 vdout1_24ck192 = 1.8 time = 1930
* CHECK dout1_25 vdout1_25ck192 = 1.8 time = 1930
* CHECK dout1_26 vdout1_26ck192 = 1.8 time = 1930
* CHECK dout1_27 vdout1_27ck192 = 0 time = 1930
* CHECK dout1_28 vdout1_28ck192 = 0 time = 1930
* CHECK dout1_29 vdout1_29ck192 = 1.8 time = 1930
* CHECK dout1_30 vdout1_30ck192 = 0 time = 1930
* CHECK dout1_31 vdout1_31ck192 = 1.8 time = 1930
* CHECK dout1_0 vdout1_0ck193 = 0 time = 1940
* CHECK dout1_1 vdout1_1ck193 = 0 time = 1940
* CHECK dout1_2 vdout1_2ck193 = 1.8 time = 1940
* CHECK dout1_3 vdout1_3ck193 = 1.8 time = 1940
* CHECK dout1_4 vdout1_4ck193 = 1.8 time = 1940
* CHECK dout1_5 vdout1_5ck193 = 1.8 time = 1940
* CHECK dout1_6 vdout1_6ck193 = 1.8 time = 1940
* CHECK dout1_7 vdout1_7ck193 = 0 time = 1940
* CHECK dout1_8 vdout1_8ck193 = 0 time = 1940
* CHECK dout1_9 vdout1_9ck193 = 0 time = 1940
* CHECK dout1_10 vdout1_10ck193 = 0 time = 1940
* CHECK dout1_11 vdout1_11ck193 = 0 time = 1940
* CHECK dout1_12 vdout1_12ck193 = 1.8 time = 1940
* CHECK dout1_13 vdout1_13ck193 = 1.8 time = 1940
* CHECK dout1_14 vdout1_14ck193 = 0 time = 1940
* CHECK dout1_15 vdout1_15ck193 = 1.8 time = 1940
* CHECK dout1_16 vdout1_16ck193 = 1.8 time = 1940
* CHECK dout1_17 vdout1_17ck193 = 0 time = 1940
* CHECK dout1_18 vdout1_18ck193 = 0 time = 1940
* CHECK dout1_19 vdout1_19ck193 = 0 time = 1940
* CHECK dout1_20 vdout1_20ck193 = 0 time = 1940
* CHECK dout1_21 vdout1_21ck193 = 1.8 time = 1940
* CHECK dout1_22 vdout1_22ck193 = 1.8 time = 1940
* CHECK dout1_23 vdout1_23ck193 = 1.8 time = 1940
* CHECK dout1_24 vdout1_24ck193 = 1.8 time = 1940
* CHECK dout1_25 vdout1_25ck193 = 1.8 time = 1940
* CHECK dout1_26 vdout1_26ck193 = 1.8 time = 1940
* CHECK dout1_27 vdout1_27ck193 = 0 time = 1940
* CHECK dout1_28 vdout1_28ck193 = 0 time = 1940
* CHECK dout1_29 vdout1_29ck193 = 1.8 time = 1940
* CHECK dout1_30 vdout1_30ck193 = 0 time = 1940
* CHECK dout1_31 vdout1_31ck193 = 1.8 time = 1940
* CHECK dout0_0 vdout0_0ck195 = 0 time = 1960
* CHECK dout0_1 vdout0_1ck195 = 1.8 time = 1960
* CHECK dout0_2 vdout0_2ck195 = 1.8 time = 1960
* CHECK dout0_3 vdout0_3ck195 = 0 time = 1960
* CHECK dout0_4 vdout0_4ck195 = 1.8 time = 1960
* CHECK dout0_5 vdout0_5ck195 = 0 time = 1960
* CHECK dout0_6 vdout0_6ck195 = 0 time = 1960
* CHECK dout0_7 vdout0_7ck195 = 1.8 time = 1960
* CHECK dout0_8 vdout0_8ck195 = 0 time = 1960
* CHECK dout0_9 vdout0_9ck195 = 1.8 time = 1960
* CHECK dout0_10 vdout0_10ck195 = 0 time = 1960
* CHECK dout0_11 vdout0_11ck195 = 0 time = 1960
* CHECK dout0_12 vdout0_12ck195 = 0 time = 1960
* CHECK dout0_13 vdout0_13ck195 = 0 time = 1960
* CHECK dout0_14 vdout0_14ck195 = 1.8 time = 1960
* CHECK dout0_15 vdout0_15ck195 = 1.8 time = 1960
* CHECK dout0_16 vdout0_16ck195 = 1.8 time = 1960
* CHECK dout0_17 vdout0_17ck195 = 1.8 time = 1960
* CHECK dout0_18 vdout0_18ck195 = 1.8 time = 1960
* CHECK dout0_19 vdout0_19ck195 = 1.8 time = 1960
* CHECK dout0_20 vdout0_20ck195 = 1.8 time = 1960
* CHECK dout0_21 vdout0_21ck195 = 1.8 time = 1960
* CHECK dout0_22 vdout0_22ck195 = 1.8 time = 1960
* CHECK dout0_23 vdout0_23ck195 = 1.8 time = 1960
* CHECK dout0_24 vdout0_24ck195 = 0 time = 1960
* CHECK dout0_25 vdout0_25ck195 = 1.8 time = 1960
* CHECK dout0_26 vdout0_26ck195 = 0 time = 1960
* CHECK dout0_27 vdout0_27ck195 = 0 time = 1960
* CHECK dout0_28 vdout0_28ck195 = 1.8 time = 1960
* CHECK dout0_29 vdout0_29ck195 = 0 time = 1960
* CHECK dout0_30 vdout0_30ck195 = 0 time = 1960
* CHECK dout0_31 vdout0_31ck195 = 0 time = 1960
* CHECK dout0_0 vdout0_0ck196 = 0 time = 1970
* CHECK dout0_1 vdout0_1ck196 = 1.8 time = 1970
* CHECK dout0_2 vdout0_2ck196 = 1.8 time = 1970
* CHECK dout0_3 vdout0_3ck196 = 0 time = 1970
* CHECK dout0_4 vdout0_4ck196 = 1.8 time = 1970
* CHECK dout0_5 vdout0_5ck196 = 0 time = 1970
* CHECK dout0_6 vdout0_6ck196 = 0 time = 1970
* CHECK dout0_7 vdout0_7ck196 = 1.8 time = 1970
* CHECK dout0_8 vdout0_8ck196 = 0 time = 1970
* CHECK dout0_9 vdout0_9ck196 = 1.8 time = 1970
* CHECK dout0_10 vdout0_10ck196 = 0 time = 1970
* CHECK dout0_11 vdout0_11ck196 = 0 time = 1970
* CHECK dout0_12 vdout0_12ck196 = 0 time = 1970
* CHECK dout0_13 vdout0_13ck196 = 0 time = 1970
* CHECK dout0_14 vdout0_14ck196 = 1.8 time = 1970
* CHECK dout0_15 vdout0_15ck196 = 1.8 time = 1970
* CHECK dout0_16 vdout0_16ck196 = 1.8 time = 1970
* CHECK dout0_17 vdout0_17ck196 = 1.8 time = 1970
* CHECK dout0_18 vdout0_18ck196 = 1.8 time = 1970
* CHECK dout0_19 vdout0_19ck196 = 1.8 time = 1970
* CHECK dout0_20 vdout0_20ck196 = 1.8 time = 1970
* CHECK dout0_21 vdout0_21ck196 = 1.8 time = 1970
* CHECK dout0_22 vdout0_22ck196 = 1.8 time = 1970
* CHECK dout0_23 vdout0_23ck196 = 1.8 time = 1970
* CHECK dout0_24 vdout0_24ck196 = 0 time = 1970
* CHECK dout0_25 vdout0_25ck196 = 1.8 time = 1970
* CHECK dout0_26 vdout0_26ck196 = 0 time = 1970
* CHECK dout0_27 vdout0_27ck196 = 0 time = 1970
* CHECK dout0_28 vdout0_28ck196 = 1.8 time = 1970
* CHECK dout0_29 vdout0_29ck196 = 0 time = 1970
* CHECK dout0_30 vdout0_30ck196 = 0 time = 1970
* CHECK dout0_31 vdout0_31ck196 = 0 time = 1970
* CHECK dout0_0 vdout0_0ck198 = 0 time = 1990
* CHECK dout0_1 vdout0_1ck198 = 0 time = 1990
* CHECK dout0_2 vdout0_2ck198 = 1.8 time = 1990
* CHECK dout0_3 vdout0_3ck198 = 1.8 time = 1990
* CHECK dout0_4 vdout0_4ck198 = 1.8 time = 1990
* CHECK dout0_5 vdout0_5ck198 = 1.8 time = 1990
* CHECK dout0_6 vdout0_6ck198 = 1.8 time = 1990
* CHECK dout0_7 vdout0_7ck198 = 0 time = 1990
* CHECK dout0_8 vdout0_8ck198 = 0 time = 1990
* CHECK dout0_9 vdout0_9ck198 = 0 time = 1990
* CHECK dout0_10 vdout0_10ck198 = 0 time = 1990
* CHECK dout0_11 vdout0_11ck198 = 0 time = 1990
* CHECK dout0_12 vdout0_12ck198 = 1.8 time = 1990
* CHECK dout0_13 vdout0_13ck198 = 1.8 time = 1990
* CHECK dout0_14 vdout0_14ck198 = 0 time = 1990
* CHECK dout0_15 vdout0_15ck198 = 1.8 time = 1990
* CHECK dout0_16 vdout0_16ck198 = 1.8 time = 1990
* CHECK dout0_17 vdout0_17ck198 = 0 time = 1990
* CHECK dout0_18 vdout0_18ck198 = 0 time = 1990
* CHECK dout0_19 vdout0_19ck198 = 0 time = 1990
* CHECK dout0_20 vdout0_20ck198 = 0 time = 1990
* CHECK dout0_21 vdout0_21ck198 = 1.8 time = 1990
* CHECK dout0_22 vdout0_22ck198 = 1.8 time = 1990
* CHECK dout0_23 vdout0_23ck198 = 1.8 time = 1990
* CHECK dout0_24 vdout0_24ck198 = 1.8 time = 1990
* CHECK dout0_25 vdout0_25ck198 = 1.8 time = 1990
* CHECK dout0_26 vdout0_26ck198 = 1.8 time = 1990
* CHECK dout0_27 vdout0_27ck198 = 0 time = 1990
* CHECK dout0_28 vdout0_28ck198 = 0 time = 1990
* CHECK dout0_29 vdout0_29ck198 = 1.8 time = 1990
* CHECK dout0_30 vdout0_30ck198 = 0 time = 1990
* CHECK dout0_31 vdout0_31ck198 = 1.8 time = 1990
* CHECK dout1_0 vdout1_0ck198 = 0 time = 1990
* CHECK dout1_1 vdout1_1ck198 = 0 time = 1990
* CHECK dout1_2 vdout1_2ck198 = 1.8 time = 1990
* CHECK dout1_3 vdout1_3ck198 = 1.8 time = 1990
* CHECK dout1_4 vdout1_4ck198 = 1.8 time = 1990
* CHECK dout1_5 vdout1_5ck198 = 1.8 time = 1990
* CHECK dout1_6 vdout1_6ck198 = 1.8 time = 1990
* CHECK dout1_7 vdout1_7ck198 = 0 time = 1990
* CHECK dout1_8 vdout1_8ck198 = 0 time = 1990
* CHECK dout1_9 vdout1_9ck198 = 0 time = 1990
* CHECK dout1_10 vdout1_10ck198 = 0 time = 1990
* CHECK dout1_11 vdout1_11ck198 = 0 time = 1990
* CHECK dout1_12 vdout1_12ck198 = 1.8 time = 1990
* CHECK dout1_13 vdout1_13ck198 = 1.8 time = 1990
* CHECK dout1_14 vdout1_14ck198 = 0 time = 1990
* CHECK dout1_15 vdout1_15ck198 = 1.8 time = 1990
* CHECK dout1_16 vdout1_16ck198 = 1.8 time = 1990
* CHECK dout1_17 vdout1_17ck198 = 0 time = 1990
* CHECK dout1_18 vdout1_18ck198 = 0 time = 1990
* CHECK dout1_19 vdout1_19ck198 = 0 time = 1990
* CHECK dout1_20 vdout1_20ck198 = 0 time = 1990
* CHECK dout1_21 vdout1_21ck198 = 1.8 time = 1990
* CHECK dout1_22 vdout1_22ck198 = 1.8 time = 1990
* CHECK dout1_23 vdout1_23ck198 = 1.8 time = 1990
* CHECK dout1_24 vdout1_24ck198 = 1.8 time = 1990
* CHECK dout1_25 vdout1_25ck198 = 1.8 time = 1990
* CHECK dout1_26 vdout1_26ck198 = 1.8 time = 1990
* CHECK dout1_27 vdout1_27ck198 = 0 time = 1990
* CHECK dout1_28 vdout1_28ck198 = 0 time = 1990
* CHECK dout1_29 vdout1_29ck198 = 1.8 time = 1990
* CHECK dout1_30 vdout1_30ck198 = 0 time = 1990
* CHECK dout1_31 vdout1_31ck198 = 1.8 time = 1990
* CHECK dout0_0 vdout0_0ck199 = 0 time = 2000
* CHECK dout0_1 vdout0_1ck199 = 1.8 time = 2000
* CHECK dout0_2 vdout0_2ck199 = 1.8 time = 2000
* CHECK dout0_3 vdout0_3ck199 = 0 time = 2000
* CHECK dout0_4 vdout0_4ck199 = 1.8 time = 2000
* CHECK dout0_5 vdout0_5ck199 = 0 time = 2000
* CHECK dout0_6 vdout0_6ck199 = 0 time = 2000
* CHECK dout0_7 vdout0_7ck199 = 1.8 time = 2000
* CHECK dout0_8 vdout0_8ck199 = 0 time = 2000
* CHECK dout0_9 vdout0_9ck199 = 1.8 time = 2000
* CHECK dout0_10 vdout0_10ck199 = 0 time = 2000
* CHECK dout0_11 vdout0_11ck199 = 0 time = 2000
* CHECK dout0_12 vdout0_12ck199 = 0 time = 2000
* CHECK dout0_13 vdout0_13ck199 = 0 time = 2000
* CHECK dout0_14 vdout0_14ck199 = 1.8 time = 2000
* CHECK dout0_15 vdout0_15ck199 = 1.8 time = 2000
* CHECK dout0_16 vdout0_16ck199 = 1.8 time = 2000
* CHECK dout0_17 vdout0_17ck199 = 1.8 time = 2000
* CHECK dout0_18 vdout0_18ck199 = 1.8 time = 2000
* CHECK dout0_19 vdout0_19ck199 = 1.8 time = 2000
* CHECK dout0_20 vdout0_20ck199 = 1.8 time = 2000
* CHECK dout0_21 vdout0_21ck199 = 1.8 time = 2000
* CHECK dout0_22 vdout0_22ck199 = 1.8 time = 2000
* CHECK dout0_23 vdout0_23ck199 = 1.8 time = 2000
* CHECK dout0_24 vdout0_24ck199 = 0 time = 2000
* CHECK dout0_25 vdout0_25ck199 = 1.8 time = 2000
* CHECK dout0_26 vdout0_26ck199 = 0 time = 2000
* CHECK dout0_27 vdout0_27ck199 = 0 time = 2000
* CHECK dout0_28 vdout0_28ck199 = 1.8 time = 2000
* CHECK dout0_29 vdout0_29ck199 = 0 time = 2000
* CHECK dout0_30 vdout0_30ck199 = 0 time = 2000
* CHECK dout0_31 vdout0_31ck199 = 0 time = 2000
* CHECK dout1_0 vdout1_0ck199 = 0 time = 2000
* CHECK dout1_1 vdout1_1ck199 = 0 time = 2000
* CHECK dout1_2 vdout1_2ck199 = 1.8 time = 2000
* CHECK dout1_3 vdout1_3ck199 = 1.8 time = 2000
* CHECK dout1_4 vdout1_4ck199 = 1.8 time = 2000
* CHECK dout1_5 vdout1_5ck199 = 1.8 time = 2000
* CHECK dout1_6 vdout1_6ck199 = 1.8 time = 2000
* CHECK dout1_7 vdout1_7ck199 = 0 time = 2000
* CHECK dout1_8 vdout1_8ck199 = 0 time = 2000
* CHECK dout1_9 vdout1_9ck199 = 0 time = 2000
* CHECK dout1_10 vdout1_10ck199 = 0 time = 2000
* CHECK dout1_11 vdout1_11ck199 = 0 time = 2000
* CHECK dout1_12 vdout1_12ck199 = 1.8 time = 2000
* CHECK dout1_13 vdout1_13ck199 = 1.8 time = 2000
* CHECK dout1_14 vdout1_14ck199 = 0 time = 2000
* CHECK dout1_15 vdout1_15ck199 = 1.8 time = 2000
* CHECK dout1_16 vdout1_16ck199 = 1.8 time = 2000
* CHECK dout1_17 vdout1_17ck199 = 0 time = 2000
* CHECK dout1_18 vdout1_18ck199 = 0 time = 2000
* CHECK dout1_19 vdout1_19ck199 = 0 time = 2000
* CHECK dout1_20 vdout1_20ck199 = 0 time = 2000
* CHECK dout1_21 vdout1_21ck199 = 1.8 time = 2000
* CHECK dout1_22 vdout1_22ck199 = 1.8 time = 2000
* CHECK dout1_23 vdout1_23ck199 = 1.8 time = 2000
* CHECK dout1_24 vdout1_24ck199 = 1.8 time = 2000
* CHECK dout1_25 vdout1_25ck199 = 1.8 time = 2000
* CHECK dout1_26 vdout1_26ck199 = 1.8 time = 2000
* CHECK dout1_27 vdout1_27ck199 = 0 time = 2000
* CHECK dout1_28 vdout1_28ck199 = 0 time = 2000
* CHECK dout1_29 vdout1_29ck199 = 1.8 time = 2000
* CHECK dout1_30 vdout1_30ck199 = 0 time = 2000
* CHECK dout1_31 vdout1_31ck199 = 1.8 time = 2000
* CHECK dout1_0 vdout1_0ck200 = 0 time = 2010
* CHECK dout1_1 vdout1_1ck200 = 1.8 time = 2010
* CHECK dout1_2 vdout1_2ck200 = 1.8 time = 2010
* CHECK dout1_3 vdout1_3ck200 = 0 time = 2010
* CHECK dout1_4 vdout1_4ck200 = 1.8 time = 2010
* CHECK dout1_5 vdout1_5ck200 = 0 time = 2010
* CHECK dout1_6 vdout1_6ck200 = 0 time = 2010
* CHECK dout1_7 vdout1_7ck200 = 1.8 time = 2010
* CHECK dout1_8 vdout1_8ck200 = 0 time = 2010
* CHECK dout1_9 vdout1_9ck200 = 1.8 time = 2010
* CHECK dout1_10 vdout1_10ck200 = 0 time = 2010
* CHECK dout1_11 vdout1_11ck200 = 0 time = 2010
* CHECK dout1_12 vdout1_12ck200 = 0 time = 2010
* CHECK dout1_13 vdout1_13ck200 = 0 time = 2010
* CHECK dout1_14 vdout1_14ck200 = 1.8 time = 2010
* CHECK dout1_15 vdout1_15ck200 = 1.8 time = 2010
* CHECK dout1_16 vdout1_16ck200 = 1.8 time = 2010
* CHECK dout1_17 vdout1_17ck200 = 1.8 time = 2010
* CHECK dout1_18 vdout1_18ck200 = 1.8 time = 2010
* CHECK dout1_19 vdout1_19ck200 = 1.8 time = 2010
* CHECK dout1_20 vdout1_20ck200 = 1.8 time = 2010
* CHECK dout1_21 vdout1_21ck200 = 1.8 time = 2010
* CHECK dout1_22 vdout1_22ck200 = 1.8 time = 2010
* CHECK dout1_23 vdout1_23ck200 = 1.8 time = 2010
* CHECK dout1_24 vdout1_24ck200 = 0 time = 2010
* CHECK dout1_25 vdout1_25ck200 = 1.8 time = 2010
* CHECK dout1_26 vdout1_26ck200 = 0 time = 2010
* CHECK dout1_27 vdout1_27ck200 = 0 time = 2010
* CHECK dout1_28 vdout1_28ck200 = 1.8 time = 2010
* CHECK dout1_29 vdout1_29ck200 = 0 time = 2010
* CHECK dout1_30 vdout1_30ck200 = 0 time = 2010
* CHECK dout1_31 vdout1_31ck200 = 0 time = 2010
* CHECK dout0_0 vdout0_0ck201 = 0 time = 2020
* CHECK dout0_1 vdout0_1ck201 = 0 time = 2020
* CHECK dout0_2 vdout0_2ck201 = 1.8 time = 2020
* CHECK dout0_3 vdout0_3ck201 = 1.8 time = 2020
* CHECK dout0_4 vdout0_4ck201 = 1.8 time = 2020
* CHECK dout0_5 vdout0_5ck201 = 1.8 time = 2020
* CHECK dout0_6 vdout0_6ck201 = 1.8 time = 2020
* CHECK dout0_7 vdout0_7ck201 = 0 time = 2020
* CHECK dout0_8 vdout0_8ck201 = 0 time = 2020
* CHECK dout0_9 vdout0_9ck201 = 0 time = 2020
* CHECK dout0_10 vdout0_10ck201 = 0 time = 2020
* CHECK dout0_11 vdout0_11ck201 = 0 time = 2020
* CHECK dout0_12 vdout0_12ck201 = 1.8 time = 2020
* CHECK dout0_13 vdout0_13ck201 = 1.8 time = 2020
* CHECK dout0_14 vdout0_14ck201 = 0 time = 2020
* CHECK dout0_15 vdout0_15ck201 = 1.8 time = 2020
* CHECK dout0_16 vdout0_16ck201 = 1.8 time = 2020
* CHECK dout0_17 vdout0_17ck201 = 0 time = 2020
* CHECK dout0_18 vdout0_18ck201 = 0 time = 2020
* CHECK dout0_19 vdout0_19ck201 = 0 time = 2020
* CHECK dout0_20 vdout0_20ck201 = 0 time = 2020
* CHECK dout0_21 vdout0_21ck201 = 1.8 time = 2020
* CHECK dout0_22 vdout0_22ck201 = 1.8 time = 2020
* CHECK dout0_23 vdout0_23ck201 = 1.8 time = 2020
* CHECK dout0_24 vdout0_24ck201 = 1.8 time = 2020
* CHECK dout0_25 vdout0_25ck201 = 1.8 time = 2020
* CHECK dout0_26 vdout0_26ck201 = 1.8 time = 2020
* CHECK dout0_27 vdout0_27ck201 = 0 time = 2020
* CHECK dout0_28 vdout0_28ck201 = 0 time = 2020
* CHECK dout0_29 vdout0_29ck201 = 1.8 time = 2020
* CHECK dout0_30 vdout0_30ck201 = 0 time = 2020
* CHECK dout0_31 vdout0_31ck201 = 1.8 time = 2020
* CHECK dout1_0 vdout1_0ck201 = 0 time = 2020
* CHECK dout1_1 vdout1_1ck201 = 0 time = 2020
* CHECK dout1_2 vdout1_2ck201 = 1.8 time = 2020
* CHECK dout1_3 vdout1_3ck201 = 1.8 time = 2020
* CHECK dout1_4 vdout1_4ck201 = 1.8 time = 2020
* CHECK dout1_5 vdout1_5ck201 = 1.8 time = 2020
* CHECK dout1_6 vdout1_6ck201 = 1.8 time = 2020
* CHECK dout1_7 vdout1_7ck201 = 0 time = 2020
* CHECK dout1_8 vdout1_8ck201 = 0 time = 2020
* CHECK dout1_9 vdout1_9ck201 = 0 time = 2020
* CHECK dout1_10 vdout1_10ck201 = 0 time = 2020
* CHECK dout1_11 vdout1_11ck201 = 0 time = 2020
* CHECK dout1_12 vdout1_12ck201 = 1.8 time = 2020
* CHECK dout1_13 vdout1_13ck201 = 1.8 time = 2020
* CHECK dout1_14 vdout1_14ck201 = 0 time = 2020
* CHECK dout1_15 vdout1_15ck201 = 1.8 time = 2020
* CHECK dout1_16 vdout1_16ck201 = 1.8 time = 2020
* CHECK dout1_17 vdout1_17ck201 = 0 time = 2020
* CHECK dout1_18 vdout1_18ck201 = 0 time = 2020
* CHECK dout1_19 vdout1_19ck201 = 0 time = 2020
* CHECK dout1_20 vdout1_20ck201 = 0 time = 2020
* CHECK dout1_21 vdout1_21ck201 = 1.8 time = 2020
* CHECK dout1_22 vdout1_22ck201 = 1.8 time = 2020
* CHECK dout1_23 vdout1_23ck201 = 1.8 time = 2020
* CHECK dout1_24 vdout1_24ck201 = 1.8 time = 2020
* CHECK dout1_25 vdout1_25ck201 = 1.8 time = 2020
* CHECK dout1_26 vdout1_26ck201 = 1.8 time = 2020
* CHECK dout1_27 vdout1_27ck201 = 0 time = 2020
* CHECK dout1_28 vdout1_28ck201 = 0 time = 2020
* CHECK dout1_29 vdout1_29ck201 = 1.8 time = 2020
* CHECK dout1_30 vdout1_30ck201 = 0 time = 2020
* CHECK dout1_31 vdout1_31ck201 = 1.8 time = 2020
* CHECK dout0_0 vdout0_0ck202 = 0 time = 2030
* CHECK dout0_1 vdout0_1ck202 = 1.8 time = 2030
* CHECK dout0_2 vdout0_2ck202 = 1.8 time = 2030
* CHECK dout0_3 vdout0_3ck202 = 0 time = 2030
* CHECK dout0_4 vdout0_4ck202 = 1.8 time = 2030
* CHECK dout0_5 vdout0_5ck202 = 0 time = 2030
* CHECK dout0_6 vdout0_6ck202 = 0 time = 2030
* CHECK dout0_7 vdout0_7ck202 = 1.8 time = 2030
* CHECK dout0_8 vdout0_8ck202 = 0 time = 2030
* CHECK dout0_9 vdout0_9ck202 = 1.8 time = 2030
* CHECK dout0_10 vdout0_10ck202 = 0 time = 2030
* CHECK dout0_11 vdout0_11ck202 = 0 time = 2030
* CHECK dout0_12 vdout0_12ck202 = 0 time = 2030
* CHECK dout0_13 vdout0_13ck202 = 0 time = 2030
* CHECK dout0_14 vdout0_14ck202 = 1.8 time = 2030
* CHECK dout0_15 vdout0_15ck202 = 1.8 time = 2030
* CHECK dout0_16 vdout0_16ck202 = 1.8 time = 2030
* CHECK dout0_17 vdout0_17ck202 = 1.8 time = 2030
* CHECK dout0_18 vdout0_18ck202 = 1.8 time = 2030
* CHECK dout0_19 vdout0_19ck202 = 1.8 time = 2030
* CHECK dout0_20 vdout0_20ck202 = 1.8 time = 2030
* CHECK dout0_21 vdout0_21ck202 = 1.8 time = 2030
* CHECK dout0_22 vdout0_22ck202 = 1.8 time = 2030
* CHECK dout0_23 vdout0_23ck202 = 1.8 time = 2030
* CHECK dout0_24 vdout0_24ck202 = 0 time = 2030
* CHECK dout0_25 vdout0_25ck202 = 1.8 time = 2030
* CHECK dout0_26 vdout0_26ck202 = 0 time = 2030
* CHECK dout0_27 vdout0_27ck202 = 0 time = 2030
* CHECK dout0_28 vdout0_28ck202 = 1.8 time = 2030
* CHECK dout0_29 vdout0_29ck202 = 0 time = 2030
* CHECK dout0_30 vdout0_30ck202 = 0 time = 2030
* CHECK dout0_31 vdout0_31ck202 = 0 time = 2030
* CHECK dout1_0 vdout1_0ck202 = 0 time = 2030
* CHECK dout1_1 vdout1_1ck202 = 1.8 time = 2030
* CHECK dout1_2 vdout1_2ck202 = 1.8 time = 2030
* CHECK dout1_3 vdout1_3ck202 = 0 time = 2030
* CHECK dout1_4 vdout1_4ck202 = 1.8 time = 2030
* CHECK dout1_5 vdout1_5ck202 = 0 time = 2030
* CHECK dout1_6 vdout1_6ck202 = 0 time = 2030
* CHECK dout1_7 vdout1_7ck202 = 1.8 time = 2030
* CHECK dout1_8 vdout1_8ck202 = 0 time = 2030
* CHECK dout1_9 vdout1_9ck202 = 1.8 time = 2030
* CHECK dout1_10 vdout1_10ck202 = 0 time = 2030
* CHECK dout1_11 vdout1_11ck202 = 0 time = 2030
* CHECK dout1_12 vdout1_12ck202 = 0 time = 2030
* CHECK dout1_13 vdout1_13ck202 = 0 time = 2030
* CHECK dout1_14 vdout1_14ck202 = 1.8 time = 2030
* CHECK dout1_15 vdout1_15ck202 = 1.8 time = 2030
* CHECK dout1_16 vdout1_16ck202 = 1.8 time = 2030
* CHECK dout1_17 vdout1_17ck202 = 1.8 time = 2030
* CHECK dout1_18 vdout1_18ck202 = 1.8 time = 2030
* CHECK dout1_19 vdout1_19ck202 = 1.8 time = 2030
* CHECK dout1_20 vdout1_20ck202 = 1.8 time = 2030
* CHECK dout1_21 vdout1_21ck202 = 1.8 time = 2030
* CHECK dout1_22 vdout1_22ck202 = 1.8 time = 2030
* CHECK dout1_23 vdout1_23ck202 = 1.8 time = 2030
* CHECK dout1_24 vdout1_24ck202 = 0 time = 2030
* CHECK dout1_25 vdout1_25ck202 = 1.8 time = 2030
* CHECK dout1_26 vdout1_26ck202 = 0 time = 2030
* CHECK dout1_27 vdout1_27ck202 = 0 time = 2030
* CHECK dout1_28 vdout1_28ck202 = 1.8 time = 2030
* CHECK dout1_29 vdout1_29ck202 = 0 time = 2030
* CHECK dout1_30 vdout1_30ck202 = 0 time = 2030
* CHECK dout1_31 vdout1_31ck202 = 0 time = 2030
* CHECK dout0_0 vdout0_0ck203 = 0 time = 2040
* CHECK dout0_1 vdout0_1ck203 = 1.8 time = 2040
* CHECK dout0_2 vdout0_2ck203 = 1.8 time = 2040
* CHECK dout0_3 vdout0_3ck203 = 0 time = 2040
* CHECK dout0_4 vdout0_4ck203 = 1.8 time = 2040
* CHECK dout0_5 vdout0_5ck203 = 0 time = 2040
* CHECK dout0_6 vdout0_6ck203 = 0 time = 2040
* CHECK dout0_7 vdout0_7ck203 = 1.8 time = 2040
* CHECK dout0_8 vdout0_8ck203 = 0 time = 2040
* CHECK dout0_9 vdout0_9ck203 = 1.8 time = 2040
* CHECK dout0_10 vdout0_10ck203 = 0 time = 2040
* CHECK dout0_11 vdout0_11ck203 = 0 time = 2040
* CHECK dout0_12 vdout0_12ck203 = 0 time = 2040
* CHECK dout0_13 vdout0_13ck203 = 0 time = 2040
* CHECK dout0_14 vdout0_14ck203 = 1.8 time = 2040
* CHECK dout0_15 vdout0_15ck203 = 1.8 time = 2040
* CHECK dout0_16 vdout0_16ck203 = 1.8 time = 2040
* CHECK dout0_17 vdout0_17ck203 = 1.8 time = 2040
* CHECK dout0_18 vdout0_18ck203 = 1.8 time = 2040
* CHECK dout0_19 vdout0_19ck203 = 1.8 time = 2040
* CHECK dout0_20 vdout0_20ck203 = 1.8 time = 2040
* CHECK dout0_21 vdout0_21ck203 = 1.8 time = 2040
* CHECK dout0_22 vdout0_22ck203 = 1.8 time = 2040
* CHECK dout0_23 vdout0_23ck203 = 1.8 time = 2040
* CHECK dout0_24 vdout0_24ck203 = 0 time = 2040
* CHECK dout0_25 vdout0_25ck203 = 1.8 time = 2040
* CHECK dout0_26 vdout0_26ck203 = 0 time = 2040
* CHECK dout0_27 vdout0_27ck203 = 0 time = 2040
* CHECK dout0_28 vdout0_28ck203 = 1.8 time = 2040
* CHECK dout0_29 vdout0_29ck203 = 0 time = 2040
* CHECK dout0_30 vdout0_30ck203 = 0 time = 2040
* CHECK dout0_31 vdout0_31ck203 = 0 time = 2040
* CHECK dout0_0 vdout0_0ck204 = 0 time = 2050
* CHECK dout0_1 vdout0_1ck204 = 1.8 time = 2050
* CHECK dout0_2 vdout0_2ck204 = 1.8 time = 2050
* CHECK dout0_3 vdout0_3ck204 = 0 time = 2050
* CHECK dout0_4 vdout0_4ck204 = 1.8 time = 2050
* CHECK dout0_5 vdout0_5ck204 = 0 time = 2050
* CHECK dout0_6 vdout0_6ck204 = 0 time = 2050
* CHECK dout0_7 vdout0_7ck204 = 1.8 time = 2050
* CHECK dout0_8 vdout0_8ck204 = 0 time = 2050
* CHECK dout0_9 vdout0_9ck204 = 1.8 time = 2050
* CHECK dout0_10 vdout0_10ck204 = 0 time = 2050
* CHECK dout0_11 vdout0_11ck204 = 0 time = 2050
* CHECK dout0_12 vdout0_12ck204 = 0 time = 2050
* CHECK dout0_13 vdout0_13ck204 = 0 time = 2050
* CHECK dout0_14 vdout0_14ck204 = 1.8 time = 2050
* CHECK dout0_15 vdout0_15ck204 = 1.8 time = 2050
* CHECK dout0_16 vdout0_16ck204 = 1.8 time = 2050
* CHECK dout0_17 vdout0_17ck204 = 1.8 time = 2050
* CHECK dout0_18 vdout0_18ck204 = 1.8 time = 2050
* CHECK dout0_19 vdout0_19ck204 = 1.8 time = 2050
* CHECK dout0_20 vdout0_20ck204 = 1.8 time = 2050
* CHECK dout0_21 vdout0_21ck204 = 1.8 time = 2050
* CHECK dout0_22 vdout0_22ck204 = 1.8 time = 2050
* CHECK dout0_23 vdout0_23ck204 = 1.8 time = 2050
* CHECK dout0_24 vdout0_24ck204 = 0 time = 2050
* CHECK dout0_25 vdout0_25ck204 = 1.8 time = 2050
* CHECK dout0_26 vdout0_26ck204 = 0 time = 2050
* CHECK dout0_27 vdout0_27ck204 = 0 time = 2050
* CHECK dout0_28 vdout0_28ck204 = 1.8 time = 2050
* CHECK dout0_29 vdout0_29ck204 = 0 time = 2050
* CHECK dout0_30 vdout0_30ck204 = 0 time = 2050
* CHECK dout0_31 vdout0_31ck204 = 0 time = 2050
.include /home/lukas/Projects/neorv32-openram-sky130/openram/spiral_min/out/sram_1rw1r_32x16/functional_meas.sp
* probe is used for hspice/xa, while plot is used in ngspice
.plot V(*)
.end
