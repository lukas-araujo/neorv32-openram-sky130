.meas tran vdout0_0ck40 FIND v(dout0_0) AT=50.05n

.meas tran vdout0_1ck40 FIND v(dout0_1) AT=50.05n

.meas tran vdout0_2ck40 FIND v(dout0_2) AT=50.05n

.meas tran vdout0_3ck40 FIND v(dout0_3) AT=50.05n

.meas tran vdout0_4ck40 FIND v(dout0_4) AT=50.05n

.meas tran vdout0_5ck40 FIND v(dout0_5) AT=50.05n

.meas tran vdout0_6ck40 FIND v(dout0_6) AT=50.05n

.meas tran vdout0_7ck40 FIND v(dout0_7) AT=50.05n

.meas tran vdout0_8ck40 FIND v(dout0_8) AT=50.05n

.meas tran vdout0_9ck40 FIND v(dout0_9) AT=50.05n

.meas tran vdout0_10ck40 FIND v(dout0_10) AT=50.05n

.meas tran vdout0_11ck40 FIND v(dout0_11) AT=50.05n

.meas tran vdout0_12ck40 FIND v(dout0_12) AT=50.05n

.meas tran vdout0_13ck40 FIND v(dout0_13) AT=50.05n

.meas tran vdout0_14ck40 FIND v(dout0_14) AT=50.05n

.meas tran vdout0_15ck40 FIND v(dout0_15) AT=50.05n

.meas tran vdout0_16ck40 FIND v(dout0_16) AT=50.05n

.meas tran vdout0_17ck40 FIND v(dout0_17) AT=50.05n

.meas tran vdout0_18ck40 FIND v(dout0_18) AT=50.05n

.meas tran vdout0_19ck40 FIND v(dout0_19) AT=50.05n

.meas tran vdout0_20ck40 FIND v(dout0_20) AT=50.05n

.meas tran vdout0_21ck40 FIND v(dout0_21) AT=50.05n

.meas tran vdout0_22ck40 FIND v(dout0_22) AT=50.05n

.meas tran vdout0_23ck40 FIND v(dout0_23) AT=50.05n

.meas tran vdout0_24ck40 FIND v(dout0_24) AT=50.05n

.meas tran vdout0_25ck40 FIND v(dout0_25) AT=50.05n

.meas tran vdout0_26ck40 FIND v(dout0_26) AT=50.05n

.meas tran vdout0_27ck40 FIND v(dout0_27) AT=50.05n

.meas tran vdout0_28ck40 FIND v(dout0_28) AT=50.05n

.meas tran vdout0_29ck40 FIND v(dout0_29) AT=50.05n

.meas tran vdout0_30ck40 FIND v(dout0_30) AT=50.05n

.meas tran vdout0_31ck40 FIND v(dout0_31) AT=50.05n

.meas tran vdout0_32ck40 FIND v(dout0_32) AT=50.05n

.meas tran vdout0_33ck40 FIND v(dout0_33) AT=50.05n

.meas tran vdout0_34ck40 FIND v(dout0_34) AT=50.05n

.meas tran vdout0_35ck40 FIND v(dout0_35) AT=50.05n

.meas tran vdout0_36ck40 FIND v(dout0_36) AT=50.05n

.meas tran vdout0_37ck40 FIND v(dout0_37) AT=50.05n

.meas tran vdout0_38ck40 FIND v(dout0_38) AT=50.05n

.meas tran vdout0_39ck40 FIND v(dout0_39) AT=50.05n

.meas tran vdout0_40ck40 FIND v(dout0_40) AT=50.05n

.meas tran vdout0_41ck40 FIND v(dout0_41) AT=50.05n

.meas tran vdout0_42ck40 FIND v(dout0_42) AT=50.05n

.meas tran vdout0_43ck40 FIND v(dout0_43) AT=50.05n

.meas tran vdout0_44ck40 FIND v(dout0_44) AT=50.05n

.meas tran vdout0_45ck40 FIND v(dout0_45) AT=50.05n

.meas tran vdout0_46ck40 FIND v(dout0_46) AT=50.05n

.meas tran vdout0_47ck40 FIND v(dout0_47) AT=50.05n

.meas tran vdout0_48ck40 FIND v(dout0_48) AT=50.05n

.meas tran vdout0_49ck40 FIND v(dout0_49) AT=50.05n

.meas tran vdout0_50ck40 FIND v(dout0_50) AT=50.05n

.meas tran vdout0_51ck40 FIND v(dout0_51) AT=50.05n

.meas tran vdout0_52ck40 FIND v(dout0_52) AT=50.05n

.meas tran vdout0_53ck40 FIND v(dout0_53) AT=50.05n

.meas tran vdout0_54ck40 FIND v(dout0_54) AT=50.05n

.meas tran vdout0_55ck40 FIND v(dout0_55) AT=50.05n

.meas tran vdout0_56ck40 FIND v(dout0_56) AT=50.05n

.meas tran vdout0_57ck40 FIND v(dout0_57) AT=50.05n

.meas tran vdout0_58ck40 FIND v(dout0_58) AT=50.05n

.meas tran vdout0_59ck40 FIND v(dout0_59) AT=50.05n

.meas tran vdout0_60ck40 FIND v(dout0_60) AT=50.05n

.meas tran vdout0_61ck40 FIND v(dout0_61) AT=50.05n

.meas tran vdout0_62ck40 FIND v(dout0_62) AT=50.05n

.meas tran vdout0_63ck40 FIND v(dout0_63) AT=50.05n

.meas tran vdout1_0ck40 FIND v(dout1_0) AT=50.05n

.meas tran vdout1_1ck40 FIND v(dout1_1) AT=50.05n

.meas tran vdout1_2ck40 FIND v(dout1_2) AT=50.05n

.meas tran vdout1_3ck40 FIND v(dout1_3) AT=50.05n

.meas tran vdout1_4ck40 FIND v(dout1_4) AT=50.05n

.meas tran vdout1_5ck40 FIND v(dout1_5) AT=50.05n

.meas tran vdout1_6ck40 FIND v(dout1_6) AT=50.05n

.meas tran vdout1_7ck40 FIND v(dout1_7) AT=50.05n

.meas tran vdout1_8ck40 FIND v(dout1_8) AT=50.05n

.meas tran vdout1_9ck40 FIND v(dout1_9) AT=50.05n

.meas tran vdout1_10ck40 FIND v(dout1_10) AT=50.05n

.meas tran vdout1_11ck40 FIND v(dout1_11) AT=50.05n

.meas tran vdout1_12ck40 FIND v(dout1_12) AT=50.05n

.meas tran vdout1_13ck40 FIND v(dout1_13) AT=50.05n

.meas tran vdout1_14ck40 FIND v(dout1_14) AT=50.05n

.meas tran vdout1_15ck40 FIND v(dout1_15) AT=50.05n

.meas tran vdout1_16ck40 FIND v(dout1_16) AT=50.05n

.meas tran vdout1_17ck40 FIND v(dout1_17) AT=50.05n

.meas tran vdout1_18ck40 FIND v(dout1_18) AT=50.05n

.meas tran vdout1_19ck40 FIND v(dout1_19) AT=50.05n

.meas tran vdout1_20ck40 FIND v(dout1_20) AT=50.05n

.meas tran vdout1_21ck40 FIND v(dout1_21) AT=50.05n

.meas tran vdout1_22ck40 FIND v(dout1_22) AT=50.05n

.meas tran vdout1_23ck40 FIND v(dout1_23) AT=50.05n

.meas tran vdout1_24ck40 FIND v(dout1_24) AT=50.05n

.meas tran vdout1_25ck40 FIND v(dout1_25) AT=50.05n

.meas tran vdout1_26ck40 FIND v(dout1_26) AT=50.05n

.meas tran vdout1_27ck40 FIND v(dout1_27) AT=50.05n

.meas tran vdout1_28ck40 FIND v(dout1_28) AT=50.05n

.meas tran vdout1_29ck40 FIND v(dout1_29) AT=50.05n

.meas tran vdout1_30ck40 FIND v(dout1_30) AT=50.05n

.meas tran vdout1_31ck40 FIND v(dout1_31) AT=50.05n

.meas tran vdout1_32ck40 FIND v(dout1_32) AT=50.05n

.meas tran vdout1_33ck40 FIND v(dout1_33) AT=50.05n

.meas tran vdout1_34ck40 FIND v(dout1_34) AT=50.05n

.meas tran vdout1_35ck40 FIND v(dout1_35) AT=50.05n

.meas tran vdout1_36ck40 FIND v(dout1_36) AT=50.05n

.meas tran vdout1_37ck40 FIND v(dout1_37) AT=50.05n

.meas tran vdout1_38ck40 FIND v(dout1_38) AT=50.05n

.meas tran vdout1_39ck40 FIND v(dout1_39) AT=50.05n

.meas tran vdout1_40ck40 FIND v(dout1_40) AT=50.05n

.meas tran vdout1_41ck40 FIND v(dout1_41) AT=50.05n

.meas tran vdout1_42ck40 FIND v(dout1_42) AT=50.05n

.meas tran vdout1_43ck40 FIND v(dout1_43) AT=50.05n

.meas tran vdout1_44ck40 FIND v(dout1_44) AT=50.05n

.meas tran vdout1_45ck40 FIND v(dout1_45) AT=50.05n

.meas tran vdout1_46ck40 FIND v(dout1_46) AT=50.05n

.meas tran vdout1_47ck40 FIND v(dout1_47) AT=50.05n

.meas tran vdout1_48ck40 FIND v(dout1_48) AT=50.05n

.meas tran vdout1_49ck40 FIND v(dout1_49) AT=50.05n

.meas tran vdout1_50ck40 FIND v(dout1_50) AT=50.05n

.meas tran vdout1_51ck40 FIND v(dout1_51) AT=50.05n

.meas tran vdout1_52ck40 FIND v(dout1_52) AT=50.05n

.meas tran vdout1_53ck40 FIND v(dout1_53) AT=50.05n

.meas tran vdout1_54ck40 FIND v(dout1_54) AT=50.05n

.meas tran vdout1_55ck40 FIND v(dout1_55) AT=50.05n

.meas tran vdout1_56ck40 FIND v(dout1_56) AT=50.05n

.meas tran vdout1_57ck40 FIND v(dout1_57) AT=50.05n

.meas tran vdout1_58ck40 FIND v(dout1_58) AT=50.05n

.meas tran vdout1_59ck40 FIND v(dout1_59) AT=50.05n

.meas tran vdout1_60ck40 FIND v(dout1_60) AT=50.05n

.meas tran vdout1_61ck40 FIND v(dout1_61) AT=50.05n

.meas tran vdout1_62ck40 FIND v(dout1_62) AT=50.05n

.meas tran vdout1_63ck40 FIND v(dout1_63) AT=50.05n

.meas tran vdout0_0ck50 FIND v(dout0_0) AT=60.05n

.meas tran vdout0_1ck50 FIND v(dout0_1) AT=60.05n

.meas tran vdout0_2ck50 FIND v(dout0_2) AT=60.05n

.meas tran vdout0_3ck50 FIND v(dout0_3) AT=60.05n

.meas tran vdout0_4ck50 FIND v(dout0_4) AT=60.05n

.meas tran vdout0_5ck50 FIND v(dout0_5) AT=60.05n

.meas tran vdout0_6ck50 FIND v(dout0_6) AT=60.05n

.meas tran vdout0_7ck50 FIND v(dout0_7) AT=60.05n

.meas tran vdout0_8ck50 FIND v(dout0_8) AT=60.05n

.meas tran vdout0_9ck50 FIND v(dout0_9) AT=60.05n

.meas tran vdout0_10ck50 FIND v(dout0_10) AT=60.05n

.meas tran vdout0_11ck50 FIND v(dout0_11) AT=60.05n

.meas tran vdout0_12ck50 FIND v(dout0_12) AT=60.05n

.meas tran vdout0_13ck50 FIND v(dout0_13) AT=60.05n

.meas tran vdout0_14ck50 FIND v(dout0_14) AT=60.05n

.meas tran vdout0_15ck50 FIND v(dout0_15) AT=60.05n

.meas tran vdout0_16ck50 FIND v(dout0_16) AT=60.05n

.meas tran vdout0_17ck50 FIND v(dout0_17) AT=60.05n

.meas tran vdout0_18ck50 FIND v(dout0_18) AT=60.05n

.meas tran vdout0_19ck50 FIND v(dout0_19) AT=60.05n

.meas tran vdout0_20ck50 FIND v(dout0_20) AT=60.05n

.meas tran vdout0_21ck50 FIND v(dout0_21) AT=60.05n

.meas tran vdout0_22ck50 FIND v(dout0_22) AT=60.05n

.meas tran vdout0_23ck50 FIND v(dout0_23) AT=60.05n

.meas tran vdout0_24ck50 FIND v(dout0_24) AT=60.05n

.meas tran vdout0_25ck50 FIND v(dout0_25) AT=60.05n

.meas tran vdout0_26ck50 FIND v(dout0_26) AT=60.05n

.meas tran vdout0_27ck50 FIND v(dout0_27) AT=60.05n

.meas tran vdout0_28ck50 FIND v(dout0_28) AT=60.05n

.meas tran vdout0_29ck50 FIND v(dout0_29) AT=60.05n

.meas tran vdout0_30ck50 FIND v(dout0_30) AT=60.05n

.meas tran vdout0_31ck50 FIND v(dout0_31) AT=60.05n

.meas tran vdout0_32ck50 FIND v(dout0_32) AT=60.05n

.meas tran vdout0_33ck50 FIND v(dout0_33) AT=60.05n

.meas tran vdout0_34ck50 FIND v(dout0_34) AT=60.05n

.meas tran vdout0_35ck50 FIND v(dout0_35) AT=60.05n

.meas tran vdout0_36ck50 FIND v(dout0_36) AT=60.05n

.meas tran vdout0_37ck50 FIND v(dout0_37) AT=60.05n

.meas tran vdout0_38ck50 FIND v(dout0_38) AT=60.05n

.meas tran vdout0_39ck50 FIND v(dout0_39) AT=60.05n

.meas tran vdout0_40ck50 FIND v(dout0_40) AT=60.05n

.meas tran vdout0_41ck50 FIND v(dout0_41) AT=60.05n

.meas tran vdout0_42ck50 FIND v(dout0_42) AT=60.05n

.meas tran vdout0_43ck50 FIND v(dout0_43) AT=60.05n

.meas tran vdout0_44ck50 FIND v(dout0_44) AT=60.05n

.meas tran vdout0_45ck50 FIND v(dout0_45) AT=60.05n

.meas tran vdout0_46ck50 FIND v(dout0_46) AT=60.05n

.meas tran vdout0_47ck50 FIND v(dout0_47) AT=60.05n

.meas tran vdout0_48ck50 FIND v(dout0_48) AT=60.05n

.meas tran vdout0_49ck50 FIND v(dout0_49) AT=60.05n

.meas tran vdout0_50ck50 FIND v(dout0_50) AT=60.05n

.meas tran vdout0_51ck50 FIND v(dout0_51) AT=60.05n

.meas tran vdout0_52ck50 FIND v(dout0_52) AT=60.05n

.meas tran vdout0_53ck50 FIND v(dout0_53) AT=60.05n

.meas tran vdout0_54ck50 FIND v(dout0_54) AT=60.05n

.meas tran vdout0_55ck50 FIND v(dout0_55) AT=60.05n

.meas tran vdout0_56ck50 FIND v(dout0_56) AT=60.05n

.meas tran vdout0_57ck50 FIND v(dout0_57) AT=60.05n

.meas tran vdout0_58ck50 FIND v(dout0_58) AT=60.05n

.meas tran vdout0_59ck50 FIND v(dout0_59) AT=60.05n

.meas tran vdout0_60ck50 FIND v(dout0_60) AT=60.05n

.meas tran vdout0_61ck50 FIND v(dout0_61) AT=60.05n

.meas tran vdout0_62ck50 FIND v(dout0_62) AT=60.05n

.meas tran vdout0_63ck50 FIND v(dout0_63) AT=60.05n

.meas tran vdout1_0ck60 FIND v(dout1_0) AT=70.05n

.meas tran vdout1_1ck60 FIND v(dout1_1) AT=70.05n

.meas tran vdout1_2ck60 FIND v(dout1_2) AT=70.05n

.meas tran vdout1_3ck60 FIND v(dout1_3) AT=70.05n

.meas tran vdout1_4ck60 FIND v(dout1_4) AT=70.05n

.meas tran vdout1_5ck60 FIND v(dout1_5) AT=70.05n

.meas tran vdout1_6ck60 FIND v(dout1_6) AT=70.05n

.meas tran vdout1_7ck60 FIND v(dout1_7) AT=70.05n

.meas tran vdout1_8ck60 FIND v(dout1_8) AT=70.05n

.meas tran vdout1_9ck60 FIND v(dout1_9) AT=70.05n

.meas tran vdout1_10ck60 FIND v(dout1_10) AT=70.05n

.meas tran vdout1_11ck60 FIND v(dout1_11) AT=70.05n

.meas tran vdout1_12ck60 FIND v(dout1_12) AT=70.05n

.meas tran vdout1_13ck60 FIND v(dout1_13) AT=70.05n

.meas tran vdout1_14ck60 FIND v(dout1_14) AT=70.05n

.meas tran vdout1_15ck60 FIND v(dout1_15) AT=70.05n

.meas tran vdout1_16ck60 FIND v(dout1_16) AT=70.05n

.meas tran vdout1_17ck60 FIND v(dout1_17) AT=70.05n

.meas tran vdout1_18ck60 FIND v(dout1_18) AT=70.05n

.meas tran vdout1_19ck60 FIND v(dout1_19) AT=70.05n

.meas tran vdout1_20ck60 FIND v(dout1_20) AT=70.05n

.meas tran vdout1_21ck60 FIND v(dout1_21) AT=70.05n

.meas tran vdout1_22ck60 FIND v(dout1_22) AT=70.05n

.meas tran vdout1_23ck60 FIND v(dout1_23) AT=70.05n

.meas tran vdout1_24ck60 FIND v(dout1_24) AT=70.05n

.meas tran vdout1_25ck60 FIND v(dout1_25) AT=70.05n

.meas tran vdout1_26ck60 FIND v(dout1_26) AT=70.05n

.meas tran vdout1_27ck60 FIND v(dout1_27) AT=70.05n

.meas tran vdout1_28ck60 FIND v(dout1_28) AT=70.05n

.meas tran vdout1_29ck60 FIND v(dout1_29) AT=70.05n

.meas tran vdout1_30ck60 FIND v(dout1_30) AT=70.05n

.meas tran vdout1_31ck60 FIND v(dout1_31) AT=70.05n

.meas tran vdout1_32ck60 FIND v(dout1_32) AT=70.05n

.meas tran vdout1_33ck60 FIND v(dout1_33) AT=70.05n

.meas tran vdout1_34ck60 FIND v(dout1_34) AT=70.05n

.meas tran vdout1_35ck60 FIND v(dout1_35) AT=70.05n

.meas tran vdout1_36ck60 FIND v(dout1_36) AT=70.05n

.meas tran vdout1_37ck60 FIND v(dout1_37) AT=70.05n

.meas tran vdout1_38ck60 FIND v(dout1_38) AT=70.05n

.meas tran vdout1_39ck60 FIND v(dout1_39) AT=70.05n

.meas tran vdout1_40ck60 FIND v(dout1_40) AT=70.05n

.meas tran vdout1_41ck60 FIND v(dout1_41) AT=70.05n

.meas tran vdout1_42ck60 FIND v(dout1_42) AT=70.05n

.meas tran vdout1_43ck60 FIND v(dout1_43) AT=70.05n

.meas tran vdout1_44ck60 FIND v(dout1_44) AT=70.05n

.meas tran vdout1_45ck60 FIND v(dout1_45) AT=70.05n

.meas tran vdout1_46ck60 FIND v(dout1_46) AT=70.05n

.meas tran vdout1_47ck60 FIND v(dout1_47) AT=70.05n

.meas tran vdout1_48ck60 FIND v(dout1_48) AT=70.05n

.meas tran vdout1_49ck60 FIND v(dout1_49) AT=70.05n

.meas tran vdout1_50ck60 FIND v(dout1_50) AT=70.05n

.meas tran vdout1_51ck60 FIND v(dout1_51) AT=70.05n

.meas tran vdout1_52ck60 FIND v(dout1_52) AT=70.05n

.meas tran vdout1_53ck60 FIND v(dout1_53) AT=70.05n

.meas tran vdout1_54ck60 FIND v(dout1_54) AT=70.05n

.meas tran vdout1_55ck60 FIND v(dout1_55) AT=70.05n

.meas tran vdout1_56ck60 FIND v(dout1_56) AT=70.05n

.meas tran vdout1_57ck60 FIND v(dout1_57) AT=70.05n

.meas tran vdout1_58ck60 FIND v(dout1_58) AT=70.05n

.meas tran vdout1_59ck60 FIND v(dout1_59) AT=70.05n

.meas tran vdout1_60ck60 FIND v(dout1_60) AT=70.05n

.meas tran vdout1_61ck60 FIND v(dout1_61) AT=70.05n

.meas tran vdout1_62ck60 FIND v(dout1_62) AT=70.05n

.meas tran vdout1_63ck60 FIND v(dout1_63) AT=70.05n

.meas tran vdout0_0ck70 FIND v(dout0_0) AT=80.05n

.meas tran vdout0_1ck70 FIND v(dout0_1) AT=80.05n

.meas tran vdout0_2ck70 FIND v(dout0_2) AT=80.05n

.meas tran vdout0_3ck70 FIND v(dout0_3) AT=80.05n

.meas tran vdout0_4ck70 FIND v(dout0_4) AT=80.05n

.meas tran vdout0_5ck70 FIND v(dout0_5) AT=80.05n

.meas tran vdout0_6ck70 FIND v(dout0_6) AT=80.05n

.meas tran vdout0_7ck70 FIND v(dout0_7) AT=80.05n

.meas tran vdout0_8ck70 FIND v(dout0_8) AT=80.05n

.meas tran vdout0_9ck70 FIND v(dout0_9) AT=80.05n

.meas tran vdout0_10ck70 FIND v(dout0_10) AT=80.05n

.meas tran vdout0_11ck70 FIND v(dout0_11) AT=80.05n

.meas tran vdout0_12ck70 FIND v(dout0_12) AT=80.05n

.meas tran vdout0_13ck70 FIND v(dout0_13) AT=80.05n

.meas tran vdout0_14ck70 FIND v(dout0_14) AT=80.05n

.meas tran vdout0_15ck70 FIND v(dout0_15) AT=80.05n

.meas tran vdout0_16ck70 FIND v(dout0_16) AT=80.05n

.meas tran vdout0_17ck70 FIND v(dout0_17) AT=80.05n

.meas tran vdout0_18ck70 FIND v(dout0_18) AT=80.05n

.meas tran vdout0_19ck70 FIND v(dout0_19) AT=80.05n

.meas tran vdout0_20ck70 FIND v(dout0_20) AT=80.05n

.meas tran vdout0_21ck70 FIND v(dout0_21) AT=80.05n

.meas tran vdout0_22ck70 FIND v(dout0_22) AT=80.05n

.meas tran vdout0_23ck70 FIND v(dout0_23) AT=80.05n

.meas tran vdout0_24ck70 FIND v(dout0_24) AT=80.05n

.meas tran vdout0_25ck70 FIND v(dout0_25) AT=80.05n

.meas tran vdout0_26ck70 FIND v(dout0_26) AT=80.05n

.meas tran vdout0_27ck70 FIND v(dout0_27) AT=80.05n

.meas tran vdout0_28ck70 FIND v(dout0_28) AT=80.05n

.meas tran vdout0_29ck70 FIND v(dout0_29) AT=80.05n

.meas tran vdout0_30ck70 FIND v(dout0_30) AT=80.05n

.meas tran vdout0_31ck70 FIND v(dout0_31) AT=80.05n

.meas tran vdout0_32ck70 FIND v(dout0_32) AT=80.05n

.meas tran vdout0_33ck70 FIND v(dout0_33) AT=80.05n

.meas tran vdout0_34ck70 FIND v(dout0_34) AT=80.05n

.meas tran vdout0_35ck70 FIND v(dout0_35) AT=80.05n

.meas tran vdout0_36ck70 FIND v(dout0_36) AT=80.05n

.meas tran vdout0_37ck70 FIND v(dout0_37) AT=80.05n

.meas tran vdout0_38ck70 FIND v(dout0_38) AT=80.05n

.meas tran vdout0_39ck70 FIND v(dout0_39) AT=80.05n

.meas tran vdout0_40ck70 FIND v(dout0_40) AT=80.05n

.meas tran vdout0_41ck70 FIND v(dout0_41) AT=80.05n

.meas tran vdout0_42ck70 FIND v(dout0_42) AT=80.05n

.meas tran vdout0_43ck70 FIND v(dout0_43) AT=80.05n

.meas tran vdout0_44ck70 FIND v(dout0_44) AT=80.05n

.meas tran vdout0_45ck70 FIND v(dout0_45) AT=80.05n

.meas tran vdout0_46ck70 FIND v(dout0_46) AT=80.05n

.meas tran vdout0_47ck70 FIND v(dout0_47) AT=80.05n

.meas tran vdout0_48ck70 FIND v(dout0_48) AT=80.05n

.meas tran vdout0_49ck70 FIND v(dout0_49) AT=80.05n

.meas tran vdout0_50ck70 FIND v(dout0_50) AT=80.05n

.meas tran vdout0_51ck70 FIND v(dout0_51) AT=80.05n

.meas tran vdout0_52ck70 FIND v(dout0_52) AT=80.05n

.meas tran vdout0_53ck70 FIND v(dout0_53) AT=80.05n

.meas tran vdout0_54ck70 FIND v(dout0_54) AT=80.05n

.meas tran vdout0_55ck70 FIND v(dout0_55) AT=80.05n

.meas tran vdout0_56ck70 FIND v(dout0_56) AT=80.05n

.meas tran vdout0_57ck70 FIND v(dout0_57) AT=80.05n

.meas tran vdout0_58ck70 FIND v(dout0_58) AT=80.05n

.meas tran vdout0_59ck70 FIND v(dout0_59) AT=80.05n

.meas tran vdout0_60ck70 FIND v(dout0_60) AT=80.05n

.meas tran vdout0_61ck70 FIND v(dout0_61) AT=80.05n

.meas tran vdout0_62ck70 FIND v(dout0_62) AT=80.05n

.meas tran vdout0_63ck70 FIND v(dout0_63) AT=80.05n

.meas tran vdout0_0ck90 FIND v(dout0_0) AT=100.05n

.meas tran vdout0_1ck90 FIND v(dout0_1) AT=100.05n

.meas tran vdout0_2ck90 FIND v(dout0_2) AT=100.05n

.meas tran vdout0_3ck90 FIND v(dout0_3) AT=100.05n

.meas tran vdout0_4ck90 FIND v(dout0_4) AT=100.05n

.meas tran vdout0_5ck90 FIND v(dout0_5) AT=100.05n

.meas tran vdout0_6ck90 FIND v(dout0_6) AT=100.05n

.meas tran vdout0_7ck90 FIND v(dout0_7) AT=100.05n

.meas tran vdout0_8ck90 FIND v(dout0_8) AT=100.05n

.meas tran vdout0_9ck90 FIND v(dout0_9) AT=100.05n

.meas tran vdout0_10ck90 FIND v(dout0_10) AT=100.05n

.meas tran vdout0_11ck90 FIND v(dout0_11) AT=100.05n

.meas tran vdout0_12ck90 FIND v(dout0_12) AT=100.05n

.meas tran vdout0_13ck90 FIND v(dout0_13) AT=100.05n

.meas tran vdout0_14ck90 FIND v(dout0_14) AT=100.05n

.meas tran vdout0_15ck90 FIND v(dout0_15) AT=100.05n

.meas tran vdout0_16ck90 FIND v(dout0_16) AT=100.05n

.meas tran vdout0_17ck90 FIND v(dout0_17) AT=100.05n

.meas tran vdout0_18ck90 FIND v(dout0_18) AT=100.05n

.meas tran vdout0_19ck90 FIND v(dout0_19) AT=100.05n

.meas tran vdout0_20ck90 FIND v(dout0_20) AT=100.05n

.meas tran vdout0_21ck90 FIND v(dout0_21) AT=100.05n

.meas tran vdout0_22ck90 FIND v(dout0_22) AT=100.05n

.meas tran vdout0_23ck90 FIND v(dout0_23) AT=100.05n

.meas tran vdout0_24ck90 FIND v(dout0_24) AT=100.05n

.meas tran vdout0_25ck90 FIND v(dout0_25) AT=100.05n

.meas tran vdout0_26ck90 FIND v(dout0_26) AT=100.05n

.meas tran vdout0_27ck90 FIND v(dout0_27) AT=100.05n

.meas tran vdout0_28ck90 FIND v(dout0_28) AT=100.05n

.meas tran vdout0_29ck90 FIND v(dout0_29) AT=100.05n

.meas tran vdout0_30ck90 FIND v(dout0_30) AT=100.05n

.meas tran vdout0_31ck90 FIND v(dout0_31) AT=100.05n

.meas tran vdout0_32ck90 FIND v(dout0_32) AT=100.05n

.meas tran vdout0_33ck90 FIND v(dout0_33) AT=100.05n

.meas tran vdout0_34ck90 FIND v(dout0_34) AT=100.05n

.meas tran vdout0_35ck90 FIND v(dout0_35) AT=100.05n

.meas tran vdout0_36ck90 FIND v(dout0_36) AT=100.05n

.meas tran vdout0_37ck90 FIND v(dout0_37) AT=100.05n

.meas tran vdout0_38ck90 FIND v(dout0_38) AT=100.05n

.meas tran vdout0_39ck90 FIND v(dout0_39) AT=100.05n

.meas tran vdout0_40ck90 FIND v(dout0_40) AT=100.05n

.meas tran vdout0_41ck90 FIND v(dout0_41) AT=100.05n

.meas tran vdout0_42ck90 FIND v(dout0_42) AT=100.05n

.meas tran vdout0_43ck90 FIND v(dout0_43) AT=100.05n

.meas tran vdout0_44ck90 FIND v(dout0_44) AT=100.05n

.meas tran vdout0_45ck90 FIND v(dout0_45) AT=100.05n

.meas tran vdout0_46ck90 FIND v(dout0_46) AT=100.05n

.meas tran vdout0_47ck90 FIND v(dout0_47) AT=100.05n

.meas tran vdout0_48ck90 FIND v(dout0_48) AT=100.05n

.meas tran vdout0_49ck90 FIND v(dout0_49) AT=100.05n

.meas tran vdout0_50ck90 FIND v(dout0_50) AT=100.05n

.meas tran vdout0_51ck90 FIND v(dout0_51) AT=100.05n

.meas tran vdout0_52ck90 FIND v(dout0_52) AT=100.05n

.meas tran vdout0_53ck90 FIND v(dout0_53) AT=100.05n

.meas tran vdout0_54ck90 FIND v(dout0_54) AT=100.05n

.meas tran vdout0_55ck90 FIND v(dout0_55) AT=100.05n

.meas tran vdout0_56ck90 FIND v(dout0_56) AT=100.05n

.meas tran vdout0_57ck90 FIND v(dout0_57) AT=100.05n

.meas tran vdout0_58ck90 FIND v(dout0_58) AT=100.05n

.meas tran vdout0_59ck90 FIND v(dout0_59) AT=100.05n

.meas tran vdout0_60ck90 FIND v(dout0_60) AT=100.05n

.meas tran vdout0_61ck90 FIND v(dout0_61) AT=100.05n

.meas tran vdout0_62ck90 FIND v(dout0_62) AT=100.05n

.meas tran vdout0_63ck90 FIND v(dout0_63) AT=100.05n

.meas tran vdout1_0ck110 FIND v(dout1_0) AT=120.05n

.meas tran vdout1_1ck110 FIND v(dout1_1) AT=120.05n

.meas tran vdout1_2ck110 FIND v(dout1_2) AT=120.05n

.meas tran vdout1_3ck110 FIND v(dout1_3) AT=120.05n

.meas tran vdout1_4ck110 FIND v(dout1_4) AT=120.05n

.meas tran vdout1_5ck110 FIND v(dout1_5) AT=120.05n

.meas tran vdout1_6ck110 FIND v(dout1_6) AT=120.05n

.meas tran vdout1_7ck110 FIND v(dout1_7) AT=120.05n

.meas tran vdout1_8ck110 FIND v(dout1_8) AT=120.05n

.meas tran vdout1_9ck110 FIND v(dout1_9) AT=120.05n

.meas tran vdout1_10ck110 FIND v(dout1_10) AT=120.05n

.meas tran vdout1_11ck110 FIND v(dout1_11) AT=120.05n

.meas tran vdout1_12ck110 FIND v(dout1_12) AT=120.05n

.meas tran vdout1_13ck110 FIND v(dout1_13) AT=120.05n

.meas tran vdout1_14ck110 FIND v(dout1_14) AT=120.05n

.meas tran vdout1_15ck110 FIND v(dout1_15) AT=120.05n

.meas tran vdout1_16ck110 FIND v(dout1_16) AT=120.05n

.meas tran vdout1_17ck110 FIND v(dout1_17) AT=120.05n

.meas tran vdout1_18ck110 FIND v(dout1_18) AT=120.05n

.meas tran vdout1_19ck110 FIND v(dout1_19) AT=120.05n

.meas tran vdout1_20ck110 FIND v(dout1_20) AT=120.05n

.meas tran vdout1_21ck110 FIND v(dout1_21) AT=120.05n

.meas tran vdout1_22ck110 FIND v(dout1_22) AT=120.05n

.meas tran vdout1_23ck110 FIND v(dout1_23) AT=120.05n

.meas tran vdout1_24ck110 FIND v(dout1_24) AT=120.05n

.meas tran vdout1_25ck110 FIND v(dout1_25) AT=120.05n

.meas tran vdout1_26ck110 FIND v(dout1_26) AT=120.05n

.meas tran vdout1_27ck110 FIND v(dout1_27) AT=120.05n

.meas tran vdout1_28ck110 FIND v(dout1_28) AT=120.05n

.meas tran vdout1_29ck110 FIND v(dout1_29) AT=120.05n

.meas tran vdout1_30ck110 FIND v(dout1_30) AT=120.05n

.meas tran vdout1_31ck110 FIND v(dout1_31) AT=120.05n

.meas tran vdout1_32ck110 FIND v(dout1_32) AT=120.05n

.meas tran vdout1_33ck110 FIND v(dout1_33) AT=120.05n

.meas tran vdout1_34ck110 FIND v(dout1_34) AT=120.05n

.meas tran vdout1_35ck110 FIND v(dout1_35) AT=120.05n

.meas tran vdout1_36ck110 FIND v(dout1_36) AT=120.05n

.meas tran vdout1_37ck110 FIND v(dout1_37) AT=120.05n

.meas tran vdout1_38ck110 FIND v(dout1_38) AT=120.05n

.meas tran vdout1_39ck110 FIND v(dout1_39) AT=120.05n

.meas tran vdout1_40ck110 FIND v(dout1_40) AT=120.05n

.meas tran vdout1_41ck110 FIND v(dout1_41) AT=120.05n

.meas tran vdout1_42ck110 FIND v(dout1_42) AT=120.05n

.meas tran vdout1_43ck110 FIND v(dout1_43) AT=120.05n

.meas tran vdout1_44ck110 FIND v(dout1_44) AT=120.05n

.meas tran vdout1_45ck110 FIND v(dout1_45) AT=120.05n

.meas tran vdout1_46ck110 FIND v(dout1_46) AT=120.05n

.meas tran vdout1_47ck110 FIND v(dout1_47) AT=120.05n

.meas tran vdout1_48ck110 FIND v(dout1_48) AT=120.05n

.meas tran vdout1_49ck110 FIND v(dout1_49) AT=120.05n

.meas tran vdout1_50ck110 FIND v(dout1_50) AT=120.05n

.meas tran vdout1_51ck110 FIND v(dout1_51) AT=120.05n

.meas tran vdout1_52ck110 FIND v(dout1_52) AT=120.05n

.meas tran vdout1_53ck110 FIND v(dout1_53) AT=120.05n

.meas tran vdout1_54ck110 FIND v(dout1_54) AT=120.05n

.meas tran vdout1_55ck110 FIND v(dout1_55) AT=120.05n

.meas tran vdout1_56ck110 FIND v(dout1_56) AT=120.05n

.meas tran vdout1_57ck110 FIND v(dout1_57) AT=120.05n

.meas tran vdout1_58ck110 FIND v(dout1_58) AT=120.05n

.meas tran vdout1_59ck110 FIND v(dout1_59) AT=120.05n

.meas tran vdout1_60ck110 FIND v(dout1_60) AT=120.05n

.meas tran vdout1_61ck110 FIND v(dout1_61) AT=120.05n

.meas tran vdout1_62ck110 FIND v(dout1_62) AT=120.05n

.meas tran vdout1_63ck110 FIND v(dout1_63) AT=120.05n

.meas tran vdout0_0ck130 FIND v(dout0_0) AT=140.05n

.meas tran vdout0_1ck130 FIND v(dout0_1) AT=140.05n

.meas tran vdout0_2ck130 FIND v(dout0_2) AT=140.05n

.meas tran vdout0_3ck130 FIND v(dout0_3) AT=140.05n

.meas tran vdout0_4ck130 FIND v(dout0_4) AT=140.05n

.meas tran vdout0_5ck130 FIND v(dout0_5) AT=140.05n

.meas tran vdout0_6ck130 FIND v(dout0_6) AT=140.05n

.meas tran vdout0_7ck130 FIND v(dout0_7) AT=140.05n

.meas tran vdout0_8ck130 FIND v(dout0_8) AT=140.05n

.meas tran vdout0_9ck130 FIND v(dout0_9) AT=140.05n

.meas tran vdout0_10ck130 FIND v(dout0_10) AT=140.05n

.meas tran vdout0_11ck130 FIND v(dout0_11) AT=140.05n

.meas tran vdout0_12ck130 FIND v(dout0_12) AT=140.05n

.meas tran vdout0_13ck130 FIND v(dout0_13) AT=140.05n

.meas tran vdout0_14ck130 FIND v(dout0_14) AT=140.05n

.meas tran vdout0_15ck130 FIND v(dout0_15) AT=140.05n

.meas tran vdout0_16ck130 FIND v(dout0_16) AT=140.05n

.meas tran vdout0_17ck130 FIND v(dout0_17) AT=140.05n

.meas tran vdout0_18ck130 FIND v(dout0_18) AT=140.05n

.meas tran vdout0_19ck130 FIND v(dout0_19) AT=140.05n

.meas tran vdout0_20ck130 FIND v(dout0_20) AT=140.05n

.meas tran vdout0_21ck130 FIND v(dout0_21) AT=140.05n

.meas tran vdout0_22ck130 FIND v(dout0_22) AT=140.05n

.meas tran vdout0_23ck130 FIND v(dout0_23) AT=140.05n

.meas tran vdout0_24ck130 FIND v(dout0_24) AT=140.05n

.meas tran vdout0_25ck130 FIND v(dout0_25) AT=140.05n

.meas tran vdout0_26ck130 FIND v(dout0_26) AT=140.05n

.meas tran vdout0_27ck130 FIND v(dout0_27) AT=140.05n

.meas tran vdout0_28ck130 FIND v(dout0_28) AT=140.05n

.meas tran vdout0_29ck130 FIND v(dout0_29) AT=140.05n

.meas tran vdout0_30ck130 FIND v(dout0_30) AT=140.05n

.meas tran vdout0_31ck130 FIND v(dout0_31) AT=140.05n

.meas tran vdout0_32ck130 FIND v(dout0_32) AT=140.05n

.meas tran vdout0_33ck130 FIND v(dout0_33) AT=140.05n

.meas tran vdout0_34ck130 FIND v(dout0_34) AT=140.05n

.meas tran vdout0_35ck130 FIND v(dout0_35) AT=140.05n

.meas tran vdout0_36ck130 FIND v(dout0_36) AT=140.05n

.meas tran vdout0_37ck130 FIND v(dout0_37) AT=140.05n

.meas tran vdout0_38ck130 FIND v(dout0_38) AT=140.05n

.meas tran vdout0_39ck130 FIND v(dout0_39) AT=140.05n

.meas tran vdout0_40ck130 FIND v(dout0_40) AT=140.05n

.meas tran vdout0_41ck130 FIND v(dout0_41) AT=140.05n

.meas tran vdout0_42ck130 FIND v(dout0_42) AT=140.05n

.meas tran vdout0_43ck130 FIND v(dout0_43) AT=140.05n

.meas tran vdout0_44ck130 FIND v(dout0_44) AT=140.05n

.meas tran vdout0_45ck130 FIND v(dout0_45) AT=140.05n

.meas tran vdout0_46ck130 FIND v(dout0_46) AT=140.05n

.meas tran vdout0_47ck130 FIND v(dout0_47) AT=140.05n

.meas tran vdout0_48ck130 FIND v(dout0_48) AT=140.05n

.meas tran vdout0_49ck130 FIND v(dout0_49) AT=140.05n

.meas tran vdout0_50ck130 FIND v(dout0_50) AT=140.05n

.meas tran vdout0_51ck130 FIND v(dout0_51) AT=140.05n

.meas tran vdout0_52ck130 FIND v(dout0_52) AT=140.05n

.meas tran vdout0_53ck130 FIND v(dout0_53) AT=140.05n

.meas tran vdout0_54ck130 FIND v(dout0_54) AT=140.05n

.meas tran vdout0_55ck130 FIND v(dout0_55) AT=140.05n

.meas tran vdout0_56ck130 FIND v(dout0_56) AT=140.05n

.meas tran vdout0_57ck130 FIND v(dout0_57) AT=140.05n

.meas tran vdout0_58ck130 FIND v(dout0_58) AT=140.05n

.meas tran vdout0_59ck130 FIND v(dout0_59) AT=140.05n

.meas tran vdout0_60ck130 FIND v(dout0_60) AT=140.05n

.meas tran vdout0_61ck130 FIND v(dout0_61) AT=140.05n

.meas tran vdout0_62ck130 FIND v(dout0_62) AT=140.05n

.meas tran vdout0_63ck130 FIND v(dout0_63) AT=140.05n

.meas tran vdout1_0ck140 FIND v(dout1_0) AT=150.05n

.meas tran vdout1_1ck140 FIND v(dout1_1) AT=150.05n

.meas tran vdout1_2ck140 FIND v(dout1_2) AT=150.05n

.meas tran vdout1_3ck140 FIND v(dout1_3) AT=150.05n

.meas tran vdout1_4ck140 FIND v(dout1_4) AT=150.05n

.meas tran vdout1_5ck140 FIND v(dout1_5) AT=150.05n

.meas tran vdout1_6ck140 FIND v(dout1_6) AT=150.05n

.meas tran vdout1_7ck140 FIND v(dout1_7) AT=150.05n

.meas tran vdout1_8ck140 FIND v(dout1_8) AT=150.05n

.meas tran vdout1_9ck140 FIND v(dout1_9) AT=150.05n

.meas tran vdout1_10ck140 FIND v(dout1_10) AT=150.05n

.meas tran vdout1_11ck140 FIND v(dout1_11) AT=150.05n

.meas tran vdout1_12ck140 FIND v(dout1_12) AT=150.05n

.meas tran vdout1_13ck140 FIND v(dout1_13) AT=150.05n

.meas tran vdout1_14ck140 FIND v(dout1_14) AT=150.05n

.meas tran vdout1_15ck140 FIND v(dout1_15) AT=150.05n

.meas tran vdout1_16ck140 FIND v(dout1_16) AT=150.05n

.meas tran vdout1_17ck140 FIND v(dout1_17) AT=150.05n

.meas tran vdout1_18ck140 FIND v(dout1_18) AT=150.05n

.meas tran vdout1_19ck140 FIND v(dout1_19) AT=150.05n

.meas tran vdout1_20ck140 FIND v(dout1_20) AT=150.05n

.meas tran vdout1_21ck140 FIND v(dout1_21) AT=150.05n

.meas tran vdout1_22ck140 FIND v(dout1_22) AT=150.05n

.meas tran vdout1_23ck140 FIND v(dout1_23) AT=150.05n

.meas tran vdout1_24ck140 FIND v(dout1_24) AT=150.05n

.meas tran vdout1_25ck140 FIND v(dout1_25) AT=150.05n

.meas tran vdout1_26ck140 FIND v(dout1_26) AT=150.05n

.meas tran vdout1_27ck140 FIND v(dout1_27) AT=150.05n

.meas tran vdout1_28ck140 FIND v(dout1_28) AT=150.05n

.meas tran vdout1_29ck140 FIND v(dout1_29) AT=150.05n

.meas tran vdout1_30ck140 FIND v(dout1_30) AT=150.05n

.meas tran vdout1_31ck140 FIND v(dout1_31) AT=150.05n

.meas tran vdout1_32ck140 FIND v(dout1_32) AT=150.05n

.meas tran vdout1_33ck140 FIND v(dout1_33) AT=150.05n

.meas tran vdout1_34ck140 FIND v(dout1_34) AT=150.05n

.meas tran vdout1_35ck140 FIND v(dout1_35) AT=150.05n

.meas tran vdout1_36ck140 FIND v(dout1_36) AT=150.05n

.meas tran vdout1_37ck140 FIND v(dout1_37) AT=150.05n

.meas tran vdout1_38ck140 FIND v(dout1_38) AT=150.05n

.meas tran vdout1_39ck140 FIND v(dout1_39) AT=150.05n

.meas tran vdout1_40ck140 FIND v(dout1_40) AT=150.05n

.meas tran vdout1_41ck140 FIND v(dout1_41) AT=150.05n

.meas tran vdout1_42ck140 FIND v(dout1_42) AT=150.05n

.meas tran vdout1_43ck140 FIND v(dout1_43) AT=150.05n

.meas tran vdout1_44ck140 FIND v(dout1_44) AT=150.05n

.meas tran vdout1_45ck140 FIND v(dout1_45) AT=150.05n

.meas tran vdout1_46ck140 FIND v(dout1_46) AT=150.05n

.meas tran vdout1_47ck140 FIND v(dout1_47) AT=150.05n

.meas tran vdout1_48ck140 FIND v(dout1_48) AT=150.05n

.meas tran vdout1_49ck140 FIND v(dout1_49) AT=150.05n

.meas tran vdout1_50ck140 FIND v(dout1_50) AT=150.05n

.meas tran vdout1_51ck140 FIND v(dout1_51) AT=150.05n

.meas tran vdout1_52ck140 FIND v(dout1_52) AT=150.05n

.meas tran vdout1_53ck140 FIND v(dout1_53) AT=150.05n

.meas tran vdout1_54ck140 FIND v(dout1_54) AT=150.05n

.meas tran vdout1_55ck140 FIND v(dout1_55) AT=150.05n

.meas tran vdout1_56ck140 FIND v(dout1_56) AT=150.05n

.meas tran vdout1_57ck140 FIND v(dout1_57) AT=150.05n

.meas tran vdout1_58ck140 FIND v(dout1_58) AT=150.05n

.meas tran vdout1_59ck140 FIND v(dout1_59) AT=150.05n

.meas tran vdout1_60ck140 FIND v(dout1_60) AT=150.05n

.meas tran vdout1_61ck140 FIND v(dout1_61) AT=150.05n

.meas tran vdout1_62ck140 FIND v(dout1_62) AT=150.05n

.meas tran vdout1_63ck140 FIND v(dout1_63) AT=150.05n

.meas tran vdout0_0ck150 FIND v(dout0_0) AT=160.05n

.meas tran vdout0_1ck150 FIND v(dout0_1) AT=160.05n

.meas tran vdout0_2ck150 FIND v(dout0_2) AT=160.05n

.meas tran vdout0_3ck150 FIND v(dout0_3) AT=160.05n

.meas tran vdout0_4ck150 FIND v(dout0_4) AT=160.05n

.meas tran vdout0_5ck150 FIND v(dout0_5) AT=160.05n

.meas tran vdout0_6ck150 FIND v(dout0_6) AT=160.05n

.meas tran vdout0_7ck150 FIND v(dout0_7) AT=160.05n

.meas tran vdout0_8ck150 FIND v(dout0_8) AT=160.05n

.meas tran vdout0_9ck150 FIND v(dout0_9) AT=160.05n

.meas tran vdout0_10ck150 FIND v(dout0_10) AT=160.05n

.meas tran vdout0_11ck150 FIND v(dout0_11) AT=160.05n

.meas tran vdout0_12ck150 FIND v(dout0_12) AT=160.05n

.meas tran vdout0_13ck150 FIND v(dout0_13) AT=160.05n

.meas tran vdout0_14ck150 FIND v(dout0_14) AT=160.05n

.meas tran vdout0_15ck150 FIND v(dout0_15) AT=160.05n

.meas tran vdout0_16ck150 FIND v(dout0_16) AT=160.05n

.meas tran vdout0_17ck150 FIND v(dout0_17) AT=160.05n

.meas tran vdout0_18ck150 FIND v(dout0_18) AT=160.05n

.meas tran vdout0_19ck150 FIND v(dout0_19) AT=160.05n

.meas tran vdout0_20ck150 FIND v(dout0_20) AT=160.05n

.meas tran vdout0_21ck150 FIND v(dout0_21) AT=160.05n

.meas tran vdout0_22ck150 FIND v(dout0_22) AT=160.05n

.meas tran vdout0_23ck150 FIND v(dout0_23) AT=160.05n

.meas tran vdout0_24ck150 FIND v(dout0_24) AT=160.05n

.meas tran vdout0_25ck150 FIND v(dout0_25) AT=160.05n

.meas tran vdout0_26ck150 FIND v(dout0_26) AT=160.05n

.meas tran vdout0_27ck150 FIND v(dout0_27) AT=160.05n

.meas tran vdout0_28ck150 FIND v(dout0_28) AT=160.05n

.meas tran vdout0_29ck150 FIND v(dout0_29) AT=160.05n

.meas tran vdout0_30ck150 FIND v(dout0_30) AT=160.05n

.meas tran vdout0_31ck150 FIND v(dout0_31) AT=160.05n

.meas tran vdout0_32ck150 FIND v(dout0_32) AT=160.05n

.meas tran vdout0_33ck150 FIND v(dout0_33) AT=160.05n

.meas tran vdout0_34ck150 FIND v(dout0_34) AT=160.05n

.meas tran vdout0_35ck150 FIND v(dout0_35) AT=160.05n

.meas tran vdout0_36ck150 FIND v(dout0_36) AT=160.05n

.meas tran vdout0_37ck150 FIND v(dout0_37) AT=160.05n

.meas tran vdout0_38ck150 FIND v(dout0_38) AT=160.05n

.meas tran vdout0_39ck150 FIND v(dout0_39) AT=160.05n

.meas tran vdout0_40ck150 FIND v(dout0_40) AT=160.05n

.meas tran vdout0_41ck150 FIND v(dout0_41) AT=160.05n

.meas tran vdout0_42ck150 FIND v(dout0_42) AT=160.05n

.meas tran vdout0_43ck150 FIND v(dout0_43) AT=160.05n

.meas tran vdout0_44ck150 FIND v(dout0_44) AT=160.05n

.meas tran vdout0_45ck150 FIND v(dout0_45) AT=160.05n

.meas tran vdout0_46ck150 FIND v(dout0_46) AT=160.05n

.meas tran vdout0_47ck150 FIND v(dout0_47) AT=160.05n

.meas tran vdout0_48ck150 FIND v(dout0_48) AT=160.05n

.meas tran vdout0_49ck150 FIND v(dout0_49) AT=160.05n

.meas tran vdout0_50ck150 FIND v(dout0_50) AT=160.05n

.meas tran vdout0_51ck150 FIND v(dout0_51) AT=160.05n

.meas tran vdout0_52ck150 FIND v(dout0_52) AT=160.05n

.meas tran vdout0_53ck150 FIND v(dout0_53) AT=160.05n

.meas tran vdout0_54ck150 FIND v(dout0_54) AT=160.05n

.meas tran vdout0_55ck150 FIND v(dout0_55) AT=160.05n

.meas tran vdout0_56ck150 FIND v(dout0_56) AT=160.05n

.meas tran vdout0_57ck150 FIND v(dout0_57) AT=160.05n

.meas tran vdout0_58ck150 FIND v(dout0_58) AT=160.05n

.meas tran vdout0_59ck150 FIND v(dout0_59) AT=160.05n

.meas tran vdout0_60ck150 FIND v(dout0_60) AT=160.05n

.meas tran vdout0_61ck150 FIND v(dout0_61) AT=160.05n

.meas tran vdout0_62ck150 FIND v(dout0_62) AT=160.05n

.meas tran vdout0_63ck150 FIND v(dout0_63) AT=160.05n

.meas tran vdout1_0ck150 FIND v(dout1_0) AT=160.05n

.meas tran vdout1_1ck150 FIND v(dout1_1) AT=160.05n

.meas tran vdout1_2ck150 FIND v(dout1_2) AT=160.05n

.meas tran vdout1_3ck150 FIND v(dout1_3) AT=160.05n

.meas tran vdout1_4ck150 FIND v(dout1_4) AT=160.05n

.meas tran vdout1_5ck150 FIND v(dout1_5) AT=160.05n

.meas tran vdout1_6ck150 FIND v(dout1_6) AT=160.05n

.meas tran vdout1_7ck150 FIND v(dout1_7) AT=160.05n

.meas tran vdout1_8ck150 FIND v(dout1_8) AT=160.05n

.meas tran vdout1_9ck150 FIND v(dout1_9) AT=160.05n

.meas tran vdout1_10ck150 FIND v(dout1_10) AT=160.05n

.meas tran vdout1_11ck150 FIND v(dout1_11) AT=160.05n

.meas tran vdout1_12ck150 FIND v(dout1_12) AT=160.05n

.meas tran vdout1_13ck150 FIND v(dout1_13) AT=160.05n

.meas tran vdout1_14ck150 FIND v(dout1_14) AT=160.05n

.meas tran vdout1_15ck150 FIND v(dout1_15) AT=160.05n

.meas tran vdout1_16ck150 FIND v(dout1_16) AT=160.05n

.meas tran vdout1_17ck150 FIND v(dout1_17) AT=160.05n

.meas tran vdout1_18ck150 FIND v(dout1_18) AT=160.05n

.meas tran vdout1_19ck150 FIND v(dout1_19) AT=160.05n

.meas tran vdout1_20ck150 FIND v(dout1_20) AT=160.05n

.meas tran vdout1_21ck150 FIND v(dout1_21) AT=160.05n

.meas tran vdout1_22ck150 FIND v(dout1_22) AT=160.05n

.meas tran vdout1_23ck150 FIND v(dout1_23) AT=160.05n

.meas tran vdout1_24ck150 FIND v(dout1_24) AT=160.05n

.meas tran vdout1_25ck150 FIND v(dout1_25) AT=160.05n

.meas tran vdout1_26ck150 FIND v(dout1_26) AT=160.05n

.meas tran vdout1_27ck150 FIND v(dout1_27) AT=160.05n

.meas tran vdout1_28ck150 FIND v(dout1_28) AT=160.05n

.meas tran vdout1_29ck150 FIND v(dout1_29) AT=160.05n

.meas tran vdout1_30ck150 FIND v(dout1_30) AT=160.05n

.meas tran vdout1_31ck150 FIND v(dout1_31) AT=160.05n

.meas tran vdout1_32ck150 FIND v(dout1_32) AT=160.05n

.meas tran vdout1_33ck150 FIND v(dout1_33) AT=160.05n

.meas tran vdout1_34ck150 FIND v(dout1_34) AT=160.05n

.meas tran vdout1_35ck150 FIND v(dout1_35) AT=160.05n

.meas tran vdout1_36ck150 FIND v(dout1_36) AT=160.05n

.meas tran vdout1_37ck150 FIND v(dout1_37) AT=160.05n

.meas tran vdout1_38ck150 FIND v(dout1_38) AT=160.05n

.meas tran vdout1_39ck150 FIND v(dout1_39) AT=160.05n

.meas tran vdout1_40ck150 FIND v(dout1_40) AT=160.05n

.meas tran vdout1_41ck150 FIND v(dout1_41) AT=160.05n

.meas tran vdout1_42ck150 FIND v(dout1_42) AT=160.05n

.meas tran vdout1_43ck150 FIND v(dout1_43) AT=160.05n

.meas tran vdout1_44ck150 FIND v(dout1_44) AT=160.05n

.meas tran vdout1_45ck150 FIND v(dout1_45) AT=160.05n

.meas tran vdout1_46ck150 FIND v(dout1_46) AT=160.05n

.meas tran vdout1_47ck150 FIND v(dout1_47) AT=160.05n

.meas tran vdout1_48ck150 FIND v(dout1_48) AT=160.05n

.meas tran vdout1_49ck150 FIND v(dout1_49) AT=160.05n

.meas tran vdout1_50ck150 FIND v(dout1_50) AT=160.05n

.meas tran vdout1_51ck150 FIND v(dout1_51) AT=160.05n

.meas tran vdout1_52ck150 FIND v(dout1_52) AT=160.05n

.meas tran vdout1_53ck150 FIND v(dout1_53) AT=160.05n

.meas tran vdout1_54ck150 FIND v(dout1_54) AT=160.05n

.meas tran vdout1_55ck150 FIND v(dout1_55) AT=160.05n

.meas tran vdout1_56ck150 FIND v(dout1_56) AT=160.05n

.meas tran vdout1_57ck150 FIND v(dout1_57) AT=160.05n

.meas tran vdout1_58ck150 FIND v(dout1_58) AT=160.05n

.meas tran vdout1_59ck150 FIND v(dout1_59) AT=160.05n

.meas tran vdout1_60ck150 FIND v(dout1_60) AT=160.05n

.meas tran vdout1_61ck150 FIND v(dout1_61) AT=160.05n

.meas tran vdout1_62ck150 FIND v(dout1_62) AT=160.05n

.meas tran vdout1_63ck150 FIND v(dout1_63) AT=160.05n

.meas tran vdout0_0ck190 FIND v(dout0_0) AT=200.05n

.meas tran vdout0_1ck190 FIND v(dout0_1) AT=200.05n

.meas tran vdout0_2ck190 FIND v(dout0_2) AT=200.05n

.meas tran vdout0_3ck190 FIND v(dout0_3) AT=200.05n

.meas tran vdout0_4ck190 FIND v(dout0_4) AT=200.05n

.meas tran vdout0_5ck190 FIND v(dout0_5) AT=200.05n

.meas tran vdout0_6ck190 FIND v(dout0_6) AT=200.05n

.meas tran vdout0_7ck190 FIND v(dout0_7) AT=200.05n

.meas tran vdout0_8ck190 FIND v(dout0_8) AT=200.05n

.meas tran vdout0_9ck190 FIND v(dout0_9) AT=200.05n

.meas tran vdout0_10ck190 FIND v(dout0_10) AT=200.05n

.meas tran vdout0_11ck190 FIND v(dout0_11) AT=200.05n

.meas tran vdout0_12ck190 FIND v(dout0_12) AT=200.05n

.meas tran vdout0_13ck190 FIND v(dout0_13) AT=200.05n

.meas tran vdout0_14ck190 FIND v(dout0_14) AT=200.05n

.meas tran vdout0_15ck190 FIND v(dout0_15) AT=200.05n

.meas tran vdout0_16ck190 FIND v(dout0_16) AT=200.05n

.meas tran vdout0_17ck190 FIND v(dout0_17) AT=200.05n

.meas tran vdout0_18ck190 FIND v(dout0_18) AT=200.05n

.meas tran vdout0_19ck190 FIND v(dout0_19) AT=200.05n

.meas tran vdout0_20ck190 FIND v(dout0_20) AT=200.05n

.meas tran vdout0_21ck190 FIND v(dout0_21) AT=200.05n

.meas tran vdout0_22ck190 FIND v(dout0_22) AT=200.05n

.meas tran vdout0_23ck190 FIND v(dout0_23) AT=200.05n

.meas tran vdout0_24ck190 FIND v(dout0_24) AT=200.05n

.meas tran vdout0_25ck190 FIND v(dout0_25) AT=200.05n

.meas tran vdout0_26ck190 FIND v(dout0_26) AT=200.05n

.meas tran vdout0_27ck190 FIND v(dout0_27) AT=200.05n

.meas tran vdout0_28ck190 FIND v(dout0_28) AT=200.05n

.meas tran vdout0_29ck190 FIND v(dout0_29) AT=200.05n

.meas tran vdout0_30ck190 FIND v(dout0_30) AT=200.05n

.meas tran vdout0_31ck190 FIND v(dout0_31) AT=200.05n

.meas tran vdout0_32ck190 FIND v(dout0_32) AT=200.05n

.meas tran vdout0_33ck190 FIND v(dout0_33) AT=200.05n

.meas tran vdout0_34ck190 FIND v(dout0_34) AT=200.05n

.meas tran vdout0_35ck190 FIND v(dout0_35) AT=200.05n

.meas tran vdout0_36ck190 FIND v(dout0_36) AT=200.05n

.meas tran vdout0_37ck190 FIND v(dout0_37) AT=200.05n

.meas tran vdout0_38ck190 FIND v(dout0_38) AT=200.05n

.meas tran vdout0_39ck190 FIND v(dout0_39) AT=200.05n

.meas tran vdout0_40ck190 FIND v(dout0_40) AT=200.05n

.meas tran vdout0_41ck190 FIND v(dout0_41) AT=200.05n

.meas tran vdout0_42ck190 FIND v(dout0_42) AT=200.05n

.meas tran vdout0_43ck190 FIND v(dout0_43) AT=200.05n

.meas tran vdout0_44ck190 FIND v(dout0_44) AT=200.05n

.meas tran vdout0_45ck190 FIND v(dout0_45) AT=200.05n

.meas tran vdout0_46ck190 FIND v(dout0_46) AT=200.05n

.meas tran vdout0_47ck190 FIND v(dout0_47) AT=200.05n

.meas tran vdout0_48ck190 FIND v(dout0_48) AT=200.05n

.meas tran vdout0_49ck190 FIND v(dout0_49) AT=200.05n

.meas tran vdout0_50ck190 FIND v(dout0_50) AT=200.05n

.meas tran vdout0_51ck190 FIND v(dout0_51) AT=200.05n

.meas tran vdout0_52ck190 FIND v(dout0_52) AT=200.05n

.meas tran vdout0_53ck190 FIND v(dout0_53) AT=200.05n

.meas tran vdout0_54ck190 FIND v(dout0_54) AT=200.05n

.meas tran vdout0_55ck190 FIND v(dout0_55) AT=200.05n

.meas tran vdout0_56ck190 FIND v(dout0_56) AT=200.05n

.meas tran vdout0_57ck190 FIND v(dout0_57) AT=200.05n

.meas tran vdout0_58ck190 FIND v(dout0_58) AT=200.05n

.meas tran vdout0_59ck190 FIND v(dout0_59) AT=200.05n

.meas tran vdout0_60ck190 FIND v(dout0_60) AT=200.05n

.meas tran vdout0_61ck190 FIND v(dout0_61) AT=200.05n

.meas tran vdout0_62ck190 FIND v(dout0_62) AT=200.05n

.meas tran vdout0_63ck190 FIND v(dout0_63) AT=200.05n

.meas tran vdout1_0ck210 FIND v(dout1_0) AT=220.05n

.meas tran vdout1_1ck210 FIND v(dout1_1) AT=220.05n

.meas tran vdout1_2ck210 FIND v(dout1_2) AT=220.05n

.meas tran vdout1_3ck210 FIND v(dout1_3) AT=220.05n

.meas tran vdout1_4ck210 FIND v(dout1_4) AT=220.05n

.meas tran vdout1_5ck210 FIND v(dout1_5) AT=220.05n

.meas tran vdout1_6ck210 FIND v(dout1_6) AT=220.05n

.meas tran vdout1_7ck210 FIND v(dout1_7) AT=220.05n

.meas tran vdout1_8ck210 FIND v(dout1_8) AT=220.05n

.meas tran vdout1_9ck210 FIND v(dout1_9) AT=220.05n

.meas tran vdout1_10ck210 FIND v(dout1_10) AT=220.05n

.meas tran vdout1_11ck210 FIND v(dout1_11) AT=220.05n

.meas tran vdout1_12ck210 FIND v(dout1_12) AT=220.05n

.meas tran vdout1_13ck210 FIND v(dout1_13) AT=220.05n

.meas tran vdout1_14ck210 FIND v(dout1_14) AT=220.05n

.meas tran vdout1_15ck210 FIND v(dout1_15) AT=220.05n

.meas tran vdout1_16ck210 FIND v(dout1_16) AT=220.05n

.meas tran vdout1_17ck210 FIND v(dout1_17) AT=220.05n

.meas tran vdout1_18ck210 FIND v(dout1_18) AT=220.05n

.meas tran vdout1_19ck210 FIND v(dout1_19) AT=220.05n

.meas tran vdout1_20ck210 FIND v(dout1_20) AT=220.05n

.meas tran vdout1_21ck210 FIND v(dout1_21) AT=220.05n

.meas tran vdout1_22ck210 FIND v(dout1_22) AT=220.05n

.meas tran vdout1_23ck210 FIND v(dout1_23) AT=220.05n

.meas tran vdout1_24ck210 FIND v(dout1_24) AT=220.05n

.meas tran vdout1_25ck210 FIND v(dout1_25) AT=220.05n

.meas tran vdout1_26ck210 FIND v(dout1_26) AT=220.05n

.meas tran vdout1_27ck210 FIND v(dout1_27) AT=220.05n

.meas tran vdout1_28ck210 FIND v(dout1_28) AT=220.05n

.meas tran vdout1_29ck210 FIND v(dout1_29) AT=220.05n

.meas tran vdout1_30ck210 FIND v(dout1_30) AT=220.05n

.meas tran vdout1_31ck210 FIND v(dout1_31) AT=220.05n

.meas tran vdout1_32ck210 FIND v(dout1_32) AT=220.05n

.meas tran vdout1_33ck210 FIND v(dout1_33) AT=220.05n

.meas tran vdout1_34ck210 FIND v(dout1_34) AT=220.05n

.meas tran vdout1_35ck210 FIND v(dout1_35) AT=220.05n

.meas tran vdout1_36ck210 FIND v(dout1_36) AT=220.05n

.meas tran vdout1_37ck210 FIND v(dout1_37) AT=220.05n

.meas tran vdout1_38ck210 FIND v(dout1_38) AT=220.05n

.meas tran vdout1_39ck210 FIND v(dout1_39) AT=220.05n

.meas tran vdout1_40ck210 FIND v(dout1_40) AT=220.05n

.meas tran vdout1_41ck210 FIND v(dout1_41) AT=220.05n

.meas tran vdout1_42ck210 FIND v(dout1_42) AT=220.05n

.meas tran vdout1_43ck210 FIND v(dout1_43) AT=220.05n

.meas tran vdout1_44ck210 FIND v(dout1_44) AT=220.05n

.meas tran vdout1_45ck210 FIND v(dout1_45) AT=220.05n

.meas tran vdout1_46ck210 FIND v(dout1_46) AT=220.05n

.meas tran vdout1_47ck210 FIND v(dout1_47) AT=220.05n

.meas tran vdout1_48ck210 FIND v(dout1_48) AT=220.05n

.meas tran vdout1_49ck210 FIND v(dout1_49) AT=220.05n

.meas tran vdout1_50ck210 FIND v(dout1_50) AT=220.05n

.meas tran vdout1_51ck210 FIND v(dout1_51) AT=220.05n

.meas tran vdout1_52ck210 FIND v(dout1_52) AT=220.05n

.meas tran vdout1_53ck210 FIND v(dout1_53) AT=220.05n

.meas tran vdout1_54ck210 FIND v(dout1_54) AT=220.05n

.meas tran vdout1_55ck210 FIND v(dout1_55) AT=220.05n

.meas tran vdout1_56ck210 FIND v(dout1_56) AT=220.05n

.meas tran vdout1_57ck210 FIND v(dout1_57) AT=220.05n

.meas tran vdout1_58ck210 FIND v(dout1_58) AT=220.05n

.meas tran vdout1_59ck210 FIND v(dout1_59) AT=220.05n

.meas tran vdout1_60ck210 FIND v(dout1_60) AT=220.05n

.meas tran vdout1_61ck210 FIND v(dout1_61) AT=220.05n

.meas tran vdout1_62ck210 FIND v(dout1_62) AT=220.05n

.meas tran vdout1_63ck210 FIND v(dout1_63) AT=220.05n

.meas tran vdout0_0ck230 FIND v(dout0_0) AT=240.05n

.meas tran vdout0_1ck230 FIND v(dout0_1) AT=240.05n

.meas tran vdout0_2ck230 FIND v(dout0_2) AT=240.05n

.meas tran vdout0_3ck230 FIND v(dout0_3) AT=240.05n

.meas tran vdout0_4ck230 FIND v(dout0_4) AT=240.05n

.meas tran vdout0_5ck230 FIND v(dout0_5) AT=240.05n

.meas tran vdout0_6ck230 FIND v(dout0_6) AT=240.05n

.meas tran vdout0_7ck230 FIND v(dout0_7) AT=240.05n

.meas tran vdout0_8ck230 FIND v(dout0_8) AT=240.05n

.meas tran vdout0_9ck230 FIND v(dout0_9) AT=240.05n

.meas tran vdout0_10ck230 FIND v(dout0_10) AT=240.05n

.meas tran vdout0_11ck230 FIND v(dout0_11) AT=240.05n

.meas tran vdout0_12ck230 FIND v(dout0_12) AT=240.05n

.meas tran vdout0_13ck230 FIND v(dout0_13) AT=240.05n

.meas tran vdout0_14ck230 FIND v(dout0_14) AT=240.05n

.meas tran vdout0_15ck230 FIND v(dout0_15) AT=240.05n

.meas tran vdout0_16ck230 FIND v(dout0_16) AT=240.05n

.meas tran vdout0_17ck230 FIND v(dout0_17) AT=240.05n

.meas tran vdout0_18ck230 FIND v(dout0_18) AT=240.05n

.meas tran vdout0_19ck230 FIND v(dout0_19) AT=240.05n

.meas tran vdout0_20ck230 FIND v(dout0_20) AT=240.05n

.meas tran vdout0_21ck230 FIND v(dout0_21) AT=240.05n

.meas tran vdout0_22ck230 FIND v(dout0_22) AT=240.05n

.meas tran vdout0_23ck230 FIND v(dout0_23) AT=240.05n

.meas tran vdout0_24ck230 FIND v(dout0_24) AT=240.05n

.meas tran vdout0_25ck230 FIND v(dout0_25) AT=240.05n

.meas tran vdout0_26ck230 FIND v(dout0_26) AT=240.05n

.meas tran vdout0_27ck230 FIND v(dout0_27) AT=240.05n

.meas tran vdout0_28ck230 FIND v(dout0_28) AT=240.05n

.meas tran vdout0_29ck230 FIND v(dout0_29) AT=240.05n

.meas tran vdout0_30ck230 FIND v(dout0_30) AT=240.05n

.meas tran vdout0_31ck230 FIND v(dout0_31) AT=240.05n

.meas tran vdout0_32ck230 FIND v(dout0_32) AT=240.05n

.meas tran vdout0_33ck230 FIND v(dout0_33) AT=240.05n

.meas tran vdout0_34ck230 FIND v(dout0_34) AT=240.05n

.meas tran vdout0_35ck230 FIND v(dout0_35) AT=240.05n

.meas tran vdout0_36ck230 FIND v(dout0_36) AT=240.05n

.meas tran vdout0_37ck230 FIND v(dout0_37) AT=240.05n

.meas tran vdout0_38ck230 FIND v(dout0_38) AT=240.05n

.meas tran vdout0_39ck230 FIND v(dout0_39) AT=240.05n

.meas tran vdout0_40ck230 FIND v(dout0_40) AT=240.05n

.meas tran vdout0_41ck230 FIND v(dout0_41) AT=240.05n

.meas tran vdout0_42ck230 FIND v(dout0_42) AT=240.05n

.meas tran vdout0_43ck230 FIND v(dout0_43) AT=240.05n

.meas tran vdout0_44ck230 FIND v(dout0_44) AT=240.05n

.meas tran vdout0_45ck230 FIND v(dout0_45) AT=240.05n

.meas tran vdout0_46ck230 FIND v(dout0_46) AT=240.05n

.meas tran vdout0_47ck230 FIND v(dout0_47) AT=240.05n

.meas tran vdout0_48ck230 FIND v(dout0_48) AT=240.05n

.meas tran vdout0_49ck230 FIND v(dout0_49) AT=240.05n

.meas tran vdout0_50ck230 FIND v(dout0_50) AT=240.05n

.meas tran vdout0_51ck230 FIND v(dout0_51) AT=240.05n

.meas tran vdout0_52ck230 FIND v(dout0_52) AT=240.05n

.meas tran vdout0_53ck230 FIND v(dout0_53) AT=240.05n

.meas tran vdout0_54ck230 FIND v(dout0_54) AT=240.05n

.meas tran vdout0_55ck230 FIND v(dout0_55) AT=240.05n

.meas tran vdout0_56ck230 FIND v(dout0_56) AT=240.05n

.meas tran vdout0_57ck230 FIND v(dout0_57) AT=240.05n

.meas tran vdout0_58ck230 FIND v(dout0_58) AT=240.05n

.meas tran vdout0_59ck230 FIND v(dout0_59) AT=240.05n

.meas tran vdout0_60ck230 FIND v(dout0_60) AT=240.05n

.meas tran vdout0_61ck230 FIND v(dout0_61) AT=240.05n

.meas tran vdout0_62ck230 FIND v(dout0_62) AT=240.05n

.meas tran vdout0_63ck230 FIND v(dout0_63) AT=240.05n

.meas tran vdout0_0ck240 FIND v(dout0_0) AT=250.05n

.meas tran vdout0_1ck240 FIND v(dout0_1) AT=250.05n

.meas tran vdout0_2ck240 FIND v(dout0_2) AT=250.05n

.meas tran vdout0_3ck240 FIND v(dout0_3) AT=250.05n

.meas tran vdout0_4ck240 FIND v(dout0_4) AT=250.05n

.meas tran vdout0_5ck240 FIND v(dout0_5) AT=250.05n

.meas tran vdout0_6ck240 FIND v(dout0_6) AT=250.05n

.meas tran vdout0_7ck240 FIND v(dout0_7) AT=250.05n

.meas tran vdout0_8ck240 FIND v(dout0_8) AT=250.05n

.meas tran vdout0_9ck240 FIND v(dout0_9) AT=250.05n

.meas tran vdout0_10ck240 FIND v(dout0_10) AT=250.05n

.meas tran vdout0_11ck240 FIND v(dout0_11) AT=250.05n

.meas tran vdout0_12ck240 FIND v(dout0_12) AT=250.05n

.meas tran vdout0_13ck240 FIND v(dout0_13) AT=250.05n

.meas tran vdout0_14ck240 FIND v(dout0_14) AT=250.05n

.meas tran vdout0_15ck240 FIND v(dout0_15) AT=250.05n

.meas tran vdout0_16ck240 FIND v(dout0_16) AT=250.05n

.meas tran vdout0_17ck240 FIND v(dout0_17) AT=250.05n

.meas tran vdout0_18ck240 FIND v(dout0_18) AT=250.05n

.meas tran vdout0_19ck240 FIND v(dout0_19) AT=250.05n

.meas tran vdout0_20ck240 FIND v(dout0_20) AT=250.05n

.meas tran vdout0_21ck240 FIND v(dout0_21) AT=250.05n

.meas tran vdout0_22ck240 FIND v(dout0_22) AT=250.05n

.meas tran vdout0_23ck240 FIND v(dout0_23) AT=250.05n

.meas tran vdout0_24ck240 FIND v(dout0_24) AT=250.05n

.meas tran vdout0_25ck240 FIND v(dout0_25) AT=250.05n

.meas tran vdout0_26ck240 FIND v(dout0_26) AT=250.05n

.meas tran vdout0_27ck240 FIND v(dout0_27) AT=250.05n

.meas tran vdout0_28ck240 FIND v(dout0_28) AT=250.05n

.meas tran vdout0_29ck240 FIND v(dout0_29) AT=250.05n

.meas tran vdout0_30ck240 FIND v(dout0_30) AT=250.05n

.meas tran vdout0_31ck240 FIND v(dout0_31) AT=250.05n

.meas tran vdout0_32ck240 FIND v(dout0_32) AT=250.05n

.meas tran vdout0_33ck240 FIND v(dout0_33) AT=250.05n

.meas tran vdout0_34ck240 FIND v(dout0_34) AT=250.05n

.meas tran vdout0_35ck240 FIND v(dout0_35) AT=250.05n

.meas tran vdout0_36ck240 FIND v(dout0_36) AT=250.05n

.meas tran vdout0_37ck240 FIND v(dout0_37) AT=250.05n

.meas tran vdout0_38ck240 FIND v(dout0_38) AT=250.05n

.meas tran vdout0_39ck240 FIND v(dout0_39) AT=250.05n

.meas tran vdout0_40ck240 FIND v(dout0_40) AT=250.05n

.meas tran vdout0_41ck240 FIND v(dout0_41) AT=250.05n

.meas tran vdout0_42ck240 FIND v(dout0_42) AT=250.05n

.meas tran vdout0_43ck240 FIND v(dout0_43) AT=250.05n

.meas tran vdout0_44ck240 FIND v(dout0_44) AT=250.05n

.meas tran vdout0_45ck240 FIND v(dout0_45) AT=250.05n

.meas tran vdout0_46ck240 FIND v(dout0_46) AT=250.05n

.meas tran vdout0_47ck240 FIND v(dout0_47) AT=250.05n

.meas tran vdout0_48ck240 FIND v(dout0_48) AT=250.05n

.meas tran vdout0_49ck240 FIND v(dout0_49) AT=250.05n

.meas tran vdout0_50ck240 FIND v(dout0_50) AT=250.05n

.meas tran vdout0_51ck240 FIND v(dout0_51) AT=250.05n

.meas tran vdout0_52ck240 FIND v(dout0_52) AT=250.05n

.meas tran vdout0_53ck240 FIND v(dout0_53) AT=250.05n

.meas tran vdout0_54ck240 FIND v(dout0_54) AT=250.05n

.meas tran vdout0_55ck240 FIND v(dout0_55) AT=250.05n

.meas tran vdout0_56ck240 FIND v(dout0_56) AT=250.05n

.meas tran vdout0_57ck240 FIND v(dout0_57) AT=250.05n

.meas tran vdout0_58ck240 FIND v(dout0_58) AT=250.05n

.meas tran vdout0_59ck240 FIND v(dout0_59) AT=250.05n

.meas tran vdout0_60ck240 FIND v(dout0_60) AT=250.05n

.meas tran vdout0_61ck240 FIND v(dout0_61) AT=250.05n

.meas tran vdout0_62ck240 FIND v(dout0_62) AT=250.05n

.meas tran vdout0_63ck240 FIND v(dout0_63) AT=250.05n

.meas tran vdout1_0ck250 FIND v(dout1_0) AT=260.05n

.meas tran vdout1_1ck250 FIND v(dout1_1) AT=260.05n

.meas tran vdout1_2ck250 FIND v(dout1_2) AT=260.05n

.meas tran vdout1_3ck250 FIND v(dout1_3) AT=260.05n

.meas tran vdout1_4ck250 FIND v(dout1_4) AT=260.05n

.meas tran vdout1_5ck250 FIND v(dout1_5) AT=260.05n

.meas tran vdout1_6ck250 FIND v(dout1_6) AT=260.05n

.meas tran vdout1_7ck250 FIND v(dout1_7) AT=260.05n

.meas tran vdout1_8ck250 FIND v(dout1_8) AT=260.05n

.meas tran vdout1_9ck250 FIND v(dout1_9) AT=260.05n

.meas tran vdout1_10ck250 FIND v(dout1_10) AT=260.05n

.meas tran vdout1_11ck250 FIND v(dout1_11) AT=260.05n

.meas tran vdout1_12ck250 FIND v(dout1_12) AT=260.05n

.meas tran vdout1_13ck250 FIND v(dout1_13) AT=260.05n

.meas tran vdout1_14ck250 FIND v(dout1_14) AT=260.05n

.meas tran vdout1_15ck250 FIND v(dout1_15) AT=260.05n

.meas tran vdout1_16ck250 FIND v(dout1_16) AT=260.05n

.meas tran vdout1_17ck250 FIND v(dout1_17) AT=260.05n

.meas tran vdout1_18ck250 FIND v(dout1_18) AT=260.05n

.meas tran vdout1_19ck250 FIND v(dout1_19) AT=260.05n

.meas tran vdout1_20ck250 FIND v(dout1_20) AT=260.05n

.meas tran vdout1_21ck250 FIND v(dout1_21) AT=260.05n

.meas tran vdout1_22ck250 FIND v(dout1_22) AT=260.05n

.meas tran vdout1_23ck250 FIND v(dout1_23) AT=260.05n

.meas tran vdout1_24ck250 FIND v(dout1_24) AT=260.05n

.meas tran vdout1_25ck250 FIND v(dout1_25) AT=260.05n

.meas tran vdout1_26ck250 FIND v(dout1_26) AT=260.05n

.meas tran vdout1_27ck250 FIND v(dout1_27) AT=260.05n

.meas tran vdout1_28ck250 FIND v(dout1_28) AT=260.05n

.meas tran vdout1_29ck250 FIND v(dout1_29) AT=260.05n

.meas tran vdout1_30ck250 FIND v(dout1_30) AT=260.05n

.meas tran vdout1_31ck250 FIND v(dout1_31) AT=260.05n

.meas tran vdout1_32ck250 FIND v(dout1_32) AT=260.05n

.meas tran vdout1_33ck250 FIND v(dout1_33) AT=260.05n

.meas tran vdout1_34ck250 FIND v(dout1_34) AT=260.05n

.meas tran vdout1_35ck250 FIND v(dout1_35) AT=260.05n

.meas tran vdout1_36ck250 FIND v(dout1_36) AT=260.05n

.meas tran vdout1_37ck250 FIND v(dout1_37) AT=260.05n

.meas tran vdout1_38ck250 FIND v(dout1_38) AT=260.05n

.meas tran vdout1_39ck250 FIND v(dout1_39) AT=260.05n

.meas tran vdout1_40ck250 FIND v(dout1_40) AT=260.05n

.meas tran vdout1_41ck250 FIND v(dout1_41) AT=260.05n

.meas tran vdout1_42ck250 FIND v(dout1_42) AT=260.05n

.meas tran vdout1_43ck250 FIND v(dout1_43) AT=260.05n

.meas tran vdout1_44ck250 FIND v(dout1_44) AT=260.05n

.meas tran vdout1_45ck250 FIND v(dout1_45) AT=260.05n

.meas tran vdout1_46ck250 FIND v(dout1_46) AT=260.05n

.meas tran vdout1_47ck250 FIND v(dout1_47) AT=260.05n

.meas tran vdout1_48ck250 FIND v(dout1_48) AT=260.05n

.meas tran vdout1_49ck250 FIND v(dout1_49) AT=260.05n

.meas tran vdout1_50ck250 FIND v(dout1_50) AT=260.05n

.meas tran vdout1_51ck250 FIND v(dout1_51) AT=260.05n

.meas tran vdout1_52ck250 FIND v(dout1_52) AT=260.05n

.meas tran vdout1_53ck250 FIND v(dout1_53) AT=260.05n

.meas tran vdout1_54ck250 FIND v(dout1_54) AT=260.05n

.meas tran vdout1_55ck250 FIND v(dout1_55) AT=260.05n

.meas tran vdout1_56ck250 FIND v(dout1_56) AT=260.05n

.meas tran vdout1_57ck250 FIND v(dout1_57) AT=260.05n

.meas tran vdout1_58ck250 FIND v(dout1_58) AT=260.05n

.meas tran vdout1_59ck250 FIND v(dout1_59) AT=260.05n

.meas tran vdout1_60ck250 FIND v(dout1_60) AT=260.05n

.meas tran vdout1_61ck250 FIND v(dout1_61) AT=260.05n

.meas tran vdout1_62ck250 FIND v(dout1_62) AT=260.05n

.meas tran vdout1_63ck250 FIND v(dout1_63) AT=260.05n

.meas tran vdout0_0ck260 FIND v(dout0_0) AT=270.05n

.meas tran vdout0_1ck260 FIND v(dout0_1) AT=270.05n

.meas tran vdout0_2ck260 FIND v(dout0_2) AT=270.05n

.meas tran vdout0_3ck260 FIND v(dout0_3) AT=270.05n

.meas tran vdout0_4ck260 FIND v(dout0_4) AT=270.05n

.meas tran vdout0_5ck260 FIND v(dout0_5) AT=270.05n

.meas tran vdout0_6ck260 FIND v(dout0_6) AT=270.05n

.meas tran vdout0_7ck260 FIND v(dout0_7) AT=270.05n

.meas tran vdout0_8ck260 FIND v(dout0_8) AT=270.05n

.meas tran vdout0_9ck260 FIND v(dout0_9) AT=270.05n

.meas tran vdout0_10ck260 FIND v(dout0_10) AT=270.05n

.meas tran vdout0_11ck260 FIND v(dout0_11) AT=270.05n

.meas tran vdout0_12ck260 FIND v(dout0_12) AT=270.05n

.meas tran vdout0_13ck260 FIND v(dout0_13) AT=270.05n

.meas tran vdout0_14ck260 FIND v(dout0_14) AT=270.05n

.meas tran vdout0_15ck260 FIND v(dout0_15) AT=270.05n

.meas tran vdout0_16ck260 FIND v(dout0_16) AT=270.05n

.meas tran vdout0_17ck260 FIND v(dout0_17) AT=270.05n

.meas tran vdout0_18ck260 FIND v(dout0_18) AT=270.05n

.meas tran vdout0_19ck260 FIND v(dout0_19) AT=270.05n

.meas tran vdout0_20ck260 FIND v(dout0_20) AT=270.05n

.meas tran vdout0_21ck260 FIND v(dout0_21) AT=270.05n

.meas tran vdout0_22ck260 FIND v(dout0_22) AT=270.05n

.meas tran vdout0_23ck260 FIND v(dout0_23) AT=270.05n

.meas tran vdout0_24ck260 FIND v(dout0_24) AT=270.05n

.meas tran vdout0_25ck260 FIND v(dout0_25) AT=270.05n

.meas tran vdout0_26ck260 FIND v(dout0_26) AT=270.05n

.meas tran vdout0_27ck260 FIND v(dout0_27) AT=270.05n

.meas tran vdout0_28ck260 FIND v(dout0_28) AT=270.05n

.meas tran vdout0_29ck260 FIND v(dout0_29) AT=270.05n

.meas tran vdout0_30ck260 FIND v(dout0_30) AT=270.05n

.meas tran vdout0_31ck260 FIND v(dout0_31) AT=270.05n

.meas tran vdout0_32ck260 FIND v(dout0_32) AT=270.05n

.meas tran vdout0_33ck260 FIND v(dout0_33) AT=270.05n

.meas tran vdout0_34ck260 FIND v(dout0_34) AT=270.05n

.meas tran vdout0_35ck260 FIND v(dout0_35) AT=270.05n

.meas tran vdout0_36ck260 FIND v(dout0_36) AT=270.05n

.meas tran vdout0_37ck260 FIND v(dout0_37) AT=270.05n

.meas tran vdout0_38ck260 FIND v(dout0_38) AT=270.05n

.meas tran vdout0_39ck260 FIND v(dout0_39) AT=270.05n

.meas tran vdout0_40ck260 FIND v(dout0_40) AT=270.05n

.meas tran vdout0_41ck260 FIND v(dout0_41) AT=270.05n

.meas tran vdout0_42ck260 FIND v(dout0_42) AT=270.05n

.meas tran vdout0_43ck260 FIND v(dout0_43) AT=270.05n

.meas tran vdout0_44ck260 FIND v(dout0_44) AT=270.05n

.meas tran vdout0_45ck260 FIND v(dout0_45) AT=270.05n

.meas tran vdout0_46ck260 FIND v(dout0_46) AT=270.05n

.meas tran vdout0_47ck260 FIND v(dout0_47) AT=270.05n

.meas tran vdout0_48ck260 FIND v(dout0_48) AT=270.05n

.meas tran vdout0_49ck260 FIND v(dout0_49) AT=270.05n

.meas tran vdout0_50ck260 FIND v(dout0_50) AT=270.05n

.meas tran vdout0_51ck260 FIND v(dout0_51) AT=270.05n

.meas tran vdout0_52ck260 FIND v(dout0_52) AT=270.05n

.meas tran vdout0_53ck260 FIND v(dout0_53) AT=270.05n

.meas tran vdout0_54ck260 FIND v(dout0_54) AT=270.05n

.meas tran vdout0_55ck260 FIND v(dout0_55) AT=270.05n

.meas tran vdout0_56ck260 FIND v(dout0_56) AT=270.05n

.meas tran vdout0_57ck260 FIND v(dout0_57) AT=270.05n

.meas tran vdout0_58ck260 FIND v(dout0_58) AT=270.05n

.meas tran vdout0_59ck260 FIND v(dout0_59) AT=270.05n

.meas tran vdout0_60ck260 FIND v(dout0_60) AT=270.05n

.meas tran vdout0_61ck260 FIND v(dout0_61) AT=270.05n

.meas tran vdout0_62ck260 FIND v(dout0_62) AT=270.05n

.meas tran vdout0_63ck260 FIND v(dout0_63) AT=270.05n

.meas tran vdout0_0ck270 FIND v(dout0_0) AT=280.05n

.meas tran vdout0_1ck270 FIND v(dout0_1) AT=280.05n

.meas tran vdout0_2ck270 FIND v(dout0_2) AT=280.05n

.meas tran vdout0_3ck270 FIND v(dout0_3) AT=280.05n

.meas tran vdout0_4ck270 FIND v(dout0_4) AT=280.05n

.meas tran vdout0_5ck270 FIND v(dout0_5) AT=280.05n

.meas tran vdout0_6ck270 FIND v(dout0_6) AT=280.05n

.meas tran vdout0_7ck270 FIND v(dout0_7) AT=280.05n

.meas tran vdout0_8ck270 FIND v(dout0_8) AT=280.05n

.meas tran vdout0_9ck270 FIND v(dout0_9) AT=280.05n

.meas tran vdout0_10ck270 FIND v(dout0_10) AT=280.05n

.meas tran vdout0_11ck270 FIND v(dout0_11) AT=280.05n

.meas tran vdout0_12ck270 FIND v(dout0_12) AT=280.05n

.meas tran vdout0_13ck270 FIND v(dout0_13) AT=280.05n

.meas tran vdout0_14ck270 FIND v(dout0_14) AT=280.05n

.meas tran vdout0_15ck270 FIND v(dout0_15) AT=280.05n

.meas tran vdout0_16ck270 FIND v(dout0_16) AT=280.05n

.meas tran vdout0_17ck270 FIND v(dout0_17) AT=280.05n

.meas tran vdout0_18ck270 FIND v(dout0_18) AT=280.05n

.meas tran vdout0_19ck270 FIND v(dout0_19) AT=280.05n

.meas tran vdout0_20ck270 FIND v(dout0_20) AT=280.05n

.meas tran vdout0_21ck270 FIND v(dout0_21) AT=280.05n

.meas tran vdout0_22ck270 FIND v(dout0_22) AT=280.05n

.meas tran vdout0_23ck270 FIND v(dout0_23) AT=280.05n

.meas tran vdout0_24ck270 FIND v(dout0_24) AT=280.05n

.meas tran vdout0_25ck270 FIND v(dout0_25) AT=280.05n

.meas tran vdout0_26ck270 FIND v(dout0_26) AT=280.05n

.meas tran vdout0_27ck270 FIND v(dout0_27) AT=280.05n

.meas tran vdout0_28ck270 FIND v(dout0_28) AT=280.05n

.meas tran vdout0_29ck270 FIND v(dout0_29) AT=280.05n

.meas tran vdout0_30ck270 FIND v(dout0_30) AT=280.05n

.meas tran vdout0_31ck270 FIND v(dout0_31) AT=280.05n

.meas tran vdout0_32ck270 FIND v(dout0_32) AT=280.05n

.meas tran vdout0_33ck270 FIND v(dout0_33) AT=280.05n

.meas tran vdout0_34ck270 FIND v(dout0_34) AT=280.05n

.meas tran vdout0_35ck270 FIND v(dout0_35) AT=280.05n

.meas tran vdout0_36ck270 FIND v(dout0_36) AT=280.05n

.meas tran vdout0_37ck270 FIND v(dout0_37) AT=280.05n

.meas tran vdout0_38ck270 FIND v(dout0_38) AT=280.05n

.meas tran vdout0_39ck270 FIND v(dout0_39) AT=280.05n

.meas tran vdout0_40ck270 FIND v(dout0_40) AT=280.05n

.meas tran vdout0_41ck270 FIND v(dout0_41) AT=280.05n

.meas tran vdout0_42ck270 FIND v(dout0_42) AT=280.05n

.meas tran vdout0_43ck270 FIND v(dout0_43) AT=280.05n

.meas tran vdout0_44ck270 FIND v(dout0_44) AT=280.05n

.meas tran vdout0_45ck270 FIND v(dout0_45) AT=280.05n

.meas tran vdout0_46ck270 FIND v(dout0_46) AT=280.05n

.meas tran vdout0_47ck270 FIND v(dout0_47) AT=280.05n

.meas tran vdout0_48ck270 FIND v(dout0_48) AT=280.05n

.meas tran vdout0_49ck270 FIND v(dout0_49) AT=280.05n

.meas tran vdout0_50ck270 FIND v(dout0_50) AT=280.05n

.meas tran vdout0_51ck270 FIND v(dout0_51) AT=280.05n

.meas tran vdout0_52ck270 FIND v(dout0_52) AT=280.05n

.meas tran vdout0_53ck270 FIND v(dout0_53) AT=280.05n

.meas tran vdout0_54ck270 FIND v(dout0_54) AT=280.05n

.meas tran vdout0_55ck270 FIND v(dout0_55) AT=280.05n

.meas tran vdout0_56ck270 FIND v(dout0_56) AT=280.05n

.meas tran vdout0_57ck270 FIND v(dout0_57) AT=280.05n

.meas tran vdout0_58ck270 FIND v(dout0_58) AT=280.05n

.meas tran vdout0_59ck270 FIND v(dout0_59) AT=280.05n

.meas tran vdout0_60ck270 FIND v(dout0_60) AT=280.05n

.meas tran vdout0_61ck270 FIND v(dout0_61) AT=280.05n

.meas tran vdout0_62ck270 FIND v(dout0_62) AT=280.05n

.meas tran vdout0_63ck270 FIND v(dout0_63) AT=280.05n

.meas tran vdout1_0ck270 FIND v(dout1_0) AT=280.05n

.meas tran vdout1_1ck270 FIND v(dout1_1) AT=280.05n

.meas tran vdout1_2ck270 FIND v(dout1_2) AT=280.05n

.meas tran vdout1_3ck270 FIND v(dout1_3) AT=280.05n

.meas tran vdout1_4ck270 FIND v(dout1_4) AT=280.05n

.meas tran vdout1_5ck270 FIND v(dout1_5) AT=280.05n

.meas tran vdout1_6ck270 FIND v(dout1_6) AT=280.05n

.meas tran vdout1_7ck270 FIND v(dout1_7) AT=280.05n

.meas tran vdout1_8ck270 FIND v(dout1_8) AT=280.05n

.meas tran vdout1_9ck270 FIND v(dout1_9) AT=280.05n

.meas tran vdout1_10ck270 FIND v(dout1_10) AT=280.05n

.meas tran vdout1_11ck270 FIND v(dout1_11) AT=280.05n

.meas tran vdout1_12ck270 FIND v(dout1_12) AT=280.05n

.meas tran vdout1_13ck270 FIND v(dout1_13) AT=280.05n

.meas tran vdout1_14ck270 FIND v(dout1_14) AT=280.05n

.meas tran vdout1_15ck270 FIND v(dout1_15) AT=280.05n

.meas tran vdout1_16ck270 FIND v(dout1_16) AT=280.05n

.meas tran vdout1_17ck270 FIND v(dout1_17) AT=280.05n

.meas tran vdout1_18ck270 FIND v(dout1_18) AT=280.05n

.meas tran vdout1_19ck270 FIND v(dout1_19) AT=280.05n

.meas tran vdout1_20ck270 FIND v(dout1_20) AT=280.05n

.meas tran vdout1_21ck270 FIND v(dout1_21) AT=280.05n

.meas tran vdout1_22ck270 FIND v(dout1_22) AT=280.05n

.meas tran vdout1_23ck270 FIND v(dout1_23) AT=280.05n

.meas tran vdout1_24ck270 FIND v(dout1_24) AT=280.05n

.meas tran vdout1_25ck270 FIND v(dout1_25) AT=280.05n

.meas tran vdout1_26ck270 FIND v(dout1_26) AT=280.05n

.meas tran vdout1_27ck270 FIND v(dout1_27) AT=280.05n

.meas tran vdout1_28ck270 FIND v(dout1_28) AT=280.05n

.meas tran vdout1_29ck270 FIND v(dout1_29) AT=280.05n

.meas tran vdout1_30ck270 FIND v(dout1_30) AT=280.05n

.meas tran vdout1_31ck270 FIND v(dout1_31) AT=280.05n

.meas tran vdout1_32ck270 FIND v(dout1_32) AT=280.05n

.meas tran vdout1_33ck270 FIND v(dout1_33) AT=280.05n

.meas tran vdout1_34ck270 FIND v(dout1_34) AT=280.05n

.meas tran vdout1_35ck270 FIND v(dout1_35) AT=280.05n

.meas tran vdout1_36ck270 FIND v(dout1_36) AT=280.05n

.meas tran vdout1_37ck270 FIND v(dout1_37) AT=280.05n

.meas tran vdout1_38ck270 FIND v(dout1_38) AT=280.05n

.meas tran vdout1_39ck270 FIND v(dout1_39) AT=280.05n

.meas tran vdout1_40ck270 FIND v(dout1_40) AT=280.05n

.meas tran vdout1_41ck270 FIND v(dout1_41) AT=280.05n

.meas tran vdout1_42ck270 FIND v(dout1_42) AT=280.05n

.meas tran vdout1_43ck270 FIND v(dout1_43) AT=280.05n

.meas tran vdout1_44ck270 FIND v(dout1_44) AT=280.05n

.meas tran vdout1_45ck270 FIND v(dout1_45) AT=280.05n

.meas tran vdout1_46ck270 FIND v(dout1_46) AT=280.05n

.meas tran vdout1_47ck270 FIND v(dout1_47) AT=280.05n

.meas tran vdout1_48ck270 FIND v(dout1_48) AT=280.05n

.meas tran vdout1_49ck270 FIND v(dout1_49) AT=280.05n

.meas tran vdout1_50ck270 FIND v(dout1_50) AT=280.05n

.meas tran vdout1_51ck270 FIND v(dout1_51) AT=280.05n

.meas tran vdout1_52ck270 FIND v(dout1_52) AT=280.05n

.meas tran vdout1_53ck270 FIND v(dout1_53) AT=280.05n

.meas tran vdout1_54ck270 FIND v(dout1_54) AT=280.05n

.meas tran vdout1_55ck270 FIND v(dout1_55) AT=280.05n

.meas tran vdout1_56ck270 FIND v(dout1_56) AT=280.05n

.meas tran vdout1_57ck270 FIND v(dout1_57) AT=280.05n

.meas tran vdout1_58ck270 FIND v(dout1_58) AT=280.05n

.meas tran vdout1_59ck270 FIND v(dout1_59) AT=280.05n

.meas tran vdout1_60ck270 FIND v(dout1_60) AT=280.05n

.meas tran vdout1_61ck270 FIND v(dout1_61) AT=280.05n

.meas tran vdout1_62ck270 FIND v(dout1_62) AT=280.05n

.meas tran vdout1_63ck270 FIND v(dout1_63) AT=280.05n

.meas tran vdout1_0ck280 FIND v(dout1_0) AT=290.05n

.meas tran vdout1_1ck280 FIND v(dout1_1) AT=290.05n

.meas tran vdout1_2ck280 FIND v(dout1_2) AT=290.05n

.meas tran vdout1_3ck280 FIND v(dout1_3) AT=290.05n

.meas tran vdout1_4ck280 FIND v(dout1_4) AT=290.05n

.meas tran vdout1_5ck280 FIND v(dout1_5) AT=290.05n

.meas tran vdout1_6ck280 FIND v(dout1_6) AT=290.05n

.meas tran vdout1_7ck280 FIND v(dout1_7) AT=290.05n

.meas tran vdout1_8ck280 FIND v(dout1_8) AT=290.05n

.meas tran vdout1_9ck280 FIND v(dout1_9) AT=290.05n

.meas tran vdout1_10ck280 FIND v(dout1_10) AT=290.05n

.meas tran vdout1_11ck280 FIND v(dout1_11) AT=290.05n

.meas tran vdout1_12ck280 FIND v(dout1_12) AT=290.05n

.meas tran vdout1_13ck280 FIND v(dout1_13) AT=290.05n

.meas tran vdout1_14ck280 FIND v(dout1_14) AT=290.05n

.meas tran vdout1_15ck280 FIND v(dout1_15) AT=290.05n

.meas tran vdout1_16ck280 FIND v(dout1_16) AT=290.05n

.meas tran vdout1_17ck280 FIND v(dout1_17) AT=290.05n

.meas tran vdout1_18ck280 FIND v(dout1_18) AT=290.05n

.meas tran vdout1_19ck280 FIND v(dout1_19) AT=290.05n

.meas tran vdout1_20ck280 FIND v(dout1_20) AT=290.05n

.meas tran vdout1_21ck280 FIND v(dout1_21) AT=290.05n

.meas tran vdout1_22ck280 FIND v(dout1_22) AT=290.05n

.meas tran vdout1_23ck280 FIND v(dout1_23) AT=290.05n

.meas tran vdout1_24ck280 FIND v(dout1_24) AT=290.05n

.meas tran vdout1_25ck280 FIND v(dout1_25) AT=290.05n

.meas tran vdout1_26ck280 FIND v(dout1_26) AT=290.05n

.meas tran vdout1_27ck280 FIND v(dout1_27) AT=290.05n

.meas tran vdout1_28ck280 FIND v(dout1_28) AT=290.05n

.meas tran vdout1_29ck280 FIND v(dout1_29) AT=290.05n

.meas tran vdout1_30ck280 FIND v(dout1_30) AT=290.05n

.meas tran vdout1_31ck280 FIND v(dout1_31) AT=290.05n

.meas tran vdout1_32ck280 FIND v(dout1_32) AT=290.05n

.meas tran vdout1_33ck280 FIND v(dout1_33) AT=290.05n

.meas tran vdout1_34ck280 FIND v(dout1_34) AT=290.05n

.meas tran vdout1_35ck280 FIND v(dout1_35) AT=290.05n

.meas tran vdout1_36ck280 FIND v(dout1_36) AT=290.05n

.meas tran vdout1_37ck280 FIND v(dout1_37) AT=290.05n

.meas tran vdout1_38ck280 FIND v(dout1_38) AT=290.05n

.meas tran vdout1_39ck280 FIND v(dout1_39) AT=290.05n

.meas tran vdout1_40ck280 FIND v(dout1_40) AT=290.05n

.meas tran vdout1_41ck280 FIND v(dout1_41) AT=290.05n

.meas tran vdout1_42ck280 FIND v(dout1_42) AT=290.05n

.meas tran vdout1_43ck280 FIND v(dout1_43) AT=290.05n

.meas tran vdout1_44ck280 FIND v(dout1_44) AT=290.05n

.meas tran vdout1_45ck280 FIND v(dout1_45) AT=290.05n

.meas tran vdout1_46ck280 FIND v(dout1_46) AT=290.05n

.meas tran vdout1_47ck280 FIND v(dout1_47) AT=290.05n

.meas tran vdout1_48ck280 FIND v(dout1_48) AT=290.05n

.meas tran vdout1_49ck280 FIND v(dout1_49) AT=290.05n

.meas tran vdout1_50ck280 FIND v(dout1_50) AT=290.05n

.meas tran vdout1_51ck280 FIND v(dout1_51) AT=290.05n

.meas tran vdout1_52ck280 FIND v(dout1_52) AT=290.05n

.meas tran vdout1_53ck280 FIND v(dout1_53) AT=290.05n

.meas tran vdout1_54ck280 FIND v(dout1_54) AT=290.05n

.meas tran vdout1_55ck280 FIND v(dout1_55) AT=290.05n

.meas tran vdout1_56ck280 FIND v(dout1_56) AT=290.05n

.meas tran vdout1_57ck280 FIND v(dout1_57) AT=290.05n

.meas tran vdout1_58ck280 FIND v(dout1_58) AT=290.05n

.meas tran vdout1_59ck280 FIND v(dout1_59) AT=290.05n

.meas tran vdout1_60ck280 FIND v(dout1_60) AT=290.05n

.meas tran vdout1_61ck280 FIND v(dout1_61) AT=290.05n

.meas tran vdout1_62ck280 FIND v(dout1_62) AT=290.05n

.meas tran vdout1_63ck280 FIND v(dout1_63) AT=290.05n

.meas tran vdout0_0ck290 FIND v(dout0_0) AT=300.05n

.meas tran vdout0_1ck290 FIND v(dout0_1) AT=300.05n

.meas tran vdout0_2ck290 FIND v(dout0_2) AT=300.05n

.meas tran vdout0_3ck290 FIND v(dout0_3) AT=300.05n

.meas tran vdout0_4ck290 FIND v(dout0_4) AT=300.05n

.meas tran vdout0_5ck290 FIND v(dout0_5) AT=300.05n

.meas tran vdout0_6ck290 FIND v(dout0_6) AT=300.05n

.meas tran vdout0_7ck290 FIND v(dout0_7) AT=300.05n

.meas tran vdout0_8ck290 FIND v(dout0_8) AT=300.05n

.meas tran vdout0_9ck290 FIND v(dout0_9) AT=300.05n

.meas tran vdout0_10ck290 FIND v(dout0_10) AT=300.05n

.meas tran vdout0_11ck290 FIND v(dout0_11) AT=300.05n

.meas tran vdout0_12ck290 FIND v(dout0_12) AT=300.05n

.meas tran vdout0_13ck290 FIND v(dout0_13) AT=300.05n

.meas tran vdout0_14ck290 FIND v(dout0_14) AT=300.05n

.meas tran vdout0_15ck290 FIND v(dout0_15) AT=300.05n

.meas tran vdout0_16ck290 FIND v(dout0_16) AT=300.05n

.meas tran vdout0_17ck290 FIND v(dout0_17) AT=300.05n

.meas tran vdout0_18ck290 FIND v(dout0_18) AT=300.05n

.meas tran vdout0_19ck290 FIND v(dout0_19) AT=300.05n

.meas tran vdout0_20ck290 FIND v(dout0_20) AT=300.05n

.meas tran vdout0_21ck290 FIND v(dout0_21) AT=300.05n

.meas tran vdout0_22ck290 FIND v(dout0_22) AT=300.05n

.meas tran vdout0_23ck290 FIND v(dout0_23) AT=300.05n

.meas tran vdout0_24ck290 FIND v(dout0_24) AT=300.05n

.meas tran vdout0_25ck290 FIND v(dout0_25) AT=300.05n

.meas tran vdout0_26ck290 FIND v(dout0_26) AT=300.05n

.meas tran vdout0_27ck290 FIND v(dout0_27) AT=300.05n

.meas tran vdout0_28ck290 FIND v(dout0_28) AT=300.05n

.meas tran vdout0_29ck290 FIND v(dout0_29) AT=300.05n

.meas tran vdout0_30ck290 FIND v(dout0_30) AT=300.05n

.meas tran vdout0_31ck290 FIND v(dout0_31) AT=300.05n

.meas tran vdout0_32ck290 FIND v(dout0_32) AT=300.05n

.meas tran vdout0_33ck290 FIND v(dout0_33) AT=300.05n

.meas tran vdout0_34ck290 FIND v(dout0_34) AT=300.05n

.meas tran vdout0_35ck290 FIND v(dout0_35) AT=300.05n

.meas tran vdout0_36ck290 FIND v(dout0_36) AT=300.05n

.meas tran vdout0_37ck290 FIND v(dout0_37) AT=300.05n

.meas tran vdout0_38ck290 FIND v(dout0_38) AT=300.05n

.meas tran vdout0_39ck290 FIND v(dout0_39) AT=300.05n

.meas tran vdout0_40ck290 FIND v(dout0_40) AT=300.05n

.meas tran vdout0_41ck290 FIND v(dout0_41) AT=300.05n

.meas tran vdout0_42ck290 FIND v(dout0_42) AT=300.05n

.meas tran vdout0_43ck290 FIND v(dout0_43) AT=300.05n

.meas tran vdout0_44ck290 FIND v(dout0_44) AT=300.05n

.meas tran vdout0_45ck290 FIND v(dout0_45) AT=300.05n

.meas tran vdout0_46ck290 FIND v(dout0_46) AT=300.05n

.meas tran vdout0_47ck290 FIND v(dout0_47) AT=300.05n

.meas tran vdout0_48ck290 FIND v(dout0_48) AT=300.05n

.meas tran vdout0_49ck290 FIND v(dout0_49) AT=300.05n

.meas tran vdout0_50ck290 FIND v(dout0_50) AT=300.05n

.meas tran vdout0_51ck290 FIND v(dout0_51) AT=300.05n

.meas tran vdout0_52ck290 FIND v(dout0_52) AT=300.05n

.meas tran vdout0_53ck290 FIND v(dout0_53) AT=300.05n

.meas tran vdout0_54ck290 FIND v(dout0_54) AT=300.05n

.meas tran vdout0_55ck290 FIND v(dout0_55) AT=300.05n

.meas tran vdout0_56ck290 FIND v(dout0_56) AT=300.05n

.meas tran vdout0_57ck290 FIND v(dout0_57) AT=300.05n

.meas tran vdout0_58ck290 FIND v(dout0_58) AT=300.05n

.meas tran vdout0_59ck290 FIND v(dout0_59) AT=300.05n

.meas tran vdout0_60ck290 FIND v(dout0_60) AT=300.05n

.meas tran vdout0_61ck290 FIND v(dout0_61) AT=300.05n

.meas tran vdout0_62ck290 FIND v(dout0_62) AT=300.05n

.meas tran vdout0_63ck290 FIND v(dout0_63) AT=300.05n

.meas tran vdout1_0ck290 FIND v(dout1_0) AT=300.05n

.meas tran vdout1_1ck290 FIND v(dout1_1) AT=300.05n

.meas tran vdout1_2ck290 FIND v(dout1_2) AT=300.05n

.meas tran vdout1_3ck290 FIND v(dout1_3) AT=300.05n

.meas tran vdout1_4ck290 FIND v(dout1_4) AT=300.05n

.meas tran vdout1_5ck290 FIND v(dout1_5) AT=300.05n

.meas tran vdout1_6ck290 FIND v(dout1_6) AT=300.05n

.meas tran vdout1_7ck290 FIND v(dout1_7) AT=300.05n

.meas tran vdout1_8ck290 FIND v(dout1_8) AT=300.05n

.meas tran vdout1_9ck290 FIND v(dout1_9) AT=300.05n

.meas tran vdout1_10ck290 FIND v(dout1_10) AT=300.05n

.meas tran vdout1_11ck290 FIND v(dout1_11) AT=300.05n

.meas tran vdout1_12ck290 FIND v(dout1_12) AT=300.05n

.meas tran vdout1_13ck290 FIND v(dout1_13) AT=300.05n

.meas tran vdout1_14ck290 FIND v(dout1_14) AT=300.05n

.meas tran vdout1_15ck290 FIND v(dout1_15) AT=300.05n

.meas tran vdout1_16ck290 FIND v(dout1_16) AT=300.05n

.meas tran vdout1_17ck290 FIND v(dout1_17) AT=300.05n

.meas tran vdout1_18ck290 FIND v(dout1_18) AT=300.05n

.meas tran vdout1_19ck290 FIND v(dout1_19) AT=300.05n

.meas tran vdout1_20ck290 FIND v(dout1_20) AT=300.05n

.meas tran vdout1_21ck290 FIND v(dout1_21) AT=300.05n

.meas tran vdout1_22ck290 FIND v(dout1_22) AT=300.05n

.meas tran vdout1_23ck290 FIND v(dout1_23) AT=300.05n

.meas tran vdout1_24ck290 FIND v(dout1_24) AT=300.05n

.meas tran vdout1_25ck290 FIND v(dout1_25) AT=300.05n

.meas tran vdout1_26ck290 FIND v(dout1_26) AT=300.05n

.meas tran vdout1_27ck290 FIND v(dout1_27) AT=300.05n

.meas tran vdout1_28ck290 FIND v(dout1_28) AT=300.05n

.meas tran vdout1_29ck290 FIND v(dout1_29) AT=300.05n

.meas tran vdout1_30ck290 FIND v(dout1_30) AT=300.05n

.meas tran vdout1_31ck290 FIND v(dout1_31) AT=300.05n

.meas tran vdout1_32ck290 FIND v(dout1_32) AT=300.05n

.meas tran vdout1_33ck290 FIND v(dout1_33) AT=300.05n

.meas tran vdout1_34ck290 FIND v(dout1_34) AT=300.05n

.meas tran vdout1_35ck290 FIND v(dout1_35) AT=300.05n

.meas tran vdout1_36ck290 FIND v(dout1_36) AT=300.05n

.meas tran vdout1_37ck290 FIND v(dout1_37) AT=300.05n

.meas tran vdout1_38ck290 FIND v(dout1_38) AT=300.05n

.meas tran vdout1_39ck290 FIND v(dout1_39) AT=300.05n

.meas tran vdout1_40ck290 FIND v(dout1_40) AT=300.05n

.meas tran vdout1_41ck290 FIND v(dout1_41) AT=300.05n

.meas tran vdout1_42ck290 FIND v(dout1_42) AT=300.05n

.meas tran vdout1_43ck290 FIND v(dout1_43) AT=300.05n

.meas tran vdout1_44ck290 FIND v(dout1_44) AT=300.05n

.meas tran vdout1_45ck290 FIND v(dout1_45) AT=300.05n

.meas tran vdout1_46ck290 FIND v(dout1_46) AT=300.05n

.meas tran vdout1_47ck290 FIND v(dout1_47) AT=300.05n

.meas tran vdout1_48ck290 FIND v(dout1_48) AT=300.05n

.meas tran vdout1_49ck290 FIND v(dout1_49) AT=300.05n

.meas tran vdout1_50ck290 FIND v(dout1_50) AT=300.05n

.meas tran vdout1_51ck290 FIND v(dout1_51) AT=300.05n

.meas tran vdout1_52ck290 FIND v(dout1_52) AT=300.05n

.meas tran vdout1_53ck290 FIND v(dout1_53) AT=300.05n

.meas tran vdout1_54ck290 FIND v(dout1_54) AT=300.05n

.meas tran vdout1_55ck290 FIND v(dout1_55) AT=300.05n

.meas tran vdout1_56ck290 FIND v(dout1_56) AT=300.05n

.meas tran vdout1_57ck290 FIND v(dout1_57) AT=300.05n

.meas tran vdout1_58ck290 FIND v(dout1_58) AT=300.05n

.meas tran vdout1_59ck290 FIND v(dout1_59) AT=300.05n

.meas tran vdout1_60ck290 FIND v(dout1_60) AT=300.05n

.meas tran vdout1_61ck290 FIND v(dout1_61) AT=300.05n

.meas tran vdout1_62ck290 FIND v(dout1_62) AT=300.05n

.meas tran vdout1_63ck290 FIND v(dout1_63) AT=300.05n

.meas tran vdout1_0ck300 FIND v(dout1_0) AT=310.05n

.meas tran vdout1_1ck300 FIND v(dout1_1) AT=310.05n

.meas tran vdout1_2ck300 FIND v(dout1_2) AT=310.05n

.meas tran vdout1_3ck300 FIND v(dout1_3) AT=310.05n

.meas tran vdout1_4ck300 FIND v(dout1_4) AT=310.05n

.meas tran vdout1_5ck300 FIND v(dout1_5) AT=310.05n

.meas tran vdout1_6ck300 FIND v(dout1_6) AT=310.05n

.meas tran vdout1_7ck300 FIND v(dout1_7) AT=310.05n

.meas tran vdout1_8ck300 FIND v(dout1_8) AT=310.05n

.meas tran vdout1_9ck300 FIND v(dout1_9) AT=310.05n

.meas tran vdout1_10ck300 FIND v(dout1_10) AT=310.05n

.meas tran vdout1_11ck300 FIND v(dout1_11) AT=310.05n

.meas tran vdout1_12ck300 FIND v(dout1_12) AT=310.05n

.meas tran vdout1_13ck300 FIND v(dout1_13) AT=310.05n

.meas tran vdout1_14ck300 FIND v(dout1_14) AT=310.05n

.meas tran vdout1_15ck300 FIND v(dout1_15) AT=310.05n

.meas tran vdout1_16ck300 FIND v(dout1_16) AT=310.05n

.meas tran vdout1_17ck300 FIND v(dout1_17) AT=310.05n

.meas tran vdout1_18ck300 FIND v(dout1_18) AT=310.05n

.meas tran vdout1_19ck300 FIND v(dout1_19) AT=310.05n

.meas tran vdout1_20ck300 FIND v(dout1_20) AT=310.05n

.meas tran vdout1_21ck300 FIND v(dout1_21) AT=310.05n

.meas tran vdout1_22ck300 FIND v(dout1_22) AT=310.05n

.meas tran vdout1_23ck300 FIND v(dout1_23) AT=310.05n

.meas tran vdout1_24ck300 FIND v(dout1_24) AT=310.05n

.meas tran vdout1_25ck300 FIND v(dout1_25) AT=310.05n

.meas tran vdout1_26ck300 FIND v(dout1_26) AT=310.05n

.meas tran vdout1_27ck300 FIND v(dout1_27) AT=310.05n

.meas tran vdout1_28ck300 FIND v(dout1_28) AT=310.05n

.meas tran vdout1_29ck300 FIND v(dout1_29) AT=310.05n

.meas tran vdout1_30ck300 FIND v(dout1_30) AT=310.05n

.meas tran vdout1_31ck300 FIND v(dout1_31) AT=310.05n

.meas tran vdout1_32ck300 FIND v(dout1_32) AT=310.05n

.meas tran vdout1_33ck300 FIND v(dout1_33) AT=310.05n

.meas tran vdout1_34ck300 FIND v(dout1_34) AT=310.05n

.meas tran vdout1_35ck300 FIND v(dout1_35) AT=310.05n

.meas tran vdout1_36ck300 FIND v(dout1_36) AT=310.05n

.meas tran vdout1_37ck300 FIND v(dout1_37) AT=310.05n

.meas tran vdout1_38ck300 FIND v(dout1_38) AT=310.05n

.meas tran vdout1_39ck300 FIND v(dout1_39) AT=310.05n

.meas tran vdout1_40ck300 FIND v(dout1_40) AT=310.05n

.meas tran vdout1_41ck300 FIND v(dout1_41) AT=310.05n

.meas tran vdout1_42ck300 FIND v(dout1_42) AT=310.05n

.meas tran vdout1_43ck300 FIND v(dout1_43) AT=310.05n

.meas tran vdout1_44ck300 FIND v(dout1_44) AT=310.05n

.meas tran vdout1_45ck300 FIND v(dout1_45) AT=310.05n

.meas tran vdout1_46ck300 FIND v(dout1_46) AT=310.05n

.meas tran vdout1_47ck300 FIND v(dout1_47) AT=310.05n

.meas tran vdout1_48ck300 FIND v(dout1_48) AT=310.05n

.meas tran vdout1_49ck300 FIND v(dout1_49) AT=310.05n

.meas tran vdout1_50ck300 FIND v(dout1_50) AT=310.05n

.meas tran vdout1_51ck300 FIND v(dout1_51) AT=310.05n

.meas tran vdout1_52ck300 FIND v(dout1_52) AT=310.05n

.meas tran vdout1_53ck300 FIND v(dout1_53) AT=310.05n

.meas tran vdout1_54ck300 FIND v(dout1_54) AT=310.05n

.meas tran vdout1_55ck300 FIND v(dout1_55) AT=310.05n

.meas tran vdout1_56ck300 FIND v(dout1_56) AT=310.05n

.meas tran vdout1_57ck300 FIND v(dout1_57) AT=310.05n

.meas tran vdout1_58ck300 FIND v(dout1_58) AT=310.05n

.meas tran vdout1_59ck300 FIND v(dout1_59) AT=310.05n

.meas tran vdout1_60ck300 FIND v(dout1_60) AT=310.05n

.meas tran vdout1_61ck300 FIND v(dout1_61) AT=310.05n

.meas tran vdout1_62ck300 FIND v(dout1_62) AT=310.05n

.meas tran vdout1_63ck300 FIND v(dout1_63) AT=310.05n

.meas tran vdout0_0ck310 FIND v(dout0_0) AT=320.05n

.meas tran vdout0_1ck310 FIND v(dout0_1) AT=320.05n

.meas tran vdout0_2ck310 FIND v(dout0_2) AT=320.05n

.meas tran vdout0_3ck310 FIND v(dout0_3) AT=320.05n

.meas tran vdout0_4ck310 FIND v(dout0_4) AT=320.05n

.meas tran vdout0_5ck310 FIND v(dout0_5) AT=320.05n

.meas tran vdout0_6ck310 FIND v(dout0_6) AT=320.05n

.meas tran vdout0_7ck310 FIND v(dout0_7) AT=320.05n

.meas tran vdout0_8ck310 FIND v(dout0_8) AT=320.05n

.meas tran vdout0_9ck310 FIND v(dout0_9) AT=320.05n

.meas tran vdout0_10ck310 FIND v(dout0_10) AT=320.05n

.meas tran vdout0_11ck310 FIND v(dout0_11) AT=320.05n

.meas tran vdout0_12ck310 FIND v(dout0_12) AT=320.05n

.meas tran vdout0_13ck310 FIND v(dout0_13) AT=320.05n

.meas tran vdout0_14ck310 FIND v(dout0_14) AT=320.05n

.meas tran vdout0_15ck310 FIND v(dout0_15) AT=320.05n

.meas tran vdout0_16ck310 FIND v(dout0_16) AT=320.05n

.meas tran vdout0_17ck310 FIND v(dout0_17) AT=320.05n

.meas tran vdout0_18ck310 FIND v(dout0_18) AT=320.05n

.meas tran vdout0_19ck310 FIND v(dout0_19) AT=320.05n

.meas tran vdout0_20ck310 FIND v(dout0_20) AT=320.05n

.meas tran vdout0_21ck310 FIND v(dout0_21) AT=320.05n

.meas tran vdout0_22ck310 FIND v(dout0_22) AT=320.05n

.meas tran vdout0_23ck310 FIND v(dout0_23) AT=320.05n

.meas tran vdout0_24ck310 FIND v(dout0_24) AT=320.05n

.meas tran vdout0_25ck310 FIND v(dout0_25) AT=320.05n

.meas tran vdout0_26ck310 FIND v(dout0_26) AT=320.05n

.meas tran vdout0_27ck310 FIND v(dout0_27) AT=320.05n

.meas tran vdout0_28ck310 FIND v(dout0_28) AT=320.05n

.meas tran vdout0_29ck310 FIND v(dout0_29) AT=320.05n

.meas tran vdout0_30ck310 FIND v(dout0_30) AT=320.05n

.meas tran vdout0_31ck310 FIND v(dout0_31) AT=320.05n

.meas tran vdout0_32ck310 FIND v(dout0_32) AT=320.05n

.meas tran vdout0_33ck310 FIND v(dout0_33) AT=320.05n

.meas tran vdout0_34ck310 FIND v(dout0_34) AT=320.05n

.meas tran vdout0_35ck310 FIND v(dout0_35) AT=320.05n

.meas tran vdout0_36ck310 FIND v(dout0_36) AT=320.05n

.meas tran vdout0_37ck310 FIND v(dout0_37) AT=320.05n

.meas tran vdout0_38ck310 FIND v(dout0_38) AT=320.05n

.meas tran vdout0_39ck310 FIND v(dout0_39) AT=320.05n

.meas tran vdout0_40ck310 FIND v(dout0_40) AT=320.05n

.meas tran vdout0_41ck310 FIND v(dout0_41) AT=320.05n

.meas tran vdout0_42ck310 FIND v(dout0_42) AT=320.05n

.meas tran vdout0_43ck310 FIND v(dout0_43) AT=320.05n

.meas tran vdout0_44ck310 FIND v(dout0_44) AT=320.05n

.meas tran vdout0_45ck310 FIND v(dout0_45) AT=320.05n

.meas tran vdout0_46ck310 FIND v(dout0_46) AT=320.05n

.meas tran vdout0_47ck310 FIND v(dout0_47) AT=320.05n

.meas tran vdout0_48ck310 FIND v(dout0_48) AT=320.05n

.meas tran vdout0_49ck310 FIND v(dout0_49) AT=320.05n

.meas tran vdout0_50ck310 FIND v(dout0_50) AT=320.05n

.meas tran vdout0_51ck310 FIND v(dout0_51) AT=320.05n

.meas tran vdout0_52ck310 FIND v(dout0_52) AT=320.05n

.meas tran vdout0_53ck310 FIND v(dout0_53) AT=320.05n

.meas tran vdout0_54ck310 FIND v(dout0_54) AT=320.05n

.meas tran vdout0_55ck310 FIND v(dout0_55) AT=320.05n

.meas tran vdout0_56ck310 FIND v(dout0_56) AT=320.05n

.meas tran vdout0_57ck310 FIND v(dout0_57) AT=320.05n

.meas tran vdout0_58ck310 FIND v(dout0_58) AT=320.05n

.meas tran vdout0_59ck310 FIND v(dout0_59) AT=320.05n

.meas tran vdout0_60ck310 FIND v(dout0_60) AT=320.05n

.meas tran vdout0_61ck310 FIND v(dout0_61) AT=320.05n

.meas tran vdout0_62ck310 FIND v(dout0_62) AT=320.05n

.meas tran vdout0_63ck310 FIND v(dout0_63) AT=320.05n

.meas tran vdout1_0ck310 FIND v(dout1_0) AT=320.05n

.meas tran vdout1_1ck310 FIND v(dout1_1) AT=320.05n

.meas tran vdout1_2ck310 FIND v(dout1_2) AT=320.05n

.meas tran vdout1_3ck310 FIND v(dout1_3) AT=320.05n

.meas tran vdout1_4ck310 FIND v(dout1_4) AT=320.05n

.meas tran vdout1_5ck310 FIND v(dout1_5) AT=320.05n

.meas tran vdout1_6ck310 FIND v(dout1_6) AT=320.05n

.meas tran vdout1_7ck310 FIND v(dout1_7) AT=320.05n

.meas tran vdout1_8ck310 FIND v(dout1_8) AT=320.05n

.meas tran vdout1_9ck310 FIND v(dout1_9) AT=320.05n

.meas tran vdout1_10ck310 FIND v(dout1_10) AT=320.05n

.meas tran vdout1_11ck310 FIND v(dout1_11) AT=320.05n

.meas tran vdout1_12ck310 FIND v(dout1_12) AT=320.05n

.meas tran vdout1_13ck310 FIND v(dout1_13) AT=320.05n

.meas tran vdout1_14ck310 FIND v(dout1_14) AT=320.05n

.meas tran vdout1_15ck310 FIND v(dout1_15) AT=320.05n

.meas tran vdout1_16ck310 FIND v(dout1_16) AT=320.05n

.meas tran vdout1_17ck310 FIND v(dout1_17) AT=320.05n

.meas tran vdout1_18ck310 FIND v(dout1_18) AT=320.05n

.meas tran vdout1_19ck310 FIND v(dout1_19) AT=320.05n

.meas tran vdout1_20ck310 FIND v(dout1_20) AT=320.05n

.meas tran vdout1_21ck310 FIND v(dout1_21) AT=320.05n

.meas tran vdout1_22ck310 FIND v(dout1_22) AT=320.05n

.meas tran vdout1_23ck310 FIND v(dout1_23) AT=320.05n

.meas tran vdout1_24ck310 FIND v(dout1_24) AT=320.05n

.meas tran vdout1_25ck310 FIND v(dout1_25) AT=320.05n

.meas tran vdout1_26ck310 FIND v(dout1_26) AT=320.05n

.meas tran vdout1_27ck310 FIND v(dout1_27) AT=320.05n

.meas tran vdout1_28ck310 FIND v(dout1_28) AT=320.05n

.meas tran vdout1_29ck310 FIND v(dout1_29) AT=320.05n

.meas tran vdout1_30ck310 FIND v(dout1_30) AT=320.05n

.meas tran vdout1_31ck310 FIND v(dout1_31) AT=320.05n

.meas tran vdout1_32ck310 FIND v(dout1_32) AT=320.05n

.meas tran vdout1_33ck310 FIND v(dout1_33) AT=320.05n

.meas tran vdout1_34ck310 FIND v(dout1_34) AT=320.05n

.meas tran vdout1_35ck310 FIND v(dout1_35) AT=320.05n

.meas tran vdout1_36ck310 FIND v(dout1_36) AT=320.05n

.meas tran vdout1_37ck310 FIND v(dout1_37) AT=320.05n

.meas tran vdout1_38ck310 FIND v(dout1_38) AT=320.05n

.meas tran vdout1_39ck310 FIND v(dout1_39) AT=320.05n

.meas tran vdout1_40ck310 FIND v(dout1_40) AT=320.05n

.meas tran vdout1_41ck310 FIND v(dout1_41) AT=320.05n

.meas tran vdout1_42ck310 FIND v(dout1_42) AT=320.05n

.meas tran vdout1_43ck310 FIND v(dout1_43) AT=320.05n

.meas tran vdout1_44ck310 FIND v(dout1_44) AT=320.05n

.meas tran vdout1_45ck310 FIND v(dout1_45) AT=320.05n

.meas tran vdout1_46ck310 FIND v(dout1_46) AT=320.05n

.meas tran vdout1_47ck310 FIND v(dout1_47) AT=320.05n

.meas tran vdout1_48ck310 FIND v(dout1_48) AT=320.05n

.meas tran vdout1_49ck310 FIND v(dout1_49) AT=320.05n

.meas tran vdout1_50ck310 FIND v(dout1_50) AT=320.05n

.meas tran vdout1_51ck310 FIND v(dout1_51) AT=320.05n

.meas tran vdout1_52ck310 FIND v(dout1_52) AT=320.05n

.meas tran vdout1_53ck310 FIND v(dout1_53) AT=320.05n

.meas tran vdout1_54ck310 FIND v(dout1_54) AT=320.05n

.meas tran vdout1_55ck310 FIND v(dout1_55) AT=320.05n

.meas tran vdout1_56ck310 FIND v(dout1_56) AT=320.05n

.meas tran vdout1_57ck310 FIND v(dout1_57) AT=320.05n

.meas tran vdout1_58ck310 FIND v(dout1_58) AT=320.05n

.meas tran vdout1_59ck310 FIND v(dout1_59) AT=320.05n

.meas tran vdout1_60ck310 FIND v(dout1_60) AT=320.05n

.meas tran vdout1_61ck310 FIND v(dout1_61) AT=320.05n

.meas tran vdout1_62ck310 FIND v(dout1_62) AT=320.05n

.meas tran vdout1_63ck310 FIND v(dout1_63) AT=320.05n

.meas tran vdout1_0ck320 FIND v(dout1_0) AT=330.05n

.meas tran vdout1_1ck320 FIND v(dout1_1) AT=330.05n

.meas tran vdout1_2ck320 FIND v(dout1_2) AT=330.05n

.meas tran vdout1_3ck320 FIND v(dout1_3) AT=330.05n

.meas tran vdout1_4ck320 FIND v(dout1_4) AT=330.05n

.meas tran vdout1_5ck320 FIND v(dout1_5) AT=330.05n

.meas tran vdout1_6ck320 FIND v(dout1_6) AT=330.05n

.meas tran vdout1_7ck320 FIND v(dout1_7) AT=330.05n

.meas tran vdout1_8ck320 FIND v(dout1_8) AT=330.05n

.meas tran vdout1_9ck320 FIND v(dout1_9) AT=330.05n

.meas tran vdout1_10ck320 FIND v(dout1_10) AT=330.05n

.meas tran vdout1_11ck320 FIND v(dout1_11) AT=330.05n

.meas tran vdout1_12ck320 FIND v(dout1_12) AT=330.05n

.meas tran vdout1_13ck320 FIND v(dout1_13) AT=330.05n

.meas tran vdout1_14ck320 FIND v(dout1_14) AT=330.05n

.meas tran vdout1_15ck320 FIND v(dout1_15) AT=330.05n

.meas tran vdout1_16ck320 FIND v(dout1_16) AT=330.05n

.meas tran vdout1_17ck320 FIND v(dout1_17) AT=330.05n

.meas tran vdout1_18ck320 FIND v(dout1_18) AT=330.05n

.meas tran vdout1_19ck320 FIND v(dout1_19) AT=330.05n

.meas tran vdout1_20ck320 FIND v(dout1_20) AT=330.05n

.meas tran vdout1_21ck320 FIND v(dout1_21) AT=330.05n

.meas tran vdout1_22ck320 FIND v(dout1_22) AT=330.05n

.meas tran vdout1_23ck320 FIND v(dout1_23) AT=330.05n

.meas tran vdout1_24ck320 FIND v(dout1_24) AT=330.05n

.meas tran vdout1_25ck320 FIND v(dout1_25) AT=330.05n

.meas tran vdout1_26ck320 FIND v(dout1_26) AT=330.05n

.meas tran vdout1_27ck320 FIND v(dout1_27) AT=330.05n

.meas tran vdout1_28ck320 FIND v(dout1_28) AT=330.05n

.meas tran vdout1_29ck320 FIND v(dout1_29) AT=330.05n

.meas tran vdout1_30ck320 FIND v(dout1_30) AT=330.05n

.meas tran vdout1_31ck320 FIND v(dout1_31) AT=330.05n

.meas tran vdout1_32ck320 FIND v(dout1_32) AT=330.05n

.meas tran vdout1_33ck320 FIND v(dout1_33) AT=330.05n

.meas tran vdout1_34ck320 FIND v(dout1_34) AT=330.05n

.meas tran vdout1_35ck320 FIND v(dout1_35) AT=330.05n

.meas tran vdout1_36ck320 FIND v(dout1_36) AT=330.05n

.meas tran vdout1_37ck320 FIND v(dout1_37) AT=330.05n

.meas tran vdout1_38ck320 FIND v(dout1_38) AT=330.05n

.meas tran vdout1_39ck320 FIND v(dout1_39) AT=330.05n

.meas tran vdout1_40ck320 FIND v(dout1_40) AT=330.05n

.meas tran vdout1_41ck320 FIND v(dout1_41) AT=330.05n

.meas tran vdout1_42ck320 FIND v(dout1_42) AT=330.05n

.meas tran vdout1_43ck320 FIND v(dout1_43) AT=330.05n

.meas tran vdout1_44ck320 FIND v(dout1_44) AT=330.05n

.meas tran vdout1_45ck320 FIND v(dout1_45) AT=330.05n

.meas tran vdout1_46ck320 FIND v(dout1_46) AT=330.05n

.meas tran vdout1_47ck320 FIND v(dout1_47) AT=330.05n

.meas tran vdout1_48ck320 FIND v(dout1_48) AT=330.05n

.meas tran vdout1_49ck320 FIND v(dout1_49) AT=330.05n

.meas tran vdout1_50ck320 FIND v(dout1_50) AT=330.05n

.meas tran vdout1_51ck320 FIND v(dout1_51) AT=330.05n

.meas tran vdout1_52ck320 FIND v(dout1_52) AT=330.05n

.meas tran vdout1_53ck320 FIND v(dout1_53) AT=330.05n

.meas tran vdout1_54ck320 FIND v(dout1_54) AT=330.05n

.meas tran vdout1_55ck320 FIND v(dout1_55) AT=330.05n

.meas tran vdout1_56ck320 FIND v(dout1_56) AT=330.05n

.meas tran vdout1_57ck320 FIND v(dout1_57) AT=330.05n

.meas tran vdout1_58ck320 FIND v(dout1_58) AT=330.05n

.meas tran vdout1_59ck320 FIND v(dout1_59) AT=330.05n

.meas tran vdout1_60ck320 FIND v(dout1_60) AT=330.05n

.meas tran vdout1_61ck320 FIND v(dout1_61) AT=330.05n

.meas tran vdout1_62ck320 FIND v(dout1_62) AT=330.05n

.meas tran vdout1_63ck320 FIND v(dout1_63) AT=330.05n

.meas tran vdout0_0ck330 FIND v(dout0_0) AT=340.05n

.meas tran vdout0_1ck330 FIND v(dout0_1) AT=340.05n

.meas tran vdout0_2ck330 FIND v(dout0_2) AT=340.05n

.meas tran vdout0_3ck330 FIND v(dout0_3) AT=340.05n

.meas tran vdout0_4ck330 FIND v(dout0_4) AT=340.05n

.meas tran vdout0_5ck330 FIND v(dout0_5) AT=340.05n

.meas tran vdout0_6ck330 FIND v(dout0_6) AT=340.05n

.meas tran vdout0_7ck330 FIND v(dout0_7) AT=340.05n

.meas tran vdout0_8ck330 FIND v(dout0_8) AT=340.05n

.meas tran vdout0_9ck330 FIND v(dout0_9) AT=340.05n

.meas tran vdout0_10ck330 FIND v(dout0_10) AT=340.05n

.meas tran vdout0_11ck330 FIND v(dout0_11) AT=340.05n

.meas tran vdout0_12ck330 FIND v(dout0_12) AT=340.05n

.meas tran vdout0_13ck330 FIND v(dout0_13) AT=340.05n

.meas tran vdout0_14ck330 FIND v(dout0_14) AT=340.05n

.meas tran vdout0_15ck330 FIND v(dout0_15) AT=340.05n

.meas tran vdout0_16ck330 FIND v(dout0_16) AT=340.05n

.meas tran vdout0_17ck330 FIND v(dout0_17) AT=340.05n

.meas tran vdout0_18ck330 FIND v(dout0_18) AT=340.05n

.meas tran vdout0_19ck330 FIND v(dout0_19) AT=340.05n

.meas tran vdout0_20ck330 FIND v(dout0_20) AT=340.05n

.meas tran vdout0_21ck330 FIND v(dout0_21) AT=340.05n

.meas tran vdout0_22ck330 FIND v(dout0_22) AT=340.05n

.meas tran vdout0_23ck330 FIND v(dout0_23) AT=340.05n

.meas tran vdout0_24ck330 FIND v(dout0_24) AT=340.05n

.meas tran vdout0_25ck330 FIND v(dout0_25) AT=340.05n

.meas tran vdout0_26ck330 FIND v(dout0_26) AT=340.05n

.meas tran vdout0_27ck330 FIND v(dout0_27) AT=340.05n

.meas tran vdout0_28ck330 FIND v(dout0_28) AT=340.05n

.meas tran vdout0_29ck330 FIND v(dout0_29) AT=340.05n

.meas tran vdout0_30ck330 FIND v(dout0_30) AT=340.05n

.meas tran vdout0_31ck330 FIND v(dout0_31) AT=340.05n

.meas tran vdout0_32ck330 FIND v(dout0_32) AT=340.05n

.meas tran vdout0_33ck330 FIND v(dout0_33) AT=340.05n

.meas tran vdout0_34ck330 FIND v(dout0_34) AT=340.05n

.meas tran vdout0_35ck330 FIND v(dout0_35) AT=340.05n

.meas tran vdout0_36ck330 FIND v(dout0_36) AT=340.05n

.meas tran vdout0_37ck330 FIND v(dout0_37) AT=340.05n

.meas tran vdout0_38ck330 FIND v(dout0_38) AT=340.05n

.meas tran vdout0_39ck330 FIND v(dout0_39) AT=340.05n

.meas tran vdout0_40ck330 FIND v(dout0_40) AT=340.05n

.meas tran vdout0_41ck330 FIND v(dout0_41) AT=340.05n

.meas tran vdout0_42ck330 FIND v(dout0_42) AT=340.05n

.meas tran vdout0_43ck330 FIND v(dout0_43) AT=340.05n

.meas tran vdout0_44ck330 FIND v(dout0_44) AT=340.05n

.meas tran vdout0_45ck330 FIND v(dout0_45) AT=340.05n

.meas tran vdout0_46ck330 FIND v(dout0_46) AT=340.05n

.meas tran vdout0_47ck330 FIND v(dout0_47) AT=340.05n

.meas tran vdout0_48ck330 FIND v(dout0_48) AT=340.05n

.meas tran vdout0_49ck330 FIND v(dout0_49) AT=340.05n

.meas tran vdout0_50ck330 FIND v(dout0_50) AT=340.05n

.meas tran vdout0_51ck330 FIND v(dout0_51) AT=340.05n

.meas tran vdout0_52ck330 FIND v(dout0_52) AT=340.05n

.meas tran vdout0_53ck330 FIND v(dout0_53) AT=340.05n

.meas tran vdout0_54ck330 FIND v(dout0_54) AT=340.05n

.meas tran vdout0_55ck330 FIND v(dout0_55) AT=340.05n

.meas tran vdout0_56ck330 FIND v(dout0_56) AT=340.05n

.meas tran vdout0_57ck330 FIND v(dout0_57) AT=340.05n

.meas tran vdout0_58ck330 FIND v(dout0_58) AT=340.05n

.meas tran vdout0_59ck330 FIND v(dout0_59) AT=340.05n

.meas tran vdout0_60ck330 FIND v(dout0_60) AT=340.05n

.meas tran vdout0_61ck330 FIND v(dout0_61) AT=340.05n

.meas tran vdout0_62ck330 FIND v(dout0_62) AT=340.05n

.meas tran vdout0_63ck330 FIND v(dout0_63) AT=340.05n

.meas tran vdout1_0ck340 FIND v(dout1_0) AT=350.05n

.meas tran vdout1_1ck340 FIND v(dout1_1) AT=350.05n

.meas tran vdout1_2ck340 FIND v(dout1_2) AT=350.05n

.meas tran vdout1_3ck340 FIND v(dout1_3) AT=350.05n

.meas tran vdout1_4ck340 FIND v(dout1_4) AT=350.05n

.meas tran vdout1_5ck340 FIND v(dout1_5) AT=350.05n

.meas tran vdout1_6ck340 FIND v(dout1_6) AT=350.05n

.meas tran vdout1_7ck340 FIND v(dout1_7) AT=350.05n

.meas tran vdout1_8ck340 FIND v(dout1_8) AT=350.05n

.meas tran vdout1_9ck340 FIND v(dout1_9) AT=350.05n

.meas tran vdout1_10ck340 FIND v(dout1_10) AT=350.05n

.meas tran vdout1_11ck340 FIND v(dout1_11) AT=350.05n

.meas tran vdout1_12ck340 FIND v(dout1_12) AT=350.05n

.meas tran vdout1_13ck340 FIND v(dout1_13) AT=350.05n

.meas tran vdout1_14ck340 FIND v(dout1_14) AT=350.05n

.meas tran vdout1_15ck340 FIND v(dout1_15) AT=350.05n

.meas tran vdout1_16ck340 FIND v(dout1_16) AT=350.05n

.meas tran vdout1_17ck340 FIND v(dout1_17) AT=350.05n

.meas tran vdout1_18ck340 FIND v(dout1_18) AT=350.05n

.meas tran vdout1_19ck340 FIND v(dout1_19) AT=350.05n

.meas tran vdout1_20ck340 FIND v(dout1_20) AT=350.05n

.meas tran vdout1_21ck340 FIND v(dout1_21) AT=350.05n

.meas tran vdout1_22ck340 FIND v(dout1_22) AT=350.05n

.meas tran vdout1_23ck340 FIND v(dout1_23) AT=350.05n

.meas tran vdout1_24ck340 FIND v(dout1_24) AT=350.05n

.meas tran vdout1_25ck340 FIND v(dout1_25) AT=350.05n

.meas tran vdout1_26ck340 FIND v(dout1_26) AT=350.05n

.meas tran vdout1_27ck340 FIND v(dout1_27) AT=350.05n

.meas tran vdout1_28ck340 FIND v(dout1_28) AT=350.05n

.meas tran vdout1_29ck340 FIND v(dout1_29) AT=350.05n

.meas tran vdout1_30ck340 FIND v(dout1_30) AT=350.05n

.meas tran vdout1_31ck340 FIND v(dout1_31) AT=350.05n

.meas tran vdout1_32ck340 FIND v(dout1_32) AT=350.05n

.meas tran vdout1_33ck340 FIND v(dout1_33) AT=350.05n

.meas tran vdout1_34ck340 FIND v(dout1_34) AT=350.05n

.meas tran vdout1_35ck340 FIND v(dout1_35) AT=350.05n

.meas tran vdout1_36ck340 FIND v(dout1_36) AT=350.05n

.meas tran vdout1_37ck340 FIND v(dout1_37) AT=350.05n

.meas tran vdout1_38ck340 FIND v(dout1_38) AT=350.05n

.meas tran vdout1_39ck340 FIND v(dout1_39) AT=350.05n

.meas tran vdout1_40ck340 FIND v(dout1_40) AT=350.05n

.meas tran vdout1_41ck340 FIND v(dout1_41) AT=350.05n

.meas tran vdout1_42ck340 FIND v(dout1_42) AT=350.05n

.meas tran vdout1_43ck340 FIND v(dout1_43) AT=350.05n

.meas tran vdout1_44ck340 FIND v(dout1_44) AT=350.05n

.meas tran vdout1_45ck340 FIND v(dout1_45) AT=350.05n

.meas tran vdout1_46ck340 FIND v(dout1_46) AT=350.05n

.meas tran vdout1_47ck340 FIND v(dout1_47) AT=350.05n

.meas tran vdout1_48ck340 FIND v(dout1_48) AT=350.05n

.meas tran vdout1_49ck340 FIND v(dout1_49) AT=350.05n

.meas tran vdout1_50ck340 FIND v(dout1_50) AT=350.05n

.meas tran vdout1_51ck340 FIND v(dout1_51) AT=350.05n

.meas tran vdout1_52ck340 FIND v(dout1_52) AT=350.05n

.meas tran vdout1_53ck340 FIND v(dout1_53) AT=350.05n

.meas tran vdout1_54ck340 FIND v(dout1_54) AT=350.05n

.meas tran vdout1_55ck340 FIND v(dout1_55) AT=350.05n

.meas tran vdout1_56ck340 FIND v(dout1_56) AT=350.05n

.meas tran vdout1_57ck340 FIND v(dout1_57) AT=350.05n

.meas tran vdout1_58ck340 FIND v(dout1_58) AT=350.05n

.meas tran vdout1_59ck340 FIND v(dout1_59) AT=350.05n

.meas tran vdout1_60ck340 FIND v(dout1_60) AT=350.05n

.meas tran vdout1_61ck340 FIND v(dout1_61) AT=350.05n

.meas tran vdout1_62ck340 FIND v(dout1_62) AT=350.05n

.meas tran vdout1_63ck340 FIND v(dout1_63) AT=350.05n

.meas tran vdout1_0ck350 FIND v(dout1_0) AT=360.05n

.meas tran vdout1_1ck350 FIND v(dout1_1) AT=360.05n

.meas tran vdout1_2ck350 FIND v(dout1_2) AT=360.05n

.meas tran vdout1_3ck350 FIND v(dout1_3) AT=360.05n

.meas tran vdout1_4ck350 FIND v(dout1_4) AT=360.05n

.meas tran vdout1_5ck350 FIND v(dout1_5) AT=360.05n

.meas tran vdout1_6ck350 FIND v(dout1_6) AT=360.05n

.meas tran vdout1_7ck350 FIND v(dout1_7) AT=360.05n

.meas tran vdout1_8ck350 FIND v(dout1_8) AT=360.05n

.meas tran vdout1_9ck350 FIND v(dout1_9) AT=360.05n

.meas tran vdout1_10ck350 FIND v(dout1_10) AT=360.05n

.meas tran vdout1_11ck350 FIND v(dout1_11) AT=360.05n

.meas tran vdout1_12ck350 FIND v(dout1_12) AT=360.05n

.meas tran vdout1_13ck350 FIND v(dout1_13) AT=360.05n

.meas tran vdout1_14ck350 FIND v(dout1_14) AT=360.05n

.meas tran vdout1_15ck350 FIND v(dout1_15) AT=360.05n

.meas tran vdout1_16ck350 FIND v(dout1_16) AT=360.05n

.meas tran vdout1_17ck350 FIND v(dout1_17) AT=360.05n

.meas tran vdout1_18ck350 FIND v(dout1_18) AT=360.05n

.meas tran vdout1_19ck350 FIND v(dout1_19) AT=360.05n

.meas tran vdout1_20ck350 FIND v(dout1_20) AT=360.05n

.meas tran vdout1_21ck350 FIND v(dout1_21) AT=360.05n

.meas tran vdout1_22ck350 FIND v(dout1_22) AT=360.05n

.meas tran vdout1_23ck350 FIND v(dout1_23) AT=360.05n

.meas tran vdout1_24ck350 FIND v(dout1_24) AT=360.05n

.meas tran vdout1_25ck350 FIND v(dout1_25) AT=360.05n

.meas tran vdout1_26ck350 FIND v(dout1_26) AT=360.05n

.meas tran vdout1_27ck350 FIND v(dout1_27) AT=360.05n

.meas tran vdout1_28ck350 FIND v(dout1_28) AT=360.05n

.meas tran vdout1_29ck350 FIND v(dout1_29) AT=360.05n

.meas tran vdout1_30ck350 FIND v(dout1_30) AT=360.05n

.meas tran vdout1_31ck350 FIND v(dout1_31) AT=360.05n

.meas tran vdout1_32ck350 FIND v(dout1_32) AT=360.05n

.meas tran vdout1_33ck350 FIND v(dout1_33) AT=360.05n

.meas tran vdout1_34ck350 FIND v(dout1_34) AT=360.05n

.meas tran vdout1_35ck350 FIND v(dout1_35) AT=360.05n

.meas tran vdout1_36ck350 FIND v(dout1_36) AT=360.05n

.meas tran vdout1_37ck350 FIND v(dout1_37) AT=360.05n

.meas tran vdout1_38ck350 FIND v(dout1_38) AT=360.05n

.meas tran vdout1_39ck350 FIND v(dout1_39) AT=360.05n

.meas tran vdout1_40ck350 FIND v(dout1_40) AT=360.05n

.meas tran vdout1_41ck350 FIND v(dout1_41) AT=360.05n

.meas tran vdout1_42ck350 FIND v(dout1_42) AT=360.05n

.meas tran vdout1_43ck350 FIND v(dout1_43) AT=360.05n

.meas tran vdout1_44ck350 FIND v(dout1_44) AT=360.05n

.meas tran vdout1_45ck350 FIND v(dout1_45) AT=360.05n

.meas tran vdout1_46ck350 FIND v(dout1_46) AT=360.05n

.meas tran vdout1_47ck350 FIND v(dout1_47) AT=360.05n

.meas tran vdout1_48ck350 FIND v(dout1_48) AT=360.05n

.meas tran vdout1_49ck350 FIND v(dout1_49) AT=360.05n

.meas tran vdout1_50ck350 FIND v(dout1_50) AT=360.05n

.meas tran vdout1_51ck350 FIND v(dout1_51) AT=360.05n

.meas tran vdout1_52ck350 FIND v(dout1_52) AT=360.05n

.meas tran vdout1_53ck350 FIND v(dout1_53) AT=360.05n

.meas tran vdout1_54ck350 FIND v(dout1_54) AT=360.05n

.meas tran vdout1_55ck350 FIND v(dout1_55) AT=360.05n

.meas tran vdout1_56ck350 FIND v(dout1_56) AT=360.05n

.meas tran vdout1_57ck350 FIND v(dout1_57) AT=360.05n

.meas tran vdout1_58ck350 FIND v(dout1_58) AT=360.05n

.meas tran vdout1_59ck350 FIND v(dout1_59) AT=360.05n

.meas tran vdout1_60ck350 FIND v(dout1_60) AT=360.05n

.meas tran vdout1_61ck350 FIND v(dout1_61) AT=360.05n

.meas tran vdout1_62ck350 FIND v(dout1_62) AT=360.05n

.meas tran vdout1_63ck350 FIND v(dout1_63) AT=360.05n

.meas tran vdout0_0ck360 FIND v(dout0_0) AT=370.05n

.meas tran vdout0_1ck360 FIND v(dout0_1) AT=370.05n

.meas tran vdout0_2ck360 FIND v(dout0_2) AT=370.05n

.meas tran vdout0_3ck360 FIND v(dout0_3) AT=370.05n

.meas tran vdout0_4ck360 FIND v(dout0_4) AT=370.05n

.meas tran vdout0_5ck360 FIND v(dout0_5) AT=370.05n

.meas tran vdout0_6ck360 FIND v(dout0_6) AT=370.05n

.meas tran vdout0_7ck360 FIND v(dout0_7) AT=370.05n

.meas tran vdout0_8ck360 FIND v(dout0_8) AT=370.05n

.meas tran vdout0_9ck360 FIND v(dout0_9) AT=370.05n

.meas tran vdout0_10ck360 FIND v(dout0_10) AT=370.05n

.meas tran vdout0_11ck360 FIND v(dout0_11) AT=370.05n

.meas tran vdout0_12ck360 FIND v(dout0_12) AT=370.05n

.meas tran vdout0_13ck360 FIND v(dout0_13) AT=370.05n

.meas tran vdout0_14ck360 FIND v(dout0_14) AT=370.05n

.meas tran vdout0_15ck360 FIND v(dout0_15) AT=370.05n

.meas tran vdout0_16ck360 FIND v(dout0_16) AT=370.05n

.meas tran vdout0_17ck360 FIND v(dout0_17) AT=370.05n

.meas tran vdout0_18ck360 FIND v(dout0_18) AT=370.05n

.meas tran vdout0_19ck360 FIND v(dout0_19) AT=370.05n

.meas tran vdout0_20ck360 FIND v(dout0_20) AT=370.05n

.meas tran vdout0_21ck360 FIND v(dout0_21) AT=370.05n

.meas tran vdout0_22ck360 FIND v(dout0_22) AT=370.05n

.meas tran vdout0_23ck360 FIND v(dout0_23) AT=370.05n

.meas tran vdout0_24ck360 FIND v(dout0_24) AT=370.05n

.meas tran vdout0_25ck360 FIND v(dout0_25) AT=370.05n

.meas tran vdout0_26ck360 FIND v(dout0_26) AT=370.05n

.meas tran vdout0_27ck360 FIND v(dout0_27) AT=370.05n

.meas tran vdout0_28ck360 FIND v(dout0_28) AT=370.05n

.meas tran vdout0_29ck360 FIND v(dout0_29) AT=370.05n

.meas tran vdout0_30ck360 FIND v(dout0_30) AT=370.05n

.meas tran vdout0_31ck360 FIND v(dout0_31) AT=370.05n

.meas tran vdout0_32ck360 FIND v(dout0_32) AT=370.05n

.meas tran vdout0_33ck360 FIND v(dout0_33) AT=370.05n

.meas tran vdout0_34ck360 FIND v(dout0_34) AT=370.05n

.meas tran vdout0_35ck360 FIND v(dout0_35) AT=370.05n

.meas tran vdout0_36ck360 FIND v(dout0_36) AT=370.05n

.meas tran vdout0_37ck360 FIND v(dout0_37) AT=370.05n

.meas tran vdout0_38ck360 FIND v(dout0_38) AT=370.05n

.meas tran vdout0_39ck360 FIND v(dout0_39) AT=370.05n

.meas tran vdout0_40ck360 FIND v(dout0_40) AT=370.05n

.meas tran vdout0_41ck360 FIND v(dout0_41) AT=370.05n

.meas tran vdout0_42ck360 FIND v(dout0_42) AT=370.05n

.meas tran vdout0_43ck360 FIND v(dout0_43) AT=370.05n

.meas tran vdout0_44ck360 FIND v(dout0_44) AT=370.05n

.meas tran vdout0_45ck360 FIND v(dout0_45) AT=370.05n

.meas tran vdout0_46ck360 FIND v(dout0_46) AT=370.05n

.meas tran vdout0_47ck360 FIND v(dout0_47) AT=370.05n

.meas tran vdout0_48ck360 FIND v(dout0_48) AT=370.05n

.meas tran vdout0_49ck360 FIND v(dout0_49) AT=370.05n

.meas tran vdout0_50ck360 FIND v(dout0_50) AT=370.05n

.meas tran vdout0_51ck360 FIND v(dout0_51) AT=370.05n

.meas tran vdout0_52ck360 FIND v(dout0_52) AT=370.05n

.meas tran vdout0_53ck360 FIND v(dout0_53) AT=370.05n

.meas tran vdout0_54ck360 FIND v(dout0_54) AT=370.05n

.meas tran vdout0_55ck360 FIND v(dout0_55) AT=370.05n

.meas tran vdout0_56ck360 FIND v(dout0_56) AT=370.05n

.meas tran vdout0_57ck360 FIND v(dout0_57) AT=370.05n

.meas tran vdout0_58ck360 FIND v(dout0_58) AT=370.05n

.meas tran vdout0_59ck360 FIND v(dout0_59) AT=370.05n

.meas tran vdout0_60ck360 FIND v(dout0_60) AT=370.05n

.meas tran vdout0_61ck360 FIND v(dout0_61) AT=370.05n

.meas tran vdout0_62ck360 FIND v(dout0_62) AT=370.05n

.meas tran vdout0_63ck360 FIND v(dout0_63) AT=370.05n

.meas tran vdout1_0ck360 FIND v(dout1_0) AT=370.05n

.meas tran vdout1_1ck360 FIND v(dout1_1) AT=370.05n

.meas tran vdout1_2ck360 FIND v(dout1_2) AT=370.05n

.meas tran vdout1_3ck360 FIND v(dout1_3) AT=370.05n

.meas tran vdout1_4ck360 FIND v(dout1_4) AT=370.05n

.meas tran vdout1_5ck360 FIND v(dout1_5) AT=370.05n

.meas tran vdout1_6ck360 FIND v(dout1_6) AT=370.05n

.meas tran vdout1_7ck360 FIND v(dout1_7) AT=370.05n

.meas tran vdout1_8ck360 FIND v(dout1_8) AT=370.05n

.meas tran vdout1_9ck360 FIND v(dout1_9) AT=370.05n

.meas tran vdout1_10ck360 FIND v(dout1_10) AT=370.05n

.meas tran vdout1_11ck360 FIND v(dout1_11) AT=370.05n

.meas tran vdout1_12ck360 FIND v(dout1_12) AT=370.05n

.meas tran vdout1_13ck360 FIND v(dout1_13) AT=370.05n

.meas tran vdout1_14ck360 FIND v(dout1_14) AT=370.05n

.meas tran vdout1_15ck360 FIND v(dout1_15) AT=370.05n

.meas tran vdout1_16ck360 FIND v(dout1_16) AT=370.05n

.meas tran vdout1_17ck360 FIND v(dout1_17) AT=370.05n

.meas tran vdout1_18ck360 FIND v(dout1_18) AT=370.05n

.meas tran vdout1_19ck360 FIND v(dout1_19) AT=370.05n

.meas tran vdout1_20ck360 FIND v(dout1_20) AT=370.05n

.meas tran vdout1_21ck360 FIND v(dout1_21) AT=370.05n

.meas tran vdout1_22ck360 FIND v(dout1_22) AT=370.05n

.meas tran vdout1_23ck360 FIND v(dout1_23) AT=370.05n

.meas tran vdout1_24ck360 FIND v(dout1_24) AT=370.05n

.meas tran vdout1_25ck360 FIND v(dout1_25) AT=370.05n

.meas tran vdout1_26ck360 FIND v(dout1_26) AT=370.05n

.meas tran vdout1_27ck360 FIND v(dout1_27) AT=370.05n

.meas tran vdout1_28ck360 FIND v(dout1_28) AT=370.05n

.meas tran vdout1_29ck360 FIND v(dout1_29) AT=370.05n

.meas tran vdout1_30ck360 FIND v(dout1_30) AT=370.05n

.meas tran vdout1_31ck360 FIND v(dout1_31) AT=370.05n

.meas tran vdout1_32ck360 FIND v(dout1_32) AT=370.05n

.meas tran vdout1_33ck360 FIND v(dout1_33) AT=370.05n

.meas tran vdout1_34ck360 FIND v(dout1_34) AT=370.05n

.meas tran vdout1_35ck360 FIND v(dout1_35) AT=370.05n

.meas tran vdout1_36ck360 FIND v(dout1_36) AT=370.05n

.meas tran vdout1_37ck360 FIND v(dout1_37) AT=370.05n

.meas tran vdout1_38ck360 FIND v(dout1_38) AT=370.05n

.meas tran vdout1_39ck360 FIND v(dout1_39) AT=370.05n

.meas tran vdout1_40ck360 FIND v(dout1_40) AT=370.05n

.meas tran vdout1_41ck360 FIND v(dout1_41) AT=370.05n

.meas tran vdout1_42ck360 FIND v(dout1_42) AT=370.05n

.meas tran vdout1_43ck360 FIND v(dout1_43) AT=370.05n

.meas tran vdout1_44ck360 FIND v(dout1_44) AT=370.05n

.meas tran vdout1_45ck360 FIND v(dout1_45) AT=370.05n

.meas tran vdout1_46ck360 FIND v(dout1_46) AT=370.05n

.meas tran vdout1_47ck360 FIND v(dout1_47) AT=370.05n

.meas tran vdout1_48ck360 FIND v(dout1_48) AT=370.05n

.meas tran vdout1_49ck360 FIND v(dout1_49) AT=370.05n

.meas tran vdout1_50ck360 FIND v(dout1_50) AT=370.05n

.meas tran vdout1_51ck360 FIND v(dout1_51) AT=370.05n

.meas tran vdout1_52ck360 FIND v(dout1_52) AT=370.05n

.meas tran vdout1_53ck360 FIND v(dout1_53) AT=370.05n

.meas tran vdout1_54ck360 FIND v(dout1_54) AT=370.05n

.meas tran vdout1_55ck360 FIND v(dout1_55) AT=370.05n

.meas tran vdout1_56ck360 FIND v(dout1_56) AT=370.05n

.meas tran vdout1_57ck360 FIND v(dout1_57) AT=370.05n

.meas tran vdout1_58ck360 FIND v(dout1_58) AT=370.05n

.meas tran vdout1_59ck360 FIND v(dout1_59) AT=370.05n

.meas tran vdout1_60ck360 FIND v(dout1_60) AT=370.05n

.meas tran vdout1_61ck360 FIND v(dout1_61) AT=370.05n

.meas tran vdout1_62ck360 FIND v(dout1_62) AT=370.05n

.meas tran vdout1_63ck360 FIND v(dout1_63) AT=370.05n

.meas tran vdout1_0ck370 FIND v(dout1_0) AT=380.05n

.meas tran vdout1_1ck370 FIND v(dout1_1) AT=380.05n

.meas tran vdout1_2ck370 FIND v(dout1_2) AT=380.05n

.meas tran vdout1_3ck370 FIND v(dout1_3) AT=380.05n

.meas tran vdout1_4ck370 FIND v(dout1_4) AT=380.05n

.meas tran vdout1_5ck370 FIND v(dout1_5) AT=380.05n

.meas tran vdout1_6ck370 FIND v(dout1_6) AT=380.05n

.meas tran vdout1_7ck370 FIND v(dout1_7) AT=380.05n

.meas tran vdout1_8ck370 FIND v(dout1_8) AT=380.05n

.meas tran vdout1_9ck370 FIND v(dout1_9) AT=380.05n

.meas tran vdout1_10ck370 FIND v(dout1_10) AT=380.05n

.meas tran vdout1_11ck370 FIND v(dout1_11) AT=380.05n

.meas tran vdout1_12ck370 FIND v(dout1_12) AT=380.05n

.meas tran vdout1_13ck370 FIND v(dout1_13) AT=380.05n

.meas tran vdout1_14ck370 FIND v(dout1_14) AT=380.05n

.meas tran vdout1_15ck370 FIND v(dout1_15) AT=380.05n

.meas tran vdout1_16ck370 FIND v(dout1_16) AT=380.05n

.meas tran vdout1_17ck370 FIND v(dout1_17) AT=380.05n

.meas tran vdout1_18ck370 FIND v(dout1_18) AT=380.05n

.meas tran vdout1_19ck370 FIND v(dout1_19) AT=380.05n

.meas tran vdout1_20ck370 FIND v(dout1_20) AT=380.05n

.meas tran vdout1_21ck370 FIND v(dout1_21) AT=380.05n

.meas tran vdout1_22ck370 FIND v(dout1_22) AT=380.05n

.meas tran vdout1_23ck370 FIND v(dout1_23) AT=380.05n

.meas tran vdout1_24ck370 FIND v(dout1_24) AT=380.05n

.meas tran vdout1_25ck370 FIND v(dout1_25) AT=380.05n

.meas tran vdout1_26ck370 FIND v(dout1_26) AT=380.05n

.meas tran vdout1_27ck370 FIND v(dout1_27) AT=380.05n

.meas tran vdout1_28ck370 FIND v(dout1_28) AT=380.05n

.meas tran vdout1_29ck370 FIND v(dout1_29) AT=380.05n

.meas tran vdout1_30ck370 FIND v(dout1_30) AT=380.05n

.meas tran vdout1_31ck370 FIND v(dout1_31) AT=380.05n

.meas tran vdout1_32ck370 FIND v(dout1_32) AT=380.05n

.meas tran vdout1_33ck370 FIND v(dout1_33) AT=380.05n

.meas tran vdout1_34ck370 FIND v(dout1_34) AT=380.05n

.meas tran vdout1_35ck370 FIND v(dout1_35) AT=380.05n

.meas tran vdout1_36ck370 FIND v(dout1_36) AT=380.05n

.meas tran vdout1_37ck370 FIND v(dout1_37) AT=380.05n

.meas tran vdout1_38ck370 FIND v(dout1_38) AT=380.05n

.meas tran vdout1_39ck370 FIND v(dout1_39) AT=380.05n

.meas tran vdout1_40ck370 FIND v(dout1_40) AT=380.05n

.meas tran vdout1_41ck370 FIND v(dout1_41) AT=380.05n

.meas tran vdout1_42ck370 FIND v(dout1_42) AT=380.05n

.meas tran vdout1_43ck370 FIND v(dout1_43) AT=380.05n

.meas tran vdout1_44ck370 FIND v(dout1_44) AT=380.05n

.meas tran vdout1_45ck370 FIND v(dout1_45) AT=380.05n

.meas tran vdout1_46ck370 FIND v(dout1_46) AT=380.05n

.meas tran vdout1_47ck370 FIND v(dout1_47) AT=380.05n

.meas tran vdout1_48ck370 FIND v(dout1_48) AT=380.05n

.meas tran vdout1_49ck370 FIND v(dout1_49) AT=380.05n

.meas tran vdout1_50ck370 FIND v(dout1_50) AT=380.05n

.meas tran vdout1_51ck370 FIND v(dout1_51) AT=380.05n

.meas tran vdout1_52ck370 FIND v(dout1_52) AT=380.05n

.meas tran vdout1_53ck370 FIND v(dout1_53) AT=380.05n

.meas tran vdout1_54ck370 FIND v(dout1_54) AT=380.05n

.meas tran vdout1_55ck370 FIND v(dout1_55) AT=380.05n

.meas tran vdout1_56ck370 FIND v(dout1_56) AT=380.05n

.meas tran vdout1_57ck370 FIND v(dout1_57) AT=380.05n

.meas tran vdout1_58ck370 FIND v(dout1_58) AT=380.05n

.meas tran vdout1_59ck370 FIND v(dout1_59) AT=380.05n

.meas tran vdout1_60ck370 FIND v(dout1_60) AT=380.05n

.meas tran vdout1_61ck370 FIND v(dout1_61) AT=380.05n

.meas tran vdout1_62ck370 FIND v(dout1_62) AT=380.05n

.meas tran vdout1_63ck370 FIND v(dout1_63) AT=380.05n

.meas tran vdout0_0ck390 FIND v(dout0_0) AT=400.05n

.meas tran vdout0_1ck390 FIND v(dout0_1) AT=400.05n

.meas tran vdout0_2ck390 FIND v(dout0_2) AT=400.05n

.meas tran vdout0_3ck390 FIND v(dout0_3) AT=400.05n

.meas tran vdout0_4ck390 FIND v(dout0_4) AT=400.05n

.meas tran vdout0_5ck390 FIND v(dout0_5) AT=400.05n

.meas tran vdout0_6ck390 FIND v(dout0_6) AT=400.05n

.meas tran vdout0_7ck390 FIND v(dout0_7) AT=400.05n

.meas tran vdout0_8ck390 FIND v(dout0_8) AT=400.05n

.meas tran vdout0_9ck390 FIND v(dout0_9) AT=400.05n

.meas tran vdout0_10ck390 FIND v(dout0_10) AT=400.05n

.meas tran vdout0_11ck390 FIND v(dout0_11) AT=400.05n

.meas tran vdout0_12ck390 FIND v(dout0_12) AT=400.05n

.meas tran vdout0_13ck390 FIND v(dout0_13) AT=400.05n

.meas tran vdout0_14ck390 FIND v(dout0_14) AT=400.05n

.meas tran vdout0_15ck390 FIND v(dout0_15) AT=400.05n

.meas tran vdout0_16ck390 FIND v(dout0_16) AT=400.05n

.meas tran vdout0_17ck390 FIND v(dout0_17) AT=400.05n

.meas tran vdout0_18ck390 FIND v(dout0_18) AT=400.05n

.meas tran vdout0_19ck390 FIND v(dout0_19) AT=400.05n

.meas tran vdout0_20ck390 FIND v(dout0_20) AT=400.05n

.meas tran vdout0_21ck390 FIND v(dout0_21) AT=400.05n

.meas tran vdout0_22ck390 FIND v(dout0_22) AT=400.05n

.meas tran vdout0_23ck390 FIND v(dout0_23) AT=400.05n

.meas tran vdout0_24ck390 FIND v(dout0_24) AT=400.05n

.meas tran vdout0_25ck390 FIND v(dout0_25) AT=400.05n

.meas tran vdout0_26ck390 FIND v(dout0_26) AT=400.05n

.meas tran vdout0_27ck390 FIND v(dout0_27) AT=400.05n

.meas tran vdout0_28ck390 FIND v(dout0_28) AT=400.05n

.meas tran vdout0_29ck390 FIND v(dout0_29) AT=400.05n

.meas tran vdout0_30ck390 FIND v(dout0_30) AT=400.05n

.meas tran vdout0_31ck390 FIND v(dout0_31) AT=400.05n

.meas tran vdout0_32ck390 FIND v(dout0_32) AT=400.05n

.meas tran vdout0_33ck390 FIND v(dout0_33) AT=400.05n

.meas tran vdout0_34ck390 FIND v(dout0_34) AT=400.05n

.meas tran vdout0_35ck390 FIND v(dout0_35) AT=400.05n

.meas tran vdout0_36ck390 FIND v(dout0_36) AT=400.05n

.meas tran vdout0_37ck390 FIND v(dout0_37) AT=400.05n

.meas tran vdout0_38ck390 FIND v(dout0_38) AT=400.05n

.meas tran vdout0_39ck390 FIND v(dout0_39) AT=400.05n

.meas tran vdout0_40ck390 FIND v(dout0_40) AT=400.05n

.meas tran vdout0_41ck390 FIND v(dout0_41) AT=400.05n

.meas tran vdout0_42ck390 FIND v(dout0_42) AT=400.05n

.meas tran vdout0_43ck390 FIND v(dout0_43) AT=400.05n

.meas tran vdout0_44ck390 FIND v(dout0_44) AT=400.05n

.meas tran vdout0_45ck390 FIND v(dout0_45) AT=400.05n

.meas tran vdout0_46ck390 FIND v(dout0_46) AT=400.05n

.meas tran vdout0_47ck390 FIND v(dout0_47) AT=400.05n

.meas tran vdout0_48ck390 FIND v(dout0_48) AT=400.05n

.meas tran vdout0_49ck390 FIND v(dout0_49) AT=400.05n

.meas tran vdout0_50ck390 FIND v(dout0_50) AT=400.05n

.meas tran vdout0_51ck390 FIND v(dout0_51) AT=400.05n

.meas tran vdout0_52ck390 FIND v(dout0_52) AT=400.05n

.meas tran vdout0_53ck390 FIND v(dout0_53) AT=400.05n

.meas tran vdout0_54ck390 FIND v(dout0_54) AT=400.05n

.meas tran vdout0_55ck390 FIND v(dout0_55) AT=400.05n

.meas tran vdout0_56ck390 FIND v(dout0_56) AT=400.05n

.meas tran vdout0_57ck390 FIND v(dout0_57) AT=400.05n

.meas tran vdout0_58ck390 FIND v(dout0_58) AT=400.05n

.meas tran vdout0_59ck390 FIND v(dout0_59) AT=400.05n

.meas tran vdout0_60ck390 FIND v(dout0_60) AT=400.05n

.meas tran vdout0_61ck390 FIND v(dout0_61) AT=400.05n

.meas tran vdout0_62ck390 FIND v(dout0_62) AT=400.05n

.meas tran vdout0_63ck390 FIND v(dout0_63) AT=400.05n

.meas tran vdout1_0ck390 FIND v(dout1_0) AT=400.05n

.meas tran vdout1_1ck390 FIND v(dout1_1) AT=400.05n

.meas tran vdout1_2ck390 FIND v(dout1_2) AT=400.05n

.meas tran vdout1_3ck390 FIND v(dout1_3) AT=400.05n

.meas tran vdout1_4ck390 FIND v(dout1_4) AT=400.05n

.meas tran vdout1_5ck390 FIND v(dout1_5) AT=400.05n

.meas tran vdout1_6ck390 FIND v(dout1_6) AT=400.05n

.meas tran vdout1_7ck390 FIND v(dout1_7) AT=400.05n

.meas tran vdout1_8ck390 FIND v(dout1_8) AT=400.05n

.meas tran vdout1_9ck390 FIND v(dout1_9) AT=400.05n

.meas tran vdout1_10ck390 FIND v(dout1_10) AT=400.05n

.meas tran vdout1_11ck390 FIND v(dout1_11) AT=400.05n

.meas tran vdout1_12ck390 FIND v(dout1_12) AT=400.05n

.meas tran vdout1_13ck390 FIND v(dout1_13) AT=400.05n

.meas tran vdout1_14ck390 FIND v(dout1_14) AT=400.05n

.meas tran vdout1_15ck390 FIND v(dout1_15) AT=400.05n

.meas tran vdout1_16ck390 FIND v(dout1_16) AT=400.05n

.meas tran vdout1_17ck390 FIND v(dout1_17) AT=400.05n

.meas tran vdout1_18ck390 FIND v(dout1_18) AT=400.05n

.meas tran vdout1_19ck390 FIND v(dout1_19) AT=400.05n

.meas tran vdout1_20ck390 FIND v(dout1_20) AT=400.05n

.meas tran vdout1_21ck390 FIND v(dout1_21) AT=400.05n

.meas tran vdout1_22ck390 FIND v(dout1_22) AT=400.05n

.meas tran vdout1_23ck390 FIND v(dout1_23) AT=400.05n

.meas tran vdout1_24ck390 FIND v(dout1_24) AT=400.05n

.meas tran vdout1_25ck390 FIND v(dout1_25) AT=400.05n

.meas tran vdout1_26ck390 FIND v(dout1_26) AT=400.05n

.meas tran vdout1_27ck390 FIND v(dout1_27) AT=400.05n

.meas tran vdout1_28ck390 FIND v(dout1_28) AT=400.05n

.meas tran vdout1_29ck390 FIND v(dout1_29) AT=400.05n

.meas tran vdout1_30ck390 FIND v(dout1_30) AT=400.05n

.meas tran vdout1_31ck390 FIND v(dout1_31) AT=400.05n

.meas tran vdout1_32ck390 FIND v(dout1_32) AT=400.05n

.meas tran vdout1_33ck390 FIND v(dout1_33) AT=400.05n

.meas tran vdout1_34ck390 FIND v(dout1_34) AT=400.05n

.meas tran vdout1_35ck390 FIND v(dout1_35) AT=400.05n

.meas tran vdout1_36ck390 FIND v(dout1_36) AT=400.05n

.meas tran vdout1_37ck390 FIND v(dout1_37) AT=400.05n

.meas tran vdout1_38ck390 FIND v(dout1_38) AT=400.05n

.meas tran vdout1_39ck390 FIND v(dout1_39) AT=400.05n

.meas tran vdout1_40ck390 FIND v(dout1_40) AT=400.05n

.meas tran vdout1_41ck390 FIND v(dout1_41) AT=400.05n

.meas tran vdout1_42ck390 FIND v(dout1_42) AT=400.05n

.meas tran vdout1_43ck390 FIND v(dout1_43) AT=400.05n

.meas tran vdout1_44ck390 FIND v(dout1_44) AT=400.05n

.meas tran vdout1_45ck390 FIND v(dout1_45) AT=400.05n

.meas tran vdout1_46ck390 FIND v(dout1_46) AT=400.05n

.meas tran vdout1_47ck390 FIND v(dout1_47) AT=400.05n

.meas tran vdout1_48ck390 FIND v(dout1_48) AT=400.05n

.meas tran vdout1_49ck390 FIND v(dout1_49) AT=400.05n

.meas tran vdout1_50ck390 FIND v(dout1_50) AT=400.05n

.meas tran vdout1_51ck390 FIND v(dout1_51) AT=400.05n

.meas tran vdout1_52ck390 FIND v(dout1_52) AT=400.05n

.meas tran vdout1_53ck390 FIND v(dout1_53) AT=400.05n

.meas tran vdout1_54ck390 FIND v(dout1_54) AT=400.05n

.meas tran vdout1_55ck390 FIND v(dout1_55) AT=400.05n

.meas tran vdout1_56ck390 FIND v(dout1_56) AT=400.05n

.meas tran vdout1_57ck390 FIND v(dout1_57) AT=400.05n

.meas tran vdout1_58ck390 FIND v(dout1_58) AT=400.05n

.meas tran vdout1_59ck390 FIND v(dout1_59) AT=400.05n

.meas tran vdout1_60ck390 FIND v(dout1_60) AT=400.05n

.meas tran vdout1_61ck390 FIND v(dout1_61) AT=400.05n

.meas tran vdout1_62ck390 FIND v(dout1_62) AT=400.05n

.meas tran vdout1_63ck390 FIND v(dout1_63) AT=400.05n

.meas tran vdout0_0ck400 FIND v(dout0_0) AT=410.05n

.meas tran vdout0_1ck400 FIND v(dout0_1) AT=410.05n

.meas tran vdout0_2ck400 FIND v(dout0_2) AT=410.05n

.meas tran vdout0_3ck400 FIND v(dout0_3) AT=410.05n

.meas tran vdout0_4ck400 FIND v(dout0_4) AT=410.05n

.meas tran vdout0_5ck400 FIND v(dout0_5) AT=410.05n

.meas tran vdout0_6ck400 FIND v(dout0_6) AT=410.05n

.meas tran vdout0_7ck400 FIND v(dout0_7) AT=410.05n

.meas tran vdout0_8ck400 FIND v(dout0_8) AT=410.05n

.meas tran vdout0_9ck400 FIND v(dout0_9) AT=410.05n

.meas tran vdout0_10ck400 FIND v(dout0_10) AT=410.05n

.meas tran vdout0_11ck400 FIND v(dout0_11) AT=410.05n

.meas tran vdout0_12ck400 FIND v(dout0_12) AT=410.05n

.meas tran vdout0_13ck400 FIND v(dout0_13) AT=410.05n

.meas tran vdout0_14ck400 FIND v(dout0_14) AT=410.05n

.meas tran vdout0_15ck400 FIND v(dout0_15) AT=410.05n

.meas tran vdout0_16ck400 FIND v(dout0_16) AT=410.05n

.meas tran vdout0_17ck400 FIND v(dout0_17) AT=410.05n

.meas tran vdout0_18ck400 FIND v(dout0_18) AT=410.05n

.meas tran vdout0_19ck400 FIND v(dout0_19) AT=410.05n

.meas tran vdout0_20ck400 FIND v(dout0_20) AT=410.05n

.meas tran vdout0_21ck400 FIND v(dout0_21) AT=410.05n

.meas tran vdout0_22ck400 FIND v(dout0_22) AT=410.05n

.meas tran vdout0_23ck400 FIND v(dout0_23) AT=410.05n

.meas tran vdout0_24ck400 FIND v(dout0_24) AT=410.05n

.meas tran vdout0_25ck400 FIND v(dout0_25) AT=410.05n

.meas tran vdout0_26ck400 FIND v(dout0_26) AT=410.05n

.meas tran vdout0_27ck400 FIND v(dout0_27) AT=410.05n

.meas tran vdout0_28ck400 FIND v(dout0_28) AT=410.05n

.meas tran vdout0_29ck400 FIND v(dout0_29) AT=410.05n

.meas tran vdout0_30ck400 FIND v(dout0_30) AT=410.05n

.meas tran vdout0_31ck400 FIND v(dout0_31) AT=410.05n

.meas tran vdout0_32ck400 FIND v(dout0_32) AT=410.05n

.meas tran vdout0_33ck400 FIND v(dout0_33) AT=410.05n

.meas tran vdout0_34ck400 FIND v(dout0_34) AT=410.05n

.meas tran vdout0_35ck400 FIND v(dout0_35) AT=410.05n

.meas tran vdout0_36ck400 FIND v(dout0_36) AT=410.05n

.meas tran vdout0_37ck400 FIND v(dout0_37) AT=410.05n

.meas tran vdout0_38ck400 FIND v(dout0_38) AT=410.05n

.meas tran vdout0_39ck400 FIND v(dout0_39) AT=410.05n

.meas tran vdout0_40ck400 FIND v(dout0_40) AT=410.05n

.meas tran vdout0_41ck400 FIND v(dout0_41) AT=410.05n

.meas tran vdout0_42ck400 FIND v(dout0_42) AT=410.05n

.meas tran vdout0_43ck400 FIND v(dout0_43) AT=410.05n

.meas tran vdout0_44ck400 FIND v(dout0_44) AT=410.05n

.meas tran vdout0_45ck400 FIND v(dout0_45) AT=410.05n

.meas tran vdout0_46ck400 FIND v(dout0_46) AT=410.05n

.meas tran vdout0_47ck400 FIND v(dout0_47) AT=410.05n

.meas tran vdout0_48ck400 FIND v(dout0_48) AT=410.05n

.meas tran vdout0_49ck400 FIND v(dout0_49) AT=410.05n

.meas tran vdout0_50ck400 FIND v(dout0_50) AT=410.05n

.meas tran vdout0_51ck400 FIND v(dout0_51) AT=410.05n

.meas tran vdout0_52ck400 FIND v(dout0_52) AT=410.05n

.meas tran vdout0_53ck400 FIND v(dout0_53) AT=410.05n

.meas tran vdout0_54ck400 FIND v(dout0_54) AT=410.05n

.meas tran vdout0_55ck400 FIND v(dout0_55) AT=410.05n

.meas tran vdout0_56ck400 FIND v(dout0_56) AT=410.05n

.meas tran vdout0_57ck400 FIND v(dout0_57) AT=410.05n

.meas tran vdout0_58ck400 FIND v(dout0_58) AT=410.05n

.meas tran vdout0_59ck400 FIND v(dout0_59) AT=410.05n

.meas tran vdout0_60ck400 FIND v(dout0_60) AT=410.05n

.meas tran vdout0_61ck400 FIND v(dout0_61) AT=410.05n

.meas tran vdout0_62ck400 FIND v(dout0_62) AT=410.05n

.meas tran vdout0_63ck400 FIND v(dout0_63) AT=410.05n

.meas tran vdout1_0ck400 FIND v(dout1_0) AT=410.05n

.meas tran vdout1_1ck400 FIND v(dout1_1) AT=410.05n

.meas tran vdout1_2ck400 FIND v(dout1_2) AT=410.05n

.meas tran vdout1_3ck400 FIND v(dout1_3) AT=410.05n

.meas tran vdout1_4ck400 FIND v(dout1_4) AT=410.05n

.meas tran vdout1_5ck400 FIND v(dout1_5) AT=410.05n

.meas tran vdout1_6ck400 FIND v(dout1_6) AT=410.05n

.meas tran vdout1_7ck400 FIND v(dout1_7) AT=410.05n

.meas tran vdout1_8ck400 FIND v(dout1_8) AT=410.05n

.meas tran vdout1_9ck400 FIND v(dout1_9) AT=410.05n

.meas tran vdout1_10ck400 FIND v(dout1_10) AT=410.05n

.meas tran vdout1_11ck400 FIND v(dout1_11) AT=410.05n

.meas tran vdout1_12ck400 FIND v(dout1_12) AT=410.05n

.meas tran vdout1_13ck400 FIND v(dout1_13) AT=410.05n

.meas tran vdout1_14ck400 FIND v(dout1_14) AT=410.05n

.meas tran vdout1_15ck400 FIND v(dout1_15) AT=410.05n

.meas tran vdout1_16ck400 FIND v(dout1_16) AT=410.05n

.meas tran vdout1_17ck400 FIND v(dout1_17) AT=410.05n

.meas tran vdout1_18ck400 FIND v(dout1_18) AT=410.05n

.meas tran vdout1_19ck400 FIND v(dout1_19) AT=410.05n

.meas tran vdout1_20ck400 FIND v(dout1_20) AT=410.05n

.meas tran vdout1_21ck400 FIND v(dout1_21) AT=410.05n

.meas tran vdout1_22ck400 FIND v(dout1_22) AT=410.05n

.meas tran vdout1_23ck400 FIND v(dout1_23) AT=410.05n

.meas tran vdout1_24ck400 FIND v(dout1_24) AT=410.05n

.meas tran vdout1_25ck400 FIND v(dout1_25) AT=410.05n

.meas tran vdout1_26ck400 FIND v(dout1_26) AT=410.05n

.meas tran vdout1_27ck400 FIND v(dout1_27) AT=410.05n

.meas tran vdout1_28ck400 FIND v(dout1_28) AT=410.05n

.meas tran vdout1_29ck400 FIND v(dout1_29) AT=410.05n

.meas tran vdout1_30ck400 FIND v(dout1_30) AT=410.05n

.meas tran vdout1_31ck400 FIND v(dout1_31) AT=410.05n

.meas tran vdout1_32ck400 FIND v(dout1_32) AT=410.05n

.meas tran vdout1_33ck400 FIND v(dout1_33) AT=410.05n

.meas tran vdout1_34ck400 FIND v(dout1_34) AT=410.05n

.meas tran vdout1_35ck400 FIND v(dout1_35) AT=410.05n

.meas tran vdout1_36ck400 FIND v(dout1_36) AT=410.05n

.meas tran vdout1_37ck400 FIND v(dout1_37) AT=410.05n

.meas tran vdout1_38ck400 FIND v(dout1_38) AT=410.05n

.meas tran vdout1_39ck400 FIND v(dout1_39) AT=410.05n

.meas tran vdout1_40ck400 FIND v(dout1_40) AT=410.05n

.meas tran vdout1_41ck400 FIND v(dout1_41) AT=410.05n

.meas tran vdout1_42ck400 FIND v(dout1_42) AT=410.05n

.meas tran vdout1_43ck400 FIND v(dout1_43) AT=410.05n

.meas tran vdout1_44ck400 FIND v(dout1_44) AT=410.05n

.meas tran vdout1_45ck400 FIND v(dout1_45) AT=410.05n

.meas tran vdout1_46ck400 FIND v(dout1_46) AT=410.05n

.meas tran vdout1_47ck400 FIND v(dout1_47) AT=410.05n

.meas tran vdout1_48ck400 FIND v(dout1_48) AT=410.05n

.meas tran vdout1_49ck400 FIND v(dout1_49) AT=410.05n

.meas tran vdout1_50ck400 FIND v(dout1_50) AT=410.05n

.meas tran vdout1_51ck400 FIND v(dout1_51) AT=410.05n

.meas tran vdout1_52ck400 FIND v(dout1_52) AT=410.05n

.meas tran vdout1_53ck400 FIND v(dout1_53) AT=410.05n

.meas tran vdout1_54ck400 FIND v(dout1_54) AT=410.05n

.meas tran vdout1_55ck400 FIND v(dout1_55) AT=410.05n

.meas tran vdout1_56ck400 FIND v(dout1_56) AT=410.05n

.meas tran vdout1_57ck400 FIND v(dout1_57) AT=410.05n

.meas tran vdout1_58ck400 FIND v(dout1_58) AT=410.05n

.meas tran vdout1_59ck400 FIND v(dout1_59) AT=410.05n

.meas tran vdout1_60ck400 FIND v(dout1_60) AT=410.05n

.meas tran vdout1_61ck400 FIND v(dout1_61) AT=410.05n

.meas tran vdout1_62ck400 FIND v(dout1_62) AT=410.05n

.meas tran vdout1_63ck400 FIND v(dout1_63) AT=410.05n

.meas tran vdout0_0ck420 FIND v(dout0_0) AT=430.05n

.meas tran vdout0_1ck420 FIND v(dout0_1) AT=430.05n

.meas tran vdout0_2ck420 FIND v(dout0_2) AT=430.05n

.meas tran vdout0_3ck420 FIND v(dout0_3) AT=430.05n

.meas tran vdout0_4ck420 FIND v(dout0_4) AT=430.05n

.meas tran vdout0_5ck420 FIND v(dout0_5) AT=430.05n

.meas tran vdout0_6ck420 FIND v(dout0_6) AT=430.05n

.meas tran vdout0_7ck420 FIND v(dout0_7) AT=430.05n

.meas tran vdout0_8ck420 FIND v(dout0_8) AT=430.05n

.meas tran vdout0_9ck420 FIND v(dout0_9) AT=430.05n

.meas tran vdout0_10ck420 FIND v(dout0_10) AT=430.05n

.meas tran vdout0_11ck420 FIND v(dout0_11) AT=430.05n

.meas tran vdout0_12ck420 FIND v(dout0_12) AT=430.05n

.meas tran vdout0_13ck420 FIND v(dout0_13) AT=430.05n

.meas tran vdout0_14ck420 FIND v(dout0_14) AT=430.05n

.meas tran vdout0_15ck420 FIND v(dout0_15) AT=430.05n

.meas tran vdout0_16ck420 FIND v(dout0_16) AT=430.05n

.meas tran vdout0_17ck420 FIND v(dout0_17) AT=430.05n

.meas tran vdout0_18ck420 FIND v(dout0_18) AT=430.05n

.meas tran vdout0_19ck420 FIND v(dout0_19) AT=430.05n

.meas tran vdout0_20ck420 FIND v(dout0_20) AT=430.05n

.meas tran vdout0_21ck420 FIND v(dout0_21) AT=430.05n

.meas tran vdout0_22ck420 FIND v(dout0_22) AT=430.05n

.meas tran vdout0_23ck420 FIND v(dout0_23) AT=430.05n

.meas tran vdout0_24ck420 FIND v(dout0_24) AT=430.05n

.meas tran vdout0_25ck420 FIND v(dout0_25) AT=430.05n

.meas tran vdout0_26ck420 FIND v(dout0_26) AT=430.05n

.meas tran vdout0_27ck420 FIND v(dout0_27) AT=430.05n

.meas tran vdout0_28ck420 FIND v(dout0_28) AT=430.05n

.meas tran vdout0_29ck420 FIND v(dout0_29) AT=430.05n

.meas tran vdout0_30ck420 FIND v(dout0_30) AT=430.05n

.meas tran vdout0_31ck420 FIND v(dout0_31) AT=430.05n

.meas tran vdout0_32ck420 FIND v(dout0_32) AT=430.05n

.meas tran vdout0_33ck420 FIND v(dout0_33) AT=430.05n

.meas tran vdout0_34ck420 FIND v(dout0_34) AT=430.05n

.meas tran vdout0_35ck420 FIND v(dout0_35) AT=430.05n

.meas tran vdout0_36ck420 FIND v(dout0_36) AT=430.05n

.meas tran vdout0_37ck420 FIND v(dout0_37) AT=430.05n

.meas tran vdout0_38ck420 FIND v(dout0_38) AT=430.05n

.meas tran vdout0_39ck420 FIND v(dout0_39) AT=430.05n

.meas tran vdout0_40ck420 FIND v(dout0_40) AT=430.05n

.meas tran vdout0_41ck420 FIND v(dout0_41) AT=430.05n

.meas tran vdout0_42ck420 FIND v(dout0_42) AT=430.05n

.meas tran vdout0_43ck420 FIND v(dout0_43) AT=430.05n

.meas tran vdout0_44ck420 FIND v(dout0_44) AT=430.05n

.meas tran vdout0_45ck420 FIND v(dout0_45) AT=430.05n

.meas tran vdout0_46ck420 FIND v(dout0_46) AT=430.05n

.meas tran vdout0_47ck420 FIND v(dout0_47) AT=430.05n

.meas tran vdout0_48ck420 FIND v(dout0_48) AT=430.05n

.meas tran vdout0_49ck420 FIND v(dout0_49) AT=430.05n

.meas tran vdout0_50ck420 FIND v(dout0_50) AT=430.05n

.meas tran vdout0_51ck420 FIND v(dout0_51) AT=430.05n

.meas tran vdout0_52ck420 FIND v(dout0_52) AT=430.05n

.meas tran vdout0_53ck420 FIND v(dout0_53) AT=430.05n

.meas tran vdout0_54ck420 FIND v(dout0_54) AT=430.05n

.meas tran vdout0_55ck420 FIND v(dout0_55) AT=430.05n

.meas tran vdout0_56ck420 FIND v(dout0_56) AT=430.05n

.meas tran vdout0_57ck420 FIND v(dout0_57) AT=430.05n

.meas tran vdout0_58ck420 FIND v(dout0_58) AT=430.05n

.meas tran vdout0_59ck420 FIND v(dout0_59) AT=430.05n

.meas tran vdout0_60ck420 FIND v(dout0_60) AT=430.05n

.meas tran vdout0_61ck420 FIND v(dout0_61) AT=430.05n

.meas tran vdout0_62ck420 FIND v(dout0_62) AT=430.05n

.meas tran vdout0_63ck420 FIND v(dout0_63) AT=430.05n

.meas tran vdout0_0ck430 FIND v(dout0_0) AT=440.05n

.meas tran vdout0_1ck430 FIND v(dout0_1) AT=440.05n

.meas tran vdout0_2ck430 FIND v(dout0_2) AT=440.05n

.meas tran vdout0_3ck430 FIND v(dout0_3) AT=440.05n

.meas tran vdout0_4ck430 FIND v(dout0_4) AT=440.05n

.meas tran vdout0_5ck430 FIND v(dout0_5) AT=440.05n

.meas tran vdout0_6ck430 FIND v(dout0_6) AT=440.05n

.meas tran vdout0_7ck430 FIND v(dout0_7) AT=440.05n

.meas tran vdout0_8ck430 FIND v(dout0_8) AT=440.05n

.meas tran vdout0_9ck430 FIND v(dout0_9) AT=440.05n

.meas tran vdout0_10ck430 FIND v(dout0_10) AT=440.05n

.meas tran vdout0_11ck430 FIND v(dout0_11) AT=440.05n

.meas tran vdout0_12ck430 FIND v(dout0_12) AT=440.05n

.meas tran vdout0_13ck430 FIND v(dout0_13) AT=440.05n

.meas tran vdout0_14ck430 FIND v(dout0_14) AT=440.05n

.meas tran vdout0_15ck430 FIND v(dout0_15) AT=440.05n

.meas tran vdout0_16ck430 FIND v(dout0_16) AT=440.05n

.meas tran vdout0_17ck430 FIND v(dout0_17) AT=440.05n

.meas tran vdout0_18ck430 FIND v(dout0_18) AT=440.05n

.meas tran vdout0_19ck430 FIND v(dout0_19) AT=440.05n

.meas tran vdout0_20ck430 FIND v(dout0_20) AT=440.05n

.meas tran vdout0_21ck430 FIND v(dout0_21) AT=440.05n

.meas tran vdout0_22ck430 FIND v(dout0_22) AT=440.05n

.meas tran vdout0_23ck430 FIND v(dout0_23) AT=440.05n

.meas tran vdout0_24ck430 FIND v(dout0_24) AT=440.05n

.meas tran vdout0_25ck430 FIND v(dout0_25) AT=440.05n

.meas tran vdout0_26ck430 FIND v(dout0_26) AT=440.05n

.meas tran vdout0_27ck430 FIND v(dout0_27) AT=440.05n

.meas tran vdout0_28ck430 FIND v(dout0_28) AT=440.05n

.meas tran vdout0_29ck430 FIND v(dout0_29) AT=440.05n

.meas tran vdout0_30ck430 FIND v(dout0_30) AT=440.05n

.meas tran vdout0_31ck430 FIND v(dout0_31) AT=440.05n

.meas tran vdout0_32ck430 FIND v(dout0_32) AT=440.05n

.meas tran vdout0_33ck430 FIND v(dout0_33) AT=440.05n

.meas tran vdout0_34ck430 FIND v(dout0_34) AT=440.05n

.meas tran vdout0_35ck430 FIND v(dout0_35) AT=440.05n

.meas tran vdout0_36ck430 FIND v(dout0_36) AT=440.05n

.meas tran vdout0_37ck430 FIND v(dout0_37) AT=440.05n

.meas tran vdout0_38ck430 FIND v(dout0_38) AT=440.05n

.meas tran vdout0_39ck430 FIND v(dout0_39) AT=440.05n

.meas tran vdout0_40ck430 FIND v(dout0_40) AT=440.05n

.meas tran vdout0_41ck430 FIND v(dout0_41) AT=440.05n

.meas tran vdout0_42ck430 FIND v(dout0_42) AT=440.05n

.meas tran vdout0_43ck430 FIND v(dout0_43) AT=440.05n

.meas tran vdout0_44ck430 FIND v(dout0_44) AT=440.05n

.meas tran vdout0_45ck430 FIND v(dout0_45) AT=440.05n

.meas tran vdout0_46ck430 FIND v(dout0_46) AT=440.05n

.meas tran vdout0_47ck430 FIND v(dout0_47) AT=440.05n

.meas tran vdout0_48ck430 FIND v(dout0_48) AT=440.05n

.meas tran vdout0_49ck430 FIND v(dout0_49) AT=440.05n

.meas tran vdout0_50ck430 FIND v(dout0_50) AT=440.05n

.meas tran vdout0_51ck430 FIND v(dout0_51) AT=440.05n

.meas tran vdout0_52ck430 FIND v(dout0_52) AT=440.05n

.meas tran vdout0_53ck430 FIND v(dout0_53) AT=440.05n

.meas tran vdout0_54ck430 FIND v(dout0_54) AT=440.05n

.meas tran vdout0_55ck430 FIND v(dout0_55) AT=440.05n

.meas tran vdout0_56ck430 FIND v(dout0_56) AT=440.05n

.meas tran vdout0_57ck430 FIND v(dout0_57) AT=440.05n

.meas tran vdout0_58ck430 FIND v(dout0_58) AT=440.05n

.meas tran vdout0_59ck430 FIND v(dout0_59) AT=440.05n

.meas tran vdout0_60ck430 FIND v(dout0_60) AT=440.05n

.meas tran vdout0_61ck430 FIND v(dout0_61) AT=440.05n

.meas tran vdout0_62ck430 FIND v(dout0_62) AT=440.05n

.meas tran vdout0_63ck430 FIND v(dout0_63) AT=440.05n

.meas tran vdout1_0ck430 FIND v(dout1_0) AT=440.05n

.meas tran vdout1_1ck430 FIND v(dout1_1) AT=440.05n

.meas tran vdout1_2ck430 FIND v(dout1_2) AT=440.05n

.meas tran vdout1_3ck430 FIND v(dout1_3) AT=440.05n

.meas tran vdout1_4ck430 FIND v(dout1_4) AT=440.05n

.meas tran vdout1_5ck430 FIND v(dout1_5) AT=440.05n

.meas tran vdout1_6ck430 FIND v(dout1_6) AT=440.05n

.meas tran vdout1_7ck430 FIND v(dout1_7) AT=440.05n

.meas tran vdout1_8ck430 FIND v(dout1_8) AT=440.05n

.meas tran vdout1_9ck430 FIND v(dout1_9) AT=440.05n

.meas tran vdout1_10ck430 FIND v(dout1_10) AT=440.05n

.meas tran vdout1_11ck430 FIND v(dout1_11) AT=440.05n

.meas tran vdout1_12ck430 FIND v(dout1_12) AT=440.05n

.meas tran vdout1_13ck430 FIND v(dout1_13) AT=440.05n

.meas tran vdout1_14ck430 FIND v(dout1_14) AT=440.05n

.meas tran vdout1_15ck430 FIND v(dout1_15) AT=440.05n

.meas tran vdout1_16ck430 FIND v(dout1_16) AT=440.05n

.meas tran vdout1_17ck430 FIND v(dout1_17) AT=440.05n

.meas tran vdout1_18ck430 FIND v(dout1_18) AT=440.05n

.meas tran vdout1_19ck430 FIND v(dout1_19) AT=440.05n

.meas tran vdout1_20ck430 FIND v(dout1_20) AT=440.05n

.meas tran vdout1_21ck430 FIND v(dout1_21) AT=440.05n

.meas tran vdout1_22ck430 FIND v(dout1_22) AT=440.05n

.meas tran vdout1_23ck430 FIND v(dout1_23) AT=440.05n

.meas tran vdout1_24ck430 FIND v(dout1_24) AT=440.05n

.meas tran vdout1_25ck430 FIND v(dout1_25) AT=440.05n

.meas tran vdout1_26ck430 FIND v(dout1_26) AT=440.05n

.meas tran vdout1_27ck430 FIND v(dout1_27) AT=440.05n

.meas tran vdout1_28ck430 FIND v(dout1_28) AT=440.05n

.meas tran vdout1_29ck430 FIND v(dout1_29) AT=440.05n

.meas tran vdout1_30ck430 FIND v(dout1_30) AT=440.05n

.meas tran vdout1_31ck430 FIND v(dout1_31) AT=440.05n

.meas tran vdout1_32ck430 FIND v(dout1_32) AT=440.05n

.meas tran vdout1_33ck430 FIND v(dout1_33) AT=440.05n

.meas tran vdout1_34ck430 FIND v(dout1_34) AT=440.05n

.meas tran vdout1_35ck430 FIND v(dout1_35) AT=440.05n

.meas tran vdout1_36ck430 FIND v(dout1_36) AT=440.05n

.meas tran vdout1_37ck430 FIND v(dout1_37) AT=440.05n

.meas tran vdout1_38ck430 FIND v(dout1_38) AT=440.05n

.meas tran vdout1_39ck430 FIND v(dout1_39) AT=440.05n

.meas tran vdout1_40ck430 FIND v(dout1_40) AT=440.05n

.meas tran vdout1_41ck430 FIND v(dout1_41) AT=440.05n

.meas tran vdout1_42ck430 FIND v(dout1_42) AT=440.05n

.meas tran vdout1_43ck430 FIND v(dout1_43) AT=440.05n

.meas tran vdout1_44ck430 FIND v(dout1_44) AT=440.05n

.meas tran vdout1_45ck430 FIND v(dout1_45) AT=440.05n

.meas tran vdout1_46ck430 FIND v(dout1_46) AT=440.05n

.meas tran vdout1_47ck430 FIND v(dout1_47) AT=440.05n

.meas tran vdout1_48ck430 FIND v(dout1_48) AT=440.05n

.meas tran vdout1_49ck430 FIND v(dout1_49) AT=440.05n

.meas tran vdout1_50ck430 FIND v(dout1_50) AT=440.05n

.meas tran vdout1_51ck430 FIND v(dout1_51) AT=440.05n

.meas tran vdout1_52ck430 FIND v(dout1_52) AT=440.05n

.meas tran vdout1_53ck430 FIND v(dout1_53) AT=440.05n

.meas tran vdout1_54ck430 FIND v(dout1_54) AT=440.05n

.meas tran vdout1_55ck430 FIND v(dout1_55) AT=440.05n

.meas tran vdout1_56ck430 FIND v(dout1_56) AT=440.05n

.meas tran vdout1_57ck430 FIND v(dout1_57) AT=440.05n

.meas tran vdout1_58ck430 FIND v(dout1_58) AT=440.05n

.meas tran vdout1_59ck430 FIND v(dout1_59) AT=440.05n

.meas tran vdout1_60ck430 FIND v(dout1_60) AT=440.05n

.meas tran vdout1_61ck430 FIND v(dout1_61) AT=440.05n

.meas tran vdout1_62ck430 FIND v(dout1_62) AT=440.05n

.meas tran vdout1_63ck430 FIND v(dout1_63) AT=440.05n

.meas tran vdout0_0ck460 FIND v(dout0_0) AT=470.05n

.meas tran vdout0_1ck460 FIND v(dout0_1) AT=470.05n

.meas tran vdout0_2ck460 FIND v(dout0_2) AT=470.05n

.meas tran vdout0_3ck460 FIND v(dout0_3) AT=470.05n

.meas tran vdout0_4ck460 FIND v(dout0_4) AT=470.05n

.meas tran vdout0_5ck460 FIND v(dout0_5) AT=470.05n

.meas tran vdout0_6ck460 FIND v(dout0_6) AT=470.05n

.meas tran vdout0_7ck460 FIND v(dout0_7) AT=470.05n

.meas tran vdout0_8ck460 FIND v(dout0_8) AT=470.05n

.meas tran vdout0_9ck460 FIND v(dout0_9) AT=470.05n

.meas tran vdout0_10ck460 FIND v(dout0_10) AT=470.05n

.meas tran vdout0_11ck460 FIND v(dout0_11) AT=470.05n

.meas tran vdout0_12ck460 FIND v(dout0_12) AT=470.05n

.meas tran vdout0_13ck460 FIND v(dout0_13) AT=470.05n

.meas tran vdout0_14ck460 FIND v(dout0_14) AT=470.05n

.meas tran vdout0_15ck460 FIND v(dout0_15) AT=470.05n

.meas tran vdout0_16ck460 FIND v(dout0_16) AT=470.05n

.meas tran vdout0_17ck460 FIND v(dout0_17) AT=470.05n

.meas tran vdout0_18ck460 FIND v(dout0_18) AT=470.05n

.meas tran vdout0_19ck460 FIND v(dout0_19) AT=470.05n

.meas tran vdout0_20ck460 FIND v(dout0_20) AT=470.05n

.meas tran vdout0_21ck460 FIND v(dout0_21) AT=470.05n

.meas tran vdout0_22ck460 FIND v(dout0_22) AT=470.05n

.meas tran vdout0_23ck460 FIND v(dout0_23) AT=470.05n

.meas tran vdout0_24ck460 FIND v(dout0_24) AT=470.05n

.meas tran vdout0_25ck460 FIND v(dout0_25) AT=470.05n

.meas tran vdout0_26ck460 FIND v(dout0_26) AT=470.05n

.meas tran vdout0_27ck460 FIND v(dout0_27) AT=470.05n

.meas tran vdout0_28ck460 FIND v(dout0_28) AT=470.05n

.meas tran vdout0_29ck460 FIND v(dout0_29) AT=470.05n

.meas tran vdout0_30ck460 FIND v(dout0_30) AT=470.05n

.meas tran vdout0_31ck460 FIND v(dout0_31) AT=470.05n

.meas tran vdout0_32ck460 FIND v(dout0_32) AT=470.05n

.meas tran vdout0_33ck460 FIND v(dout0_33) AT=470.05n

.meas tran vdout0_34ck460 FIND v(dout0_34) AT=470.05n

.meas tran vdout0_35ck460 FIND v(dout0_35) AT=470.05n

.meas tran vdout0_36ck460 FIND v(dout0_36) AT=470.05n

.meas tran vdout0_37ck460 FIND v(dout0_37) AT=470.05n

.meas tran vdout0_38ck460 FIND v(dout0_38) AT=470.05n

.meas tran vdout0_39ck460 FIND v(dout0_39) AT=470.05n

.meas tran vdout0_40ck460 FIND v(dout0_40) AT=470.05n

.meas tran vdout0_41ck460 FIND v(dout0_41) AT=470.05n

.meas tran vdout0_42ck460 FIND v(dout0_42) AT=470.05n

.meas tran vdout0_43ck460 FIND v(dout0_43) AT=470.05n

.meas tran vdout0_44ck460 FIND v(dout0_44) AT=470.05n

.meas tran vdout0_45ck460 FIND v(dout0_45) AT=470.05n

.meas tran vdout0_46ck460 FIND v(dout0_46) AT=470.05n

.meas tran vdout0_47ck460 FIND v(dout0_47) AT=470.05n

.meas tran vdout0_48ck460 FIND v(dout0_48) AT=470.05n

.meas tran vdout0_49ck460 FIND v(dout0_49) AT=470.05n

.meas tran vdout0_50ck460 FIND v(dout0_50) AT=470.05n

.meas tran vdout0_51ck460 FIND v(dout0_51) AT=470.05n

.meas tran vdout0_52ck460 FIND v(dout0_52) AT=470.05n

.meas tran vdout0_53ck460 FIND v(dout0_53) AT=470.05n

.meas tran vdout0_54ck460 FIND v(dout0_54) AT=470.05n

.meas tran vdout0_55ck460 FIND v(dout0_55) AT=470.05n

.meas tran vdout0_56ck460 FIND v(dout0_56) AT=470.05n

.meas tran vdout0_57ck460 FIND v(dout0_57) AT=470.05n

.meas tran vdout0_58ck460 FIND v(dout0_58) AT=470.05n

.meas tran vdout0_59ck460 FIND v(dout0_59) AT=470.05n

.meas tran vdout0_60ck460 FIND v(dout0_60) AT=470.05n

.meas tran vdout0_61ck460 FIND v(dout0_61) AT=470.05n

.meas tran vdout0_62ck460 FIND v(dout0_62) AT=470.05n

.meas tran vdout0_63ck460 FIND v(dout0_63) AT=470.05n

.meas tran vdout1_0ck460 FIND v(dout1_0) AT=470.05n

.meas tran vdout1_1ck460 FIND v(dout1_1) AT=470.05n

.meas tran vdout1_2ck460 FIND v(dout1_2) AT=470.05n

.meas tran vdout1_3ck460 FIND v(dout1_3) AT=470.05n

.meas tran vdout1_4ck460 FIND v(dout1_4) AT=470.05n

.meas tran vdout1_5ck460 FIND v(dout1_5) AT=470.05n

.meas tran vdout1_6ck460 FIND v(dout1_6) AT=470.05n

.meas tran vdout1_7ck460 FIND v(dout1_7) AT=470.05n

.meas tran vdout1_8ck460 FIND v(dout1_8) AT=470.05n

.meas tran vdout1_9ck460 FIND v(dout1_9) AT=470.05n

.meas tran vdout1_10ck460 FIND v(dout1_10) AT=470.05n

.meas tran vdout1_11ck460 FIND v(dout1_11) AT=470.05n

.meas tran vdout1_12ck460 FIND v(dout1_12) AT=470.05n

.meas tran vdout1_13ck460 FIND v(dout1_13) AT=470.05n

.meas tran vdout1_14ck460 FIND v(dout1_14) AT=470.05n

.meas tran vdout1_15ck460 FIND v(dout1_15) AT=470.05n

.meas tran vdout1_16ck460 FIND v(dout1_16) AT=470.05n

.meas tran vdout1_17ck460 FIND v(dout1_17) AT=470.05n

.meas tran vdout1_18ck460 FIND v(dout1_18) AT=470.05n

.meas tran vdout1_19ck460 FIND v(dout1_19) AT=470.05n

.meas tran vdout1_20ck460 FIND v(dout1_20) AT=470.05n

.meas tran vdout1_21ck460 FIND v(dout1_21) AT=470.05n

.meas tran vdout1_22ck460 FIND v(dout1_22) AT=470.05n

.meas tran vdout1_23ck460 FIND v(dout1_23) AT=470.05n

.meas tran vdout1_24ck460 FIND v(dout1_24) AT=470.05n

.meas tran vdout1_25ck460 FIND v(dout1_25) AT=470.05n

.meas tran vdout1_26ck460 FIND v(dout1_26) AT=470.05n

.meas tran vdout1_27ck460 FIND v(dout1_27) AT=470.05n

.meas tran vdout1_28ck460 FIND v(dout1_28) AT=470.05n

.meas tran vdout1_29ck460 FIND v(dout1_29) AT=470.05n

.meas tran vdout1_30ck460 FIND v(dout1_30) AT=470.05n

.meas tran vdout1_31ck460 FIND v(dout1_31) AT=470.05n

.meas tran vdout1_32ck460 FIND v(dout1_32) AT=470.05n

.meas tran vdout1_33ck460 FIND v(dout1_33) AT=470.05n

.meas tran vdout1_34ck460 FIND v(dout1_34) AT=470.05n

.meas tran vdout1_35ck460 FIND v(dout1_35) AT=470.05n

.meas tran vdout1_36ck460 FIND v(dout1_36) AT=470.05n

.meas tran vdout1_37ck460 FIND v(dout1_37) AT=470.05n

.meas tran vdout1_38ck460 FIND v(dout1_38) AT=470.05n

.meas tran vdout1_39ck460 FIND v(dout1_39) AT=470.05n

.meas tran vdout1_40ck460 FIND v(dout1_40) AT=470.05n

.meas tran vdout1_41ck460 FIND v(dout1_41) AT=470.05n

.meas tran vdout1_42ck460 FIND v(dout1_42) AT=470.05n

.meas tran vdout1_43ck460 FIND v(dout1_43) AT=470.05n

.meas tran vdout1_44ck460 FIND v(dout1_44) AT=470.05n

.meas tran vdout1_45ck460 FIND v(dout1_45) AT=470.05n

.meas tran vdout1_46ck460 FIND v(dout1_46) AT=470.05n

.meas tran vdout1_47ck460 FIND v(dout1_47) AT=470.05n

.meas tran vdout1_48ck460 FIND v(dout1_48) AT=470.05n

.meas tran vdout1_49ck460 FIND v(dout1_49) AT=470.05n

.meas tran vdout1_50ck460 FIND v(dout1_50) AT=470.05n

.meas tran vdout1_51ck460 FIND v(dout1_51) AT=470.05n

.meas tran vdout1_52ck460 FIND v(dout1_52) AT=470.05n

.meas tran vdout1_53ck460 FIND v(dout1_53) AT=470.05n

.meas tran vdout1_54ck460 FIND v(dout1_54) AT=470.05n

.meas tran vdout1_55ck460 FIND v(dout1_55) AT=470.05n

.meas tran vdout1_56ck460 FIND v(dout1_56) AT=470.05n

.meas tran vdout1_57ck460 FIND v(dout1_57) AT=470.05n

.meas tran vdout1_58ck460 FIND v(dout1_58) AT=470.05n

.meas tran vdout1_59ck460 FIND v(dout1_59) AT=470.05n

.meas tran vdout1_60ck460 FIND v(dout1_60) AT=470.05n

.meas tran vdout1_61ck460 FIND v(dout1_61) AT=470.05n

.meas tran vdout1_62ck460 FIND v(dout1_62) AT=470.05n

.meas tran vdout1_63ck460 FIND v(dout1_63) AT=470.05n

.meas tran vdout0_0ck480 FIND v(dout0_0) AT=490.05n

.meas tran vdout0_1ck480 FIND v(dout0_1) AT=490.05n

.meas tran vdout0_2ck480 FIND v(dout0_2) AT=490.05n

.meas tran vdout0_3ck480 FIND v(dout0_3) AT=490.05n

.meas tran vdout0_4ck480 FIND v(dout0_4) AT=490.05n

.meas tran vdout0_5ck480 FIND v(dout0_5) AT=490.05n

.meas tran vdout0_6ck480 FIND v(dout0_6) AT=490.05n

.meas tran vdout0_7ck480 FIND v(dout0_7) AT=490.05n

.meas tran vdout0_8ck480 FIND v(dout0_8) AT=490.05n

.meas tran vdout0_9ck480 FIND v(dout0_9) AT=490.05n

.meas tran vdout0_10ck480 FIND v(dout0_10) AT=490.05n

.meas tran vdout0_11ck480 FIND v(dout0_11) AT=490.05n

.meas tran vdout0_12ck480 FIND v(dout0_12) AT=490.05n

.meas tran vdout0_13ck480 FIND v(dout0_13) AT=490.05n

.meas tran vdout0_14ck480 FIND v(dout0_14) AT=490.05n

.meas tran vdout0_15ck480 FIND v(dout0_15) AT=490.05n

.meas tran vdout0_16ck480 FIND v(dout0_16) AT=490.05n

.meas tran vdout0_17ck480 FIND v(dout0_17) AT=490.05n

.meas tran vdout0_18ck480 FIND v(dout0_18) AT=490.05n

.meas tran vdout0_19ck480 FIND v(dout0_19) AT=490.05n

.meas tran vdout0_20ck480 FIND v(dout0_20) AT=490.05n

.meas tran vdout0_21ck480 FIND v(dout0_21) AT=490.05n

.meas tran vdout0_22ck480 FIND v(dout0_22) AT=490.05n

.meas tran vdout0_23ck480 FIND v(dout0_23) AT=490.05n

.meas tran vdout0_24ck480 FIND v(dout0_24) AT=490.05n

.meas tran vdout0_25ck480 FIND v(dout0_25) AT=490.05n

.meas tran vdout0_26ck480 FIND v(dout0_26) AT=490.05n

.meas tran vdout0_27ck480 FIND v(dout0_27) AT=490.05n

.meas tran vdout0_28ck480 FIND v(dout0_28) AT=490.05n

.meas tran vdout0_29ck480 FIND v(dout0_29) AT=490.05n

.meas tran vdout0_30ck480 FIND v(dout0_30) AT=490.05n

.meas tran vdout0_31ck480 FIND v(dout0_31) AT=490.05n

.meas tran vdout0_32ck480 FIND v(dout0_32) AT=490.05n

.meas tran vdout0_33ck480 FIND v(dout0_33) AT=490.05n

.meas tran vdout0_34ck480 FIND v(dout0_34) AT=490.05n

.meas tran vdout0_35ck480 FIND v(dout0_35) AT=490.05n

.meas tran vdout0_36ck480 FIND v(dout0_36) AT=490.05n

.meas tran vdout0_37ck480 FIND v(dout0_37) AT=490.05n

.meas tran vdout0_38ck480 FIND v(dout0_38) AT=490.05n

.meas tran vdout0_39ck480 FIND v(dout0_39) AT=490.05n

.meas tran vdout0_40ck480 FIND v(dout0_40) AT=490.05n

.meas tran vdout0_41ck480 FIND v(dout0_41) AT=490.05n

.meas tran vdout0_42ck480 FIND v(dout0_42) AT=490.05n

.meas tran vdout0_43ck480 FIND v(dout0_43) AT=490.05n

.meas tran vdout0_44ck480 FIND v(dout0_44) AT=490.05n

.meas tran vdout0_45ck480 FIND v(dout0_45) AT=490.05n

.meas tran vdout0_46ck480 FIND v(dout0_46) AT=490.05n

.meas tran vdout0_47ck480 FIND v(dout0_47) AT=490.05n

.meas tran vdout0_48ck480 FIND v(dout0_48) AT=490.05n

.meas tran vdout0_49ck480 FIND v(dout0_49) AT=490.05n

.meas tran vdout0_50ck480 FIND v(dout0_50) AT=490.05n

.meas tran vdout0_51ck480 FIND v(dout0_51) AT=490.05n

.meas tran vdout0_52ck480 FIND v(dout0_52) AT=490.05n

.meas tran vdout0_53ck480 FIND v(dout0_53) AT=490.05n

.meas tran vdout0_54ck480 FIND v(dout0_54) AT=490.05n

.meas tran vdout0_55ck480 FIND v(dout0_55) AT=490.05n

.meas tran vdout0_56ck480 FIND v(dout0_56) AT=490.05n

.meas tran vdout0_57ck480 FIND v(dout0_57) AT=490.05n

.meas tran vdout0_58ck480 FIND v(dout0_58) AT=490.05n

.meas tran vdout0_59ck480 FIND v(dout0_59) AT=490.05n

.meas tran vdout0_60ck480 FIND v(dout0_60) AT=490.05n

.meas tran vdout0_61ck480 FIND v(dout0_61) AT=490.05n

.meas tran vdout0_62ck480 FIND v(dout0_62) AT=490.05n

.meas tran vdout0_63ck480 FIND v(dout0_63) AT=490.05n

.meas tran vdout1_0ck490 FIND v(dout1_0) AT=500.05n

.meas tran vdout1_1ck490 FIND v(dout1_1) AT=500.05n

.meas tran vdout1_2ck490 FIND v(dout1_2) AT=500.05n

.meas tran vdout1_3ck490 FIND v(dout1_3) AT=500.05n

.meas tran vdout1_4ck490 FIND v(dout1_4) AT=500.05n

.meas tran vdout1_5ck490 FIND v(dout1_5) AT=500.05n

.meas tran vdout1_6ck490 FIND v(dout1_6) AT=500.05n

.meas tran vdout1_7ck490 FIND v(dout1_7) AT=500.05n

.meas tran vdout1_8ck490 FIND v(dout1_8) AT=500.05n

.meas tran vdout1_9ck490 FIND v(dout1_9) AT=500.05n

.meas tran vdout1_10ck490 FIND v(dout1_10) AT=500.05n

.meas tran vdout1_11ck490 FIND v(dout1_11) AT=500.05n

.meas tran vdout1_12ck490 FIND v(dout1_12) AT=500.05n

.meas tran vdout1_13ck490 FIND v(dout1_13) AT=500.05n

.meas tran vdout1_14ck490 FIND v(dout1_14) AT=500.05n

.meas tran vdout1_15ck490 FIND v(dout1_15) AT=500.05n

.meas tran vdout1_16ck490 FIND v(dout1_16) AT=500.05n

.meas tran vdout1_17ck490 FIND v(dout1_17) AT=500.05n

.meas tran vdout1_18ck490 FIND v(dout1_18) AT=500.05n

.meas tran vdout1_19ck490 FIND v(dout1_19) AT=500.05n

.meas tran vdout1_20ck490 FIND v(dout1_20) AT=500.05n

.meas tran vdout1_21ck490 FIND v(dout1_21) AT=500.05n

.meas tran vdout1_22ck490 FIND v(dout1_22) AT=500.05n

.meas tran vdout1_23ck490 FIND v(dout1_23) AT=500.05n

.meas tran vdout1_24ck490 FIND v(dout1_24) AT=500.05n

.meas tran vdout1_25ck490 FIND v(dout1_25) AT=500.05n

.meas tran vdout1_26ck490 FIND v(dout1_26) AT=500.05n

.meas tran vdout1_27ck490 FIND v(dout1_27) AT=500.05n

.meas tran vdout1_28ck490 FIND v(dout1_28) AT=500.05n

.meas tran vdout1_29ck490 FIND v(dout1_29) AT=500.05n

.meas tran vdout1_30ck490 FIND v(dout1_30) AT=500.05n

.meas tran vdout1_31ck490 FIND v(dout1_31) AT=500.05n

.meas tran vdout1_32ck490 FIND v(dout1_32) AT=500.05n

.meas tran vdout1_33ck490 FIND v(dout1_33) AT=500.05n

.meas tran vdout1_34ck490 FIND v(dout1_34) AT=500.05n

.meas tran vdout1_35ck490 FIND v(dout1_35) AT=500.05n

.meas tran vdout1_36ck490 FIND v(dout1_36) AT=500.05n

.meas tran vdout1_37ck490 FIND v(dout1_37) AT=500.05n

.meas tran vdout1_38ck490 FIND v(dout1_38) AT=500.05n

.meas tran vdout1_39ck490 FIND v(dout1_39) AT=500.05n

.meas tran vdout1_40ck490 FIND v(dout1_40) AT=500.05n

.meas tran vdout1_41ck490 FIND v(dout1_41) AT=500.05n

.meas tran vdout1_42ck490 FIND v(dout1_42) AT=500.05n

.meas tran vdout1_43ck490 FIND v(dout1_43) AT=500.05n

.meas tran vdout1_44ck490 FIND v(dout1_44) AT=500.05n

.meas tran vdout1_45ck490 FIND v(dout1_45) AT=500.05n

.meas tran vdout1_46ck490 FIND v(dout1_46) AT=500.05n

.meas tran vdout1_47ck490 FIND v(dout1_47) AT=500.05n

.meas tran vdout1_48ck490 FIND v(dout1_48) AT=500.05n

.meas tran vdout1_49ck490 FIND v(dout1_49) AT=500.05n

.meas tran vdout1_50ck490 FIND v(dout1_50) AT=500.05n

.meas tran vdout1_51ck490 FIND v(dout1_51) AT=500.05n

.meas tran vdout1_52ck490 FIND v(dout1_52) AT=500.05n

.meas tran vdout1_53ck490 FIND v(dout1_53) AT=500.05n

.meas tran vdout1_54ck490 FIND v(dout1_54) AT=500.05n

.meas tran vdout1_55ck490 FIND v(dout1_55) AT=500.05n

.meas tran vdout1_56ck490 FIND v(dout1_56) AT=500.05n

.meas tran vdout1_57ck490 FIND v(dout1_57) AT=500.05n

.meas tran vdout1_58ck490 FIND v(dout1_58) AT=500.05n

.meas tran vdout1_59ck490 FIND v(dout1_59) AT=500.05n

.meas tran vdout1_60ck490 FIND v(dout1_60) AT=500.05n

.meas tran vdout1_61ck490 FIND v(dout1_61) AT=500.05n

.meas tran vdout1_62ck490 FIND v(dout1_62) AT=500.05n

.meas tran vdout1_63ck490 FIND v(dout1_63) AT=500.05n

.meas tran vdout0_0ck500 FIND v(dout0_0) AT=510.05n

.meas tran vdout0_1ck500 FIND v(dout0_1) AT=510.05n

.meas tran vdout0_2ck500 FIND v(dout0_2) AT=510.05n

.meas tran vdout0_3ck500 FIND v(dout0_3) AT=510.05n

.meas tran vdout0_4ck500 FIND v(dout0_4) AT=510.05n

.meas tran vdout0_5ck500 FIND v(dout0_5) AT=510.05n

.meas tran vdout0_6ck500 FIND v(dout0_6) AT=510.05n

.meas tran vdout0_7ck500 FIND v(dout0_7) AT=510.05n

.meas tran vdout0_8ck500 FIND v(dout0_8) AT=510.05n

.meas tran vdout0_9ck500 FIND v(dout0_9) AT=510.05n

.meas tran vdout0_10ck500 FIND v(dout0_10) AT=510.05n

.meas tran vdout0_11ck500 FIND v(dout0_11) AT=510.05n

.meas tran vdout0_12ck500 FIND v(dout0_12) AT=510.05n

.meas tran vdout0_13ck500 FIND v(dout0_13) AT=510.05n

.meas tran vdout0_14ck500 FIND v(dout0_14) AT=510.05n

.meas tran vdout0_15ck500 FIND v(dout0_15) AT=510.05n

.meas tran vdout0_16ck500 FIND v(dout0_16) AT=510.05n

.meas tran vdout0_17ck500 FIND v(dout0_17) AT=510.05n

.meas tran vdout0_18ck500 FIND v(dout0_18) AT=510.05n

.meas tran vdout0_19ck500 FIND v(dout0_19) AT=510.05n

.meas tran vdout0_20ck500 FIND v(dout0_20) AT=510.05n

.meas tran vdout0_21ck500 FIND v(dout0_21) AT=510.05n

.meas tran vdout0_22ck500 FIND v(dout0_22) AT=510.05n

.meas tran vdout0_23ck500 FIND v(dout0_23) AT=510.05n

.meas tran vdout0_24ck500 FIND v(dout0_24) AT=510.05n

.meas tran vdout0_25ck500 FIND v(dout0_25) AT=510.05n

.meas tran vdout0_26ck500 FIND v(dout0_26) AT=510.05n

.meas tran vdout0_27ck500 FIND v(dout0_27) AT=510.05n

.meas tran vdout0_28ck500 FIND v(dout0_28) AT=510.05n

.meas tran vdout0_29ck500 FIND v(dout0_29) AT=510.05n

.meas tran vdout0_30ck500 FIND v(dout0_30) AT=510.05n

.meas tran vdout0_31ck500 FIND v(dout0_31) AT=510.05n

.meas tran vdout0_32ck500 FIND v(dout0_32) AT=510.05n

.meas tran vdout0_33ck500 FIND v(dout0_33) AT=510.05n

.meas tran vdout0_34ck500 FIND v(dout0_34) AT=510.05n

.meas tran vdout0_35ck500 FIND v(dout0_35) AT=510.05n

.meas tran vdout0_36ck500 FIND v(dout0_36) AT=510.05n

.meas tran vdout0_37ck500 FIND v(dout0_37) AT=510.05n

.meas tran vdout0_38ck500 FIND v(dout0_38) AT=510.05n

.meas tran vdout0_39ck500 FIND v(dout0_39) AT=510.05n

.meas tran vdout0_40ck500 FIND v(dout0_40) AT=510.05n

.meas tran vdout0_41ck500 FIND v(dout0_41) AT=510.05n

.meas tran vdout0_42ck500 FIND v(dout0_42) AT=510.05n

.meas tran vdout0_43ck500 FIND v(dout0_43) AT=510.05n

.meas tran vdout0_44ck500 FIND v(dout0_44) AT=510.05n

.meas tran vdout0_45ck500 FIND v(dout0_45) AT=510.05n

.meas tran vdout0_46ck500 FIND v(dout0_46) AT=510.05n

.meas tran vdout0_47ck500 FIND v(dout0_47) AT=510.05n

.meas tran vdout0_48ck500 FIND v(dout0_48) AT=510.05n

.meas tran vdout0_49ck500 FIND v(dout0_49) AT=510.05n

.meas tran vdout0_50ck500 FIND v(dout0_50) AT=510.05n

.meas tran vdout0_51ck500 FIND v(dout0_51) AT=510.05n

.meas tran vdout0_52ck500 FIND v(dout0_52) AT=510.05n

.meas tran vdout0_53ck500 FIND v(dout0_53) AT=510.05n

.meas tran vdout0_54ck500 FIND v(dout0_54) AT=510.05n

.meas tran vdout0_55ck500 FIND v(dout0_55) AT=510.05n

.meas tran vdout0_56ck500 FIND v(dout0_56) AT=510.05n

.meas tran vdout0_57ck500 FIND v(dout0_57) AT=510.05n

.meas tran vdout0_58ck500 FIND v(dout0_58) AT=510.05n

.meas tran vdout0_59ck500 FIND v(dout0_59) AT=510.05n

.meas tran vdout0_60ck500 FIND v(dout0_60) AT=510.05n

.meas tran vdout0_61ck500 FIND v(dout0_61) AT=510.05n

.meas tran vdout0_62ck500 FIND v(dout0_62) AT=510.05n

.meas tran vdout0_63ck500 FIND v(dout0_63) AT=510.05n

.meas tran vdout1_0ck500 FIND v(dout1_0) AT=510.05n

.meas tran vdout1_1ck500 FIND v(dout1_1) AT=510.05n

.meas tran vdout1_2ck500 FIND v(dout1_2) AT=510.05n

.meas tran vdout1_3ck500 FIND v(dout1_3) AT=510.05n

.meas tran vdout1_4ck500 FIND v(dout1_4) AT=510.05n

.meas tran vdout1_5ck500 FIND v(dout1_5) AT=510.05n

.meas tran vdout1_6ck500 FIND v(dout1_6) AT=510.05n

.meas tran vdout1_7ck500 FIND v(dout1_7) AT=510.05n

.meas tran vdout1_8ck500 FIND v(dout1_8) AT=510.05n

.meas tran vdout1_9ck500 FIND v(dout1_9) AT=510.05n

.meas tran vdout1_10ck500 FIND v(dout1_10) AT=510.05n

.meas tran vdout1_11ck500 FIND v(dout1_11) AT=510.05n

.meas tran vdout1_12ck500 FIND v(dout1_12) AT=510.05n

.meas tran vdout1_13ck500 FIND v(dout1_13) AT=510.05n

.meas tran vdout1_14ck500 FIND v(dout1_14) AT=510.05n

.meas tran vdout1_15ck500 FIND v(dout1_15) AT=510.05n

.meas tran vdout1_16ck500 FIND v(dout1_16) AT=510.05n

.meas tran vdout1_17ck500 FIND v(dout1_17) AT=510.05n

.meas tran vdout1_18ck500 FIND v(dout1_18) AT=510.05n

.meas tran vdout1_19ck500 FIND v(dout1_19) AT=510.05n

.meas tran vdout1_20ck500 FIND v(dout1_20) AT=510.05n

.meas tran vdout1_21ck500 FIND v(dout1_21) AT=510.05n

.meas tran vdout1_22ck500 FIND v(dout1_22) AT=510.05n

.meas tran vdout1_23ck500 FIND v(dout1_23) AT=510.05n

.meas tran vdout1_24ck500 FIND v(dout1_24) AT=510.05n

.meas tran vdout1_25ck500 FIND v(dout1_25) AT=510.05n

.meas tran vdout1_26ck500 FIND v(dout1_26) AT=510.05n

.meas tran vdout1_27ck500 FIND v(dout1_27) AT=510.05n

.meas tran vdout1_28ck500 FIND v(dout1_28) AT=510.05n

.meas tran vdout1_29ck500 FIND v(dout1_29) AT=510.05n

.meas tran vdout1_30ck500 FIND v(dout1_30) AT=510.05n

.meas tran vdout1_31ck500 FIND v(dout1_31) AT=510.05n

.meas tran vdout1_32ck500 FIND v(dout1_32) AT=510.05n

.meas tran vdout1_33ck500 FIND v(dout1_33) AT=510.05n

.meas tran vdout1_34ck500 FIND v(dout1_34) AT=510.05n

.meas tran vdout1_35ck500 FIND v(dout1_35) AT=510.05n

.meas tran vdout1_36ck500 FIND v(dout1_36) AT=510.05n

.meas tran vdout1_37ck500 FIND v(dout1_37) AT=510.05n

.meas tran vdout1_38ck500 FIND v(dout1_38) AT=510.05n

.meas tran vdout1_39ck500 FIND v(dout1_39) AT=510.05n

.meas tran vdout1_40ck500 FIND v(dout1_40) AT=510.05n

.meas tran vdout1_41ck500 FIND v(dout1_41) AT=510.05n

.meas tran vdout1_42ck500 FIND v(dout1_42) AT=510.05n

.meas tran vdout1_43ck500 FIND v(dout1_43) AT=510.05n

.meas tran vdout1_44ck500 FIND v(dout1_44) AT=510.05n

.meas tran vdout1_45ck500 FIND v(dout1_45) AT=510.05n

.meas tran vdout1_46ck500 FIND v(dout1_46) AT=510.05n

.meas tran vdout1_47ck500 FIND v(dout1_47) AT=510.05n

.meas tran vdout1_48ck500 FIND v(dout1_48) AT=510.05n

.meas tran vdout1_49ck500 FIND v(dout1_49) AT=510.05n

.meas tran vdout1_50ck500 FIND v(dout1_50) AT=510.05n

.meas tran vdout1_51ck500 FIND v(dout1_51) AT=510.05n

.meas tran vdout1_52ck500 FIND v(dout1_52) AT=510.05n

.meas tran vdout1_53ck500 FIND v(dout1_53) AT=510.05n

.meas tran vdout1_54ck500 FIND v(dout1_54) AT=510.05n

.meas tran vdout1_55ck500 FIND v(dout1_55) AT=510.05n

.meas tran vdout1_56ck500 FIND v(dout1_56) AT=510.05n

.meas tran vdout1_57ck500 FIND v(dout1_57) AT=510.05n

.meas tran vdout1_58ck500 FIND v(dout1_58) AT=510.05n

.meas tran vdout1_59ck500 FIND v(dout1_59) AT=510.05n

.meas tran vdout1_60ck500 FIND v(dout1_60) AT=510.05n

.meas tran vdout1_61ck500 FIND v(dout1_61) AT=510.05n

.meas tran vdout1_62ck500 FIND v(dout1_62) AT=510.05n

.meas tran vdout1_63ck500 FIND v(dout1_63) AT=510.05n

.meas tran vdout0_0ck510 FIND v(dout0_0) AT=520.05n

.meas tran vdout0_1ck510 FIND v(dout0_1) AT=520.05n

.meas tran vdout0_2ck510 FIND v(dout0_2) AT=520.05n

.meas tran vdout0_3ck510 FIND v(dout0_3) AT=520.05n

.meas tran vdout0_4ck510 FIND v(dout0_4) AT=520.05n

.meas tran vdout0_5ck510 FIND v(dout0_5) AT=520.05n

.meas tran vdout0_6ck510 FIND v(dout0_6) AT=520.05n

.meas tran vdout0_7ck510 FIND v(dout0_7) AT=520.05n

.meas tran vdout0_8ck510 FIND v(dout0_8) AT=520.05n

.meas tran vdout0_9ck510 FIND v(dout0_9) AT=520.05n

.meas tran vdout0_10ck510 FIND v(dout0_10) AT=520.05n

.meas tran vdout0_11ck510 FIND v(dout0_11) AT=520.05n

.meas tran vdout0_12ck510 FIND v(dout0_12) AT=520.05n

.meas tran vdout0_13ck510 FIND v(dout0_13) AT=520.05n

.meas tran vdout0_14ck510 FIND v(dout0_14) AT=520.05n

.meas tran vdout0_15ck510 FIND v(dout0_15) AT=520.05n

.meas tran vdout0_16ck510 FIND v(dout0_16) AT=520.05n

.meas tran vdout0_17ck510 FIND v(dout0_17) AT=520.05n

.meas tran vdout0_18ck510 FIND v(dout0_18) AT=520.05n

.meas tran vdout0_19ck510 FIND v(dout0_19) AT=520.05n

.meas tran vdout0_20ck510 FIND v(dout0_20) AT=520.05n

.meas tran vdout0_21ck510 FIND v(dout0_21) AT=520.05n

.meas tran vdout0_22ck510 FIND v(dout0_22) AT=520.05n

.meas tran vdout0_23ck510 FIND v(dout0_23) AT=520.05n

.meas tran vdout0_24ck510 FIND v(dout0_24) AT=520.05n

.meas tran vdout0_25ck510 FIND v(dout0_25) AT=520.05n

.meas tran vdout0_26ck510 FIND v(dout0_26) AT=520.05n

.meas tran vdout0_27ck510 FIND v(dout0_27) AT=520.05n

.meas tran vdout0_28ck510 FIND v(dout0_28) AT=520.05n

.meas tran vdout0_29ck510 FIND v(dout0_29) AT=520.05n

.meas tran vdout0_30ck510 FIND v(dout0_30) AT=520.05n

.meas tran vdout0_31ck510 FIND v(dout0_31) AT=520.05n

.meas tran vdout0_32ck510 FIND v(dout0_32) AT=520.05n

.meas tran vdout0_33ck510 FIND v(dout0_33) AT=520.05n

.meas tran vdout0_34ck510 FIND v(dout0_34) AT=520.05n

.meas tran vdout0_35ck510 FIND v(dout0_35) AT=520.05n

.meas tran vdout0_36ck510 FIND v(dout0_36) AT=520.05n

.meas tran vdout0_37ck510 FIND v(dout0_37) AT=520.05n

.meas tran vdout0_38ck510 FIND v(dout0_38) AT=520.05n

.meas tran vdout0_39ck510 FIND v(dout0_39) AT=520.05n

.meas tran vdout0_40ck510 FIND v(dout0_40) AT=520.05n

.meas tran vdout0_41ck510 FIND v(dout0_41) AT=520.05n

.meas tran vdout0_42ck510 FIND v(dout0_42) AT=520.05n

.meas tran vdout0_43ck510 FIND v(dout0_43) AT=520.05n

.meas tran vdout0_44ck510 FIND v(dout0_44) AT=520.05n

.meas tran vdout0_45ck510 FIND v(dout0_45) AT=520.05n

.meas tran vdout0_46ck510 FIND v(dout0_46) AT=520.05n

.meas tran vdout0_47ck510 FIND v(dout0_47) AT=520.05n

.meas tran vdout0_48ck510 FIND v(dout0_48) AT=520.05n

.meas tran vdout0_49ck510 FIND v(dout0_49) AT=520.05n

.meas tran vdout0_50ck510 FIND v(dout0_50) AT=520.05n

.meas tran vdout0_51ck510 FIND v(dout0_51) AT=520.05n

.meas tran vdout0_52ck510 FIND v(dout0_52) AT=520.05n

.meas tran vdout0_53ck510 FIND v(dout0_53) AT=520.05n

.meas tran vdout0_54ck510 FIND v(dout0_54) AT=520.05n

.meas tran vdout0_55ck510 FIND v(dout0_55) AT=520.05n

.meas tran vdout0_56ck510 FIND v(dout0_56) AT=520.05n

.meas tran vdout0_57ck510 FIND v(dout0_57) AT=520.05n

.meas tran vdout0_58ck510 FIND v(dout0_58) AT=520.05n

.meas tran vdout0_59ck510 FIND v(dout0_59) AT=520.05n

.meas tran vdout0_60ck510 FIND v(dout0_60) AT=520.05n

.meas tran vdout0_61ck510 FIND v(dout0_61) AT=520.05n

.meas tran vdout0_62ck510 FIND v(dout0_62) AT=520.05n

.meas tran vdout0_63ck510 FIND v(dout0_63) AT=520.05n

.meas tran vdout1_0ck520 FIND v(dout1_0) AT=530.05n

.meas tran vdout1_1ck520 FIND v(dout1_1) AT=530.05n

.meas tran vdout1_2ck520 FIND v(dout1_2) AT=530.05n

.meas tran vdout1_3ck520 FIND v(dout1_3) AT=530.05n

.meas tran vdout1_4ck520 FIND v(dout1_4) AT=530.05n

.meas tran vdout1_5ck520 FIND v(dout1_5) AT=530.05n

.meas tran vdout1_6ck520 FIND v(dout1_6) AT=530.05n

.meas tran vdout1_7ck520 FIND v(dout1_7) AT=530.05n

.meas tran vdout1_8ck520 FIND v(dout1_8) AT=530.05n

.meas tran vdout1_9ck520 FIND v(dout1_9) AT=530.05n

.meas tran vdout1_10ck520 FIND v(dout1_10) AT=530.05n

.meas tran vdout1_11ck520 FIND v(dout1_11) AT=530.05n

.meas tran vdout1_12ck520 FIND v(dout1_12) AT=530.05n

.meas tran vdout1_13ck520 FIND v(dout1_13) AT=530.05n

.meas tran vdout1_14ck520 FIND v(dout1_14) AT=530.05n

.meas tran vdout1_15ck520 FIND v(dout1_15) AT=530.05n

.meas tran vdout1_16ck520 FIND v(dout1_16) AT=530.05n

.meas tran vdout1_17ck520 FIND v(dout1_17) AT=530.05n

.meas tran vdout1_18ck520 FIND v(dout1_18) AT=530.05n

.meas tran vdout1_19ck520 FIND v(dout1_19) AT=530.05n

.meas tran vdout1_20ck520 FIND v(dout1_20) AT=530.05n

.meas tran vdout1_21ck520 FIND v(dout1_21) AT=530.05n

.meas tran vdout1_22ck520 FIND v(dout1_22) AT=530.05n

.meas tran vdout1_23ck520 FIND v(dout1_23) AT=530.05n

.meas tran vdout1_24ck520 FIND v(dout1_24) AT=530.05n

.meas tran vdout1_25ck520 FIND v(dout1_25) AT=530.05n

.meas tran vdout1_26ck520 FIND v(dout1_26) AT=530.05n

.meas tran vdout1_27ck520 FIND v(dout1_27) AT=530.05n

.meas tran vdout1_28ck520 FIND v(dout1_28) AT=530.05n

.meas tran vdout1_29ck520 FIND v(dout1_29) AT=530.05n

.meas tran vdout1_30ck520 FIND v(dout1_30) AT=530.05n

.meas tran vdout1_31ck520 FIND v(dout1_31) AT=530.05n

.meas tran vdout1_32ck520 FIND v(dout1_32) AT=530.05n

.meas tran vdout1_33ck520 FIND v(dout1_33) AT=530.05n

.meas tran vdout1_34ck520 FIND v(dout1_34) AT=530.05n

.meas tran vdout1_35ck520 FIND v(dout1_35) AT=530.05n

.meas tran vdout1_36ck520 FIND v(dout1_36) AT=530.05n

.meas tran vdout1_37ck520 FIND v(dout1_37) AT=530.05n

.meas tran vdout1_38ck520 FIND v(dout1_38) AT=530.05n

.meas tran vdout1_39ck520 FIND v(dout1_39) AT=530.05n

.meas tran vdout1_40ck520 FIND v(dout1_40) AT=530.05n

.meas tran vdout1_41ck520 FIND v(dout1_41) AT=530.05n

.meas tran vdout1_42ck520 FIND v(dout1_42) AT=530.05n

.meas tran vdout1_43ck520 FIND v(dout1_43) AT=530.05n

.meas tran vdout1_44ck520 FIND v(dout1_44) AT=530.05n

.meas tran vdout1_45ck520 FIND v(dout1_45) AT=530.05n

.meas tran vdout1_46ck520 FIND v(dout1_46) AT=530.05n

.meas tran vdout1_47ck520 FIND v(dout1_47) AT=530.05n

.meas tran vdout1_48ck520 FIND v(dout1_48) AT=530.05n

.meas tran vdout1_49ck520 FIND v(dout1_49) AT=530.05n

.meas tran vdout1_50ck520 FIND v(dout1_50) AT=530.05n

.meas tran vdout1_51ck520 FIND v(dout1_51) AT=530.05n

.meas tran vdout1_52ck520 FIND v(dout1_52) AT=530.05n

.meas tran vdout1_53ck520 FIND v(dout1_53) AT=530.05n

.meas tran vdout1_54ck520 FIND v(dout1_54) AT=530.05n

.meas tran vdout1_55ck520 FIND v(dout1_55) AT=530.05n

.meas tran vdout1_56ck520 FIND v(dout1_56) AT=530.05n

.meas tran vdout1_57ck520 FIND v(dout1_57) AT=530.05n

.meas tran vdout1_58ck520 FIND v(dout1_58) AT=530.05n

.meas tran vdout1_59ck520 FIND v(dout1_59) AT=530.05n

.meas tran vdout1_60ck520 FIND v(dout1_60) AT=530.05n

.meas tran vdout1_61ck520 FIND v(dout1_61) AT=530.05n

.meas tran vdout1_62ck520 FIND v(dout1_62) AT=530.05n

.meas tran vdout1_63ck520 FIND v(dout1_63) AT=530.05n

.meas tran vdout0_0ck530 FIND v(dout0_0) AT=540.05n

.meas tran vdout0_1ck530 FIND v(dout0_1) AT=540.05n

.meas tran vdout0_2ck530 FIND v(dout0_2) AT=540.05n

.meas tran vdout0_3ck530 FIND v(dout0_3) AT=540.05n

.meas tran vdout0_4ck530 FIND v(dout0_4) AT=540.05n

.meas tran vdout0_5ck530 FIND v(dout0_5) AT=540.05n

.meas tran vdout0_6ck530 FIND v(dout0_6) AT=540.05n

.meas tran vdout0_7ck530 FIND v(dout0_7) AT=540.05n

.meas tran vdout0_8ck530 FIND v(dout0_8) AT=540.05n

.meas tran vdout0_9ck530 FIND v(dout0_9) AT=540.05n

.meas tran vdout0_10ck530 FIND v(dout0_10) AT=540.05n

.meas tran vdout0_11ck530 FIND v(dout0_11) AT=540.05n

.meas tran vdout0_12ck530 FIND v(dout0_12) AT=540.05n

.meas tran vdout0_13ck530 FIND v(dout0_13) AT=540.05n

.meas tran vdout0_14ck530 FIND v(dout0_14) AT=540.05n

.meas tran vdout0_15ck530 FIND v(dout0_15) AT=540.05n

.meas tran vdout0_16ck530 FIND v(dout0_16) AT=540.05n

.meas tran vdout0_17ck530 FIND v(dout0_17) AT=540.05n

.meas tran vdout0_18ck530 FIND v(dout0_18) AT=540.05n

.meas tran vdout0_19ck530 FIND v(dout0_19) AT=540.05n

.meas tran vdout0_20ck530 FIND v(dout0_20) AT=540.05n

.meas tran vdout0_21ck530 FIND v(dout0_21) AT=540.05n

.meas tran vdout0_22ck530 FIND v(dout0_22) AT=540.05n

.meas tran vdout0_23ck530 FIND v(dout0_23) AT=540.05n

.meas tran vdout0_24ck530 FIND v(dout0_24) AT=540.05n

.meas tran vdout0_25ck530 FIND v(dout0_25) AT=540.05n

.meas tran vdout0_26ck530 FIND v(dout0_26) AT=540.05n

.meas tran vdout0_27ck530 FIND v(dout0_27) AT=540.05n

.meas tran vdout0_28ck530 FIND v(dout0_28) AT=540.05n

.meas tran vdout0_29ck530 FIND v(dout0_29) AT=540.05n

.meas tran vdout0_30ck530 FIND v(dout0_30) AT=540.05n

.meas tran vdout0_31ck530 FIND v(dout0_31) AT=540.05n

.meas tran vdout0_32ck530 FIND v(dout0_32) AT=540.05n

.meas tran vdout0_33ck530 FIND v(dout0_33) AT=540.05n

.meas tran vdout0_34ck530 FIND v(dout0_34) AT=540.05n

.meas tran vdout0_35ck530 FIND v(dout0_35) AT=540.05n

.meas tran vdout0_36ck530 FIND v(dout0_36) AT=540.05n

.meas tran vdout0_37ck530 FIND v(dout0_37) AT=540.05n

.meas tran vdout0_38ck530 FIND v(dout0_38) AT=540.05n

.meas tran vdout0_39ck530 FIND v(dout0_39) AT=540.05n

.meas tran vdout0_40ck530 FIND v(dout0_40) AT=540.05n

.meas tran vdout0_41ck530 FIND v(dout0_41) AT=540.05n

.meas tran vdout0_42ck530 FIND v(dout0_42) AT=540.05n

.meas tran vdout0_43ck530 FIND v(dout0_43) AT=540.05n

.meas tran vdout0_44ck530 FIND v(dout0_44) AT=540.05n

.meas tran vdout0_45ck530 FIND v(dout0_45) AT=540.05n

.meas tran vdout0_46ck530 FIND v(dout0_46) AT=540.05n

.meas tran vdout0_47ck530 FIND v(dout0_47) AT=540.05n

.meas tran vdout0_48ck530 FIND v(dout0_48) AT=540.05n

.meas tran vdout0_49ck530 FIND v(dout0_49) AT=540.05n

.meas tran vdout0_50ck530 FIND v(dout0_50) AT=540.05n

.meas tran vdout0_51ck530 FIND v(dout0_51) AT=540.05n

.meas tran vdout0_52ck530 FIND v(dout0_52) AT=540.05n

.meas tran vdout0_53ck530 FIND v(dout0_53) AT=540.05n

.meas tran vdout0_54ck530 FIND v(dout0_54) AT=540.05n

.meas tran vdout0_55ck530 FIND v(dout0_55) AT=540.05n

.meas tran vdout0_56ck530 FIND v(dout0_56) AT=540.05n

.meas tran vdout0_57ck530 FIND v(dout0_57) AT=540.05n

.meas tran vdout0_58ck530 FIND v(dout0_58) AT=540.05n

.meas tran vdout0_59ck530 FIND v(dout0_59) AT=540.05n

.meas tran vdout0_60ck530 FIND v(dout0_60) AT=540.05n

.meas tran vdout0_61ck530 FIND v(dout0_61) AT=540.05n

.meas tran vdout0_62ck530 FIND v(dout0_62) AT=540.05n

.meas tran vdout0_63ck530 FIND v(dout0_63) AT=540.05n

.meas tran vdout1_0ck560 FIND v(dout1_0) AT=570.05n

.meas tran vdout1_1ck560 FIND v(dout1_1) AT=570.05n

.meas tran vdout1_2ck560 FIND v(dout1_2) AT=570.05n

.meas tran vdout1_3ck560 FIND v(dout1_3) AT=570.05n

.meas tran vdout1_4ck560 FIND v(dout1_4) AT=570.05n

.meas tran vdout1_5ck560 FIND v(dout1_5) AT=570.05n

.meas tran vdout1_6ck560 FIND v(dout1_6) AT=570.05n

.meas tran vdout1_7ck560 FIND v(dout1_7) AT=570.05n

.meas tran vdout1_8ck560 FIND v(dout1_8) AT=570.05n

.meas tran vdout1_9ck560 FIND v(dout1_9) AT=570.05n

.meas tran vdout1_10ck560 FIND v(dout1_10) AT=570.05n

.meas tran vdout1_11ck560 FIND v(dout1_11) AT=570.05n

.meas tran vdout1_12ck560 FIND v(dout1_12) AT=570.05n

.meas tran vdout1_13ck560 FIND v(dout1_13) AT=570.05n

.meas tran vdout1_14ck560 FIND v(dout1_14) AT=570.05n

.meas tran vdout1_15ck560 FIND v(dout1_15) AT=570.05n

.meas tran vdout1_16ck560 FIND v(dout1_16) AT=570.05n

.meas tran vdout1_17ck560 FIND v(dout1_17) AT=570.05n

.meas tran vdout1_18ck560 FIND v(dout1_18) AT=570.05n

.meas tran vdout1_19ck560 FIND v(dout1_19) AT=570.05n

.meas tran vdout1_20ck560 FIND v(dout1_20) AT=570.05n

.meas tran vdout1_21ck560 FIND v(dout1_21) AT=570.05n

.meas tran vdout1_22ck560 FIND v(dout1_22) AT=570.05n

.meas tran vdout1_23ck560 FIND v(dout1_23) AT=570.05n

.meas tran vdout1_24ck560 FIND v(dout1_24) AT=570.05n

.meas tran vdout1_25ck560 FIND v(dout1_25) AT=570.05n

.meas tran vdout1_26ck560 FIND v(dout1_26) AT=570.05n

.meas tran vdout1_27ck560 FIND v(dout1_27) AT=570.05n

.meas tran vdout1_28ck560 FIND v(dout1_28) AT=570.05n

.meas tran vdout1_29ck560 FIND v(dout1_29) AT=570.05n

.meas tran vdout1_30ck560 FIND v(dout1_30) AT=570.05n

.meas tran vdout1_31ck560 FIND v(dout1_31) AT=570.05n

.meas tran vdout1_32ck560 FIND v(dout1_32) AT=570.05n

.meas tran vdout1_33ck560 FIND v(dout1_33) AT=570.05n

.meas tran vdout1_34ck560 FIND v(dout1_34) AT=570.05n

.meas tran vdout1_35ck560 FIND v(dout1_35) AT=570.05n

.meas tran vdout1_36ck560 FIND v(dout1_36) AT=570.05n

.meas tran vdout1_37ck560 FIND v(dout1_37) AT=570.05n

.meas tran vdout1_38ck560 FIND v(dout1_38) AT=570.05n

.meas tran vdout1_39ck560 FIND v(dout1_39) AT=570.05n

.meas tran vdout1_40ck560 FIND v(dout1_40) AT=570.05n

.meas tran vdout1_41ck560 FIND v(dout1_41) AT=570.05n

.meas tran vdout1_42ck560 FIND v(dout1_42) AT=570.05n

.meas tran vdout1_43ck560 FIND v(dout1_43) AT=570.05n

.meas tran vdout1_44ck560 FIND v(dout1_44) AT=570.05n

.meas tran vdout1_45ck560 FIND v(dout1_45) AT=570.05n

.meas tran vdout1_46ck560 FIND v(dout1_46) AT=570.05n

.meas tran vdout1_47ck560 FIND v(dout1_47) AT=570.05n

.meas tran vdout1_48ck560 FIND v(dout1_48) AT=570.05n

.meas tran vdout1_49ck560 FIND v(dout1_49) AT=570.05n

.meas tran vdout1_50ck560 FIND v(dout1_50) AT=570.05n

.meas tran vdout1_51ck560 FIND v(dout1_51) AT=570.05n

.meas tran vdout1_52ck560 FIND v(dout1_52) AT=570.05n

.meas tran vdout1_53ck560 FIND v(dout1_53) AT=570.05n

.meas tran vdout1_54ck560 FIND v(dout1_54) AT=570.05n

.meas tran vdout1_55ck560 FIND v(dout1_55) AT=570.05n

.meas tran vdout1_56ck560 FIND v(dout1_56) AT=570.05n

.meas tran vdout1_57ck560 FIND v(dout1_57) AT=570.05n

.meas tran vdout1_58ck560 FIND v(dout1_58) AT=570.05n

.meas tran vdout1_59ck560 FIND v(dout1_59) AT=570.05n

.meas tran vdout1_60ck560 FIND v(dout1_60) AT=570.05n

.meas tran vdout1_61ck560 FIND v(dout1_61) AT=570.05n

.meas tran vdout1_62ck560 FIND v(dout1_62) AT=570.05n

.meas tran vdout1_63ck560 FIND v(dout1_63) AT=570.05n

.meas tran vdout1_0ck570 FIND v(dout1_0) AT=580.05n

.meas tran vdout1_1ck570 FIND v(dout1_1) AT=580.05n

.meas tran vdout1_2ck570 FIND v(dout1_2) AT=580.05n

.meas tran vdout1_3ck570 FIND v(dout1_3) AT=580.05n

.meas tran vdout1_4ck570 FIND v(dout1_4) AT=580.05n

.meas tran vdout1_5ck570 FIND v(dout1_5) AT=580.05n

.meas tran vdout1_6ck570 FIND v(dout1_6) AT=580.05n

.meas tran vdout1_7ck570 FIND v(dout1_7) AT=580.05n

.meas tran vdout1_8ck570 FIND v(dout1_8) AT=580.05n

.meas tran vdout1_9ck570 FIND v(dout1_9) AT=580.05n

.meas tran vdout1_10ck570 FIND v(dout1_10) AT=580.05n

.meas tran vdout1_11ck570 FIND v(dout1_11) AT=580.05n

.meas tran vdout1_12ck570 FIND v(dout1_12) AT=580.05n

.meas tran vdout1_13ck570 FIND v(dout1_13) AT=580.05n

.meas tran vdout1_14ck570 FIND v(dout1_14) AT=580.05n

.meas tran vdout1_15ck570 FIND v(dout1_15) AT=580.05n

.meas tran vdout1_16ck570 FIND v(dout1_16) AT=580.05n

.meas tran vdout1_17ck570 FIND v(dout1_17) AT=580.05n

.meas tran vdout1_18ck570 FIND v(dout1_18) AT=580.05n

.meas tran vdout1_19ck570 FIND v(dout1_19) AT=580.05n

.meas tran vdout1_20ck570 FIND v(dout1_20) AT=580.05n

.meas tran vdout1_21ck570 FIND v(dout1_21) AT=580.05n

.meas tran vdout1_22ck570 FIND v(dout1_22) AT=580.05n

.meas tran vdout1_23ck570 FIND v(dout1_23) AT=580.05n

.meas tran vdout1_24ck570 FIND v(dout1_24) AT=580.05n

.meas tran vdout1_25ck570 FIND v(dout1_25) AT=580.05n

.meas tran vdout1_26ck570 FIND v(dout1_26) AT=580.05n

.meas tran vdout1_27ck570 FIND v(dout1_27) AT=580.05n

.meas tran vdout1_28ck570 FIND v(dout1_28) AT=580.05n

.meas tran vdout1_29ck570 FIND v(dout1_29) AT=580.05n

.meas tran vdout1_30ck570 FIND v(dout1_30) AT=580.05n

.meas tran vdout1_31ck570 FIND v(dout1_31) AT=580.05n

.meas tran vdout1_32ck570 FIND v(dout1_32) AT=580.05n

.meas tran vdout1_33ck570 FIND v(dout1_33) AT=580.05n

.meas tran vdout1_34ck570 FIND v(dout1_34) AT=580.05n

.meas tran vdout1_35ck570 FIND v(dout1_35) AT=580.05n

.meas tran vdout1_36ck570 FIND v(dout1_36) AT=580.05n

.meas tran vdout1_37ck570 FIND v(dout1_37) AT=580.05n

.meas tran vdout1_38ck570 FIND v(dout1_38) AT=580.05n

.meas tran vdout1_39ck570 FIND v(dout1_39) AT=580.05n

.meas tran vdout1_40ck570 FIND v(dout1_40) AT=580.05n

.meas tran vdout1_41ck570 FIND v(dout1_41) AT=580.05n

.meas tran vdout1_42ck570 FIND v(dout1_42) AT=580.05n

.meas tran vdout1_43ck570 FIND v(dout1_43) AT=580.05n

.meas tran vdout1_44ck570 FIND v(dout1_44) AT=580.05n

.meas tran vdout1_45ck570 FIND v(dout1_45) AT=580.05n

.meas tran vdout1_46ck570 FIND v(dout1_46) AT=580.05n

.meas tran vdout1_47ck570 FIND v(dout1_47) AT=580.05n

.meas tran vdout1_48ck570 FIND v(dout1_48) AT=580.05n

.meas tran vdout1_49ck570 FIND v(dout1_49) AT=580.05n

.meas tran vdout1_50ck570 FIND v(dout1_50) AT=580.05n

.meas tran vdout1_51ck570 FIND v(dout1_51) AT=580.05n

.meas tran vdout1_52ck570 FIND v(dout1_52) AT=580.05n

.meas tran vdout1_53ck570 FIND v(dout1_53) AT=580.05n

.meas tran vdout1_54ck570 FIND v(dout1_54) AT=580.05n

.meas tran vdout1_55ck570 FIND v(dout1_55) AT=580.05n

.meas tran vdout1_56ck570 FIND v(dout1_56) AT=580.05n

.meas tran vdout1_57ck570 FIND v(dout1_57) AT=580.05n

.meas tran vdout1_58ck570 FIND v(dout1_58) AT=580.05n

.meas tran vdout1_59ck570 FIND v(dout1_59) AT=580.05n

.meas tran vdout1_60ck570 FIND v(dout1_60) AT=580.05n

.meas tran vdout1_61ck570 FIND v(dout1_61) AT=580.05n

.meas tran vdout1_62ck570 FIND v(dout1_62) AT=580.05n

.meas tran vdout1_63ck570 FIND v(dout1_63) AT=580.05n

.meas tran vdout0_0ck590 FIND v(dout0_0) AT=600.05n

.meas tran vdout0_1ck590 FIND v(dout0_1) AT=600.05n

.meas tran vdout0_2ck590 FIND v(dout0_2) AT=600.05n

.meas tran vdout0_3ck590 FIND v(dout0_3) AT=600.05n

.meas tran vdout0_4ck590 FIND v(dout0_4) AT=600.05n

.meas tran vdout0_5ck590 FIND v(dout0_5) AT=600.05n

.meas tran vdout0_6ck590 FIND v(dout0_6) AT=600.05n

.meas tran vdout0_7ck590 FIND v(dout0_7) AT=600.05n

.meas tran vdout0_8ck590 FIND v(dout0_8) AT=600.05n

.meas tran vdout0_9ck590 FIND v(dout0_9) AT=600.05n

.meas tran vdout0_10ck590 FIND v(dout0_10) AT=600.05n

.meas tran vdout0_11ck590 FIND v(dout0_11) AT=600.05n

.meas tran vdout0_12ck590 FIND v(dout0_12) AT=600.05n

.meas tran vdout0_13ck590 FIND v(dout0_13) AT=600.05n

.meas tran vdout0_14ck590 FIND v(dout0_14) AT=600.05n

.meas tran vdout0_15ck590 FIND v(dout0_15) AT=600.05n

.meas tran vdout0_16ck590 FIND v(dout0_16) AT=600.05n

.meas tran vdout0_17ck590 FIND v(dout0_17) AT=600.05n

.meas tran vdout0_18ck590 FIND v(dout0_18) AT=600.05n

.meas tran vdout0_19ck590 FIND v(dout0_19) AT=600.05n

.meas tran vdout0_20ck590 FIND v(dout0_20) AT=600.05n

.meas tran vdout0_21ck590 FIND v(dout0_21) AT=600.05n

.meas tran vdout0_22ck590 FIND v(dout0_22) AT=600.05n

.meas tran vdout0_23ck590 FIND v(dout0_23) AT=600.05n

.meas tran vdout0_24ck590 FIND v(dout0_24) AT=600.05n

.meas tran vdout0_25ck590 FIND v(dout0_25) AT=600.05n

.meas tran vdout0_26ck590 FIND v(dout0_26) AT=600.05n

.meas tran vdout0_27ck590 FIND v(dout0_27) AT=600.05n

.meas tran vdout0_28ck590 FIND v(dout0_28) AT=600.05n

.meas tran vdout0_29ck590 FIND v(dout0_29) AT=600.05n

.meas tran vdout0_30ck590 FIND v(dout0_30) AT=600.05n

.meas tran vdout0_31ck590 FIND v(dout0_31) AT=600.05n

.meas tran vdout0_32ck590 FIND v(dout0_32) AT=600.05n

.meas tran vdout0_33ck590 FIND v(dout0_33) AT=600.05n

.meas tran vdout0_34ck590 FIND v(dout0_34) AT=600.05n

.meas tran vdout0_35ck590 FIND v(dout0_35) AT=600.05n

.meas tran vdout0_36ck590 FIND v(dout0_36) AT=600.05n

.meas tran vdout0_37ck590 FIND v(dout0_37) AT=600.05n

.meas tran vdout0_38ck590 FIND v(dout0_38) AT=600.05n

.meas tran vdout0_39ck590 FIND v(dout0_39) AT=600.05n

.meas tran vdout0_40ck590 FIND v(dout0_40) AT=600.05n

.meas tran vdout0_41ck590 FIND v(dout0_41) AT=600.05n

.meas tran vdout0_42ck590 FIND v(dout0_42) AT=600.05n

.meas tran vdout0_43ck590 FIND v(dout0_43) AT=600.05n

.meas tran vdout0_44ck590 FIND v(dout0_44) AT=600.05n

.meas tran vdout0_45ck590 FIND v(dout0_45) AT=600.05n

.meas tran vdout0_46ck590 FIND v(dout0_46) AT=600.05n

.meas tran vdout0_47ck590 FIND v(dout0_47) AT=600.05n

.meas tran vdout0_48ck590 FIND v(dout0_48) AT=600.05n

.meas tran vdout0_49ck590 FIND v(dout0_49) AT=600.05n

.meas tran vdout0_50ck590 FIND v(dout0_50) AT=600.05n

.meas tran vdout0_51ck590 FIND v(dout0_51) AT=600.05n

.meas tran vdout0_52ck590 FIND v(dout0_52) AT=600.05n

.meas tran vdout0_53ck590 FIND v(dout0_53) AT=600.05n

.meas tran vdout0_54ck590 FIND v(dout0_54) AT=600.05n

.meas tran vdout0_55ck590 FIND v(dout0_55) AT=600.05n

.meas tran vdout0_56ck590 FIND v(dout0_56) AT=600.05n

.meas tran vdout0_57ck590 FIND v(dout0_57) AT=600.05n

.meas tran vdout0_58ck590 FIND v(dout0_58) AT=600.05n

.meas tran vdout0_59ck590 FIND v(dout0_59) AT=600.05n

.meas tran vdout0_60ck590 FIND v(dout0_60) AT=600.05n

.meas tran vdout0_61ck590 FIND v(dout0_61) AT=600.05n

.meas tran vdout0_62ck590 FIND v(dout0_62) AT=600.05n

.meas tran vdout0_63ck590 FIND v(dout0_63) AT=600.05n

.meas tran vdout1_0ck590 FIND v(dout1_0) AT=600.05n

.meas tran vdout1_1ck590 FIND v(dout1_1) AT=600.05n

.meas tran vdout1_2ck590 FIND v(dout1_2) AT=600.05n

.meas tran vdout1_3ck590 FIND v(dout1_3) AT=600.05n

.meas tran vdout1_4ck590 FIND v(dout1_4) AT=600.05n

.meas tran vdout1_5ck590 FIND v(dout1_5) AT=600.05n

.meas tran vdout1_6ck590 FIND v(dout1_6) AT=600.05n

.meas tran vdout1_7ck590 FIND v(dout1_7) AT=600.05n

.meas tran vdout1_8ck590 FIND v(dout1_8) AT=600.05n

.meas tran vdout1_9ck590 FIND v(dout1_9) AT=600.05n

.meas tran vdout1_10ck590 FIND v(dout1_10) AT=600.05n

.meas tran vdout1_11ck590 FIND v(dout1_11) AT=600.05n

.meas tran vdout1_12ck590 FIND v(dout1_12) AT=600.05n

.meas tran vdout1_13ck590 FIND v(dout1_13) AT=600.05n

.meas tran vdout1_14ck590 FIND v(dout1_14) AT=600.05n

.meas tran vdout1_15ck590 FIND v(dout1_15) AT=600.05n

.meas tran vdout1_16ck590 FIND v(dout1_16) AT=600.05n

.meas tran vdout1_17ck590 FIND v(dout1_17) AT=600.05n

.meas tran vdout1_18ck590 FIND v(dout1_18) AT=600.05n

.meas tran vdout1_19ck590 FIND v(dout1_19) AT=600.05n

.meas tran vdout1_20ck590 FIND v(dout1_20) AT=600.05n

.meas tran vdout1_21ck590 FIND v(dout1_21) AT=600.05n

.meas tran vdout1_22ck590 FIND v(dout1_22) AT=600.05n

.meas tran vdout1_23ck590 FIND v(dout1_23) AT=600.05n

.meas tran vdout1_24ck590 FIND v(dout1_24) AT=600.05n

.meas tran vdout1_25ck590 FIND v(dout1_25) AT=600.05n

.meas tran vdout1_26ck590 FIND v(dout1_26) AT=600.05n

.meas tran vdout1_27ck590 FIND v(dout1_27) AT=600.05n

.meas tran vdout1_28ck590 FIND v(dout1_28) AT=600.05n

.meas tran vdout1_29ck590 FIND v(dout1_29) AT=600.05n

.meas tran vdout1_30ck590 FIND v(dout1_30) AT=600.05n

.meas tran vdout1_31ck590 FIND v(dout1_31) AT=600.05n

.meas tran vdout1_32ck590 FIND v(dout1_32) AT=600.05n

.meas tran vdout1_33ck590 FIND v(dout1_33) AT=600.05n

.meas tran vdout1_34ck590 FIND v(dout1_34) AT=600.05n

.meas tran vdout1_35ck590 FIND v(dout1_35) AT=600.05n

.meas tran vdout1_36ck590 FIND v(dout1_36) AT=600.05n

.meas tran vdout1_37ck590 FIND v(dout1_37) AT=600.05n

.meas tran vdout1_38ck590 FIND v(dout1_38) AT=600.05n

.meas tran vdout1_39ck590 FIND v(dout1_39) AT=600.05n

.meas tran vdout1_40ck590 FIND v(dout1_40) AT=600.05n

.meas tran vdout1_41ck590 FIND v(dout1_41) AT=600.05n

.meas tran vdout1_42ck590 FIND v(dout1_42) AT=600.05n

.meas tran vdout1_43ck590 FIND v(dout1_43) AT=600.05n

.meas tran vdout1_44ck590 FIND v(dout1_44) AT=600.05n

.meas tran vdout1_45ck590 FIND v(dout1_45) AT=600.05n

.meas tran vdout1_46ck590 FIND v(dout1_46) AT=600.05n

.meas tran vdout1_47ck590 FIND v(dout1_47) AT=600.05n

.meas tran vdout1_48ck590 FIND v(dout1_48) AT=600.05n

.meas tran vdout1_49ck590 FIND v(dout1_49) AT=600.05n

.meas tran vdout1_50ck590 FIND v(dout1_50) AT=600.05n

.meas tran vdout1_51ck590 FIND v(dout1_51) AT=600.05n

.meas tran vdout1_52ck590 FIND v(dout1_52) AT=600.05n

.meas tran vdout1_53ck590 FIND v(dout1_53) AT=600.05n

.meas tran vdout1_54ck590 FIND v(dout1_54) AT=600.05n

.meas tran vdout1_55ck590 FIND v(dout1_55) AT=600.05n

.meas tran vdout1_56ck590 FIND v(dout1_56) AT=600.05n

.meas tran vdout1_57ck590 FIND v(dout1_57) AT=600.05n

.meas tran vdout1_58ck590 FIND v(dout1_58) AT=600.05n

.meas tran vdout1_59ck590 FIND v(dout1_59) AT=600.05n

.meas tran vdout1_60ck590 FIND v(dout1_60) AT=600.05n

.meas tran vdout1_61ck590 FIND v(dout1_61) AT=600.05n

.meas tran vdout1_62ck590 FIND v(dout1_62) AT=600.05n

.meas tran vdout1_63ck590 FIND v(dout1_63) AT=600.05n

.meas tran vdout0_0ck600 FIND v(dout0_0) AT=610.05n

.meas tran vdout0_1ck600 FIND v(dout0_1) AT=610.05n

.meas tran vdout0_2ck600 FIND v(dout0_2) AT=610.05n

.meas tran vdout0_3ck600 FIND v(dout0_3) AT=610.05n

.meas tran vdout0_4ck600 FIND v(dout0_4) AT=610.05n

.meas tran vdout0_5ck600 FIND v(dout0_5) AT=610.05n

.meas tran vdout0_6ck600 FIND v(dout0_6) AT=610.05n

.meas tran vdout0_7ck600 FIND v(dout0_7) AT=610.05n

.meas tran vdout0_8ck600 FIND v(dout0_8) AT=610.05n

.meas tran vdout0_9ck600 FIND v(dout0_9) AT=610.05n

.meas tran vdout0_10ck600 FIND v(dout0_10) AT=610.05n

.meas tran vdout0_11ck600 FIND v(dout0_11) AT=610.05n

.meas tran vdout0_12ck600 FIND v(dout0_12) AT=610.05n

.meas tran vdout0_13ck600 FIND v(dout0_13) AT=610.05n

.meas tran vdout0_14ck600 FIND v(dout0_14) AT=610.05n

.meas tran vdout0_15ck600 FIND v(dout0_15) AT=610.05n

.meas tran vdout0_16ck600 FIND v(dout0_16) AT=610.05n

.meas tran vdout0_17ck600 FIND v(dout0_17) AT=610.05n

.meas tran vdout0_18ck600 FIND v(dout0_18) AT=610.05n

.meas tran vdout0_19ck600 FIND v(dout0_19) AT=610.05n

.meas tran vdout0_20ck600 FIND v(dout0_20) AT=610.05n

.meas tran vdout0_21ck600 FIND v(dout0_21) AT=610.05n

.meas tran vdout0_22ck600 FIND v(dout0_22) AT=610.05n

.meas tran vdout0_23ck600 FIND v(dout0_23) AT=610.05n

.meas tran vdout0_24ck600 FIND v(dout0_24) AT=610.05n

.meas tran vdout0_25ck600 FIND v(dout0_25) AT=610.05n

.meas tran vdout0_26ck600 FIND v(dout0_26) AT=610.05n

.meas tran vdout0_27ck600 FIND v(dout0_27) AT=610.05n

.meas tran vdout0_28ck600 FIND v(dout0_28) AT=610.05n

.meas tran vdout0_29ck600 FIND v(dout0_29) AT=610.05n

.meas tran vdout0_30ck600 FIND v(dout0_30) AT=610.05n

.meas tran vdout0_31ck600 FIND v(dout0_31) AT=610.05n

.meas tran vdout0_32ck600 FIND v(dout0_32) AT=610.05n

.meas tran vdout0_33ck600 FIND v(dout0_33) AT=610.05n

.meas tran vdout0_34ck600 FIND v(dout0_34) AT=610.05n

.meas tran vdout0_35ck600 FIND v(dout0_35) AT=610.05n

.meas tran vdout0_36ck600 FIND v(dout0_36) AT=610.05n

.meas tran vdout0_37ck600 FIND v(dout0_37) AT=610.05n

.meas tran vdout0_38ck600 FIND v(dout0_38) AT=610.05n

.meas tran vdout0_39ck600 FIND v(dout0_39) AT=610.05n

.meas tran vdout0_40ck600 FIND v(dout0_40) AT=610.05n

.meas tran vdout0_41ck600 FIND v(dout0_41) AT=610.05n

.meas tran vdout0_42ck600 FIND v(dout0_42) AT=610.05n

.meas tran vdout0_43ck600 FIND v(dout0_43) AT=610.05n

.meas tran vdout0_44ck600 FIND v(dout0_44) AT=610.05n

.meas tran vdout0_45ck600 FIND v(dout0_45) AT=610.05n

.meas tran vdout0_46ck600 FIND v(dout0_46) AT=610.05n

.meas tran vdout0_47ck600 FIND v(dout0_47) AT=610.05n

.meas tran vdout0_48ck600 FIND v(dout0_48) AT=610.05n

.meas tran vdout0_49ck600 FIND v(dout0_49) AT=610.05n

.meas tran vdout0_50ck600 FIND v(dout0_50) AT=610.05n

.meas tran vdout0_51ck600 FIND v(dout0_51) AT=610.05n

.meas tran vdout0_52ck600 FIND v(dout0_52) AT=610.05n

.meas tran vdout0_53ck600 FIND v(dout0_53) AT=610.05n

.meas tran vdout0_54ck600 FIND v(dout0_54) AT=610.05n

.meas tran vdout0_55ck600 FIND v(dout0_55) AT=610.05n

.meas tran vdout0_56ck600 FIND v(dout0_56) AT=610.05n

.meas tran vdout0_57ck600 FIND v(dout0_57) AT=610.05n

.meas tran vdout0_58ck600 FIND v(dout0_58) AT=610.05n

.meas tran vdout0_59ck600 FIND v(dout0_59) AT=610.05n

.meas tran vdout0_60ck600 FIND v(dout0_60) AT=610.05n

.meas tran vdout0_61ck600 FIND v(dout0_61) AT=610.05n

.meas tran vdout0_62ck600 FIND v(dout0_62) AT=610.05n

.meas tran vdout0_63ck600 FIND v(dout0_63) AT=610.05n

.meas tran vdout0_0ck610 FIND v(dout0_0) AT=620.05n

.meas tran vdout0_1ck610 FIND v(dout0_1) AT=620.05n

.meas tran vdout0_2ck610 FIND v(dout0_2) AT=620.05n

.meas tran vdout0_3ck610 FIND v(dout0_3) AT=620.05n

.meas tran vdout0_4ck610 FIND v(dout0_4) AT=620.05n

.meas tran vdout0_5ck610 FIND v(dout0_5) AT=620.05n

.meas tran vdout0_6ck610 FIND v(dout0_6) AT=620.05n

.meas tran vdout0_7ck610 FIND v(dout0_7) AT=620.05n

.meas tran vdout0_8ck610 FIND v(dout0_8) AT=620.05n

.meas tran vdout0_9ck610 FIND v(dout0_9) AT=620.05n

.meas tran vdout0_10ck610 FIND v(dout0_10) AT=620.05n

.meas tran vdout0_11ck610 FIND v(dout0_11) AT=620.05n

.meas tran vdout0_12ck610 FIND v(dout0_12) AT=620.05n

.meas tran vdout0_13ck610 FIND v(dout0_13) AT=620.05n

.meas tran vdout0_14ck610 FIND v(dout0_14) AT=620.05n

.meas tran vdout0_15ck610 FIND v(dout0_15) AT=620.05n

.meas tran vdout0_16ck610 FIND v(dout0_16) AT=620.05n

.meas tran vdout0_17ck610 FIND v(dout0_17) AT=620.05n

.meas tran vdout0_18ck610 FIND v(dout0_18) AT=620.05n

.meas tran vdout0_19ck610 FIND v(dout0_19) AT=620.05n

.meas tran vdout0_20ck610 FIND v(dout0_20) AT=620.05n

.meas tran vdout0_21ck610 FIND v(dout0_21) AT=620.05n

.meas tran vdout0_22ck610 FIND v(dout0_22) AT=620.05n

.meas tran vdout0_23ck610 FIND v(dout0_23) AT=620.05n

.meas tran vdout0_24ck610 FIND v(dout0_24) AT=620.05n

.meas tran vdout0_25ck610 FIND v(dout0_25) AT=620.05n

.meas tran vdout0_26ck610 FIND v(dout0_26) AT=620.05n

.meas tran vdout0_27ck610 FIND v(dout0_27) AT=620.05n

.meas tran vdout0_28ck610 FIND v(dout0_28) AT=620.05n

.meas tran vdout0_29ck610 FIND v(dout0_29) AT=620.05n

.meas tran vdout0_30ck610 FIND v(dout0_30) AT=620.05n

.meas tran vdout0_31ck610 FIND v(dout0_31) AT=620.05n

.meas tran vdout0_32ck610 FIND v(dout0_32) AT=620.05n

.meas tran vdout0_33ck610 FIND v(dout0_33) AT=620.05n

.meas tran vdout0_34ck610 FIND v(dout0_34) AT=620.05n

.meas tran vdout0_35ck610 FIND v(dout0_35) AT=620.05n

.meas tran vdout0_36ck610 FIND v(dout0_36) AT=620.05n

.meas tran vdout0_37ck610 FIND v(dout0_37) AT=620.05n

.meas tran vdout0_38ck610 FIND v(dout0_38) AT=620.05n

.meas tran vdout0_39ck610 FIND v(dout0_39) AT=620.05n

.meas tran vdout0_40ck610 FIND v(dout0_40) AT=620.05n

.meas tran vdout0_41ck610 FIND v(dout0_41) AT=620.05n

.meas tran vdout0_42ck610 FIND v(dout0_42) AT=620.05n

.meas tran vdout0_43ck610 FIND v(dout0_43) AT=620.05n

.meas tran vdout0_44ck610 FIND v(dout0_44) AT=620.05n

.meas tran vdout0_45ck610 FIND v(dout0_45) AT=620.05n

.meas tran vdout0_46ck610 FIND v(dout0_46) AT=620.05n

.meas tran vdout0_47ck610 FIND v(dout0_47) AT=620.05n

.meas tran vdout0_48ck610 FIND v(dout0_48) AT=620.05n

.meas tran vdout0_49ck610 FIND v(dout0_49) AT=620.05n

.meas tran vdout0_50ck610 FIND v(dout0_50) AT=620.05n

.meas tran vdout0_51ck610 FIND v(dout0_51) AT=620.05n

.meas tran vdout0_52ck610 FIND v(dout0_52) AT=620.05n

.meas tran vdout0_53ck610 FIND v(dout0_53) AT=620.05n

.meas tran vdout0_54ck610 FIND v(dout0_54) AT=620.05n

.meas tran vdout0_55ck610 FIND v(dout0_55) AT=620.05n

.meas tran vdout0_56ck610 FIND v(dout0_56) AT=620.05n

.meas tran vdout0_57ck610 FIND v(dout0_57) AT=620.05n

.meas tran vdout0_58ck610 FIND v(dout0_58) AT=620.05n

.meas tran vdout0_59ck610 FIND v(dout0_59) AT=620.05n

.meas tran vdout0_60ck610 FIND v(dout0_60) AT=620.05n

.meas tran vdout0_61ck610 FIND v(dout0_61) AT=620.05n

.meas tran vdout0_62ck610 FIND v(dout0_62) AT=620.05n

.meas tran vdout0_63ck610 FIND v(dout0_63) AT=620.05n

.meas tran vdout0_0ck630 FIND v(dout0_0) AT=640.05n

.meas tran vdout0_1ck630 FIND v(dout0_1) AT=640.05n

.meas tran vdout0_2ck630 FIND v(dout0_2) AT=640.05n

.meas tran vdout0_3ck630 FIND v(dout0_3) AT=640.05n

.meas tran vdout0_4ck630 FIND v(dout0_4) AT=640.05n

.meas tran vdout0_5ck630 FIND v(dout0_5) AT=640.05n

.meas tran vdout0_6ck630 FIND v(dout0_6) AT=640.05n

.meas tran vdout0_7ck630 FIND v(dout0_7) AT=640.05n

.meas tran vdout0_8ck630 FIND v(dout0_8) AT=640.05n

.meas tran vdout0_9ck630 FIND v(dout0_9) AT=640.05n

.meas tran vdout0_10ck630 FIND v(dout0_10) AT=640.05n

.meas tran vdout0_11ck630 FIND v(dout0_11) AT=640.05n

.meas tran vdout0_12ck630 FIND v(dout0_12) AT=640.05n

.meas tran vdout0_13ck630 FIND v(dout0_13) AT=640.05n

.meas tran vdout0_14ck630 FIND v(dout0_14) AT=640.05n

.meas tran vdout0_15ck630 FIND v(dout0_15) AT=640.05n

.meas tran vdout0_16ck630 FIND v(dout0_16) AT=640.05n

.meas tran vdout0_17ck630 FIND v(dout0_17) AT=640.05n

.meas tran vdout0_18ck630 FIND v(dout0_18) AT=640.05n

.meas tran vdout0_19ck630 FIND v(dout0_19) AT=640.05n

.meas tran vdout0_20ck630 FIND v(dout0_20) AT=640.05n

.meas tran vdout0_21ck630 FIND v(dout0_21) AT=640.05n

.meas tran vdout0_22ck630 FIND v(dout0_22) AT=640.05n

.meas tran vdout0_23ck630 FIND v(dout0_23) AT=640.05n

.meas tran vdout0_24ck630 FIND v(dout0_24) AT=640.05n

.meas tran vdout0_25ck630 FIND v(dout0_25) AT=640.05n

.meas tran vdout0_26ck630 FIND v(dout0_26) AT=640.05n

.meas tran vdout0_27ck630 FIND v(dout0_27) AT=640.05n

.meas tran vdout0_28ck630 FIND v(dout0_28) AT=640.05n

.meas tran vdout0_29ck630 FIND v(dout0_29) AT=640.05n

.meas tran vdout0_30ck630 FIND v(dout0_30) AT=640.05n

.meas tran vdout0_31ck630 FIND v(dout0_31) AT=640.05n

.meas tran vdout0_32ck630 FIND v(dout0_32) AT=640.05n

.meas tran vdout0_33ck630 FIND v(dout0_33) AT=640.05n

.meas tran vdout0_34ck630 FIND v(dout0_34) AT=640.05n

.meas tran vdout0_35ck630 FIND v(dout0_35) AT=640.05n

.meas tran vdout0_36ck630 FIND v(dout0_36) AT=640.05n

.meas tran vdout0_37ck630 FIND v(dout0_37) AT=640.05n

.meas tran vdout0_38ck630 FIND v(dout0_38) AT=640.05n

.meas tran vdout0_39ck630 FIND v(dout0_39) AT=640.05n

.meas tran vdout0_40ck630 FIND v(dout0_40) AT=640.05n

.meas tran vdout0_41ck630 FIND v(dout0_41) AT=640.05n

.meas tran vdout0_42ck630 FIND v(dout0_42) AT=640.05n

.meas tran vdout0_43ck630 FIND v(dout0_43) AT=640.05n

.meas tran vdout0_44ck630 FIND v(dout0_44) AT=640.05n

.meas tran vdout0_45ck630 FIND v(dout0_45) AT=640.05n

.meas tran vdout0_46ck630 FIND v(dout0_46) AT=640.05n

.meas tran vdout0_47ck630 FIND v(dout0_47) AT=640.05n

.meas tran vdout0_48ck630 FIND v(dout0_48) AT=640.05n

.meas tran vdout0_49ck630 FIND v(dout0_49) AT=640.05n

.meas tran vdout0_50ck630 FIND v(dout0_50) AT=640.05n

.meas tran vdout0_51ck630 FIND v(dout0_51) AT=640.05n

.meas tran vdout0_52ck630 FIND v(dout0_52) AT=640.05n

.meas tran vdout0_53ck630 FIND v(dout0_53) AT=640.05n

.meas tran vdout0_54ck630 FIND v(dout0_54) AT=640.05n

.meas tran vdout0_55ck630 FIND v(dout0_55) AT=640.05n

.meas tran vdout0_56ck630 FIND v(dout0_56) AT=640.05n

.meas tran vdout0_57ck630 FIND v(dout0_57) AT=640.05n

.meas tran vdout0_58ck630 FIND v(dout0_58) AT=640.05n

.meas tran vdout0_59ck630 FIND v(dout0_59) AT=640.05n

.meas tran vdout0_60ck630 FIND v(dout0_60) AT=640.05n

.meas tran vdout0_61ck630 FIND v(dout0_61) AT=640.05n

.meas tran vdout0_62ck630 FIND v(dout0_62) AT=640.05n

.meas tran vdout0_63ck630 FIND v(dout0_63) AT=640.05n

.meas tran vdout0_0ck640 FIND v(dout0_0) AT=650.05n

.meas tran vdout0_1ck640 FIND v(dout0_1) AT=650.05n

.meas tran vdout0_2ck640 FIND v(dout0_2) AT=650.05n

.meas tran vdout0_3ck640 FIND v(dout0_3) AT=650.05n

.meas tran vdout0_4ck640 FIND v(dout0_4) AT=650.05n

.meas tran vdout0_5ck640 FIND v(dout0_5) AT=650.05n

.meas tran vdout0_6ck640 FIND v(dout0_6) AT=650.05n

.meas tran vdout0_7ck640 FIND v(dout0_7) AT=650.05n

.meas tran vdout0_8ck640 FIND v(dout0_8) AT=650.05n

.meas tran vdout0_9ck640 FIND v(dout0_9) AT=650.05n

.meas tran vdout0_10ck640 FIND v(dout0_10) AT=650.05n

.meas tran vdout0_11ck640 FIND v(dout0_11) AT=650.05n

.meas tran vdout0_12ck640 FIND v(dout0_12) AT=650.05n

.meas tran vdout0_13ck640 FIND v(dout0_13) AT=650.05n

.meas tran vdout0_14ck640 FIND v(dout0_14) AT=650.05n

.meas tran vdout0_15ck640 FIND v(dout0_15) AT=650.05n

.meas tran vdout0_16ck640 FIND v(dout0_16) AT=650.05n

.meas tran vdout0_17ck640 FIND v(dout0_17) AT=650.05n

.meas tran vdout0_18ck640 FIND v(dout0_18) AT=650.05n

.meas tran vdout0_19ck640 FIND v(dout0_19) AT=650.05n

.meas tran vdout0_20ck640 FIND v(dout0_20) AT=650.05n

.meas tran vdout0_21ck640 FIND v(dout0_21) AT=650.05n

.meas tran vdout0_22ck640 FIND v(dout0_22) AT=650.05n

.meas tran vdout0_23ck640 FIND v(dout0_23) AT=650.05n

.meas tran vdout0_24ck640 FIND v(dout0_24) AT=650.05n

.meas tran vdout0_25ck640 FIND v(dout0_25) AT=650.05n

.meas tran vdout0_26ck640 FIND v(dout0_26) AT=650.05n

.meas tran vdout0_27ck640 FIND v(dout0_27) AT=650.05n

.meas tran vdout0_28ck640 FIND v(dout0_28) AT=650.05n

.meas tran vdout0_29ck640 FIND v(dout0_29) AT=650.05n

.meas tran vdout0_30ck640 FIND v(dout0_30) AT=650.05n

.meas tran vdout0_31ck640 FIND v(dout0_31) AT=650.05n

.meas tran vdout0_32ck640 FIND v(dout0_32) AT=650.05n

.meas tran vdout0_33ck640 FIND v(dout0_33) AT=650.05n

.meas tran vdout0_34ck640 FIND v(dout0_34) AT=650.05n

.meas tran vdout0_35ck640 FIND v(dout0_35) AT=650.05n

.meas tran vdout0_36ck640 FIND v(dout0_36) AT=650.05n

.meas tran vdout0_37ck640 FIND v(dout0_37) AT=650.05n

.meas tran vdout0_38ck640 FIND v(dout0_38) AT=650.05n

.meas tran vdout0_39ck640 FIND v(dout0_39) AT=650.05n

.meas tran vdout0_40ck640 FIND v(dout0_40) AT=650.05n

.meas tran vdout0_41ck640 FIND v(dout0_41) AT=650.05n

.meas tran vdout0_42ck640 FIND v(dout0_42) AT=650.05n

.meas tran vdout0_43ck640 FIND v(dout0_43) AT=650.05n

.meas tran vdout0_44ck640 FIND v(dout0_44) AT=650.05n

.meas tran vdout0_45ck640 FIND v(dout0_45) AT=650.05n

.meas tran vdout0_46ck640 FIND v(dout0_46) AT=650.05n

.meas tran vdout0_47ck640 FIND v(dout0_47) AT=650.05n

.meas tran vdout0_48ck640 FIND v(dout0_48) AT=650.05n

.meas tran vdout0_49ck640 FIND v(dout0_49) AT=650.05n

.meas tran vdout0_50ck640 FIND v(dout0_50) AT=650.05n

.meas tran vdout0_51ck640 FIND v(dout0_51) AT=650.05n

.meas tran vdout0_52ck640 FIND v(dout0_52) AT=650.05n

.meas tran vdout0_53ck640 FIND v(dout0_53) AT=650.05n

.meas tran vdout0_54ck640 FIND v(dout0_54) AT=650.05n

.meas tran vdout0_55ck640 FIND v(dout0_55) AT=650.05n

.meas tran vdout0_56ck640 FIND v(dout0_56) AT=650.05n

.meas tran vdout0_57ck640 FIND v(dout0_57) AT=650.05n

.meas tran vdout0_58ck640 FIND v(dout0_58) AT=650.05n

.meas tran vdout0_59ck640 FIND v(dout0_59) AT=650.05n

.meas tran vdout0_60ck640 FIND v(dout0_60) AT=650.05n

.meas tran vdout0_61ck640 FIND v(dout0_61) AT=650.05n

.meas tran vdout0_62ck640 FIND v(dout0_62) AT=650.05n

.meas tran vdout0_63ck640 FIND v(dout0_63) AT=650.05n

.meas tran vdout1_0ck640 FIND v(dout1_0) AT=650.05n

.meas tran vdout1_1ck640 FIND v(dout1_1) AT=650.05n

.meas tran vdout1_2ck640 FIND v(dout1_2) AT=650.05n

.meas tran vdout1_3ck640 FIND v(dout1_3) AT=650.05n

.meas tran vdout1_4ck640 FIND v(dout1_4) AT=650.05n

.meas tran vdout1_5ck640 FIND v(dout1_5) AT=650.05n

.meas tran vdout1_6ck640 FIND v(dout1_6) AT=650.05n

.meas tran vdout1_7ck640 FIND v(dout1_7) AT=650.05n

.meas tran vdout1_8ck640 FIND v(dout1_8) AT=650.05n

.meas tran vdout1_9ck640 FIND v(dout1_9) AT=650.05n

.meas tran vdout1_10ck640 FIND v(dout1_10) AT=650.05n

.meas tran vdout1_11ck640 FIND v(dout1_11) AT=650.05n

.meas tran vdout1_12ck640 FIND v(dout1_12) AT=650.05n

.meas tran vdout1_13ck640 FIND v(dout1_13) AT=650.05n

.meas tran vdout1_14ck640 FIND v(dout1_14) AT=650.05n

.meas tran vdout1_15ck640 FIND v(dout1_15) AT=650.05n

.meas tran vdout1_16ck640 FIND v(dout1_16) AT=650.05n

.meas tran vdout1_17ck640 FIND v(dout1_17) AT=650.05n

.meas tran vdout1_18ck640 FIND v(dout1_18) AT=650.05n

.meas tran vdout1_19ck640 FIND v(dout1_19) AT=650.05n

.meas tran vdout1_20ck640 FIND v(dout1_20) AT=650.05n

.meas tran vdout1_21ck640 FIND v(dout1_21) AT=650.05n

.meas tran vdout1_22ck640 FIND v(dout1_22) AT=650.05n

.meas tran vdout1_23ck640 FIND v(dout1_23) AT=650.05n

.meas tran vdout1_24ck640 FIND v(dout1_24) AT=650.05n

.meas tran vdout1_25ck640 FIND v(dout1_25) AT=650.05n

.meas tran vdout1_26ck640 FIND v(dout1_26) AT=650.05n

.meas tran vdout1_27ck640 FIND v(dout1_27) AT=650.05n

.meas tran vdout1_28ck640 FIND v(dout1_28) AT=650.05n

.meas tran vdout1_29ck640 FIND v(dout1_29) AT=650.05n

.meas tran vdout1_30ck640 FIND v(dout1_30) AT=650.05n

.meas tran vdout1_31ck640 FIND v(dout1_31) AT=650.05n

.meas tran vdout1_32ck640 FIND v(dout1_32) AT=650.05n

.meas tran vdout1_33ck640 FIND v(dout1_33) AT=650.05n

.meas tran vdout1_34ck640 FIND v(dout1_34) AT=650.05n

.meas tran vdout1_35ck640 FIND v(dout1_35) AT=650.05n

.meas tran vdout1_36ck640 FIND v(dout1_36) AT=650.05n

.meas tran vdout1_37ck640 FIND v(dout1_37) AT=650.05n

.meas tran vdout1_38ck640 FIND v(dout1_38) AT=650.05n

.meas tran vdout1_39ck640 FIND v(dout1_39) AT=650.05n

.meas tran vdout1_40ck640 FIND v(dout1_40) AT=650.05n

.meas tran vdout1_41ck640 FIND v(dout1_41) AT=650.05n

.meas tran vdout1_42ck640 FIND v(dout1_42) AT=650.05n

.meas tran vdout1_43ck640 FIND v(dout1_43) AT=650.05n

.meas tran vdout1_44ck640 FIND v(dout1_44) AT=650.05n

.meas tran vdout1_45ck640 FIND v(dout1_45) AT=650.05n

.meas tran vdout1_46ck640 FIND v(dout1_46) AT=650.05n

.meas tran vdout1_47ck640 FIND v(dout1_47) AT=650.05n

.meas tran vdout1_48ck640 FIND v(dout1_48) AT=650.05n

.meas tran vdout1_49ck640 FIND v(dout1_49) AT=650.05n

.meas tran vdout1_50ck640 FIND v(dout1_50) AT=650.05n

.meas tran vdout1_51ck640 FIND v(dout1_51) AT=650.05n

.meas tran vdout1_52ck640 FIND v(dout1_52) AT=650.05n

.meas tran vdout1_53ck640 FIND v(dout1_53) AT=650.05n

.meas tran vdout1_54ck640 FIND v(dout1_54) AT=650.05n

.meas tran vdout1_55ck640 FIND v(dout1_55) AT=650.05n

.meas tran vdout1_56ck640 FIND v(dout1_56) AT=650.05n

.meas tran vdout1_57ck640 FIND v(dout1_57) AT=650.05n

.meas tran vdout1_58ck640 FIND v(dout1_58) AT=650.05n

.meas tran vdout1_59ck640 FIND v(dout1_59) AT=650.05n

.meas tran vdout1_60ck640 FIND v(dout1_60) AT=650.05n

.meas tran vdout1_61ck640 FIND v(dout1_61) AT=650.05n

.meas tran vdout1_62ck640 FIND v(dout1_62) AT=650.05n

.meas tran vdout1_63ck640 FIND v(dout1_63) AT=650.05n

.meas tran vdout0_0ck660 FIND v(dout0_0) AT=670.05n

.meas tran vdout0_1ck660 FIND v(dout0_1) AT=670.05n

.meas tran vdout0_2ck660 FIND v(dout0_2) AT=670.05n

.meas tran vdout0_3ck660 FIND v(dout0_3) AT=670.05n

.meas tran vdout0_4ck660 FIND v(dout0_4) AT=670.05n

.meas tran vdout0_5ck660 FIND v(dout0_5) AT=670.05n

.meas tran vdout0_6ck660 FIND v(dout0_6) AT=670.05n

.meas tran vdout0_7ck660 FIND v(dout0_7) AT=670.05n

.meas tran vdout0_8ck660 FIND v(dout0_8) AT=670.05n

.meas tran vdout0_9ck660 FIND v(dout0_9) AT=670.05n

.meas tran vdout0_10ck660 FIND v(dout0_10) AT=670.05n

.meas tran vdout0_11ck660 FIND v(dout0_11) AT=670.05n

.meas tran vdout0_12ck660 FIND v(dout0_12) AT=670.05n

.meas tran vdout0_13ck660 FIND v(dout0_13) AT=670.05n

.meas tran vdout0_14ck660 FIND v(dout0_14) AT=670.05n

.meas tran vdout0_15ck660 FIND v(dout0_15) AT=670.05n

.meas tran vdout0_16ck660 FIND v(dout0_16) AT=670.05n

.meas tran vdout0_17ck660 FIND v(dout0_17) AT=670.05n

.meas tran vdout0_18ck660 FIND v(dout0_18) AT=670.05n

.meas tran vdout0_19ck660 FIND v(dout0_19) AT=670.05n

.meas tran vdout0_20ck660 FIND v(dout0_20) AT=670.05n

.meas tran vdout0_21ck660 FIND v(dout0_21) AT=670.05n

.meas tran vdout0_22ck660 FIND v(dout0_22) AT=670.05n

.meas tran vdout0_23ck660 FIND v(dout0_23) AT=670.05n

.meas tran vdout0_24ck660 FIND v(dout0_24) AT=670.05n

.meas tran vdout0_25ck660 FIND v(dout0_25) AT=670.05n

.meas tran vdout0_26ck660 FIND v(dout0_26) AT=670.05n

.meas tran vdout0_27ck660 FIND v(dout0_27) AT=670.05n

.meas tran vdout0_28ck660 FIND v(dout0_28) AT=670.05n

.meas tran vdout0_29ck660 FIND v(dout0_29) AT=670.05n

.meas tran vdout0_30ck660 FIND v(dout0_30) AT=670.05n

.meas tran vdout0_31ck660 FIND v(dout0_31) AT=670.05n

.meas tran vdout0_32ck660 FIND v(dout0_32) AT=670.05n

.meas tran vdout0_33ck660 FIND v(dout0_33) AT=670.05n

.meas tran vdout0_34ck660 FIND v(dout0_34) AT=670.05n

.meas tran vdout0_35ck660 FIND v(dout0_35) AT=670.05n

.meas tran vdout0_36ck660 FIND v(dout0_36) AT=670.05n

.meas tran vdout0_37ck660 FIND v(dout0_37) AT=670.05n

.meas tran vdout0_38ck660 FIND v(dout0_38) AT=670.05n

.meas tran vdout0_39ck660 FIND v(dout0_39) AT=670.05n

.meas tran vdout0_40ck660 FIND v(dout0_40) AT=670.05n

.meas tran vdout0_41ck660 FIND v(dout0_41) AT=670.05n

.meas tran vdout0_42ck660 FIND v(dout0_42) AT=670.05n

.meas tran vdout0_43ck660 FIND v(dout0_43) AT=670.05n

.meas tran vdout0_44ck660 FIND v(dout0_44) AT=670.05n

.meas tran vdout0_45ck660 FIND v(dout0_45) AT=670.05n

.meas tran vdout0_46ck660 FIND v(dout0_46) AT=670.05n

.meas tran vdout0_47ck660 FIND v(dout0_47) AT=670.05n

.meas tran vdout0_48ck660 FIND v(dout0_48) AT=670.05n

.meas tran vdout0_49ck660 FIND v(dout0_49) AT=670.05n

.meas tran vdout0_50ck660 FIND v(dout0_50) AT=670.05n

.meas tran vdout0_51ck660 FIND v(dout0_51) AT=670.05n

.meas tran vdout0_52ck660 FIND v(dout0_52) AT=670.05n

.meas tran vdout0_53ck660 FIND v(dout0_53) AT=670.05n

.meas tran vdout0_54ck660 FIND v(dout0_54) AT=670.05n

.meas tran vdout0_55ck660 FIND v(dout0_55) AT=670.05n

.meas tran vdout0_56ck660 FIND v(dout0_56) AT=670.05n

.meas tran vdout0_57ck660 FIND v(dout0_57) AT=670.05n

.meas tran vdout0_58ck660 FIND v(dout0_58) AT=670.05n

.meas tran vdout0_59ck660 FIND v(dout0_59) AT=670.05n

.meas tran vdout0_60ck660 FIND v(dout0_60) AT=670.05n

.meas tran vdout0_61ck660 FIND v(dout0_61) AT=670.05n

.meas tran vdout0_62ck660 FIND v(dout0_62) AT=670.05n

.meas tran vdout0_63ck660 FIND v(dout0_63) AT=670.05n

.meas tran vdout0_0ck670 FIND v(dout0_0) AT=680.05n

.meas tran vdout0_1ck670 FIND v(dout0_1) AT=680.05n

.meas tran vdout0_2ck670 FIND v(dout0_2) AT=680.05n

.meas tran vdout0_3ck670 FIND v(dout0_3) AT=680.05n

.meas tran vdout0_4ck670 FIND v(dout0_4) AT=680.05n

.meas tran vdout0_5ck670 FIND v(dout0_5) AT=680.05n

.meas tran vdout0_6ck670 FIND v(dout0_6) AT=680.05n

.meas tran vdout0_7ck670 FIND v(dout0_7) AT=680.05n

.meas tran vdout0_8ck670 FIND v(dout0_8) AT=680.05n

.meas tran vdout0_9ck670 FIND v(dout0_9) AT=680.05n

.meas tran vdout0_10ck670 FIND v(dout0_10) AT=680.05n

.meas tran vdout0_11ck670 FIND v(dout0_11) AT=680.05n

.meas tran vdout0_12ck670 FIND v(dout0_12) AT=680.05n

.meas tran vdout0_13ck670 FIND v(dout0_13) AT=680.05n

.meas tran vdout0_14ck670 FIND v(dout0_14) AT=680.05n

.meas tran vdout0_15ck670 FIND v(dout0_15) AT=680.05n

.meas tran vdout0_16ck670 FIND v(dout0_16) AT=680.05n

.meas tran vdout0_17ck670 FIND v(dout0_17) AT=680.05n

.meas tran vdout0_18ck670 FIND v(dout0_18) AT=680.05n

.meas tran vdout0_19ck670 FIND v(dout0_19) AT=680.05n

.meas tran vdout0_20ck670 FIND v(dout0_20) AT=680.05n

.meas tran vdout0_21ck670 FIND v(dout0_21) AT=680.05n

.meas tran vdout0_22ck670 FIND v(dout0_22) AT=680.05n

.meas tran vdout0_23ck670 FIND v(dout0_23) AT=680.05n

.meas tran vdout0_24ck670 FIND v(dout0_24) AT=680.05n

.meas tran vdout0_25ck670 FIND v(dout0_25) AT=680.05n

.meas tran vdout0_26ck670 FIND v(dout0_26) AT=680.05n

.meas tran vdout0_27ck670 FIND v(dout0_27) AT=680.05n

.meas tran vdout0_28ck670 FIND v(dout0_28) AT=680.05n

.meas tran vdout0_29ck670 FIND v(dout0_29) AT=680.05n

.meas tran vdout0_30ck670 FIND v(dout0_30) AT=680.05n

.meas tran vdout0_31ck670 FIND v(dout0_31) AT=680.05n

.meas tran vdout0_32ck670 FIND v(dout0_32) AT=680.05n

.meas tran vdout0_33ck670 FIND v(dout0_33) AT=680.05n

.meas tran vdout0_34ck670 FIND v(dout0_34) AT=680.05n

.meas tran vdout0_35ck670 FIND v(dout0_35) AT=680.05n

.meas tran vdout0_36ck670 FIND v(dout0_36) AT=680.05n

.meas tran vdout0_37ck670 FIND v(dout0_37) AT=680.05n

.meas tran vdout0_38ck670 FIND v(dout0_38) AT=680.05n

.meas tran vdout0_39ck670 FIND v(dout0_39) AT=680.05n

.meas tran vdout0_40ck670 FIND v(dout0_40) AT=680.05n

.meas tran vdout0_41ck670 FIND v(dout0_41) AT=680.05n

.meas tran vdout0_42ck670 FIND v(dout0_42) AT=680.05n

.meas tran vdout0_43ck670 FIND v(dout0_43) AT=680.05n

.meas tran vdout0_44ck670 FIND v(dout0_44) AT=680.05n

.meas tran vdout0_45ck670 FIND v(dout0_45) AT=680.05n

.meas tran vdout0_46ck670 FIND v(dout0_46) AT=680.05n

.meas tran vdout0_47ck670 FIND v(dout0_47) AT=680.05n

.meas tran vdout0_48ck670 FIND v(dout0_48) AT=680.05n

.meas tran vdout0_49ck670 FIND v(dout0_49) AT=680.05n

.meas tran vdout0_50ck670 FIND v(dout0_50) AT=680.05n

.meas tran vdout0_51ck670 FIND v(dout0_51) AT=680.05n

.meas tran vdout0_52ck670 FIND v(dout0_52) AT=680.05n

.meas tran vdout0_53ck670 FIND v(dout0_53) AT=680.05n

.meas tran vdout0_54ck670 FIND v(dout0_54) AT=680.05n

.meas tran vdout0_55ck670 FIND v(dout0_55) AT=680.05n

.meas tran vdout0_56ck670 FIND v(dout0_56) AT=680.05n

.meas tran vdout0_57ck670 FIND v(dout0_57) AT=680.05n

.meas tran vdout0_58ck670 FIND v(dout0_58) AT=680.05n

.meas tran vdout0_59ck670 FIND v(dout0_59) AT=680.05n

.meas tran vdout0_60ck670 FIND v(dout0_60) AT=680.05n

.meas tran vdout0_61ck670 FIND v(dout0_61) AT=680.05n

.meas tran vdout0_62ck670 FIND v(dout0_62) AT=680.05n

.meas tran vdout0_63ck670 FIND v(dout0_63) AT=680.05n

.meas tran vdout0_0ck680 FIND v(dout0_0) AT=690.05n

.meas tran vdout0_1ck680 FIND v(dout0_1) AT=690.05n

.meas tran vdout0_2ck680 FIND v(dout0_2) AT=690.05n

.meas tran vdout0_3ck680 FIND v(dout0_3) AT=690.05n

.meas tran vdout0_4ck680 FIND v(dout0_4) AT=690.05n

.meas tran vdout0_5ck680 FIND v(dout0_5) AT=690.05n

.meas tran vdout0_6ck680 FIND v(dout0_6) AT=690.05n

.meas tran vdout0_7ck680 FIND v(dout0_7) AT=690.05n

.meas tran vdout0_8ck680 FIND v(dout0_8) AT=690.05n

.meas tran vdout0_9ck680 FIND v(dout0_9) AT=690.05n

.meas tran vdout0_10ck680 FIND v(dout0_10) AT=690.05n

.meas tran vdout0_11ck680 FIND v(dout0_11) AT=690.05n

.meas tran vdout0_12ck680 FIND v(dout0_12) AT=690.05n

.meas tran vdout0_13ck680 FIND v(dout0_13) AT=690.05n

.meas tran vdout0_14ck680 FIND v(dout0_14) AT=690.05n

.meas tran vdout0_15ck680 FIND v(dout0_15) AT=690.05n

.meas tran vdout0_16ck680 FIND v(dout0_16) AT=690.05n

.meas tran vdout0_17ck680 FIND v(dout0_17) AT=690.05n

.meas tran vdout0_18ck680 FIND v(dout0_18) AT=690.05n

.meas tran vdout0_19ck680 FIND v(dout0_19) AT=690.05n

.meas tran vdout0_20ck680 FIND v(dout0_20) AT=690.05n

.meas tran vdout0_21ck680 FIND v(dout0_21) AT=690.05n

.meas tran vdout0_22ck680 FIND v(dout0_22) AT=690.05n

.meas tran vdout0_23ck680 FIND v(dout0_23) AT=690.05n

.meas tran vdout0_24ck680 FIND v(dout0_24) AT=690.05n

.meas tran vdout0_25ck680 FIND v(dout0_25) AT=690.05n

.meas tran vdout0_26ck680 FIND v(dout0_26) AT=690.05n

.meas tran vdout0_27ck680 FIND v(dout0_27) AT=690.05n

.meas tran vdout0_28ck680 FIND v(dout0_28) AT=690.05n

.meas tran vdout0_29ck680 FIND v(dout0_29) AT=690.05n

.meas tran vdout0_30ck680 FIND v(dout0_30) AT=690.05n

.meas tran vdout0_31ck680 FIND v(dout0_31) AT=690.05n

.meas tran vdout0_32ck680 FIND v(dout0_32) AT=690.05n

.meas tran vdout0_33ck680 FIND v(dout0_33) AT=690.05n

.meas tran vdout0_34ck680 FIND v(dout0_34) AT=690.05n

.meas tran vdout0_35ck680 FIND v(dout0_35) AT=690.05n

.meas tran vdout0_36ck680 FIND v(dout0_36) AT=690.05n

.meas tran vdout0_37ck680 FIND v(dout0_37) AT=690.05n

.meas tran vdout0_38ck680 FIND v(dout0_38) AT=690.05n

.meas tran vdout0_39ck680 FIND v(dout0_39) AT=690.05n

.meas tran vdout0_40ck680 FIND v(dout0_40) AT=690.05n

.meas tran vdout0_41ck680 FIND v(dout0_41) AT=690.05n

.meas tran vdout0_42ck680 FIND v(dout0_42) AT=690.05n

.meas tran vdout0_43ck680 FIND v(dout0_43) AT=690.05n

.meas tran vdout0_44ck680 FIND v(dout0_44) AT=690.05n

.meas tran vdout0_45ck680 FIND v(dout0_45) AT=690.05n

.meas tran vdout0_46ck680 FIND v(dout0_46) AT=690.05n

.meas tran vdout0_47ck680 FIND v(dout0_47) AT=690.05n

.meas tran vdout0_48ck680 FIND v(dout0_48) AT=690.05n

.meas tran vdout0_49ck680 FIND v(dout0_49) AT=690.05n

.meas tran vdout0_50ck680 FIND v(dout0_50) AT=690.05n

.meas tran vdout0_51ck680 FIND v(dout0_51) AT=690.05n

.meas tran vdout0_52ck680 FIND v(dout0_52) AT=690.05n

.meas tran vdout0_53ck680 FIND v(dout0_53) AT=690.05n

.meas tran vdout0_54ck680 FIND v(dout0_54) AT=690.05n

.meas tran vdout0_55ck680 FIND v(dout0_55) AT=690.05n

.meas tran vdout0_56ck680 FIND v(dout0_56) AT=690.05n

.meas tran vdout0_57ck680 FIND v(dout0_57) AT=690.05n

.meas tran vdout0_58ck680 FIND v(dout0_58) AT=690.05n

.meas tran vdout0_59ck680 FIND v(dout0_59) AT=690.05n

.meas tran vdout0_60ck680 FIND v(dout0_60) AT=690.05n

.meas tran vdout0_61ck680 FIND v(dout0_61) AT=690.05n

.meas tran vdout0_62ck680 FIND v(dout0_62) AT=690.05n

.meas tran vdout0_63ck680 FIND v(dout0_63) AT=690.05n

.meas tran vdout1_0ck680 FIND v(dout1_0) AT=690.05n

.meas tran vdout1_1ck680 FIND v(dout1_1) AT=690.05n

.meas tran vdout1_2ck680 FIND v(dout1_2) AT=690.05n

.meas tran vdout1_3ck680 FIND v(dout1_3) AT=690.05n

.meas tran vdout1_4ck680 FIND v(dout1_4) AT=690.05n

.meas tran vdout1_5ck680 FIND v(dout1_5) AT=690.05n

.meas tran vdout1_6ck680 FIND v(dout1_6) AT=690.05n

.meas tran vdout1_7ck680 FIND v(dout1_7) AT=690.05n

.meas tran vdout1_8ck680 FIND v(dout1_8) AT=690.05n

.meas tran vdout1_9ck680 FIND v(dout1_9) AT=690.05n

.meas tran vdout1_10ck680 FIND v(dout1_10) AT=690.05n

.meas tran vdout1_11ck680 FIND v(dout1_11) AT=690.05n

.meas tran vdout1_12ck680 FIND v(dout1_12) AT=690.05n

.meas tran vdout1_13ck680 FIND v(dout1_13) AT=690.05n

.meas tran vdout1_14ck680 FIND v(dout1_14) AT=690.05n

.meas tran vdout1_15ck680 FIND v(dout1_15) AT=690.05n

.meas tran vdout1_16ck680 FIND v(dout1_16) AT=690.05n

.meas tran vdout1_17ck680 FIND v(dout1_17) AT=690.05n

.meas tran vdout1_18ck680 FIND v(dout1_18) AT=690.05n

.meas tran vdout1_19ck680 FIND v(dout1_19) AT=690.05n

.meas tran vdout1_20ck680 FIND v(dout1_20) AT=690.05n

.meas tran vdout1_21ck680 FIND v(dout1_21) AT=690.05n

.meas tran vdout1_22ck680 FIND v(dout1_22) AT=690.05n

.meas tran vdout1_23ck680 FIND v(dout1_23) AT=690.05n

.meas tran vdout1_24ck680 FIND v(dout1_24) AT=690.05n

.meas tran vdout1_25ck680 FIND v(dout1_25) AT=690.05n

.meas tran vdout1_26ck680 FIND v(dout1_26) AT=690.05n

.meas tran vdout1_27ck680 FIND v(dout1_27) AT=690.05n

.meas tran vdout1_28ck680 FIND v(dout1_28) AT=690.05n

.meas tran vdout1_29ck680 FIND v(dout1_29) AT=690.05n

.meas tran vdout1_30ck680 FIND v(dout1_30) AT=690.05n

.meas tran vdout1_31ck680 FIND v(dout1_31) AT=690.05n

.meas tran vdout1_32ck680 FIND v(dout1_32) AT=690.05n

.meas tran vdout1_33ck680 FIND v(dout1_33) AT=690.05n

.meas tran vdout1_34ck680 FIND v(dout1_34) AT=690.05n

.meas tran vdout1_35ck680 FIND v(dout1_35) AT=690.05n

.meas tran vdout1_36ck680 FIND v(dout1_36) AT=690.05n

.meas tran vdout1_37ck680 FIND v(dout1_37) AT=690.05n

.meas tran vdout1_38ck680 FIND v(dout1_38) AT=690.05n

.meas tran vdout1_39ck680 FIND v(dout1_39) AT=690.05n

.meas tran vdout1_40ck680 FIND v(dout1_40) AT=690.05n

.meas tran vdout1_41ck680 FIND v(dout1_41) AT=690.05n

.meas tran vdout1_42ck680 FIND v(dout1_42) AT=690.05n

.meas tran vdout1_43ck680 FIND v(dout1_43) AT=690.05n

.meas tran vdout1_44ck680 FIND v(dout1_44) AT=690.05n

.meas tran vdout1_45ck680 FIND v(dout1_45) AT=690.05n

.meas tran vdout1_46ck680 FIND v(dout1_46) AT=690.05n

.meas tran vdout1_47ck680 FIND v(dout1_47) AT=690.05n

.meas tran vdout1_48ck680 FIND v(dout1_48) AT=690.05n

.meas tran vdout1_49ck680 FIND v(dout1_49) AT=690.05n

.meas tran vdout1_50ck680 FIND v(dout1_50) AT=690.05n

.meas tran vdout1_51ck680 FIND v(dout1_51) AT=690.05n

.meas tran vdout1_52ck680 FIND v(dout1_52) AT=690.05n

.meas tran vdout1_53ck680 FIND v(dout1_53) AT=690.05n

.meas tran vdout1_54ck680 FIND v(dout1_54) AT=690.05n

.meas tran vdout1_55ck680 FIND v(dout1_55) AT=690.05n

.meas tran vdout1_56ck680 FIND v(dout1_56) AT=690.05n

.meas tran vdout1_57ck680 FIND v(dout1_57) AT=690.05n

.meas tran vdout1_58ck680 FIND v(dout1_58) AT=690.05n

.meas tran vdout1_59ck680 FIND v(dout1_59) AT=690.05n

.meas tran vdout1_60ck680 FIND v(dout1_60) AT=690.05n

.meas tran vdout1_61ck680 FIND v(dout1_61) AT=690.05n

.meas tran vdout1_62ck680 FIND v(dout1_62) AT=690.05n

.meas tran vdout1_63ck680 FIND v(dout1_63) AT=690.05n

.meas tran vdout0_0ck690 FIND v(dout0_0) AT=700.05n

.meas tran vdout0_1ck690 FIND v(dout0_1) AT=700.05n

.meas tran vdout0_2ck690 FIND v(dout0_2) AT=700.05n

.meas tran vdout0_3ck690 FIND v(dout0_3) AT=700.05n

.meas tran vdout0_4ck690 FIND v(dout0_4) AT=700.05n

.meas tran vdout0_5ck690 FIND v(dout0_5) AT=700.05n

.meas tran vdout0_6ck690 FIND v(dout0_6) AT=700.05n

.meas tran vdout0_7ck690 FIND v(dout0_7) AT=700.05n

.meas tran vdout0_8ck690 FIND v(dout0_8) AT=700.05n

.meas tran vdout0_9ck690 FIND v(dout0_9) AT=700.05n

.meas tran vdout0_10ck690 FIND v(dout0_10) AT=700.05n

.meas tran vdout0_11ck690 FIND v(dout0_11) AT=700.05n

.meas tran vdout0_12ck690 FIND v(dout0_12) AT=700.05n

.meas tran vdout0_13ck690 FIND v(dout0_13) AT=700.05n

.meas tran vdout0_14ck690 FIND v(dout0_14) AT=700.05n

.meas tran vdout0_15ck690 FIND v(dout0_15) AT=700.05n

.meas tran vdout0_16ck690 FIND v(dout0_16) AT=700.05n

.meas tran vdout0_17ck690 FIND v(dout0_17) AT=700.05n

.meas tran vdout0_18ck690 FIND v(dout0_18) AT=700.05n

.meas tran vdout0_19ck690 FIND v(dout0_19) AT=700.05n

.meas tran vdout0_20ck690 FIND v(dout0_20) AT=700.05n

.meas tran vdout0_21ck690 FIND v(dout0_21) AT=700.05n

.meas tran vdout0_22ck690 FIND v(dout0_22) AT=700.05n

.meas tran vdout0_23ck690 FIND v(dout0_23) AT=700.05n

.meas tran vdout0_24ck690 FIND v(dout0_24) AT=700.05n

.meas tran vdout0_25ck690 FIND v(dout0_25) AT=700.05n

.meas tran vdout0_26ck690 FIND v(dout0_26) AT=700.05n

.meas tran vdout0_27ck690 FIND v(dout0_27) AT=700.05n

.meas tran vdout0_28ck690 FIND v(dout0_28) AT=700.05n

.meas tran vdout0_29ck690 FIND v(dout0_29) AT=700.05n

.meas tran vdout0_30ck690 FIND v(dout0_30) AT=700.05n

.meas tran vdout0_31ck690 FIND v(dout0_31) AT=700.05n

.meas tran vdout0_32ck690 FIND v(dout0_32) AT=700.05n

.meas tran vdout0_33ck690 FIND v(dout0_33) AT=700.05n

.meas tran vdout0_34ck690 FIND v(dout0_34) AT=700.05n

.meas tran vdout0_35ck690 FIND v(dout0_35) AT=700.05n

.meas tran vdout0_36ck690 FIND v(dout0_36) AT=700.05n

.meas tran vdout0_37ck690 FIND v(dout0_37) AT=700.05n

.meas tran vdout0_38ck690 FIND v(dout0_38) AT=700.05n

.meas tran vdout0_39ck690 FIND v(dout0_39) AT=700.05n

.meas tran vdout0_40ck690 FIND v(dout0_40) AT=700.05n

.meas tran vdout0_41ck690 FIND v(dout0_41) AT=700.05n

.meas tran vdout0_42ck690 FIND v(dout0_42) AT=700.05n

.meas tran vdout0_43ck690 FIND v(dout0_43) AT=700.05n

.meas tran vdout0_44ck690 FIND v(dout0_44) AT=700.05n

.meas tran vdout0_45ck690 FIND v(dout0_45) AT=700.05n

.meas tran vdout0_46ck690 FIND v(dout0_46) AT=700.05n

.meas tran vdout0_47ck690 FIND v(dout0_47) AT=700.05n

.meas tran vdout0_48ck690 FIND v(dout0_48) AT=700.05n

.meas tran vdout0_49ck690 FIND v(dout0_49) AT=700.05n

.meas tran vdout0_50ck690 FIND v(dout0_50) AT=700.05n

.meas tran vdout0_51ck690 FIND v(dout0_51) AT=700.05n

.meas tran vdout0_52ck690 FIND v(dout0_52) AT=700.05n

.meas tran vdout0_53ck690 FIND v(dout0_53) AT=700.05n

.meas tran vdout0_54ck690 FIND v(dout0_54) AT=700.05n

.meas tran vdout0_55ck690 FIND v(dout0_55) AT=700.05n

.meas tran vdout0_56ck690 FIND v(dout0_56) AT=700.05n

.meas tran vdout0_57ck690 FIND v(dout0_57) AT=700.05n

.meas tran vdout0_58ck690 FIND v(dout0_58) AT=700.05n

.meas tran vdout0_59ck690 FIND v(dout0_59) AT=700.05n

.meas tran vdout0_60ck690 FIND v(dout0_60) AT=700.05n

.meas tran vdout0_61ck690 FIND v(dout0_61) AT=700.05n

.meas tran vdout0_62ck690 FIND v(dout0_62) AT=700.05n

.meas tran vdout0_63ck690 FIND v(dout0_63) AT=700.05n

.meas tran vdout1_0ck690 FIND v(dout1_0) AT=700.05n

.meas tran vdout1_1ck690 FIND v(dout1_1) AT=700.05n

.meas tran vdout1_2ck690 FIND v(dout1_2) AT=700.05n

.meas tran vdout1_3ck690 FIND v(dout1_3) AT=700.05n

.meas tran vdout1_4ck690 FIND v(dout1_4) AT=700.05n

.meas tran vdout1_5ck690 FIND v(dout1_5) AT=700.05n

.meas tran vdout1_6ck690 FIND v(dout1_6) AT=700.05n

.meas tran vdout1_7ck690 FIND v(dout1_7) AT=700.05n

.meas tran vdout1_8ck690 FIND v(dout1_8) AT=700.05n

.meas tran vdout1_9ck690 FIND v(dout1_9) AT=700.05n

.meas tran vdout1_10ck690 FIND v(dout1_10) AT=700.05n

.meas tran vdout1_11ck690 FIND v(dout1_11) AT=700.05n

.meas tran vdout1_12ck690 FIND v(dout1_12) AT=700.05n

.meas tran vdout1_13ck690 FIND v(dout1_13) AT=700.05n

.meas tran vdout1_14ck690 FIND v(dout1_14) AT=700.05n

.meas tran vdout1_15ck690 FIND v(dout1_15) AT=700.05n

.meas tran vdout1_16ck690 FIND v(dout1_16) AT=700.05n

.meas tran vdout1_17ck690 FIND v(dout1_17) AT=700.05n

.meas tran vdout1_18ck690 FIND v(dout1_18) AT=700.05n

.meas tran vdout1_19ck690 FIND v(dout1_19) AT=700.05n

.meas tran vdout1_20ck690 FIND v(dout1_20) AT=700.05n

.meas tran vdout1_21ck690 FIND v(dout1_21) AT=700.05n

.meas tran vdout1_22ck690 FIND v(dout1_22) AT=700.05n

.meas tran vdout1_23ck690 FIND v(dout1_23) AT=700.05n

.meas tran vdout1_24ck690 FIND v(dout1_24) AT=700.05n

.meas tran vdout1_25ck690 FIND v(dout1_25) AT=700.05n

.meas tran vdout1_26ck690 FIND v(dout1_26) AT=700.05n

.meas tran vdout1_27ck690 FIND v(dout1_27) AT=700.05n

.meas tran vdout1_28ck690 FIND v(dout1_28) AT=700.05n

.meas tran vdout1_29ck690 FIND v(dout1_29) AT=700.05n

.meas tran vdout1_30ck690 FIND v(dout1_30) AT=700.05n

.meas tran vdout1_31ck690 FIND v(dout1_31) AT=700.05n

.meas tran vdout1_32ck690 FIND v(dout1_32) AT=700.05n

.meas tran vdout1_33ck690 FIND v(dout1_33) AT=700.05n

.meas tran vdout1_34ck690 FIND v(dout1_34) AT=700.05n

.meas tran vdout1_35ck690 FIND v(dout1_35) AT=700.05n

.meas tran vdout1_36ck690 FIND v(dout1_36) AT=700.05n

.meas tran vdout1_37ck690 FIND v(dout1_37) AT=700.05n

.meas tran vdout1_38ck690 FIND v(dout1_38) AT=700.05n

.meas tran vdout1_39ck690 FIND v(dout1_39) AT=700.05n

.meas tran vdout1_40ck690 FIND v(dout1_40) AT=700.05n

.meas tran vdout1_41ck690 FIND v(dout1_41) AT=700.05n

.meas tran vdout1_42ck690 FIND v(dout1_42) AT=700.05n

.meas tran vdout1_43ck690 FIND v(dout1_43) AT=700.05n

.meas tran vdout1_44ck690 FIND v(dout1_44) AT=700.05n

.meas tran vdout1_45ck690 FIND v(dout1_45) AT=700.05n

.meas tran vdout1_46ck690 FIND v(dout1_46) AT=700.05n

.meas tran vdout1_47ck690 FIND v(dout1_47) AT=700.05n

.meas tran vdout1_48ck690 FIND v(dout1_48) AT=700.05n

.meas tran vdout1_49ck690 FIND v(dout1_49) AT=700.05n

.meas tran vdout1_50ck690 FIND v(dout1_50) AT=700.05n

.meas tran vdout1_51ck690 FIND v(dout1_51) AT=700.05n

.meas tran vdout1_52ck690 FIND v(dout1_52) AT=700.05n

.meas tran vdout1_53ck690 FIND v(dout1_53) AT=700.05n

.meas tran vdout1_54ck690 FIND v(dout1_54) AT=700.05n

.meas tran vdout1_55ck690 FIND v(dout1_55) AT=700.05n

.meas tran vdout1_56ck690 FIND v(dout1_56) AT=700.05n

.meas tran vdout1_57ck690 FIND v(dout1_57) AT=700.05n

.meas tran vdout1_58ck690 FIND v(dout1_58) AT=700.05n

.meas tran vdout1_59ck690 FIND v(dout1_59) AT=700.05n

.meas tran vdout1_60ck690 FIND v(dout1_60) AT=700.05n

.meas tran vdout1_61ck690 FIND v(dout1_61) AT=700.05n

.meas tran vdout1_62ck690 FIND v(dout1_62) AT=700.05n

.meas tran vdout1_63ck690 FIND v(dout1_63) AT=700.05n

.meas tran vdout0_0ck700 FIND v(dout0_0) AT=710.05n

.meas tran vdout0_1ck700 FIND v(dout0_1) AT=710.05n

.meas tran vdout0_2ck700 FIND v(dout0_2) AT=710.05n

.meas tran vdout0_3ck700 FIND v(dout0_3) AT=710.05n

.meas tran vdout0_4ck700 FIND v(dout0_4) AT=710.05n

.meas tran vdout0_5ck700 FIND v(dout0_5) AT=710.05n

.meas tran vdout0_6ck700 FIND v(dout0_6) AT=710.05n

.meas tran vdout0_7ck700 FIND v(dout0_7) AT=710.05n

.meas tran vdout0_8ck700 FIND v(dout0_8) AT=710.05n

.meas tran vdout0_9ck700 FIND v(dout0_9) AT=710.05n

.meas tran vdout0_10ck700 FIND v(dout0_10) AT=710.05n

.meas tran vdout0_11ck700 FIND v(dout0_11) AT=710.05n

.meas tran vdout0_12ck700 FIND v(dout0_12) AT=710.05n

.meas tran vdout0_13ck700 FIND v(dout0_13) AT=710.05n

.meas tran vdout0_14ck700 FIND v(dout0_14) AT=710.05n

.meas tran vdout0_15ck700 FIND v(dout0_15) AT=710.05n

.meas tran vdout0_16ck700 FIND v(dout0_16) AT=710.05n

.meas tran vdout0_17ck700 FIND v(dout0_17) AT=710.05n

.meas tran vdout0_18ck700 FIND v(dout0_18) AT=710.05n

.meas tran vdout0_19ck700 FIND v(dout0_19) AT=710.05n

.meas tran vdout0_20ck700 FIND v(dout0_20) AT=710.05n

.meas tran vdout0_21ck700 FIND v(dout0_21) AT=710.05n

.meas tran vdout0_22ck700 FIND v(dout0_22) AT=710.05n

.meas tran vdout0_23ck700 FIND v(dout0_23) AT=710.05n

.meas tran vdout0_24ck700 FIND v(dout0_24) AT=710.05n

.meas tran vdout0_25ck700 FIND v(dout0_25) AT=710.05n

.meas tran vdout0_26ck700 FIND v(dout0_26) AT=710.05n

.meas tran vdout0_27ck700 FIND v(dout0_27) AT=710.05n

.meas tran vdout0_28ck700 FIND v(dout0_28) AT=710.05n

.meas tran vdout0_29ck700 FIND v(dout0_29) AT=710.05n

.meas tran vdout0_30ck700 FIND v(dout0_30) AT=710.05n

.meas tran vdout0_31ck700 FIND v(dout0_31) AT=710.05n

.meas tran vdout0_32ck700 FIND v(dout0_32) AT=710.05n

.meas tran vdout0_33ck700 FIND v(dout0_33) AT=710.05n

.meas tran vdout0_34ck700 FIND v(dout0_34) AT=710.05n

.meas tran vdout0_35ck700 FIND v(dout0_35) AT=710.05n

.meas tran vdout0_36ck700 FIND v(dout0_36) AT=710.05n

.meas tran vdout0_37ck700 FIND v(dout0_37) AT=710.05n

.meas tran vdout0_38ck700 FIND v(dout0_38) AT=710.05n

.meas tran vdout0_39ck700 FIND v(dout0_39) AT=710.05n

.meas tran vdout0_40ck700 FIND v(dout0_40) AT=710.05n

.meas tran vdout0_41ck700 FIND v(dout0_41) AT=710.05n

.meas tran vdout0_42ck700 FIND v(dout0_42) AT=710.05n

.meas tran vdout0_43ck700 FIND v(dout0_43) AT=710.05n

.meas tran vdout0_44ck700 FIND v(dout0_44) AT=710.05n

.meas tran vdout0_45ck700 FIND v(dout0_45) AT=710.05n

.meas tran vdout0_46ck700 FIND v(dout0_46) AT=710.05n

.meas tran vdout0_47ck700 FIND v(dout0_47) AT=710.05n

.meas tran vdout0_48ck700 FIND v(dout0_48) AT=710.05n

.meas tran vdout0_49ck700 FIND v(dout0_49) AT=710.05n

.meas tran vdout0_50ck700 FIND v(dout0_50) AT=710.05n

.meas tran vdout0_51ck700 FIND v(dout0_51) AT=710.05n

.meas tran vdout0_52ck700 FIND v(dout0_52) AT=710.05n

.meas tran vdout0_53ck700 FIND v(dout0_53) AT=710.05n

.meas tran vdout0_54ck700 FIND v(dout0_54) AT=710.05n

.meas tran vdout0_55ck700 FIND v(dout0_55) AT=710.05n

.meas tran vdout0_56ck700 FIND v(dout0_56) AT=710.05n

.meas tran vdout0_57ck700 FIND v(dout0_57) AT=710.05n

.meas tran vdout0_58ck700 FIND v(dout0_58) AT=710.05n

.meas tran vdout0_59ck700 FIND v(dout0_59) AT=710.05n

.meas tran vdout0_60ck700 FIND v(dout0_60) AT=710.05n

.meas tran vdout0_61ck700 FIND v(dout0_61) AT=710.05n

.meas tran vdout0_62ck700 FIND v(dout0_62) AT=710.05n

.meas tran vdout0_63ck700 FIND v(dout0_63) AT=710.05n

.meas tran vdout0_0ck710 FIND v(dout0_0) AT=720.05n

.meas tran vdout0_1ck710 FIND v(dout0_1) AT=720.05n

.meas tran vdout0_2ck710 FIND v(dout0_2) AT=720.05n

.meas tran vdout0_3ck710 FIND v(dout0_3) AT=720.05n

.meas tran vdout0_4ck710 FIND v(dout0_4) AT=720.05n

.meas tran vdout0_5ck710 FIND v(dout0_5) AT=720.05n

.meas tran vdout0_6ck710 FIND v(dout0_6) AT=720.05n

.meas tran vdout0_7ck710 FIND v(dout0_7) AT=720.05n

.meas tran vdout0_8ck710 FIND v(dout0_8) AT=720.05n

.meas tran vdout0_9ck710 FIND v(dout0_9) AT=720.05n

.meas tran vdout0_10ck710 FIND v(dout0_10) AT=720.05n

.meas tran vdout0_11ck710 FIND v(dout0_11) AT=720.05n

.meas tran vdout0_12ck710 FIND v(dout0_12) AT=720.05n

.meas tran vdout0_13ck710 FIND v(dout0_13) AT=720.05n

.meas tran vdout0_14ck710 FIND v(dout0_14) AT=720.05n

.meas tran vdout0_15ck710 FIND v(dout0_15) AT=720.05n

.meas tran vdout0_16ck710 FIND v(dout0_16) AT=720.05n

.meas tran vdout0_17ck710 FIND v(dout0_17) AT=720.05n

.meas tran vdout0_18ck710 FIND v(dout0_18) AT=720.05n

.meas tran vdout0_19ck710 FIND v(dout0_19) AT=720.05n

.meas tran vdout0_20ck710 FIND v(dout0_20) AT=720.05n

.meas tran vdout0_21ck710 FIND v(dout0_21) AT=720.05n

.meas tran vdout0_22ck710 FIND v(dout0_22) AT=720.05n

.meas tran vdout0_23ck710 FIND v(dout0_23) AT=720.05n

.meas tran vdout0_24ck710 FIND v(dout0_24) AT=720.05n

.meas tran vdout0_25ck710 FIND v(dout0_25) AT=720.05n

.meas tran vdout0_26ck710 FIND v(dout0_26) AT=720.05n

.meas tran vdout0_27ck710 FIND v(dout0_27) AT=720.05n

.meas tran vdout0_28ck710 FIND v(dout0_28) AT=720.05n

.meas tran vdout0_29ck710 FIND v(dout0_29) AT=720.05n

.meas tran vdout0_30ck710 FIND v(dout0_30) AT=720.05n

.meas tran vdout0_31ck710 FIND v(dout0_31) AT=720.05n

.meas tran vdout0_32ck710 FIND v(dout0_32) AT=720.05n

.meas tran vdout0_33ck710 FIND v(dout0_33) AT=720.05n

.meas tran vdout0_34ck710 FIND v(dout0_34) AT=720.05n

.meas tran vdout0_35ck710 FIND v(dout0_35) AT=720.05n

.meas tran vdout0_36ck710 FIND v(dout0_36) AT=720.05n

.meas tran vdout0_37ck710 FIND v(dout0_37) AT=720.05n

.meas tran vdout0_38ck710 FIND v(dout0_38) AT=720.05n

.meas tran vdout0_39ck710 FIND v(dout0_39) AT=720.05n

.meas tran vdout0_40ck710 FIND v(dout0_40) AT=720.05n

.meas tran vdout0_41ck710 FIND v(dout0_41) AT=720.05n

.meas tran vdout0_42ck710 FIND v(dout0_42) AT=720.05n

.meas tran vdout0_43ck710 FIND v(dout0_43) AT=720.05n

.meas tran vdout0_44ck710 FIND v(dout0_44) AT=720.05n

.meas tran vdout0_45ck710 FIND v(dout0_45) AT=720.05n

.meas tran vdout0_46ck710 FIND v(dout0_46) AT=720.05n

.meas tran vdout0_47ck710 FIND v(dout0_47) AT=720.05n

.meas tran vdout0_48ck710 FIND v(dout0_48) AT=720.05n

.meas tran vdout0_49ck710 FIND v(dout0_49) AT=720.05n

.meas tran vdout0_50ck710 FIND v(dout0_50) AT=720.05n

.meas tran vdout0_51ck710 FIND v(dout0_51) AT=720.05n

.meas tran vdout0_52ck710 FIND v(dout0_52) AT=720.05n

.meas tran vdout0_53ck710 FIND v(dout0_53) AT=720.05n

.meas tran vdout0_54ck710 FIND v(dout0_54) AT=720.05n

.meas tran vdout0_55ck710 FIND v(dout0_55) AT=720.05n

.meas tran vdout0_56ck710 FIND v(dout0_56) AT=720.05n

.meas tran vdout0_57ck710 FIND v(dout0_57) AT=720.05n

.meas tran vdout0_58ck710 FIND v(dout0_58) AT=720.05n

.meas tran vdout0_59ck710 FIND v(dout0_59) AT=720.05n

.meas tran vdout0_60ck710 FIND v(dout0_60) AT=720.05n

.meas tran vdout0_61ck710 FIND v(dout0_61) AT=720.05n

.meas tran vdout0_62ck710 FIND v(dout0_62) AT=720.05n

.meas tran vdout0_63ck710 FIND v(dout0_63) AT=720.05n

.meas tran vdout1_0ck710 FIND v(dout1_0) AT=720.05n

.meas tran vdout1_1ck710 FIND v(dout1_1) AT=720.05n

.meas tran vdout1_2ck710 FIND v(dout1_2) AT=720.05n

.meas tran vdout1_3ck710 FIND v(dout1_3) AT=720.05n

.meas tran vdout1_4ck710 FIND v(dout1_4) AT=720.05n

.meas tran vdout1_5ck710 FIND v(dout1_5) AT=720.05n

.meas tran vdout1_6ck710 FIND v(dout1_6) AT=720.05n

.meas tran vdout1_7ck710 FIND v(dout1_7) AT=720.05n

.meas tran vdout1_8ck710 FIND v(dout1_8) AT=720.05n

.meas tran vdout1_9ck710 FIND v(dout1_9) AT=720.05n

.meas tran vdout1_10ck710 FIND v(dout1_10) AT=720.05n

.meas tran vdout1_11ck710 FIND v(dout1_11) AT=720.05n

.meas tran vdout1_12ck710 FIND v(dout1_12) AT=720.05n

.meas tran vdout1_13ck710 FIND v(dout1_13) AT=720.05n

.meas tran vdout1_14ck710 FIND v(dout1_14) AT=720.05n

.meas tran vdout1_15ck710 FIND v(dout1_15) AT=720.05n

.meas tran vdout1_16ck710 FIND v(dout1_16) AT=720.05n

.meas tran vdout1_17ck710 FIND v(dout1_17) AT=720.05n

.meas tran vdout1_18ck710 FIND v(dout1_18) AT=720.05n

.meas tran vdout1_19ck710 FIND v(dout1_19) AT=720.05n

.meas tran vdout1_20ck710 FIND v(dout1_20) AT=720.05n

.meas tran vdout1_21ck710 FIND v(dout1_21) AT=720.05n

.meas tran vdout1_22ck710 FIND v(dout1_22) AT=720.05n

.meas tran vdout1_23ck710 FIND v(dout1_23) AT=720.05n

.meas tran vdout1_24ck710 FIND v(dout1_24) AT=720.05n

.meas tran vdout1_25ck710 FIND v(dout1_25) AT=720.05n

.meas tran vdout1_26ck710 FIND v(dout1_26) AT=720.05n

.meas tran vdout1_27ck710 FIND v(dout1_27) AT=720.05n

.meas tran vdout1_28ck710 FIND v(dout1_28) AT=720.05n

.meas tran vdout1_29ck710 FIND v(dout1_29) AT=720.05n

.meas tran vdout1_30ck710 FIND v(dout1_30) AT=720.05n

.meas tran vdout1_31ck710 FIND v(dout1_31) AT=720.05n

.meas tran vdout1_32ck710 FIND v(dout1_32) AT=720.05n

.meas tran vdout1_33ck710 FIND v(dout1_33) AT=720.05n

.meas tran vdout1_34ck710 FIND v(dout1_34) AT=720.05n

.meas tran vdout1_35ck710 FIND v(dout1_35) AT=720.05n

.meas tran vdout1_36ck710 FIND v(dout1_36) AT=720.05n

.meas tran vdout1_37ck710 FIND v(dout1_37) AT=720.05n

.meas tran vdout1_38ck710 FIND v(dout1_38) AT=720.05n

.meas tran vdout1_39ck710 FIND v(dout1_39) AT=720.05n

.meas tran vdout1_40ck710 FIND v(dout1_40) AT=720.05n

.meas tran vdout1_41ck710 FIND v(dout1_41) AT=720.05n

.meas tran vdout1_42ck710 FIND v(dout1_42) AT=720.05n

.meas tran vdout1_43ck710 FIND v(dout1_43) AT=720.05n

.meas tran vdout1_44ck710 FIND v(dout1_44) AT=720.05n

.meas tran vdout1_45ck710 FIND v(dout1_45) AT=720.05n

.meas tran vdout1_46ck710 FIND v(dout1_46) AT=720.05n

.meas tran vdout1_47ck710 FIND v(dout1_47) AT=720.05n

.meas tran vdout1_48ck710 FIND v(dout1_48) AT=720.05n

.meas tran vdout1_49ck710 FIND v(dout1_49) AT=720.05n

.meas tran vdout1_50ck710 FIND v(dout1_50) AT=720.05n

.meas tran vdout1_51ck710 FIND v(dout1_51) AT=720.05n

.meas tran vdout1_52ck710 FIND v(dout1_52) AT=720.05n

.meas tran vdout1_53ck710 FIND v(dout1_53) AT=720.05n

.meas tran vdout1_54ck710 FIND v(dout1_54) AT=720.05n

.meas tran vdout1_55ck710 FIND v(dout1_55) AT=720.05n

.meas tran vdout1_56ck710 FIND v(dout1_56) AT=720.05n

.meas tran vdout1_57ck710 FIND v(dout1_57) AT=720.05n

.meas tran vdout1_58ck710 FIND v(dout1_58) AT=720.05n

.meas tran vdout1_59ck710 FIND v(dout1_59) AT=720.05n

.meas tran vdout1_60ck710 FIND v(dout1_60) AT=720.05n

.meas tran vdout1_61ck710 FIND v(dout1_61) AT=720.05n

.meas tran vdout1_62ck710 FIND v(dout1_62) AT=720.05n

.meas tran vdout1_63ck710 FIND v(dout1_63) AT=720.05n

.meas tran vdout1_0ck720 FIND v(dout1_0) AT=730.05n

.meas tran vdout1_1ck720 FIND v(dout1_1) AT=730.05n

.meas tran vdout1_2ck720 FIND v(dout1_2) AT=730.05n

.meas tran vdout1_3ck720 FIND v(dout1_3) AT=730.05n

.meas tran vdout1_4ck720 FIND v(dout1_4) AT=730.05n

.meas tran vdout1_5ck720 FIND v(dout1_5) AT=730.05n

.meas tran vdout1_6ck720 FIND v(dout1_6) AT=730.05n

.meas tran vdout1_7ck720 FIND v(dout1_7) AT=730.05n

.meas tran vdout1_8ck720 FIND v(dout1_8) AT=730.05n

.meas tran vdout1_9ck720 FIND v(dout1_9) AT=730.05n

.meas tran vdout1_10ck720 FIND v(dout1_10) AT=730.05n

.meas tran vdout1_11ck720 FIND v(dout1_11) AT=730.05n

.meas tran vdout1_12ck720 FIND v(dout1_12) AT=730.05n

.meas tran vdout1_13ck720 FIND v(dout1_13) AT=730.05n

.meas tran vdout1_14ck720 FIND v(dout1_14) AT=730.05n

.meas tran vdout1_15ck720 FIND v(dout1_15) AT=730.05n

.meas tran vdout1_16ck720 FIND v(dout1_16) AT=730.05n

.meas tran vdout1_17ck720 FIND v(dout1_17) AT=730.05n

.meas tran vdout1_18ck720 FIND v(dout1_18) AT=730.05n

.meas tran vdout1_19ck720 FIND v(dout1_19) AT=730.05n

.meas tran vdout1_20ck720 FIND v(dout1_20) AT=730.05n

.meas tran vdout1_21ck720 FIND v(dout1_21) AT=730.05n

.meas tran vdout1_22ck720 FIND v(dout1_22) AT=730.05n

.meas tran vdout1_23ck720 FIND v(dout1_23) AT=730.05n

.meas tran vdout1_24ck720 FIND v(dout1_24) AT=730.05n

.meas tran vdout1_25ck720 FIND v(dout1_25) AT=730.05n

.meas tran vdout1_26ck720 FIND v(dout1_26) AT=730.05n

.meas tran vdout1_27ck720 FIND v(dout1_27) AT=730.05n

.meas tran vdout1_28ck720 FIND v(dout1_28) AT=730.05n

.meas tran vdout1_29ck720 FIND v(dout1_29) AT=730.05n

.meas tran vdout1_30ck720 FIND v(dout1_30) AT=730.05n

.meas tran vdout1_31ck720 FIND v(dout1_31) AT=730.05n

.meas tran vdout1_32ck720 FIND v(dout1_32) AT=730.05n

.meas tran vdout1_33ck720 FIND v(dout1_33) AT=730.05n

.meas tran vdout1_34ck720 FIND v(dout1_34) AT=730.05n

.meas tran vdout1_35ck720 FIND v(dout1_35) AT=730.05n

.meas tran vdout1_36ck720 FIND v(dout1_36) AT=730.05n

.meas tran vdout1_37ck720 FIND v(dout1_37) AT=730.05n

.meas tran vdout1_38ck720 FIND v(dout1_38) AT=730.05n

.meas tran vdout1_39ck720 FIND v(dout1_39) AT=730.05n

.meas tran vdout1_40ck720 FIND v(dout1_40) AT=730.05n

.meas tran vdout1_41ck720 FIND v(dout1_41) AT=730.05n

.meas tran vdout1_42ck720 FIND v(dout1_42) AT=730.05n

.meas tran vdout1_43ck720 FIND v(dout1_43) AT=730.05n

.meas tran vdout1_44ck720 FIND v(dout1_44) AT=730.05n

.meas tran vdout1_45ck720 FIND v(dout1_45) AT=730.05n

.meas tran vdout1_46ck720 FIND v(dout1_46) AT=730.05n

.meas tran vdout1_47ck720 FIND v(dout1_47) AT=730.05n

.meas tran vdout1_48ck720 FIND v(dout1_48) AT=730.05n

.meas tran vdout1_49ck720 FIND v(dout1_49) AT=730.05n

.meas tran vdout1_50ck720 FIND v(dout1_50) AT=730.05n

.meas tran vdout1_51ck720 FIND v(dout1_51) AT=730.05n

.meas tran vdout1_52ck720 FIND v(dout1_52) AT=730.05n

.meas tran vdout1_53ck720 FIND v(dout1_53) AT=730.05n

.meas tran vdout1_54ck720 FIND v(dout1_54) AT=730.05n

.meas tran vdout1_55ck720 FIND v(dout1_55) AT=730.05n

.meas tran vdout1_56ck720 FIND v(dout1_56) AT=730.05n

.meas tran vdout1_57ck720 FIND v(dout1_57) AT=730.05n

.meas tran vdout1_58ck720 FIND v(dout1_58) AT=730.05n

.meas tran vdout1_59ck720 FIND v(dout1_59) AT=730.05n

.meas tran vdout1_60ck720 FIND v(dout1_60) AT=730.05n

.meas tran vdout1_61ck720 FIND v(dout1_61) AT=730.05n

.meas tran vdout1_62ck720 FIND v(dout1_62) AT=730.05n

.meas tran vdout1_63ck720 FIND v(dout1_63) AT=730.05n

.meas tran vdout1_0ck730 FIND v(dout1_0) AT=740.05n

.meas tran vdout1_1ck730 FIND v(dout1_1) AT=740.05n

.meas tran vdout1_2ck730 FIND v(dout1_2) AT=740.05n

.meas tran vdout1_3ck730 FIND v(dout1_3) AT=740.05n

.meas tran vdout1_4ck730 FIND v(dout1_4) AT=740.05n

.meas tran vdout1_5ck730 FIND v(dout1_5) AT=740.05n

.meas tran vdout1_6ck730 FIND v(dout1_6) AT=740.05n

.meas tran vdout1_7ck730 FIND v(dout1_7) AT=740.05n

.meas tran vdout1_8ck730 FIND v(dout1_8) AT=740.05n

.meas tran vdout1_9ck730 FIND v(dout1_9) AT=740.05n

.meas tran vdout1_10ck730 FIND v(dout1_10) AT=740.05n

.meas tran vdout1_11ck730 FIND v(dout1_11) AT=740.05n

.meas tran vdout1_12ck730 FIND v(dout1_12) AT=740.05n

.meas tran vdout1_13ck730 FIND v(dout1_13) AT=740.05n

.meas tran vdout1_14ck730 FIND v(dout1_14) AT=740.05n

.meas tran vdout1_15ck730 FIND v(dout1_15) AT=740.05n

.meas tran vdout1_16ck730 FIND v(dout1_16) AT=740.05n

.meas tran vdout1_17ck730 FIND v(dout1_17) AT=740.05n

.meas tran vdout1_18ck730 FIND v(dout1_18) AT=740.05n

.meas tran vdout1_19ck730 FIND v(dout1_19) AT=740.05n

.meas tran vdout1_20ck730 FIND v(dout1_20) AT=740.05n

.meas tran vdout1_21ck730 FIND v(dout1_21) AT=740.05n

.meas tran vdout1_22ck730 FIND v(dout1_22) AT=740.05n

.meas tran vdout1_23ck730 FIND v(dout1_23) AT=740.05n

.meas tran vdout1_24ck730 FIND v(dout1_24) AT=740.05n

.meas tran vdout1_25ck730 FIND v(dout1_25) AT=740.05n

.meas tran vdout1_26ck730 FIND v(dout1_26) AT=740.05n

.meas tran vdout1_27ck730 FIND v(dout1_27) AT=740.05n

.meas tran vdout1_28ck730 FIND v(dout1_28) AT=740.05n

.meas tran vdout1_29ck730 FIND v(dout1_29) AT=740.05n

.meas tran vdout1_30ck730 FIND v(dout1_30) AT=740.05n

.meas tran vdout1_31ck730 FIND v(dout1_31) AT=740.05n

.meas tran vdout1_32ck730 FIND v(dout1_32) AT=740.05n

.meas tran vdout1_33ck730 FIND v(dout1_33) AT=740.05n

.meas tran vdout1_34ck730 FIND v(dout1_34) AT=740.05n

.meas tran vdout1_35ck730 FIND v(dout1_35) AT=740.05n

.meas tran vdout1_36ck730 FIND v(dout1_36) AT=740.05n

.meas tran vdout1_37ck730 FIND v(dout1_37) AT=740.05n

.meas tran vdout1_38ck730 FIND v(dout1_38) AT=740.05n

.meas tran vdout1_39ck730 FIND v(dout1_39) AT=740.05n

.meas tran vdout1_40ck730 FIND v(dout1_40) AT=740.05n

.meas tran vdout1_41ck730 FIND v(dout1_41) AT=740.05n

.meas tran vdout1_42ck730 FIND v(dout1_42) AT=740.05n

.meas tran vdout1_43ck730 FIND v(dout1_43) AT=740.05n

.meas tran vdout1_44ck730 FIND v(dout1_44) AT=740.05n

.meas tran vdout1_45ck730 FIND v(dout1_45) AT=740.05n

.meas tran vdout1_46ck730 FIND v(dout1_46) AT=740.05n

.meas tran vdout1_47ck730 FIND v(dout1_47) AT=740.05n

.meas tran vdout1_48ck730 FIND v(dout1_48) AT=740.05n

.meas tran vdout1_49ck730 FIND v(dout1_49) AT=740.05n

.meas tran vdout1_50ck730 FIND v(dout1_50) AT=740.05n

.meas tran vdout1_51ck730 FIND v(dout1_51) AT=740.05n

.meas tran vdout1_52ck730 FIND v(dout1_52) AT=740.05n

.meas tran vdout1_53ck730 FIND v(dout1_53) AT=740.05n

.meas tran vdout1_54ck730 FIND v(dout1_54) AT=740.05n

.meas tran vdout1_55ck730 FIND v(dout1_55) AT=740.05n

.meas tran vdout1_56ck730 FIND v(dout1_56) AT=740.05n

.meas tran vdout1_57ck730 FIND v(dout1_57) AT=740.05n

.meas tran vdout1_58ck730 FIND v(dout1_58) AT=740.05n

.meas tran vdout1_59ck730 FIND v(dout1_59) AT=740.05n

.meas tran vdout1_60ck730 FIND v(dout1_60) AT=740.05n

.meas tran vdout1_61ck730 FIND v(dout1_61) AT=740.05n

.meas tran vdout1_62ck730 FIND v(dout1_62) AT=740.05n

.meas tran vdout1_63ck730 FIND v(dout1_63) AT=740.05n

.meas tran vdout0_0ck750 FIND v(dout0_0) AT=760.05n

.meas tran vdout0_1ck750 FIND v(dout0_1) AT=760.05n

.meas tran vdout0_2ck750 FIND v(dout0_2) AT=760.05n

.meas tran vdout0_3ck750 FIND v(dout0_3) AT=760.05n

.meas tran vdout0_4ck750 FIND v(dout0_4) AT=760.05n

.meas tran vdout0_5ck750 FIND v(dout0_5) AT=760.05n

.meas tran vdout0_6ck750 FIND v(dout0_6) AT=760.05n

.meas tran vdout0_7ck750 FIND v(dout0_7) AT=760.05n

.meas tran vdout0_8ck750 FIND v(dout0_8) AT=760.05n

.meas tran vdout0_9ck750 FIND v(dout0_9) AT=760.05n

.meas tran vdout0_10ck750 FIND v(dout0_10) AT=760.05n

.meas tran vdout0_11ck750 FIND v(dout0_11) AT=760.05n

.meas tran vdout0_12ck750 FIND v(dout0_12) AT=760.05n

.meas tran vdout0_13ck750 FIND v(dout0_13) AT=760.05n

.meas tran vdout0_14ck750 FIND v(dout0_14) AT=760.05n

.meas tran vdout0_15ck750 FIND v(dout0_15) AT=760.05n

.meas tran vdout0_16ck750 FIND v(dout0_16) AT=760.05n

.meas tran vdout0_17ck750 FIND v(dout0_17) AT=760.05n

.meas tran vdout0_18ck750 FIND v(dout0_18) AT=760.05n

.meas tran vdout0_19ck750 FIND v(dout0_19) AT=760.05n

.meas tran vdout0_20ck750 FIND v(dout0_20) AT=760.05n

.meas tran vdout0_21ck750 FIND v(dout0_21) AT=760.05n

.meas tran vdout0_22ck750 FIND v(dout0_22) AT=760.05n

.meas tran vdout0_23ck750 FIND v(dout0_23) AT=760.05n

.meas tran vdout0_24ck750 FIND v(dout0_24) AT=760.05n

.meas tran vdout0_25ck750 FIND v(dout0_25) AT=760.05n

.meas tran vdout0_26ck750 FIND v(dout0_26) AT=760.05n

.meas tran vdout0_27ck750 FIND v(dout0_27) AT=760.05n

.meas tran vdout0_28ck750 FIND v(dout0_28) AT=760.05n

.meas tran vdout0_29ck750 FIND v(dout0_29) AT=760.05n

.meas tran vdout0_30ck750 FIND v(dout0_30) AT=760.05n

.meas tran vdout0_31ck750 FIND v(dout0_31) AT=760.05n

.meas tran vdout0_32ck750 FIND v(dout0_32) AT=760.05n

.meas tran vdout0_33ck750 FIND v(dout0_33) AT=760.05n

.meas tran vdout0_34ck750 FIND v(dout0_34) AT=760.05n

.meas tran vdout0_35ck750 FIND v(dout0_35) AT=760.05n

.meas tran vdout0_36ck750 FIND v(dout0_36) AT=760.05n

.meas tran vdout0_37ck750 FIND v(dout0_37) AT=760.05n

.meas tran vdout0_38ck750 FIND v(dout0_38) AT=760.05n

.meas tran vdout0_39ck750 FIND v(dout0_39) AT=760.05n

.meas tran vdout0_40ck750 FIND v(dout0_40) AT=760.05n

.meas tran vdout0_41ck750 FIND v(dout0_41) AT=760.05n

.meas tran vdout0_42ck750 FIND v(dout0_42) AT=760.05n

.meas tran vdout0_43ck750 FIND v(dout0_43) AT=760.05n

.meas tran vdout0_44ck750 FIND v(dout0_44) AT=760.05n

.meas tran vdout0_45ck750 FIND v(dout0_45) AT=760.05n

.meas tran vdout0_46ck750 FIND v(dout0_46) AT=760.05n

.meas tran vdout0_47ck750 FIND v(dout0_47) AT=760.05n

.meas tran vdout0_48ck750 FIND v(dout0_48) AT=760.05n

.meas tran vdout0_49ck750 FIND v(dout0_49) AT=760.05n

.meas tran vdout0_50ck750 FIND v(dout0_50) AT=760.05n

.meas tran vdout0_51ck750 FIND v(dout0_51) AT=760.05n

.meas tran vdout0_52ck750 FIND v(dout0_52) AT=760.05n

.meas tran vdout0_53ck750 FIND v(dout0_53) AT=760.05n

.meas tran vdout0_54ck750 FIND v(dout0_54) AT=760.05n

.meas tran vdout0_55ck750 FIND v(dout0_55) AT=760.05n

.meas tran vdout0_56ck750 FIND v(dout0_56) AT=760.05n

.meas tran vdout0_57ck750 FIND v(dout0_57) AT=760.05n

.meas tran vdout0_58ck750 FIND v(dout0_58) AT=760.05n

.meas tran vdout0_59ck750 FIND v(dout0_59) AT=760.05n

.meas tran vdout0_60ck750 FIND v(dout0_60) AT=760.05n

.meas tran vdout0_61ck750 FIND v(dout0_61) AT=760.05n

.meas tran vdout0_62ck750 FIND v(dout0_62) AT=760.05n

.meas tran vdout0_63ck750 FIND v(dout0_63) AT=760.05n

.meas tran vdout0_0ck760 FIND v(dout0_0) AT=770.05n

.meas tran vdout0_1ck760 FIND v(dout0_1) AT=770.05n

.meas tran vdout0_2ck760 FIND v(dout0_2) AT=770.05n

.meas tran vdout0_3ck760 FIND v(dout0_3) AT=770.05n

.meas tran vdout0_4ck760 FIND v(dout0_4) AT=770.05n

.meas tran vdout0_5ck760 FIND v(dout0_5) AT=770.05n

.meas tran vdout0_6ck760 FIND v(dout0_6) AT=770.05n

.meas tran vdout0_7ck760 FIND v(dout0_7) AT=770.05n

.meas tran vdout0_8ck760 FIND v(dout0_8) AT=770.05n

.meas tran vdout0_9ck760 FIND v(dout0_9) AT=770.05n

.meas tran vdout0_10ck760 FIND v(dout0_10) AT=770.05n

.meas tran vdout0_11ck760 FIND v(dout0_11) AT=770.05n

.meas tran vdout0_12ck760 FIND v(dout0_12) AT=770.05n

.meas tran vdout0_13ck760 FIND v(dout0_13) AT=770.05n

.meas tran vdout0_14ck760 FIND v(dout0_14) AT=770.05n

.meas tran vdout0_15ck760 FIND v(dout0_15) AT=770.05n

.meas tran vdout0_16ck760 FIND v(dout0_16) AT=770.05n

.meas tran vdout0_17ck760 FIND v(dout0_17) AT=770.05n

.meas tran vdout0_18ck760 FIND v(dout0_18) AT=770.05n

.meas tran vdout0_19ck760 FIND v(dout0_19) AT=770.05n

.meas tran vdout0_20ck760 FIND v(dout0_20) AT=770.05n

.meas tran vdout0_21ck760 FIND v(dout0_21) AT=770.05n

.meas tran vdout0_22ck760 FIND v(dout0_22) AT=770.05n

.meas tran vdout0_23ck760 FIND v(dout0_23) AT=770.05n

.meas tran vdout0_24ck760 FIND v(dout0_24) AT=770.05n

.meas tran vdout0_25ck760 FIND v(dout0_25) AT=770.05n

.meas tran vdout0_26ck760 FIND v(dout0_26) AT=770.05n

.meas tran vdout0_27ck760 FIND v(dout0_27) AT=770.05n

.meas tran vdout0_28ck760 FIND v(dout0_28) AT=770.05n

.meas tran vdout0_29ck760 FIND v(dout0_29) AT=770.05n

.meas tran vdout0_30ck760 FIND v(dout0_30) AT=770.05n

.meas tran vdout0_31ck760 FIND v(dout0_31) AT=770.05n

.meas tran vdout0_32ck760 FIND v(dout0_32) AT=770.05n

.meas tran vdout0_33ck760 FIND v(dout0_33) AT=770.05n

.meas tran vdout0_34ck760 FIND v(dout0_34) AT=770.05n

.meas tran vdout0_35ck760 FIND v(dout0_35) AT=770.05n

.meas tran vdout0_36ck760 FIND v(dout0_36) AT=770.05n

.meas tran vdout0_37ck760 FIND v(dout0_37) AT=770.05n

.meas tran vdout0_38ck760 FIND v(dout0_38) AT=770.05n

.meas tran vdout0_39ck760 FIND v(dout0_39) AT=770.05n

.meas tran vdout0_40ck760 FIND v(dout0_40) AT=770.05n

.meas tran vdout0_41ck760 FIND v(dout0_41) AT=770.05n

.meas tran vdout0_42ck760 FIND v(dout0_42) AT=770.05n

.meas tran vdout0_43ck760 FIND v(dout0_43) AT=770.05n

.meas tran vdout0_44ck760 FIND v(dout0_44) AT=770.05n

.meas tran vdout0_45ck760 FIND v(dout0_45) AT=770.05n

.meas tran vdout0_46ck760 FIND v(dout0_46) AT=770.05n

.meas tran vdout0_47ck760 FIND v(dout0_47) AT=770.05n

.meas tran vdout0_48ck760 FIND v(dout0_48) AT=770.05n

.meas tran vdout0_49ck760 FIND v(dout0_49) AT=770.05n

.meas tran vdout0_50ck760 FIND v(dout0_50) AT=770.05n

.meas tran vdout0_51ck760 FIND v(dout0_51) AT=770.05n

.meas tran vdout0_52ck760 FIND v(dout0_52) AT=770.05n

.meas tran vdout0_53ck760 FIND v(dout0_53) AT=770.05n

.meas tran vdout0_54ck760 FIND v(dout0_54) AT=770.05n

.meas tran vdout0_55ck760 FIND v(dout0_55) AT=770.05n

.meas tran vdout0_56ck760 FIND v(dout0_56) AT=770.05n

.meas tran vdout0_57ck760 FIND v(dout0_57) AT=770.05n

.meas tran vdout0_58ck760 FIND v(dout0_58) AT=770.05n

.meas tran vdout0_59ck760 FIND v(dout0_59) AT=770.05n

.meas tran vdout0_60ck760 FIND v(dout0_60) AT=770.05n

.meas tran vdout0_61ck760 FIND v(dout0_61) AT=770.05n

.meas tran vdout0_62ck760 FIND v(dout0_62) AT=770.05n

.meas tran vdout0_63ck760 FIND v(dout0_63) AT=770.05n

.meas tran vdout0_0ck770 FIND v(dout0_0) AT=780.05n

.meas tran vdout0_1ck770 FIND v(dout0_1) AT=780.05n

.meas tran vdout0_2ck770 FIND v(dout0_2) AT=780.05n

.meas tran vdout0_3ck770 FIND v(dout0_3) AT=780.05n

.meas tran vdout0_4ck770 FIND v(dout0_4) AT=780.05n

.meas tran vdout0_5ck770 FIND v(dout0_5) AT=780.05n

.meas tran vdout0_6ck770 FIND v(dout0_6) AT=780.05n

.meas tran vdout0_7ck770 FIND v(dout0_7) AT=780.05n

.meas tran vdout0_8ck770 FIND v(dout0_8) AT=780.05n

.meas tran vdout0_9ck770 FIND v(dout0_9) AT=780.05n

.meas tran vdout0_10ck770 FIND v(dout0_10) AT=780.05n

.meas tran vdout0_11ck770 FIND v(dout0_11) AT=780.05n

.meas tran vdout0_12ck770 FIND v(dout0_12) AT=780.05n

.meas tran vdout0_13ck770 FIND v(dout0_13) AT=780.05n

.meas tran vdout0_14ck770 FIND v(dout0_14) AT=780.05n

.meas tran vdout0_15ck770 FIND v(dout0_15) AT=780.05n

.meas tran vdout0_16ck770 FIND v(dout0_16) AT=780.05n

.meas tran vdout0_17ck770 FIND v(dout0_17) AT=780.05n

.meas tran vdout0_18ck770 FIND v(dout0_18) AT=780.05n

.meas tran vdout0_19ck770 FIND v(dout0_19) AT=780.05n

.meas tran vdout0_20ck770 FIND v(dout0_20) AT=780.05n

.meas tran vdout0_21ck770 FIND v(dout0_21) AT=780.05n

.meas tran vdout0_22ck770 FIND v(dout0_22) AT=780.05n

.meas tran vdout0_23ck770 FIND v(dout0_23) AT=780.05n

.meas tran vdout0_24ck770 FIND v(dout0_24) AT=780.05n

.meas tran vdout0_25ck770 FIND v(dout0_25) AT=780.05n

.meas tran vdout0_26ck770 FIND v(dout0_26) AT=780.05n

.meas tran vdout0_27ck770 FIND v(dout0_27) AT=780.05n

.meas tran vdout0_28ck770 FIND v(dout0_28) AT=780.05n

.meas tran vdout0_29ck770 FIND v(dout0_29) AT=780.05n

.meas tran vdout0_30ck770 FIND v(dout0_30) AT=780.05n

.meas tran vdout0_31ck770 FIND v(dout0_31) AT=780.05n

.meas tran vdout0_32ck770 FIND v(dout0_32) AT=780.05n

.meas tran vdout0_33ck770 FIND v(dout0_33) AT=780.05n

.meas tran vdout0_34ck770 FIND v(dout0_34) AT=780.05n

.meas tran vdout0_35ck770 FIND v(dout0_35) AT=780.05n

.meas tran vdout0_36ck770 FIND v(dout0_36) AT=780.05n

.meas tran vdout0_37ck770 FIND v(dout0_37) AT=780.05n

.meas tran vdout0_38ck770 FIND v(dout0_38) AT=780.05n

.meas tran vdout0_39ck770 FIND v(dout0_39) AT=780.05n

.meas tran vdout0_40ck770 FIND v(dout0_40) AT=780.05n

.meas tran vdout0_41ck770 FIND v(dout0_41) AT=780.05n

.meas tran vdout0_42ck770 FIND v(dout0_42) AT=780.05n

.meas tran vdout0_43ck770 FIND v(dout0_43) AT=780.05n

.meas tran vdout0_44ck770 FIND v(dout0_44) AT=780.05n

.meas tran vdout0_45ck770 FIND v(dout0_45) AT=780.05n

.meas tran vdout0_46ck770 FIND v(dout0_46) AT=780.05n

.meas tran vdout0_47ck770 FIND v(dout0_47) AT=780.05n

.meas tran vdout0_48ck770 FIND v(dout0_48) AT=780.05n

.meas tran vdout0_49ck770 FIND v(dout0_49) AT=780.05n

.meas tran vdout0_50ck770 FIND v(dout0_50) AT=780.05n

.meas tran vdout0_51ck770 FIND v(dout0_51) AT=780.05n

.meas tran vdout0_52ck770 FIND v(dout0_52) AT=780.05n

.meas tran vdout0_53ck770 FIND v(dout0_53) AT=780.05n

.meas tran vdout0_54ck770 FIND v(dout0_54) AT=780.05n

.meas tran vdout0_55ck770 FIND v(dout0_55) AT=780.05n

.meas tran vdout0_56ck770 FIND v(dout0_56) AT=780.05n

.meas tran vdout0_57ck770 FIND v(dout0_57) AT=780.05n

.meas tran vdout0_58ck770 FIND v(dout0_58) AT=780.05n

.meas tran vdout0_59ck770 FIND v(dout0_59) AT=780.05n

.meas tran vdout0_60ck770 FIND v(dout0_60) AT=780.05n

.meas tran vdout0_61ck770 FIND v(dout0_61) AT=780.05n

.meas tran vdout0_62ck770 FIND v(dout0_62) AT=780.05n

.meas tran vdout0_63ck770 FIND v(dout0_63) AT=780.05n

.meas tran vdout0_0ck780 FIND v(dout0_0) AT=790.05n

.meas tran vdout0_1ck780 FIND v(dout0_1) AT=790.05n

.meas tran vdout0_2ck780 FIND v(dout0_2) AT=790.05n

.meas tran vdout0_3ck780 FIND v(dout0_3) AT=790.05n

.meas tran vdout0_4ck780 FIND v(dout0_4) AT=790.05n

.meas tran vdout0_5ck780 FIND v(dout0_5) AT=790.05n

.meas tran vdout0_6ck780 FIND v(dout0_6) AT=790.05n

.meas tran vdout0_7ck780 FIND v(dout0_7) AT=790.05n

.meas tran vdout0_8ck780 FIND v(dout0_8) AT=790.05n

.meas tran vdout0_9ck780 FIND v(dout0_9) AT=790.05n

.meas tran vdout0_10ck780 FIND v(dout0_10) AT=790.05n

.meas tran vdout0_11ck780 FIND v(dout0_11) AT=790.05n

.meas tran vdout0_12ck780 FIND v(dout0_12) AT=790.05n

.meas tran vdout0_13ck780 FIND v(dout0_13) AT=790.05n

.meas tran vdout0_14ck780 FIND v(dout0_14) AT=790.05n

.meas tran vdout0_15ck780 FIND v(dout0_15) AT=790.05n

.meas tran vdout0_16ck780 FIND v(dout0_16) AT=790.05n

.meas tran vdout0_17ck780 FIND v(dout0_17) AT=790.05n

.meas tran vdout0_18ck780 FIND v(dout0_18) AT=790.05n

.meas tran vdout0_19ck780 FIND v(dout0_19) AT=790.05n

.meas tran vdout0_20ck780 FIND v(dout0_20) AT=790.05n

.meas tran vdout0_21ck780 FIND v(dout0_21) AT=790.05n

.meas tran vdout0_22ck780 FIND v(dout0_22) AT=790.05n

.meas tran vdout0_23ck780 FIND v(dout0_23) AT=790.05n

.meas tran vdout0_24ck780 FIND v(dout0_24) AT=790.05n

.meas tran vdout0_25ck780 FIND v(dout0_25) AT=790.05n

.meas tran vdout0_26ck780 FIND v(dout0_26) AT=790.05n

.meas tran vdout0_27ck780 FIND v(dout0_27) AT=790.05n

.meas tran vdout0_28ck780 FIND v(dout0_28) AT=790.05n

.meas tran vdout0_29ck780 FIND v(dout0_29) AT=790.05n

.meas tran vdout0_30ck780 FIND v(dout0_30) AT=790.05n

.meas tran vdout0_31ck780 FIND v(dout0_31) AT=790.05n

.meas tran vdout0_32ck780 FIND v(dout0_32) AT=790.05n

.meas tran vdout0_33ck780 FIND v(dout0_33) AT=790.05n

.meas tran vdout0_34ck780 FIND v(dout0_34) AT=790.05n

.meas tran vdout0_35ck780 FIND v(dout0_35) AT=790.05n

.meas tran vdout0_36ck780 FIND v(dout0_36) AT=790.05n

.meas tran vdout0_37ck780 FIND v(dout0_37) AT=790.05n

.meas tran vdout0_38ck780 FIND v(dout0_38) AT=790.05n

.meas tran vdout0_39ck780 FIND v(dout0_39) AT=790.05n

.meas tran vdout0_40ck780 FIND v(dout0_40) AT=790.05n

.meas tran vdout0_41ck780 FIND v(dout0_41) AT=790.05n

.meas tran vdout0_42ck780 FIND v(dout0_42) AT=790.05n

.meas tran vdout0_43ck780 FIND v(dout0_43) AT=790.05n

.meas tran vdout0_44ck780 FIND v(dout0_44) AT=790.05n

.meas tran vdout0_45ck780 FIND v(dout0_45) AT=790.05n

.meas tran vdout0_46ck780 FIND v(dout0_46) AT=790.05n

.meas tran vdout0_47ck780 FIND v(dout0_47) AT=790.05n

.meas tran vdout0_48ck780 FIND v(dout0_48) AT=790.05n

.meas tran vdout0_49ck780 FIND v(dout0_49) AT=790.05n

.meas tran vdout0_50ck780 FIND v(dout0_50) AT=790.05n

.meas tran vdout0_51ck780 FIND v(dout0_51) AT=790.05n

.meas tran vdout0_52ck780 FIND v(dout0_52) AT=790.05n

.meas tran vdout0_53ck780 FIND v(dout0_53) AT=790.05n

.meas tran vdout0_54ck780 FIND v(dout0_54) AT=790.05n

.meas tran vdout0_55ck780 FIND v(dout0_55) AT=790.05n

.meas tran vdout0_56ck780 FIND v(dout0_56) AT=790.05n

.meas tran vdout0_57ck780 FIND v(dout0_57) AT=790.05n

.meas tran vdout0_58ck780 FIND v(dout0_58) AT=790.05n

.meas tran vdout0_59ck780 FIND v(dout0_59) AT=790.05n

.meas tran vdout0_60ck780 FIND v(dout0_60) AT=790.05n

.meas tran vdout0_61ck780 FIND v(dout0_61) AT=790.05n

.meas tran vdout0_62ck780 FIND v(dout0_62) AT=790.05n

.meas tran vdout0_63ck780 FIND v(dout0_63) AT=790.05n

.meas tran vdout1_0ck780 FIND v(dout1_0) AT=790.05n

.meas tran vdout1_1ck780 FIND v(dout1_1) AT=790.05n

.meas tran vdout1_2ck780 FIND v(dout1_2) AT=790.05n

.meas tran vdout1_3ck780 FIND v(dout1_3) AT=790.05n

.meas tran vdout1_4ck780 FIND v(dout1_4) AT=790.05n

.meas tran vdout1_5ck780 FIND v(dout1_5) AT=790.05n

.meas tran vdout1_6ck780 FIND v(dout1_6) AT=790.05n

.meas tran vdout1_7ck780 FIND v(dout1_7) AT=790.05n

.meas tran vdout1_8ck780 FIND v(dout1_8) AT=790.05n

.meas tran vdout1_9ck780 FIND v(dout1_9) AT=790.05n

.meas tran vdout1_10ck780 FIND v(dout1_10) AT=790.05n

.meas tran vdout1_11ck780 FIND v(dout1_11) AT=790.05n

.meas tran vdout1_12ck780 FIND v(dout1_12) AT=790.05n

.meas tran vdout1_13ck780 FIND v(dout1_13) AT=790.05n

.meas tran vdout1_14ck780 FIND v(dout1_14) AT=790.05n

.meas tran vdout1_15ck780 FIND v(dout1_15) AT=790.05n

.meas tran vdout1_16ck780 FIND v(dout1_16) AT=790.05n

.meas tran vdout1_17ck780 FIND v(dout1_17) AT=790.05n

.meas tran vdout1_18ck780 FIND v(dout1_18) AT=790.05n

.meas tran vdout1_19ck780 FIND v(dout1_19) AT=790.05n

.meas tran vdout1_20ck780 FIND v(dout1_20) AT=790.05n

.meas tran vdout1_21ck780 FIND v(dout1_21) AT=790.05n

.meas tran vdout1_22ck780 FIND v(dout1_22) AT=790.05n

.meas tran vdout1_23ck780 FIND v(dout1_23) AT=790.05n

.meas tran vdout1_24ck780 FIND v(dout1_24) AT=790.05n

.meas tran vdout1_25ck780 FIND v(dout1_25) AT=790.05n

.meas tran vdout1_26ck780 FIND v(dout1_26) AT=790.05n

.meas tran vdout1_27ck780 FIND v(dout1_27) AT=790.05n

.meas tran vdout1_28ck780 FIND v(dout1_28) AT=790.05n

.meas tran vdout1_29ck780 FIND v(dout1_29) AT=790.05n

.meas tran vdout1_30ck780 FIND v(dout1_30) AT=790.05n

.meas tran vdout1_31ck780 FIND v(dout1_31) AT=790.05n

.meas tran vdout1_32ck780 FIND v(dout1_32) AT=790.05n

.meas tran vdout1_33ck780 FIND v(dout1_33) AT=790.05n

.meas tran vdout1_34ck780 FIND v(dout1_34) AT=790.05n

.meas tran vdout1_35ck780 FIND v(dout1_35) AT=790.05n

.meas tran vdout1_36ck780 FIND v(dout1_36) AT=790.05n

.meas tran vdout1_37ck780 FIND v(dout1_37) AT=790.05n

.meas tran vdout1_38ck780 FIND v(dout1_38) AT=790.05n

.meas tran vdout1_39ck780 FIND v(dout1_39) AT=790.05n

.meas tran vdout1_40ck780 FIND v(dout1_40) AT=790.05n

.meas tran vdout1_41ck780 FIND v(dout1_41) AT=790.05n

.meas tran vdout1_42ck780 FIND v(dout1_42) AT=790.05n

.meas tran vdout1_43ck780 FIND v(dout1_43) AT=790.05n

.meas tran vdout1_44ck780 FIND v(dout1_44) AT=790.05n

.meas tran vdout1_45ck780 FIND v(dout1_45) AT=790.05n

.meas tran vdout1_46ck780 FIND v(dout1_46) AT=790.05n

.meas tran vdout1_47ck780 FIND v(dout1_47) AT=790.05n

.meas tran vdout1_48ck780 FIND v(dout1_48) AT=790.05n

.meas tran vdout1_49ck780 FIND v(dout1_49) AT=790.05n

.meas tran vdout1_50ck780 FIND v(dout1_50) AT=790.05n

.meas tran vdout1_51ck780 FIND v(dout1_51) AT=790.05n

.meas tran vdout1_52ck780 FIND v(dout1_52) AT=790.05n

.meas tran vdout1_53ck780 FIND v(dout1_53) AT=790.05n

.meas tran vdout1_54ck780 FIND v(dout1_54) AT=790.05n

.meas tran vdout1_55ck780 FIND v(dout1_55) AT=790.05n

.meas tran vdout1_56ck780 FIND v(dout1_56) AT=790.05n

.meas tran vdout1_57ck780 FIND v(dout1_57) AT=790.05n

.meas tran vdout1_58ck780 FIND v(dout1_58) AT=790.05n

.meas tran vdout1_59ck780 FIND v(dout1_59) AT=790.05n

.meas tran vdout1_60ck780 FIND v(dout1_60) AT=790.05n

.meas tran vdout1_61ck780 FIND v(dout1_61) AT=790.05n

.meas tran vdout1_62ck780 FIND v(dout1_62) AT=790.05n

.meas tran vdout1_63ck780 FIND v(dout1_63) AT=790.05n

.meas tran vdout1_0ck790 FIND v(dout1_0) AT=800.05n

.meas tran vdout1_1ck790 FIND v(dout1_1) AT=800.05n

.meas tran vdout1_2ck790 FIND v(dout1_2) AT=800.05n

.meas tran vdout1_3ck790 FIND v(dout1_3) AT=800.05n

.meas tran vdout1_4ck790 FIND v(dout1_4) AT=800.05n

.meas tran vdout1_5ck790 FIND v(dout1_5) AT=800.05n

.meas tran vdout1_6ck790 FIND v(dout1_6) AT=800.05n

.meas tran vdout1_7ck790 FIND v(dout1_7) AT=800.05n

.meas tran vdout1_8ck790 FIND v(dout1_8) AT=800.05n

.meas tran vdout1_9ck790 FIND v(dout1_9) AT=800.05n

.meas tran vdout1_10ck790 FIND v(dout1_10) AT=800.05n

.meas tran vdout1_11ck790 FIND v(dout1_11) AT=800.05n

.meas tran vdout1_12ck790 FIND v(dout1_12) AT=800.05n

.meas tran vdout1_13ck790 FIND v(dout1_13) AT=800.05n

.meas tran vdout1_14ck790 FIND v(dout1_14) AT=800.05n

.meas tran vdout1_15ck790 FIND v(dout1_15) AT=800.05n

.meas tran vdout1_16ck790 FIND v(dout1_16) AT=800.05n

.meas tran vdout1_17ck790 FIND v(dout1_17) AT=800.05n

.meas tran vdout1_18ck790 FIND v(dout1_18) AT=800.05n

.meas tran vdout1_19ck790 FIND v(dout1_19) AT=800.05n

.meas tran vdout1_20ck790 FIND v(dout1_20) AT=800.05n

.meas tran vdout1_21ck790 FIND v(dout1_21) AT=800.05n

.meas tran vdout1_22ck790 FIND v(dout1_22) AT=800.05n

.meas tran vdout1_23ck790 FIND v(dout1_23) AT=800.05n

.meas tran vdout1_24ck790 FIND v(dout1_24) AT=800.05n

.meas tran vdout1_25ck790 FIND v(dout1_25) AT=800.05n

.meas tran vdout1_26ck790 FIND v(dout1_26) AT=800.05n

.meas tran vdout1_27ck790 FIND v(dout1_27) AT=800.05n

.meas tran vdout1_28ck790 FIND v(dout1_28) AT=800.05n

.meas tran vdout1_29ck790 FIND v(dout1_29) AT=800.05n

.meas tran vdout1_30ck790 FIND v(dout1_30) AT=800.05n

.meas tran vdout1_31ck790 FIND v(dout1_31) AT=800.05n

.meas tran vdout1_32ck790 FIND v(dout1_32) AT=800.05n

.meas tran vdout1_33ck790 FIND v(dout1_33) AT=800.05n

.meas tran vdout1_34ck790 FIND v(dout1_34) AT=800.05n

.meas tran vdout1_35ck790 FIND v(dout1_35) AT=800.05n

.meas tran vdout1_36ck790 FIND v(dout1_36) AT=800.05n

.meas tran vdout1_37ck790 FIND v(dout1_37) AT=800.05n

.meas tran vdout1_38ck790 FIND v(dout1_38) AT=800.05n

.meas tran vdout1_39ck790 FIND v(dout1_39) AT=800.05n

.meas tran vdout1_40ck790 FIND v(dout1_40) AT=800.05n

.meas tran vdout1_41ck790 FIND v(dout1_41) AT=800.05n

.meas tran vdout1_42ck790 FIND v(dout1_42) AT=800.05n

.meas tran vdout1_43ck790 FIND v(dout1_43) AT=800.05n

.meas tran vdout1_44ck790 FIND v(dout1_44) AT=800.05n

.meas tran vdout1_45ck790 FIND v(dout1_45) AT=800.05n

.meas tran vdout1_46ck790 FIND v(dout1_46) AT=800.05n

.meas tran vdout1_47ck790 FIND v(dout1_47) AT=800.05n

.meas tran vdout1_48ck790 FIND v(dout1_48) AT=800.05n

.meas tran vdout1_49ck790 FIND v(dout1_49) AT=800.05n

.meas tran vdout1_50ck790 FIND v(dout1_50) AT=800.05n

.meas tran vdout1_51ck790 FIND v(dout1_51) AT=800.05n

.meas tran vdout1_52ck790 FIND v(dout1_52) AT=800.05n

.meas tran vdout1_53ck790 FIND v(dout1_53) AT=800.05n

.meas tran vdout1_54ck790 FIND v(dout1_54) AT=800.05n

.meas tran vdout1_55ck790 FIND v(dout1_55) AT=800.05n

.meas tran vdout1_56ck790 FIND v(dout1_56) AT=800.05n

.meas tran vdout1_57ck790 FIND v(dout1_57) AT=800.05n

.meas tran vdout1_58ck790 FIND v(dout1_58) AT=800.05n

.meas tran vdout1_59ck790 FIND v(dout1_59) AT=800.05n

.meas tran vdout1_60ck790 FIND v(dout1_60) AT=800.05n

.meas tran vdout1_61ck790 FIND v(dout1_61) AT=800.05n

.meas tran vdout1_62ck790 FIND v(dout1_62) AT=800.05n

.meas tran vdout1_63ck790 FIND v(dout1_63) AT=800.05n

.meas tran vdout1_0ck820 FIND v(dout1_0) AT=830.05n

.meas tran vdout1_1ck820 FIND v(dout1_1) AT=830.05n

.meas tran vdout1_2ck820 FIND v(dout1_2) AT=830.05n

.meas tran vdout1_3ck820 FIND v(dout1_3) AT=830.05n

.meas tran vdout1_4ck820 FIND v(dout1_4) AT=830.05n

.meas tran vdout1_5ck820 FIND v(dout1_5) AT=830.05n

.meas tran vdout1_6ck820 FIND v(dout1_6) AT=830.05n

.meas tran vdout1_7ck820 FIND v(dout1_7) AT=830.05n

.meas tran vdout1_8ck820 FIND v(dout1_8) AT=830.05n

.meas tran vdout1_9ck820 FIND v(dout1_9) AT=830.05n

.meas tran vdout1_10ck820 FIND v(dout1_10) AT=830.05n

.meas tran vdout1_11ck820 FIND v(dout1_11) AT=830.05n

.meas tran vdout1_12ck820 FIND v(dout1_12) AT=830.05n

.meas tran vdout1_13ck820 FIND v(dout1_13) AT=830.05n

.meas tran vdout1_14ck820 FIND v(dout1_14) AT=830.05n

.meas tran vdout1_15ck820 FIND v(dout1_15) AT=830.05n

.meas tran vdout1_16ck820 FIND v(dout1_16) AT=830.05n

.meas tran vdout1_17ck820 FIND v(dout1_17) AT=830.05n

.meas tran vdout1_18ck820 FIND v(dout1_18) AT=830.05n

.meas tran vdout1_19ck820 FIND v(dout1_19) AT=830.05n

.meas tran vdout1_20ck820 FIND v(dout1_20) AT=830.05n

.meas tran vdout1_21ck820 FIND v(dout1_21) AT=830.05n

.meas tran vdout1_22ck820 FIND v(dout1_22) AT=830.05n

.meas tran vdout1_23ck820 FIND v(dout1_23) AT=830.05n

.meas tran vdout1_24ck820 FIND v(dout1_24) AT=830.05n

.meas tran vdout1_25ck820 FIND v(dout1_25) AT=830.05n

.meas tran vdout1_26ck820 FIND v(dout1_26) AT=830.05n

.meas tran vdout1_27ck820 FIND v(dout1_27) AT=830.05n

.meas tran vdout1_28ck820 FIND v(dout1_28) AT=830.05n

.meas tran vdout1_29ck820 FIND v(dout1_29) AT=830.05n

.meas tran vdout1_30ck820 FIND v(dout1_30) AT=830.05n

.meas tran vdout1_31ck820 FIND v(dout1_31) AT=830.05n

.meas tran vdout1_32ck820 FIND v(dout1_32) AT=830.05n

.meas tran vdout1_33ck820 FIND v(dout1_33) AT=830.05n

.meas tran vdout1_34ck820 FIND v(dout1_34) AT=830.05n

.meas tran vdout1_35ck820 FIND v(dout1_35) AT=830.05n

.meas tran vdout1_36ck820 FIND v(dout1_36) AT=830.05n

.meas tran vdout1_37ck820 FIND v(dout1_37) AT=830.05n

.meas tran vdout1_38ck820 FIND v(dout1_38) AT=830.05n

.meas tran vdout1_39ck820 FIND v(dout1_39) AT=830.05n

.meas tran vdout1_40ck820 FIND v(dout1_40) AT=830.05n

.meas tran vdout1_41ck820 FIND v(dout1_41) AT=830.05n

.meas tran vdout1_42ck820 FIND v(dout1_42) AT=830.05n

.meas tran vdout1_43ck820 FIND v(dout1_43) AT=830.05n

.meas tran vdout1_44ck820 FIND v(dout1_44) AT=830.05n

.meas tran vdout1_45ck820 FIND v(dout1_45) AT=830.05n

.meas tran vdout1_46ck820 FIND v(dout1_46) AT=830.05n

.meas tran vdout1_47ck820 FIND v(dout1_47) AT=830.05n

.meas tran vdout1_48ck820 FIND v(dout1_48) AT=830.05n

.meas tran vdout1_49ck820 FIND v(dout1_49) AT=830.05n

.meas tran vdout1_50ck820 FIND v(dout1_50) AT=830.05n

.meas tran vdout1_51ck820 FIND v(dout1_51) AT=830.05n

.meas tran vdout1_52ck820 FIND v(dout1_52) AT=830.05n

.meas tran vdout1_53ck820 FIND v(dout1_53) AT=830.05n

.meas tran vdout1_54ck820 FIND v(dout1_54) AT=830.05n

.meas tran vdout1_55ck820 FIND v(dout1_55) AT=830.05n

.meas tran vdout1_56ck820 FIND v(dout1_56) AT=830.05n

.meas tran vdout1_57ck820 FIND v(dout1_57) AT=830.05n

.meas tran vdout1_58ck820 FIND v(dout1_58) AT=830.05n

.meas tran vdout1_59ck820 FIND v(dout1_59) AT=830.05n

.meas tran vdout1_60ck820 FIND v(dout1_60) AT=830.05n

.meas tran vdout1_61ck820 FIND v(dout1_61) AT=830.05n

.meas tran vdout1_62ck820 FIND v(dout1_62) AT=830.05n

.meas tran vdout1_63ck820 FIND v(dout1_63) AT=830.05n

.meas tran vdout0_0ck830 FIND v(dout0_0) AT=840.05n

.meas tran vdout0_1ck830 FIND v(dout0_1) AT=840.05n

.meas tran vdout0_2ck830 FIND v(dout0_2) AT=840.05n

.meas tran vdout0_3ck830 FIND v(dout0_3) AT=840.05n

.meas tran vdout0_4ck830 FIND v(dout0_4) AT=840.05n

.meas tran vdout0_5ck830 FIND v(dout0_5) AT=840.05n

.meas tran vdout0_6ck830 FIND v(dout0_6) AT=840.05n

.meas tran vdout0_7ck830 FIND v(dout0_7) AT=840.05n

.meas tran vdout0_8ck830 FIND v(dout0_8) AT=840.05n

.meas tran vdout0_9ck830 FIND v(dout0_9) AT=840.05n

.meas tran vdout0_10ck830 FIND v(dout0_10) AT=840.05n

.meas tran vdout0_11ck830 FIND v(dout0_11) AT=840.05n

.meas tran vdout0_12ck830 FIND v(dout0_12) AT=840.05n

.meas tran vdout0_13ck830 FIND v(dout0_13) AT=840.05n

.meas tran vdout0_14ck830 FIND v(dout0_14) AT=840.05n

.meas tran vdout0_15ck830 FIND v(dout0_15) AT=840.05n

.meas tran vdout0_16ck830 FIND v(dout0_16) AT=840.05n

.meas tran vdout0_17ck830 FIND v(dout0_17) AT=840.05n

.meas tran vdout0_18ck830 FIND v(dout0_18) AT=840.05n

.meas tran vdout0_19ck830 FIND v(dout0_19) AT=840.05n

.meas tran vdout0_20ck830 FIND v(dout0_20) AT=840.05n

.meas tran vdout0_21ck830 FIND v(dout0_21) AT=840.05n

.meas tran vdout0_22ck830 FIND v(dout0_22) AT=840.05n

.meas tran vdout0_23ck830 FIND v(dout0_23) AT=840.05n

.meas tran vdout0_24ck830 FIND v(dout0_24) AT=840.05n

.meas tran vdout0_25ck830 FIND v(dout0_25) AT=840.05n

.meas tran vdout0_26ck830 FIND v(dout0_26) AT=840.05n

.meas tran vdout0_27ck830 FIND v(dout0_27) AT=840.05n

.meas tran vdout0_28ck830 FIND v(dout0_28) AT=840.05n

.meas tran vdout0_29ck830 FIND v(dout0_29) AT=840.05n

.meas tran vdout0_30ck830 FIND v(dout0_30) AT=840.05n

.meas tran vdout0_31ck830 FIND v(dout0_31) AT=840.05n

.meas tran vdout0_32ck830 FIND v(dout0_32) AT=840.05n

.meas tran vdout0_33ck830 FIND v(dout0_33) AT=840.05n

.meas tran vdout0_34ck830 FIND v(dout0_34) AT=840.05n

.meas tran vdout0_35ck830 FIND v(dout0_35) AT=840.05n

.meas tran vdout0_36ck830 FIND v(dout0_36) AT=840.05n

.meas tran vdout0_37ck830 FIND v(dout0_37) AT=840.05n

.meas tran vdout0_38ck830 FIND v(dout0_38) AT=840.05n

.meas tran vdout0_39ck830 FIND v(dout0_39) AT=840.05n

.meas tran vdout0_40ck830 FIND v(dout0_40) AT=840.05n

.meas tran vdout0_41ck830 FIND v(dout0_41) AT=840.05n

.meas tran vdout0_42ck830 FIND v(dout0_42) AT=840.05n

.meas tran vdout0_43ck830 FIND v(dout0_43) AT=840.05n

.meas tran vdout0_44ck830 FIND v(dout0_44) AT=840.05n

.meas tran vdout0_45ck830 FIND v(dout0_45) AT=840.05n

.meas tran vdout0_46ck830 FIND v(dout0_46) AT=840.05n

.meas tran vdout0_47ck830 FIND v(dout0_47) AT=840.05n

.meas tran vdout0_48ck830 FIND v(dout0_48) AT=840.05n

.meas tran vdout0_49ck830 FIND v(dout0_49) AT=840.05n

.meas tran vdout0_50ck830 FIND v(dout0_50) AT=840.05n

.meas tran vdout0_51ck830 FIND v(dout0_51) AT=840.05n

.meas tran vdout0_52ck830 FIND v(dout0_52) AT=840.05n

.meas tran vdout0_53ck830 FIND v(dout0_53) AT=840.05n

.meas tran vdout0_54ck830 FIND v(dout0_54) AT=840.05n

.meas tran vdout0_55ck830 FIND v(dout0_55) AT=840.05n

.meas tran vdout0_56ck830 FIND v(dout0_56) AT=840.05n

.meas tran vdout0_57ck830 FIND v(dout0_57) AT=840.05n

.meas tran vdout0_58ck830 FIND v(dout0_58) AT=840.05n

.meas tran vdout0_59ck830 FIND v(dout0_59) AT=840.05n

.meas tran vdout0_60ck830 FIND v(dout0_60) AT=840.05n

.meas tran vdout0_61ck830 FIND v(dout0_61) AT=840.05n

.meas tran vdout0_62ck830 FIND v(dout0_62) AT=840.05n

.meas tran vdout0_63ck830 FIND v(dout0_63) AT=840.05n

.meas tran vdout0_0ck850 FIND v(dout0_0) AT=860.05n

.meas tran vdout0_1ck850 FIND v(dout0_1) AT=860.05n

.meas tran vdout0_2ck850 FIND v(dout0_2) AT=860.05n

.meas tran vdout0_3ck850 FIND v(dout0_3) AT=860.05n

.meas tran vdout0_4ck850 FIND v(dout0_4) AT=860.05n

.meas tran vdout0_5ck850 FIND v(dout0_5) AT=860.05n

.meas tran vdout0_6ck850 FIND v(dout0_6) AT=860.05n

.meas tran vdout0_7ck850 FIND v(dout0_7) AT=860.05n

.meas tran vdout0_8ck850 FIND v(dout0_8) AT=860.05n

.meas tran vdout0_9ck850 FIND v(dout0_9) AT=860.05n

.meas tran vdout0_10ck850 FIND v(dout0_10) AT=860.05n

.meas tran vdout0_11ck850 FIND v(dout0_11) AT=860.05n

.meas tran vdout0_12ck850 FIND v(dout0_12) AT=860.05n

.meas tran vdout0_13ck850 FIND v(dout0_13) AT=860.05n

.meas tran vdout0_14ck850 FIND v(dout0_14) AT=860.05n

.meas tran vdout0_15ck850 FIND v(dout0_15) AT=860.05n

.meas tran vdout0_16ck850 FIND v(dout0_16) AT=860.05n

.meas tran vdout0_17ck850 FIND v(dout0_17) AT=860.05n

.meas tran vdout0_18ck850 FIND v(dout0_18) AT=860.05n

.meas tran vdout0_19ck850 FIND v(dout0_19) AT=860.05n

.meas tran vdout0_20ck850 FIND v(dout0_20) AT=860.05n

.meas tran vdout0_21ck850 FIND v(dout0_21) AT=860.05n

.meas tran vdout0_22ck850 FIND v(dout0_22) AT=860.05n

.meas tran vdout0_23ck850 FIND v(dout0_23) AT=860.05n

.meas tran vdout0_24ck850 FIND v(dout0_24) AT=860.05n

.meas tran vdout0_25ck850 FIND v(dout0_25) AT=860.05n

.meas tran vdout0_26ck850 FIND v(dout0_26) AT=860.05n

.meas tran vdout0_27ck850 FIND v(dout0_27) AT=860.05n

.meas tran vdout0_28ck850 FIND v(dout0_28) AT=860.05n

.meas tran vdout0_29ck850 FIND v(dout0_29) AT=860.05n

.meas tran vdout0_30ck850 FIND v(dout0_30) AT=860.05n

.meas tran vdout0_31ck850 FIND v(dout0_31) AT=860.05n

.meas tran vdout0_32ck850 FIND v(dout0_32) AT=860.05n

.meas tran vdout0_33ck850 FIND v(dout0_33) AT=860.05n

.meas tran vdout0_34ck850 FIND v(dout0_34) AT=860.05n

.meas tran vdout0_35ck850 FIND v(dout0_35) AT=860.05n

.meas tran vdout0_36ck850 FIND v(dout0_36) AT=860.05n

.meas tran vdout0_37ck850 FIND v(dout0_37) AT=860.05n

.meas tran vdout0_38ck850 FIND v(dout0_38) AT=860.05n

.meas tran vdout0_39ck850 FIND v(dout0_39) AT=860.05n

.meas tran vdout0_40ck850 FIND v(dout0_40) AT=860.05n

.meas tran vdout0_41ck850 FIND v(dout0_41) AT=860.05n

.meas tran vdout0_42ck850 FIND v(dout0_42) AT=860.05n

.meas tran vdout0_43ck850 FIND v(dout0_43) AT=860.05n

.meas tran vdout0_44ck850 FIND v(dout0_44) AT=860.05n

.meas tran vdout0_45ck850 FIND v(dout0_45) AT=860.05n

.meas tran vdout0_46ck850 FIND v(dout0_46) AT=860.05n

.meas tran vdout0_47ck850 FIND v(dout0_47) AT=860.05n

.meas tran vdout0_48ck850 FIND v(dout0_48) AT=860.05n

.meas tran vdout0_49ck850 FIND v(dout0_49) AT=860.05n

.meas tran vdout0_50ck850 FIND v(dout0_50) AT=860.05n

.meas tran vdout0_51ck850 FIND v(dout0_51) AT=860.05n

.meas tran vdout0_52ck850 FIND v(dout0_52) AT=860.05n

.meas tran vdout0_53ck850 FIND v(dout0_53) AT=860.05n

.meas tran vdout0_54ck850 FIND v(dout0_54) AT=860.05n

.meas tran vdout0_55ck850 FIND v(dout0_55) AT=860.05n

.meas tran vdout0_56ck850 FIND v(dout0_56) AT=860.05n

.meas tran vdout0_57ck850 FIND v(dout0_57) AT=860.05n

.meas tran vdout0_58ck850 FIND v(dout0_58) AT=860.05n

.meas tran vdout0_59ck850 FIND v(dout0_59) AT=860.05n

.meas tran vdout0_60ck850 FIND v(dout0_60) AT=860.05n

.meas tran vdout0_61ck850 FIND v(dout0_61) AT=860.05n

.meas tran vdout0_62ck850 FIND v(dout0_62) AT=860.05n

.meas tran vdout0_63ck850 FIND v(dout0_63) AT=860.05n

.meas tran vdout1_0ck850 FIND v(dout1_0) AT=860.05n

.meas tran vdout1_1ck850 FIND v(dout1_1) AT=860.05n

.meas tran vdout1_2ck850 FIND v(dout1_2) AT=860.05n

.meas tran vdout1_3ck850 FIND v(dout1_3) AT=860.05n

.meas tran vdout1_4ck850 FIND v(dout1_4) AT=860.05n

.meas tran vdout1_5ck850 FIND v(dout1_5) AT=860.05n

.meas tran vdout1_6ck850 FIND v(dout1_6) AT=860.05n

.meas tran vdout1_7ck850 FIND v(dout1_7) AT=860.05n

.meas tran vdout1_8ck850 FIND v(dout1_8) AT=860.05n

.meas tran vdout1_9ck850 FIND v(dout1_9) AT=860.05n

.meas tran vdout1_10ck850 FIND v(dout1_10) AT=860.05n

.meas tran vdout1_11ck850 FIND v(dout1_11) AT=860.05n

.meas tran vdout1_12ck850 FIND v(dout1_12) AT=860.05n

.meas tran vdout1_13ck850 FIND v(dout1_13) AT=860.05n

.meas tran vdout1_14ck850 FIND v(dout1_14) AT=860.05n

.meas tran vdout1_15ck850 FIND v(dout1_15) AT=860.05n

.meas tran vdout1_16ck850 FIND v(dout1_16) AT=860.05n

.meas tran vdout1_17ck850 FIND v(dout1_17) AT=860.05n

.meas tran vdout1_18ck850 FIND v(dout1_18) AT=860.05n

.meas tran vdout1_19ck850 FIND v(dout1_19) AT=860.05n

.meas tran vdout1_20ck850 FIND v(dout1_20) AT=860.05n

.meas tran vdout1_21ck850 FIND v(dout1_21) AT=860.05n

.meas tran vdout1_22ck850 FIND v(dout1_22) AT=860.05n

.meas tran vdout1_23ck850 FIND v(dout1_23) AT=860.05n

.meas tran vdout1_24ck850 FIND v(dout1_24) AT=860.05n

.meas tran vdout1_25ck850 FIND v(dout1_25) AT=860.05n

.meas tran vdout1_26ck850 FIND v(dout1_26) AT=860.05n

.meas tran vdout1_27ck850 FIND v(dout1_27) AT=860.05n

.meas tran vdout1_28ck850 FIND v(dout1_28) AT=860.05n

.meas tran vdout1_29ck850 FIND v(dout1_29) AT=860.05n

.meas tran vdout1_30ck850 FIND v(dout1_30) AT=860.05n

.meas tran vdout1_31ck850 FIND v(dout1_31) AT=860.05n

.meas tran vdout1_32ck850 FIND v(dout1_32) AT=860.05n

.meas tran vdout1_33ck850 FIND v(dout1_33) AT=860.05n

.meas tran vdout1_34ck850 FIND v(dout1_34) AT=860.05n

.meas tran vdout1_35ck850 FIND v(dout1_35) AT=860.05n

.meas tran vdout1_36ck850 FIND v(dout1_36) AT=860.05n

.meas tran vdout1_37ck850 FIND v(dout1_37) AT=860.05n

.meas tran vdout1_38ck850 FIND v(dout1_38) AT=860.05n

.meas tran vdout1_39ck850 FIND v(dout1_39) AT=860.05n

.meas tran vdout1_40ck850 FIND v(dout1_40) AT=860.05n

.meas tran vdout1_41ck850 FIND v(dout1_41) AT=860.05n

.meas tran vdout1_42ck850 FIND v(dout1_42) AT=860.05n

.meas tran vdout1_43ck850 FIND v(dout1_43) AT=860.05n

.meas tran vdout1_44ck850 FIND v(dout1_44) AT=860.05n

.meas tran vdout1_45ck850 FIND v(dout1_45) AT=860.05n

.meas tran vdout1_46ck850 FIND v(dout1_46) AT=860.05n

.meas tran vdout1_47ck850 FIND v(dout1_47) AT=860.05n

.meas tran vdout1_48ck850 FIND v(dout1_48) AT=860.05n

.meas tran vdout1_49ck850 FIND v(dout1_49) AT=860.05n

.meas tran vdout1_50ck850 FIND v(dout1_50) AT=860.05n

.meas tran vdout1_51ck850 FIND v(dout1_51) AT=860.05n

.meas tran vdout1_52ck850 FIND v(dout1_52) AT=860.05n

.meas tran vdout1_53ck850 FIND v(dout1_53) AT=860.05n

.meas tran vdout1_54ck850 FIND v(dout1_54) AT=860.05n

.meas tran vdout1_55ck850 FIND v(dout1_55) AT=860.05n

.meas tran vdout1_56ck850 FIND v(dout1_56) AT=860.05n

.meas tran vdout1_57ck850 FIND v(dout1_57) AT=860.05n

.meas tran vdout1_58ck850 FIND v(dout1_58) AT=860.05n

.meas tran vdout1_59ck850 FIND v(dout1_59) AT=860.05n

.meas tran vdout1_60ck850 FIND v(dout1_60) AT=860.05n

.meas tran vdout1_61ck850 FIND v(dout1_61) AT=860.05n

.meas tran vdout1_62ck850 FIND v(dout1_62) AT=860.05n

.meas tran vdout1_63ck850 FIND v(dout1_63) AT=860.05n

.meas tran vdout0_0ck860 FIND v(dout0_0) AT=870.05n

.meas tran vdout0_1ck860 FIND v(dout0_1) AT=870.05n

.meas tran vdout0_2ck860 FIND v(dout0_2) AT=870.05n

.meas tran vdout0_3ck860 FIND v(dout0_3) AT=870.05n

.meas tran vdout0_4ck860 FIND v(dout0_4) AT=870.05n

.meas tran vdout0_5ck860 FIND v(dout0_5) AT=870.05n

.meas tran vdout0_6ck860 FIND v(dout0_6) AT=870.05n

.meas tran vdout0_7ck860 FIND v(dout0_7) AT=870.05n

.meas tran vdout0_8ck860 FIND v(dout0_8) AT=870.05n

.meas tran vdout0_9ck860 FIND v(dout0_9) AT=870.05n

.meas tran vdout0_10ck860 FIND v(dout0_10) AT=870.05n

.meas tran vdout0_11ck860 FIND v(dout0_11) AT=870.05n

.meas tran vdout0_12ck860 FIND v(dout0_12) AT=870.05n

.meas tran vdout0_13ck860 FIND v(dout0_13) AT=870.05n

.meas tran vdout0_14ck860 FIND v(dout0_14) AT=870.05n

.meas tran vdout0_15ck860 FIND v(dout0_15) AT=870.05n

.meas tran vdout0_16ck860 FIND v(dout0_16) AT=870.05n

.meas tran vdout0_17ck860 FIND v(dout0_17) AT=870.05n

.meas tran vdout0_18ck860 FIND v(dout0_18) AT=870.05n

.meas tran vdout0_19ck860 FIND v(dout0_19) AT=870.05n

.meas tran vdout0_20ck860 FIND v(dout0_20) AT=870.05n

.meas tran vdout0_21ck860 FIND v(dout0_21) AT=870.05n

.meas tran vdout0_22ck860 FIND v(dout0_22) AT=870.05n

.meas tran vdout0_23ck860 FIND v(dout0_23) AT=870.05n

.meas tran vdout0_24ck860 FIND v(dout0_24) AT=870.05n

.meas tran vdout0_25ck860 FIND v(dout0_25) AT=870.05n

.meas tran vdout0_26ck860 FIND v(dout0_26) AT=870.05n

.meas tran vdout0_27ck860 FIND v(dout0_27) AT=870.05n

.meas tran vdout0_28ck860 FIND v(dout0_28) AT=870.05n

.meas tran vdout0_29ck860 FIND v(dout0_29) AT=870.05n

.meas tran vdout0_30ck860 FIND v(dout0_30) AT=870.05n

.meas tran vdout0_31ck860 FIND v(dout0_31) AT=870.05n

.meas tran vdout0_32ck860 FIND v(dout0_32) AT=870.05n

.meas tran vdout0_33ck860 FIND v(dout0_33) AT=870.05n

.meas tran vdout0_34ck860 FIND v(dout0_34) AT=870.05n

.meas tran vdout0_35ck860 FIND v(dout0_35) AT=870.05n

.meas tran vdout0_36ck860 FIND v(dout0_36) AT=870.05n

.meas tran vdout0_37ck860 FIND v(dout0_37) AT=870.05n

.meas tran vdout0_38ck860 FIND v(dout0_38) AT=870.05n

.meas tran vdout0_39ck860 FIND v(dout0_39) AT=870.05n

.meas tran vdout0_40ck860 FIND v(dout0_40) AT=870.05n

.meas tran vdout0_41ck860 FIND v(dout0_41) AT=870.05n

.meas tran vdout0_42ck860 FIND v(dout0_42) AT=870.05n

.meas tran vdout0_43ck860 FIND v(dout0_43) AT=870.05n

.meas tran vdout0_44ck860 FIND v(dout0_44) AT=870.05n

.meas tran vdout0_45ck860 FIND v(dout0_45) AT=870.05n

.meas tran vdout0_46ck860 FIND v(dout0_46) AT=870.05n

.meas tran vdout0_47ck860 FIND v(dout0_47) AT=870.05n

.meas tran vdout0_48ck860 FIND v(dout0_48) AT=870.05n

.meas tran vdout0_49ck860 FIND v(dout0_49) AT=870.05n

.meas tran vdout0_50ck860 FIND v(dout0_50) AT=870.05n

.meas tran vdout0_51ck860 FIND v(dout0_51) AT=870.05n

.meas tran vdout0_52ck860 FIND v(dout0_52) AT=870.05n

.meas tran vdout0_53ck860 FIND v(dout0_53) AT=870.05n

.meas tran vdout0_54ck860 FIND v(dout0_54) AT=870.05n

.meas tran vdout0_55ck860 FIND v(dout0_55) AT=870.05n

.meas tran vdout0_56ck860 FIND v(dout0_56) AT=870.05n

.meas tran vdout0_57ck860 FIND v(dout0_57) AT=870.05n

.meas tran vdout0_58ck860 FIND v(dout0_58) AT=870.05n

.meas tran vdout0_59ck860 FIND v(dout0_59) AT=870.05n

.meas tran vdout0_60ck860 FIND v(dout0_60) AT=870.05n

.meas tran vdout0_61ck860 FIND v(dout0_61) AT=870.05n

.meas tran vdout0_62ck860 FIND v(dout0_62) AT=870.05n

.meas tran vdout0_63ck860 FIND v(dout0_63) AT=870.05n

.meas tran vdout0_0ck870 FIND v(dout0_0) AT=880.05n

.meas tran vdout0_1ck870 FIND v(dout0_1) AT=880.05n

.meas tran vdout0_2ck870 FIND v(dout0_2) AT=880.05n

.meas tran vdout0_3ck870 FIND v(dout0_3) AT=880.05n

.meas tran vdout0_4ck870 FIND v(dout0_4) AT=880.05n

.meas tran vdout0_5ck870 FIND v(dout0_5) AT=880.05n

.meas tran vdout0_6ck870 FIND v(dout0_6) AT=880.05n

.meas tran vdout0_7ck870 FIND v(dout0_7) AT=880.05n

.meas tran vdout0_8ck870 FIND v(dout0_8) AT=880.05n

.meas tran vdout0_9ck870 FIND v(dout0_9) AT=880.05n

.meas tran vdout0_10ck870 FIND v(dout0_10) AT=880.05n

.meas tran vdout0_11ck870 FIND v(dout0_11) AT=880.05n

.meas tran vdout0_12ck870 FIND v(dout0_12) AT=880.05n

.meas tran vdout0_13ck870 FIND v(dout0_13) AT=880.05n

.meas tran vdout0_14ck870 FIND v(dout0_14) AT=880.05n

.meas tran vdout0_15ck870 FIND v(dout0_15) AT=880.05n

.meas tran vdout0_16ck870 FIND v(dout0_16) AT=880.05n

.meas tran vdout0_17ck870 FIND v(dout0_17) AT=880.05n

.meas tran vdout0_18ck870 FIND v(dout0_18) AT=880.05n

.meas tran vdout0_19ck870 FIND v(dout0_19) AT=880.05n

.meas tran vdout0_20ck870 FIND v(dout0_20) AT=880.05n

.meas tran vdout0_21ck870 FIND v(dout0_21) AT=880.05n

.meas tran vdout0_22ck870 FIND v(dout0_22) AT=880.05n

.meas tran vdout0_23ck870 FIND v(dout0_23) AT=880.05n

.meas tran vdout0_24ck870 FIND v(dout0_24) AT=880.05n

.meas tran vdout0_25ck870 FIND v(dout0_25) AT=880.05n

.meas tran vdout0_26ck870 FIND v(dout0_26) AT=880.05n

.meas tran vdout0_27ck870 FIND v(dout0_27) AT=880.05n

.meas tran vdout0_28ck870 FIND v(dout0_28) AT=880.05n

.meas tran vdout0_29ck870 FIND v(dout0_29) AT=880.05n

.meas tran vdout0_30ck870 FIND v(dout0_30) AT=880.05n

.meas tran vdout0_31ck870 FIND v(dout0_31) AT=880.05n

.meas tran vdout0_32ck870 FIND v(dout0_32) AT=880.05n

.meas tran vdout0_33ck870 FIND v(dout0_33) AT=880.05n

.meas tran vdout0_34ck870 FIND v(dout0_34) AT=880.05n

.meas tran vdout0_35ck870 FIND v(dout0_35) AT=880.05n

.meas tran vdout0_36ck870 FIND v(dout0_36) AT=880.05n

.meas tran vdout0_37ck870 FIND v(dout0_37) AT=880.05n

.meas tran vdout0_38ck870 FIND v(dout0_38) AT=880.05n

.meas tran vdout0_39ck870 FIND v(dout0_39) AT=880.05n

.meas tran vdout0_40ck870 FIND v(dout0_40) AT=880.05n

.meas tran vdout0_41ck870 FIND v(dout0_41) AT=880.05n

.meas tran vdout0_42ck870 FIND v(dout0_42) AT=880.05n

.meas tran vdout0_43ck870 FIND v(dout0_43) AT=880.05n

.meas tran vdout0_44ck870 FIND v(dout0_44) AT=880.05n

.meas tran vdout0_45ck870 FIND v(dout0_45) AT=880.05n

.meas tran vdout0_46ck870 FIND v(dout0_46) AT=880.05n

.meas tran vdout0_47ck870 FIND v(dout0_47) AT=880.05n

.meas tran vdout0_48ck870 FIND v(dout0_48) AT=880.05n

.meas tran vdout0_49ck870 FIND v(dout0_49) AT=880.05n

.meas tran vdout0_50ck870 FIND v(dout0_50) AT=880.05n

.meas tran vdout0_51ck870 FIND v(dout0_51) AT=880.05n

.meas tran vdout0_52ck870 FIND v(dout0_52) AT=880.05n

.meas tran vdout0_53ck870 FIND v(dout0_53) AT=880.05n

.meas tran vdout0_54ck870 FIND v(dout0_54) AT=880.05n

.meas tran vdout0_55ck870 FIND v(dout0_55) AT=880.05n

.meas tran vdout0_56ck870 FIND v(dout0_56) AT=880.05n

.meas tran vdout0_57ck870 FIND v(dout0_57) AT=880.05n

.meas tran vdout0_58ck870 FIND v(dout0_58) AT=880.05n

.meas tran vdout0_59ck870 FIND v(dout0_59) AT=880.05n

.meas tran vdout0_60ck870 FIND v(dout0_60) AT=880.05n

.meas tran vdout0_61ck870 FIND v(dout0_61) AT=880.05n

.meas tran vdout0_62ck870 FIND v(dout0_62) AT=880.05n

.meas tran vdout0_63ck870 FIND v(dout0_63) AT=880.05n

.meas tran vdout0_0ck890 FIND v(dout0_0) AT=900.05n

.meas tran vdout0_1ck890 FIND v(dout0_1) AT=900.05n

.meas tran vdout0_2ck890 FIND v(dout0_2) AT=900.05n

.meas tran vdout0_3ck890 FIND v(dout0_3) AT=900.05n

.meas tran vdout0_4ck890 FIND v(dout0_4) AT=900.05n

.meas tran vdout0_5ck890 FIND v(dout0_5) AT=900.05n

.meas tran vdout0_6ck890 FIND v(dout0_6) AT=900.05n

.meas tran vdout0_7ck890 FIND v(dout0_7) AT=900.05n

.meas tran vdout0_8ck890 FIND v(dout0_8) AT=900.05n

.meas tran vdout0_9ck890 FIND v(dout0_9) AT=900.05n

.meas tran vdout0_10ck890 FIND v(dout0_10) AT=900.05n

.meas tran vdout0_11ck890 FIND v(dout0_11) AT=900.05n

.meas tran vdout0_12ck890 FIND v(dout0_12) AT=900.05n

.meas tran vdout0_13ck890 FIND v(dout0_13) AT=900.05n

.meas tran vdout0_14ck890 FIND v(dout0_14) AT=900.05n

.meas tran vdout0_15ck890 FIND v(dout0_15) AT=900.05n

.meas tran vdout0_16ck890 FIND v(dout0_16) AT=900.05n

.meas tran vdout0_17ck890 FIND v(dout0_17) AT=900.05n

.meas tran vdout0_18ck890 FIND v(dout0_18) AT=900.05n

.meas tran vdout0_19ck890 FIND v(dout0_19) AT=900.05n

.meas tran vdout0_20ck890 FIND v(dout0_20) AT=900.05n

.meas tran vdout0_21ck890 FIND v(dout0_21) AT=900.05n

.meas tran vdout0_22ck890 FIND v(dout0_22) AT=900.05n

.meas tran vdout0_23ck890 FIND v(dout0_23) AT=900.05n

.meas tran vdout0_24ck890 FIND v(dout0_24) AT=900.05n

.meas tran vdout0_25ck890 FIND v(dout0_25) AT=900.05n

.meas tran vdout0_26ck890 FIND v(dout0_26) AT=900.05n

.meas tran vdout0_27ck890 FIND v(dout0_27) AT=900.05n

.meas tran vdout0_28ck890 FIND v(dout0_28) AT=900.05n

.meas tran vdout0_29ck890 FIND v(dout0_29) AT=900.05n

.meas tran vdout0_30ck890 FIND v(dout0_30) AT=900.05n

.meas tran vdout0_31ck890 FIND v(dout0_31) AT=900.05n

.meas tran vdout0_32ck890 FIND v(dout0_32) AT=900.05n

.meas tran vdout0_33ck890 FIND v(dout0_33) AT=900.05n

.meas tran vdout0_34ck890 FIND v(dout0_34) AT=900.05n

.meas tran vdout0_35ck890 FIND v(dout0_35) AT=900.05n

.meas tran vdout0_36ck890 FIND v(dout0_36) AT=900.05n

.meas tran vdout0_37ck890 FIND v(dout0_37) AT=900.05n

.meas tran vdout0_38ck890 FIND v(dout0_38) AT=900.05n

.meas tran vdout0_39ck890 FIND v(dout0_39) AT=900.05n

.meas tran vdout0_40ck890 FIND v(dout0_40) AT=900.05n

.meas tran vdout0_41ck890 FIND v(dout0_41) AT=900.05n

.meas tran vdout0_42ck890 FIND v(dout0_42) AT=900.05n

.meas tran vdout0_43ck890 FIND v(dout0_43) AT=900.05n

.meas tran vdout0_44ck890 FIND v(dout0_44) AT=900.05n

.meas tran vdout0_45ck890 FIND v(dout0_45) AT=900.05n

.meas tran vdout0_46ck890 FIND v(dout0_46) AT=900.05n

.meas tran vdout0_47ck890 FIND v(dout0_47) AT=900.05n

.meas tran vdout0_48ck890 FIND v(dout0_48) AT=900.05n

.meas tran vdout0_49ck890 FIND v(dout0_49) AT=900.05n

.meas tran vdout0_50ck890 FIND v(dout0_50) AT=900.05n

.meas tran vdout0_51ck890 FIND v(dout0_51) AT=900.05n

.meas tran vdout0_52ck890 FIND v(dout0_52) AT=900.05n

.meas tran vdout0_53ck890 FIND v(dout0_53) AT=900.05n

.meas tran vdout0_54ck890 FIND v(dout0_54) AT=900.05n

.meas tran vdout0_55ck890 FIND v(dout0_55) AT=900.05n

.meas tran vdout0_56ck890 FIND v(dout0_56) AT=900.05n

.meas tran vdout0_57ck890 FIND v(dout0_57) AT=900.05n

.meas tran vdout0_58ck890 FIND v(dout0_58) AT=900.05n

.meas tran vdout0_59ck890 FIND v(dout0_59) AT=900.05n

.meas tran vdout0_60ck890 FIND v(dout0_60) AT=900.05n

.meas tran vdout0_61ck890 FIND v(dout0_61) AT=900.05n

.meas tran vdout0_62ck890 FIND v(dout0_62) AT=900.05n

.meas tran vdout0_63ck890 FIND v(dout0_63) AT=900.05n

.meas tran vdout0_0ck910 FIND v(dout0_0) AT=920.05n

.meas tran vdout0_1ck910 FIND v(dout0_1) AT=920.05n

.meas tran vdout0_2ck910 FIND v(dout0_2) AT=920.05n

.meas tran vdout0_3ck910 FIND v(dout0_3) AT=920.05n

.meas tran vdout0_4ck910 FIND v(dout0_4) AT=920.05n

.meas tran vdout0_5ck910 FIND v(dout0_5) AT=920.05n

.meas tran vdout0_6ck910 FIND v(dout0_6) AT=920.05n

.meas tran vdout0_7ck910 FIND v(dout0_7) AT=920.05n

.meas tran vdout0_8ck910 FIND v(dout0_8) AT=920.05n

.meas tran vdout0_9ck910 FIND v(dout0_9) AT=920.05n

.meas tran vdout0_10ck910 FIND v(dout0_10) AT=920.05n

.meas tran vdout0_11ck910 FIND v(dout0_11) AT=920.05n

.meas tran vdout0_12ck910 FIND v(dout0_12) AT=920.05n

.meas tran vdout0_13ck910 FIND v(dout0_13) AT=920.05n

.meas tran vdout0_14ck910 FIND v(dout0_14) AT=920.05n

.meas tran vdout0_15ck910 FIND v(dout0_15) AT=920.05n

.meas tran vdout0_16ck910 FIND v(dout0_16) AT=920.05n

.meas tran vdout0_17ck910 FIND v(dout0_17) AT=920.05n

.meas tran vdout0_18ck910 FIND v(dout0_18) AT=920.05n

.meas tran vdout0_19ck910 FIND v(dout0_19) AT=920.05n

.meas tran vdout0_20ck910 FIND v(dout0_20) AT=920.05n

.meas tran vdout0_21ck910 FIND v(dout0_21) AT=920.05n

.meas tran vdout0_22ck910 FIND v(dout0_22) AT=920.05n

.meas tran vdout0_23ck910 FIND v(dout0_23) AT=920.05n

.meas tran vdout0_24ck910 FIND v(dout0_24) AT=920.05n

.meas tran vdout0_25ck910 FIND v(dout0_25) AT=920.05n

.meas tran vdout0_26ck910 FIND v(dout0_26) AT=920.05n

.meas tran vdout0_27ck910 FIND v(dout0_27) AT=920.05n

.meas tran vdout0_28ck910 FIND v(dout0_28) AT=920.05n

.meas tran vdout0_29ck910 FIND v(dout0_29) AT=920.05n

.meas tran vdout0_30ck910 FIND v(dout0_30) AT=920.05n

.meas tran vdout0_31ck910 FIND v(dout0_31) AT=920.05n

.meas tran vdout0_32ck910 FIND v(dout0_32) AT=920.05n

.meas tran vdout0_33ck910 FIND v(dout0_33) AT=920.05n

.meas tran vdout0_34ck910 FIND v(dout0_34) AT=920.05n

.meas tran vdout0_35ck910 FIND v(dout0_35) AT=920.05n

.meas tran vdout0_36ck910 FIND v(dout0_36) AT=920.05n

.meas tran vdout0_37ck910 FIND v(dout0_37) AT=920.05n

.meas tran vdout0_38ck910 FIND v(dout0_38) AT=920.05n

.meas tran vdout0_39ck910 FIND v(dout0_39) AT=920.05n

.meas tran vdout0_40ck910 FIND v(dout0_40) AT=920.05n

.meas tran vdout0_41ck910 FIND v(dout0_41) AT=920.05n

.meas tran vdout0_42ck910 FIND v(dout0_42) AT=920.05n

.meas tran vdout0_43ck910 FIND v(dout0_43) AT=920.05n

.meas tran vdout0_44ck910 FIND v(dout0_44) AT=920.05n

.meas tran vdout0_45ck910 FIND v(dout0_45) AT=920.05n

.meas tran vdout0_46ck910 FIND v(dout0_46) AT=920.05n

.meas tran vdout0_47ck910 FIND v(dout0_47) AT=920.05n

.meas tran vdout0_48ck910 FIND v(dout0_48) AT=920.05n

.meas tran vdout0_49ck910 FIND v(dout0_49) AT=920.05n

.meas tran vdout0_50ck910 FIND v(dout0_50) AT=920.05n

.meas tran vdout0_51ck910 FIND v(dout0_51) AT=920.05n

.meas tran vdout0_52ck910 FIND v(dout0_52) AT=920.05n

.meas tran vdout0_53ck910 FIND v(dout0_53) AT=920.05n

.meas tran vdout0_54ck910 FIND v(dout0_54) AT=920.05n

.meas tran vdout0_55ck910 FIND v(dout0_55) AT=920.05n

.meas tran vdout0_56ck910 FIND v(dout0_56) AT=920.05n

.meas tran vdout0_57ck910 FIND v(dout0_57) AT=920.05n

.meas tran vdout0_58ck910 FIND v(dout0_58) AT=920.05n

.meas tran vdout0_59ck910 FIND v(dout0_59) AT=920.05n

.meas tran vdout0_60ck910 FIND v(dout0_60) AT=920.05n

.meas tran vdout0_61ck910 FIND v(dout0_61) AT=920.05n

.meas tran vdout0_62ck910 FIND v(dout0_62) AT=920.05n

.meas tran vdout0_63ck910 FIND v(dout0_63) AT=920.05n

.meas tran vdout0_0ck920 FIND v(dout0_0) AT=930.05n

.meas tran vdout0_1ck920 FIND v(dout0_1) AT=930.05n

.meas tran vdout0_2ck920 FIND v(dout0_2) AT=930.05n

.meas tran vdout0_3ck920 FIND v(dout0_3) AT=930.05n

.meas tran vdout0_4ck920 FIND v(dout0_4) AT=930.05n

.meas tran vdout0_5ck920 FIND v(dout0_5) AT=930.05n

.meas tran vdout0_6ck920 FIND v(dout0_6) AT=930.05n

.meas tran vdout0_7ck920 FIND v(dout0_7) AT=930.05n

.meas tran vdout0_8ck920 FIND v(dout0_8) AT=930.05n

.meas tran vdout0_9ck920 FIND v(dout0_9) AT=930.05n

.meas tran vdout0_10ck920 FIND v(dout0_10) AT=930.05n

.meas tran vdout0_11ck920 FIND v(dout0_11) AT=930.05n

.meas tran vdout0_12ck920 FIND v(dout0_12) AT=930.05n

.meas tran vdout0_13ck920 FIND v(dout0_13) AT=930.05n

.meas tran vdout0_14ck920 FIND v(dout0_14) AT=930.05n

.meas tran vdout0_15ck920 FIND v(dout0_15) AT=930.05n

.meas tran vdout0_16ck920 FIND v(dout0_16) AT=930.05n

.meas tran vdout0_17ck920 FIND v(dout0_17) AT=930.05n

.meas tran vdout0_18ck920 FIND v(dout0_18) AT=930.05n

.meas tran vdout0_19ck920 FIND v(dout0_19) AT=930.05n

.meas tran vdout0_20ck920 FIND v(dout0_20) AT=930.05n

.meas tran vdout0_21ck920 FIND v(dout0_21) AT=930.05n

.meas tran vdout0_22ck920 FIND v(dout0_22) AT=930.05n

.meas tran vdout0_23ck920 FIND v(dout0_23) AT=930.05n

.meas tran vdout0_24ck920 FIND v(dout0_24) AT=930.05n

.meas tran vdout0_25ck920 FIND v(dout0_25) AT=930.05n

.meas tran vdout0_26ck920 FIND v(dout0_26) AT=930.05n

.meas tran vdout0_27ck920 FIND v(dout0_27) AT=930.05n

.meas tran vdout0_28ck920 FIND v(dout0_28) AT=930.05n

.meas tran vdout0_29ck920 FIND v(dout0_29) AT=930.05n

.meas tran vdout0_30ck920 FIND v(dout0_30) AT=930.05n

.meas tran vdout0_31ck920 FIND v(dout0_31) AT=930.05n

.meas tran vdout0_32ck920 FIND v(dout0_32) AT=930.05n

.meas tran vdout0_33ck920 FIND v(dout0_33) AT=930.05n

.meas tran vdout0_34ck920 FIND v(dout0_34) AT=930.05n

.meas tran vdout0_35ck920 FIND v(dout0_35) AT=930.05n

.meas tran vdout0_36ck920 FIND v(dout0_36) AT=930.05n

.meas tran vdout0_37ck920 FIND v(dout0_37) AT=930.05n

.meas tran vdout0_38ck920 FIND v(dout0_38) AT=930.05n

.meas tran vdout0_39ck920 FIND v(dout0_39) AT=930.05n

.meas tran vdout0_40ck920 FIND v(dout0_40) AT=930.05n

.meas tran vdout0_41ck920 FIND v(dout0_41) AT=930.05n

.meas tran vdout0_42ck920 FIND v(dout0_42) AT=930.05n

.meas tran vdout0_43ck920 FIND v(dout0_43) AT=930.05n

.meas tran vdout0_44ck920 FIND v(dout0_44) AT=930.05n

.meas tran vdout0_45ck920 FIND v(dout0_45) AT=930.05n

.meas tran vdout0_46ck920 FIND v(dout0_46) AT=930.05n

.meas tran vdout0_47ck920 FIND v(dout0_47) AT=930.05n

.meas tran vdout0_48ck920 FIND v(dout0_48) AT=930.05n

.meas tran vdout0_49ck920 FIND v(dout0_49) AT=930.05n

.meas tran vdout0_50ck920 FIND v(dout0_50) AT=930.05n

.meas tran vdout0_51ck920 FIND v(dout0_51) AT=930.05n

.meas tran vdout0_52ck920 FIND v(dout0_52) AT=930.05n

.meas tran vdout0_53ck920 FIND v(dout0_53) AT=930.05n

.meas tran vdout0_54ck920 FIND v(dout0_54) AT=930.05n

.meas tran vdout0_55ck920 FIND v(dout0_55) AT=930.05n

.meas tran vdout0_56ck920 FIND v(dout0_56) AT=930.05n

.meas tran vdout0_57ck920 FIND v(dout0_57) AT=930.05n

.meas tran vdout0_58ck920 FIND v(dout0_58) AT=930.05n

.meas tran vdout0_59ck920 FIND v(dout0_59) AT=930.05n

.meas tran vdout0_60ck920 FIND v(dout0_60) AT=930.05n

.meas tran vdout0_61ck920 FIND v(dout0_61) AT=930.05n

.meas tran vdout0_62ck920 FIND v(dout0_62) AT=930.05n

.meas tran vdout0_63ck920 FIND v(dout0_63) AT=930.05n

.meas tran vdout0_0ck930 FIND v(dout0_0) AT=940.05n

.meas tran vdout0_1ck930 FIND v(dout0_1) AT=940.05n

.meas tran vdout0_2ck930 FIND v(dout0_2) AT=940.05n

.meas tran vdout0_3ck930 FIND v(dout0_3) AT=940.05n

.meas tran vdout0_4ck930 FIND v(dout0_4) AT=940.05n

.meas tran vdout0_5ck930 FIND v(dout0_5) AT=940.05n

.meas tran vdout0_6ck930 FIND v(dout0_6) AT=940.05n

.meas tran vdout0_7ck930 FIND v(dout0_7) AT=940.05n

.meas tran vdout0_8ck930 FIND v(dout0_8) AT=940.05n

.meas tran vdout0_9ck930 FIND v(dout0_9) AT=940.05n

.meas tran vdout0_10ck930 FIND v(dout0_10) AT=940.05n

.meas tran vdout0_11ck930 FIND v(dout0_11) AT=940.05n

.meas tran vdout0_12ck930 FIND v(dout0_12) AT=940.05n

.meas tran vdout0_13ck930 FIND v(dout0_13) AT=940.05n

.meas tran vdout0_14ck930 FIND v(dout0_14) AT=940.05n

.meas tran vdout0_15ck930 FIND v(dout0_15) AT=940.05n

.meas tran vdout0_16ck930 FIND v(dout0_16) AT=940.05n

.meas tran vdout0_17ck930 FIND v(dout0_17) AT=940.05n

.meas tran vdout0_18ck930 FIND v(dout0_18) AT=940.05n

.meas tran vdout0_19ck930 FIND v(dout0_19) AT=940.05n

.meas tran vdout0_20ck930 FIND v(dout0_20) AT=940.05n

.meas tran vdout0_21ck930 FIND v(dout0_21) AT=940.05n

.meas tran vdout0_22ck930 FIND v(dout0_22) AT=940.05n

.meas tran vdout0_23ck930 FIND v(dout0_23) AT=940.05n

.meas tran vdout0_24ck930 FIND v(dout0_24) AT=940.05n

.meas tran vdout0_25ck930 FIND v(dout0_25) AT=940.05n

.meas tran vdout0_26ck930 FIND v(dout0_26) AT=940.05n

.meas tran vdout0_27ck930 FIND v(dout0_27) AT=940.05n

.meas tran vdout0_28ck930 FIND v(dout0_28) AT=940.05n

.meas tran vdout0_29ck930 FIND v(dout0_29) AT=940.05n

.meas tran vdout0_30ck930 FIND v(dout0_30) AT=940.05n

.meas tran vdout0_31ck930 FIND v(dout0_31) AT=940.05n

.meas tran vdout0_32ck930 FIND v(dout0_32) AT=940.05n

.meas tran vdout0_33ck930 FIND v(dout0_33) AT=940.05n

.meas tran vdout0_34ck930 FIND v(dout0_34) AT=940.05n

.meas tran vdout0_35ck930 FIND v(dout0_35) AT=940.05n

.meas tran vdout0_36ck930 FIND v(dout0_36) AT=940.05n

.meas tran vdout0_37ck930 FIND v(dout0_37) AT=940.05n

.meas tran vdout0_38ck930 FIND v(dout0_38) AT=940.05n

.meas tran vdout0_39ck930 FIND v(dout0_39) AT=940.05n

.meas tran vdout0_40ck930 FIND v(dout0_40) AT=940.05n

.meas tran vdout0_41ck930 FIND v(dout0_41) AT=940.05n

.meas tran vdout0_42ck930 FIND v(dout0_42) AT=940.05n

.meas tran vdout0_43ck930 FIND v(dout0_43) AT=940.05n

.meas tran vdout0_44ck930 FIND v(dout0_44) AT=940.05n

.meas tran vdout0_45ck930 FIND v(dout0_45) AT=940.05n

.meas tran vdout0_46ck930 FIND v(dout0_46) AT=940.05n

.meas tran vdout0_47ck930 FIND v(dout0_47) AT=940.05n

.meas tran vdout0_48ck930 FIND v(dout0_48) AT=940.05n

.meas tran vdout0_49ck930 FIND v(dout0_49) AT=940.05n

.meas tran vdout0_50ck930 FIND v(dout0_50) AT=940.05n

.meas tran vdout0_51ck930 FIND v(dout0_51) AT=940.05n

.meas tran vdout0_52ck930 FIND v(dout0_52) AT=940.05n

.meas tran vdout0_53ck930 FIND v(dout0_53) AT=940.05n

.meas tran vdout0_54ck930 FIND v(dout0_54) AT=940.05n

.meas tran vdout0_55ck930 FIND v(dout0_55) AT=940.05n

.meas tran vdout0_56ck930 FIND v(dout0_56) AT=940.05n

.meas tran vdout0_57ck930 FIND v(dout0_57) AT=940.05n

.meas tran vdout0_58ck930 FIND v(dout0_58) AT=940.05n

.meas tran vdout0_59ck930 FIND v(dout0_59) AT=940.05n

.meas tran vdout0_60ck930 FIND v(dout0_60) AT=940.05n

.meas tran vdout0_61ck930 FIND v(dout0_61) AT=940.05n

.meas tran vdout0_62ck930 FIND v(dout0_62) AT=940.05n

.meas tran vdout0_63ck930 FIND v(dout0_63) AT=940.05n

.meas tran vdout1_0ck930 FIND v(dout1_0) AT=940.05n

.meas tran vdout1_1ck930 FIND v(dout1_1) AT=940.05n

.meas tran vdout1_2ck930 FIND v(dout1_2) AT=940.05n

.meas tran vdout1_3ck930 FIND v(dout1_3) AT=940.05n

.meas tran vdout1_4ck930 FIND v(dout1_4) AT=940.05n

.meas tran vdout1_5ck930 FIND v(dout1_5) AT=940.05n

.meas tran vdout1_6ck930 FIND v(dout1_6) AT=940.05n

.meas tran vdout1_7ck930 FIND v(dout1_7) AT=940.05n

.meas tran vdout1_8ck930 FIND v(dout1_8) AT=940.05n

.meas tran vdout1_9ck930 FIND v(dout1_9) AT=940.05n

.meas tran vdout1_10ck930 FIND v(dout1_10) AT=940.05n

.meas tran vdout1_11ck930 FIND v(dout1_11) AT=940.05n

.meas tran vdout1_12ck930 FIND v(dout1_12) AT=940.05n

.meas tran vdout1_13ck930 FIND v(dout1_13) AT=940.05n

.meas tran vdout1_14ck930 FIND v(dout1_14) AT=940.05n

.meas tran vdout1_15ck930 FIND v(dout1_15) AT=940.05n

.meas tran vdout1_16ck930 FIND v(dout1_16) AT=940.05n

.meas tran vdout1_17ck930 FIND v(dout1_17) AT=940.05n

.meas tran vdout1_18ck930 FIND v(dout1_18) AT=940.05n

.meas tran vdout1_19ck930 FIND v(dout1_19) AT=940.05n

.meas tran vdout1_20ck930 FIND v(dout1_20) AT=940.05n

.meas tran vdout1_21ck930 FIND v(dout1_21) AT=940.05n

.meas tran vdout1_22ck930 FIND v(dout1_22) AT=940.05n

.meas tran vdout1_23ck930 FIND v(dout1_23) AT=940.05n

.meas tran vdout1_24ck930 FIND v(dout1_24) AT=940.05n

.meas tran vdout1_25ck930 FIND v(dout1_25) AT=940.05n

.meas tran vdout1_26ck930 FIND v(dout1_26) AT=940.05n

.meas tran vdout1_27ck930 FIND v(dout1_27) AT=940.05n

.meas tran vdout1_28ck930 FIND v(dout1_28) AT=940.05n

.meas tran vdout1_29ck930 FIND v(dout1_29) AT=940.05n

.meas tran vdout1_30ck930 FIND v(dout1_30) AT=940.05n

.meas tran vdout1_31ck930 FIND v(dout1_31) AT=940.05n

.meas tran vdout1_32ck930 FIND v(dout1_32) AT=940.05n

.meas tran vdout1_33ck930 FIND v(dout1_33) AT=940.05n

.meas tran vdout1_34ck930 FIND v(dout1_34) AT=940.05n

.meas tran vdout1_35ck930 FIND v(dout1_35) AT=940.05n

.meas tran vdout1_36ck930 FIND v(dout1_36) AT=940.05n

.meas tran vdout1_37ck930 FIND v(dout1_37) AT=940.05n

.meas tran vdout1_38ck930 FIND v(dout1_38) AT=940.05n

.meas tran vdout1_39ck930 FIND v(dout1_39) AT=940.05n

.meas tran vdout1_40ck930 FIND v(dout1_40) AT=940.05n

.meas tran vdout1_41ck930 FIND v(dout1_41) AT=940.05n

.meas tran vdout1_42ck930 FIND v(dout1_42) AT=940.05n

.meas tran vdout1_43ck930 FIND v(dout1_43) AT=940.05n

.meas tran vdout1_44ck930 FIND v(dout1_44) AT=940.05n

.meas tran vdout1_45ck930 FIND v(dout1_45) AT=940.05n

.meas tran vdout1_46ck930 FIND v(dout1_46) AT=940.05n

.meas tran vdout1_47ck930 FIND v(dout1_47) AT=940.05n

.meas tran vdout1_48ck930 FIND v(dout1_48) AT=940.05n

.meas tran vdout1_49ck930 FIND v(dout1_49) AT=940.05n

.meas tran vdout1_50ck930 FIND v(dout1_50) AT=940.05n

.meas tran vdout1_51ck930 FIND v(dout1_51) AT=940.05n

.meas tran vdout1_52ck930 FIND v(dout1_52) AT=940.05n

.meas tran vdout1_53ck930 FIND v(dout1_53) AT=940.05n

.meas tran vdout1_54ck930 FIND v(dout1_54) AT=940.05n

.meas tran vdout1_55ck930 FIND v(dout1_55) AT=940.05n

.meas tran vdout1_56ck930 FIND v(dout1_56) AT=940.05n

.meas tran vdout1_57ck930 FIND v(dout1_57) AT=940.05n

.meas tran vdout1_58ck930 FIND v(dout1_58) AT=940.05n

.meas tran vdout1_59ck930 FIND v(dout1_59) AT=940.05n

.meas tran vdout1_60ck930 FIND v(dout1_60) AT=940.05n

.meas tran vdout1_61ck930 FIND v(dout1_61) AT=940.05n

.meas tran vdout1_62ck930 FIND v(dout1_62) AT=940.05n

.meas tran vdout1_63ck930 FIND v(dout1_63) AT=940.05n

.meas tran vdout0_0ck940 FIND v(dout0_0) AT=950.05n

.meas tran vdout0_1ck940 FIND v(dout0_1) AT=950.05n

.meas tran vdout0_2ck940 FIND v(dout0_2) AT=950.05n

.meas tran vdout0_3ck940 FIND v(dout0_3) AT=950.05n

.meas tran vdout0_4ck940 FIND v(dout0_4) AT=950.05n

.meas tran vdout0_5ck940 FIND v(dout0_5) AT=950.05n

.meas tran vdout0_6ck940 FIND v(dout0_6) AT=950.05n

.meas tran vdout0_7ck940 FIND v(dout0_7) AT=950.05n

.meas tran vdout0_8ck940 FIND v(dout0_8) AT=950.05n

.meas tran vdout0_9ck940 FIND v(dout0_9) AT=950.05n

.meas tran vdout0_10ck940 FIND v(dout0_10) AT=950.05n

.meas tran vdout0_11ck940 FIND v(dout0_11) AT=950.05n

.meas tran vdout0_12ck940 FIND v(dout0_12) AT=950.05n

.meas tran vdout0_13ck940 FIND v(dout0_13) AT=950.05n

.meas tran vdout0_14ck940 FIND v(dout0_14) AT=950.05n

.meas tran vdout0_15ck940 FIND v(dout0_15) AT=950.05n

.meas tran vdout0_16ck940 FIND v(dout0_16) AT=950.05n

.meas tran vdout0_17ck940 FIND v(dout0_17) AT=950.05n

.meas tran vdout0_18ck940 FIND v(dout0_18) AT=950.05n

.meas tran vdout0_19ck940 FIND v(dout0_19) AT=950.05n

.meas tran vdout0_20ck940 FIND v(dout0_20) AT=950.05n

.meas tran vdout0_21ck940 FIND v(dout0_21) AT=950.05n

.meas tran vdout0_22ck940 FIND v(dout0_22) AT=950.05n

.meas tran vdout0_23ck940 FIND v(dout0_23) AT=950.05n

.meas tran vdout0_24ck940 FIND v(dout0_24) AT=950.05n

.meas tran vdout0_25ck940 FIND v(dout0_25) AT=950.05n

.meas tran vdout0_26ck940 FIND v(dout0_26) AT=950.05n

.meas tran vdout0_27ck940 FIND v(dout0_27) AT=950.05n

.meas tran vdout0_28ck940 FIND v(dout0_28) AT=950.05n

.meas tran vdout0_29ck940 FIND v(dout0_29) AT=950.05n

.meas tran vdout0_30ck940 FIND v(dout0_30) AT=950.05n

.meas tran vdout0_31ck940 FIND v(dout0_31) AT=950.05n

.meas tran vdout0_32ck940 FIND v(dout0_32) AT=950.05n

.meas tran vdout0_33ck940 FIND v(dout0_33) AT=950.05n

.meas tran vdout0_34ck940 FIND v(dout0_34) AT=950.05n

.meas tran vdout0_35ck940 FIND v(dout0_35) AT=950.05n

.meas tran vdout0_36ck940 FIND v(dout0_36) AT=950.05n

.meas tran vdout0_37ck940 FIND v(dout0_37) AT=950.05n

.meas tran vdout0_38ck940 FIND v(dout0_38) AT=950.05n

.meas tran vdout0_39ck940 FIND v(dout0_39) AT=950.05n

.meas tran vdout0_40ck940 FIND v(dout0_40) AT=950.05n

.meas tran vdout0_41ck940 FIND v(dout0_41) AT=950.05n

.meas tran vdout0_42ck940 FIND v(dout0_42) AT=950.05n

.meas tran vdout0_43ck940 FIND v(dout0_43) AT=950.05n

.meas tran vdout0_44ck940 FIND v(dout0_44) AT=950.05n

.meas tran vdout0_45ck940 FIND v(dout0_45) AT=950.05n

.meas tran vdout0_46ck940 FIND v(dout0_46) AT=950.05n

.meas tran vdout0_47ck940 FIND v(dout0_47) AT=950.05n

.meas tran vdout0_48ck940 FIND v(dout0_48) AT=950.05n

.meas tran vdout0_49ck940 FIND v(dout0_49) AT=950.05n

.meas tran vdout0_50ck940 FIND v(dout0_50) AT=950.05n

.meas tran vdout0_51ck940 FIND v(dout0_51) AT=950.05n

.meas tran vdout0_52ck940 FIND v(dout0_52) AT=950.05n

.meas tran vdout0_53ck940 FIND v(dout0_53) AT=950.05n

.meas tran vdout0_54ck940 FIND v(dout0_54) AT=950.05n

.meas tran vdout0_55ck940 FIND v(dout0_55) AT=950.05n

.meas tran vdout0_56ck940 FIND v(dout0_56) AT=950.05n

.meas tran vdout0_57ck940 FIND v(dout0_57) AT=950.05n

.meas tran vdout0_58ck940 FIND v(dout0_58) AT=950.05n

.meas tran vdout0_59ck940 FIND v(dout0_59) AT=950.05n

.meas tran vdout0_60ck940 FIND v(dout0_60) AT=950.05n

.meas tran vdout0_61ck940 FIND v(dout0_61) AT=950.05n

.meas tran vdout0_62ck940 FIND v(dout0_62) AT=950.05n

.meas tran vdout0_63ck940 FIND v(dout0_63) AT=950.05n

.meas tran vdout1_0ck940 FIND v(dout1_0) AT=950.05n

.meas tran vdout1_1ck940 FIND v(dout1_1) AT=950.05n

.meas tran vdout1_2ck940 FIND v(dout1_2) AT=950.05n

.meas tran vdout1_3ck940 FIND v(dout1_3) AT=950.05n

.meas tran vdout1_4ck940 FIND v(dout1_4) AT=950.05n

.meas tran vdout1_5ck940 FIND v(dout1_5) AT=950.05n

.meas tran vdout1_6ck940 FIND v(dout1_6) AT=950.05n

.meas tran vdout1_7ck940 FIND v(dout1_7) AT=950.05n

.meas tran vdout1_8ck940 FIND v(dout1_8) AT=950.05n

.meas tran vdout1_9ck940 FIND v(dout1_9) AT=950.05n

.meas tran vdout1_10ck940 FIND v(dout1_10) AT=950.05n

.meas tran vdout1_11ck940 FIND v(dout1_11) AT=950.05n

.meas tran vdout1_12ck940 FIND v(dout1_12) AT=950.05n

.meas tran vdout1_13ck940 FIND v(dout1_13) AT=950.05n

.meas tran vdout1_14ck940 FIND v(dout1_14) AT=950.05n

.meas tran vdout1_15ck940 FIND v(dout1_15) AT=950.05n

.meas tran vdout1_16ck940 FIND v(dout1_16) AT=950.05n

.meas tran vdout1_17ck940 FIND v(dout1_17) AT=950.05n

.meas tran vdout1_18ck940 FIND v(dout1_18) AT=950.05n

.meas tran vdout1_19ck940 FIND v(dout1_19) AT=950.05n

.meas tran vdout1_20ck940 FIND v(dout1_20) AT=950.05n

.meas tran vdout1_21ck940 FIND v(dout1_21) AT=950.05n

.meas tran vdout1_22ck940 FIND v(dout1_22) AT=950.05n

.meas tran vdout1_23ck940 FIND v(dout1_23) AT=950.05n

.meas tran vdout1_24ck940 FIND v(dout1_24) AT=950.05n

.meas tran vdout1_25ck940 FIND v(dout1_25) AT=950.05n

.meas tran vdout1_26ck940 FIND v(dout1_26) AT=950.05n

.meas tran vdout1_27ck940 FIND v(dout1_27) AT=950.05n

.meas tran vdout1_28ck940 FIND v(dout1_28) AT=950.05n

.meas tran vdout1_29ck940 FIND v(dout1_29) AT=950.05n

.meas tran vdout1_30ck940 FIND v(dout1_30) AT=950.05n

.meas tran vdout1_31ck940 FIND v(dout1_31) AT=950.05n

.meas tran vdout1_32ck940 FIND v(dout1_32) AT=950.05n

.meas tran vdout1_33ck940 FIND v(dout1_33) AT=950.05n

.meas tran vdout1_34ck940 FIND v(dout1_34) AT=950.05n

.meas tran vdout1_35ck940 FIND v(dout1_35) AT=950.05n

.meas tran vdout1_36ck940 FIND v(dout1_36) AT=950.05n

.meas tran vdout1_37ck940 FIND v(dout1_37) AT=950.05n

.meas tran vdout1_38ck940 FIND v(dout1_38) AT=950.05n

.meas tran vdout1_39ck940 FIND v(dout1_39) AT=950.05n

.meas tran vdout1_40ck940 FIND v(dout1_40) AT=950.05n

.meas tran vdout1_41ck940 FIND v(dout1_41) AT=950.05n

.meas tran vdout1_42ck940 FIND v(dout1_42) AT=950.05n

.meas tran vdout1_43ck940 FIND v(dout1_43) AT=950.05n

.meas tran vdout1_44ck940 FIND v(dout1_44) AT=950.05n

.meas tran vdout1_45ck940 FIND v(dout1_45) AT=950.05n

.meas tran vdout1_46ck940 FIND v(dout1_46) AT=950.05n

.meas tran vdout1_47ck940 FIND v(dout1_47) AT=950.05n

.meas tran vdout1_48ck940 FIND v(dout1_48) AT=950.05n

.meas tran vdout1_49ck940 FIND v(dout1_49) AT=950.05n

.meas tran vdout1_50ck940 FIND v(dout1_50) AT=950.05n

.meas tran vdout1_51ck940 FIND v(dout1_51) AT=950.05n

.meas tran vdout1_52ck940 FIND v(dout1_52) AT=950.05n

.meas tran vdout1_53ck940 FIND v(dout1_53) AT=950.05n

.meas tran vdout1_54ck940 FIND v(dout1_54) AT=950.05n

.meas tran vdout1_55ck940 FIND v(dout1_55) AT=950.05n

.meas tran vdout1_56ck940 FIND v(dout1_56) AT=950.05n

.meas tran vdout1_57ck940 FIND v(dout1_57) AT=950.05n

.meas tran vdout1_58ck940 FIND v(dout1_58) AT=950.05n

.meas tran vdout1_59ck940 FIND v(dout1_59) AT=950.05n

.meas tran vdout1_60ck940 FIND v(dout1_60) AT=950.05n

.meas tran vdout1_61ck940 FIND v(dout1_61) AT=950.05n

.meas tran vdout1_62ck940 FIND v(dout1_62) AT=950.05n

.meas tran vdout1_63ck940 FIND v(dout1_63) AT=950.05n

.meas tran vdout0_0ck950 FIND v(dout0_0) AT=960.05n

.meas tran vdout0_1ck950 FIND v(dout0_1) AT=960.05n

.meas tran vdout0_2ck950 FIND v(dout0_2) AT=960.05n

.meas tran vdout0_3ck950 FIND v(dout0_3) AT=960.05n

.meas tran vdout0_4ck950 FIND v(dout0_4) AT=960.05n

.meas tran vdout0_5ck950 FIND v(dout0_5) AT=960.05n

.meas tran vdout0_6ck950 FIND v(dout0_6) AT=960.05n

.meas tran vdout0_7ck950 FIND v(dout0_7) AT=960.05n

.meas tran vdout0_8ck950 FIND v(dout0_8) AT=960.05n

.meas tran vdout0_9ck950 FIND v(dout0_9) AT=960.05n

.meas tran vdout0_10ck950 FIND v(dout0_10) AT=960.05n

.meas tran vdout0_11ck950 FIND v(dout0_11) AT=960.05n

.meas tran vdout0_12ck950 FIND v(dout0_12) AT=960.05n

.meas tran vdout0_13ck950 FIND v(dout0_13) AT=960.05n

.meas tran vdout0_14ck950 FIND v(dout0_14) AT=960.05n

.meas tran vdout0_15ck950 FIND v(dout0_15) AT=960.05n

.meas tran vdout0_16ck950 FIND v(dout0_16) AT=960.05n

.meas tran vdout0_17ck950 FIND v(dout0_17) AT=960.05n

.meas tran vdout0_18ck950 FIND v(dout0_18) AT=960.05n

.meas tran vdout0_19ck950 FIND v(dout0_19) AT=960.05n

.meas tran vdout0_20ck950 FIND v(dout0_20) AT=960.05n

.meas tran vdout0_21ck950 FIND v(dout0_21) AT=960.05n

.meas tran vdout0_22ck950 FIND v(dout0_22) AT=960.05n

.meas tran vdout0_23ck950 FIND v(dout0_23) AT=960.05n

.meas tran vdout0_24ck950 FIND v(dout0_24) AT=960.05n

.meas tran vdout0_25ck950 FIND v(dout0_25) AT=960.05n

.meas tran vdout0_26ck950 FIND v(dout0_26) AT=960.05n

.meas tran vdout0_27ck950 FIND v(dout0_27) AT=960.05n

.meas tran vdout0_28ck950 FIND v(dout0_28) AT=960.05n

.meas tran vdout0_29ck950 FIND v(dout0_29) AT=960.05n

.meas tran vdout0_30ck950 FIND v(dout0_30) AT=960.05n

.meas tran vdout0_31ck950 FIND v(dout0_31) AT=960.05n

.meas tran vdout0_32ck950 FIND v(dout0_32) AT=960.05n

.meas tran vdout0_33ck950 FIND v(dout0_33) AT=960.05n

.meas tran vdout0_34ck950 FIND v(dout0_34) AT=960.05n

.meas tran vdout0_35ck950 FIND v(dout0_35) AT=960.05n

.meas tran vdout0_36ck950 FIND v(dout0_36) AT=960.05n

.meas tran vdout0_37ck950 FIND v(dout0_37) AT=960.05n

.meas tran vdout0_38ck950 FIND v(dout0_38) AT=960.05n

.meas tran vdout0_39ck950 FIND v(dout0_39) AT=960.05n

.meas tran vdout0_40ck950 FIND v(dout0_40) AT=960.05n

.meas tran vdout0_41ck950 FIND v(dout0_41) AT=960.05n

.meas tran vdout0_42ck950 FIND v(dout0_42) AT=960.05n

.meas tran vdout0_43ck950 FIND v(dout0_43) AT=960.05n

.meas tran vdout0_44ck950 FIND v(dout0_44) AT=960.05n

.meas tran vdout0_45ck950 FIND v(dout0_45) AT=960.05n

.meas tran vdout0_46ck950 FIND v(dout0_46) AT=960.05n

.meas tran vdout0_47ck950 FIND v(dout0_47) AT=960.05n

.meas tran vdout0_48ck950 FIND v(dout0_48) AT=960.05n

.meas tran vdout0_49ck950 FIND v(dout0_49) AT=960.05n

.meas tran vdout0_50ck950 FIND v(dout0_50) AT=960.05n

.meas tran vdout0_51ck950 FIND v(dout0_51) AT=960.05n

.meas tran vdout0_52ck950 FIND v(dout0_52) AT=960.05n

.meas tran vdout0_53ck950 FIND v(dout0_53) AT=960.05n

.meas tran vdout0_54ck950 FIND v(dout0_54) AT=960.05n

.meas tran vdout0_55ck950 FIND v(dout0_55) AT=960.05n

.meas tran vdout0_56ck950 FIND v(dout0_56) AT=960.05n

.meas tran vdout0_57ck950 FIND v(dout0_57) AT=960.05n

.meas tran vdout0_58ck950 FIND v(dout0_58) AT=960.05n

.meas tran vdout0_59ck950 FIND v(dout0_59) AT=960.05n

.meas tran vdout0_60ck950 FIND v(dout0_60) AT=960.05n

.meas tran vdout0_61ck950 FIND v(dout0_61) AT=960.05n

.meas tran vdout0_62ck950 FIND v(dout0_62) AT=960.05n

.meas tran vdout0_63ck950 FIND v(dout0_63) AT=960.05n

.meas tran vdout1_0ck950 FIND v(dout1_0) AT=960.05n

.meas tran vdout1_1ck950 FIND v(dout1_1) AT=960.05n

.meas tran vdout1_2ck950 FIND v(dout1_2) AT=960.05n

.meas tran vdout1_3ck950 FIND v(dout1_3) AT=960.05n

.meas tran vdout1_4ck950 FIND v(dout1_4) AT=960.05n

.meas tran vdout1_5ck950 FIND v(dout1_5) AT=960.05n

.meas tran vdout1_6ck950 FIND v(dout1_6) AT=960.05n

.meas tran vdout1_7ck950 FIND v(dout1_7) AT=960.05n

.meas tran vdout1_8ck950 FIND v(dout1_8) AT=960.05n

.meas tran vdout1_9ck950 FIND v(dout1_9) AT=960.05n

.meas tran vdout1_10ck950 FIND v(dout1_10) AT=960.05n

.meas tran vdout1_11ck950 FIND v(dout1_11) AT=960.05n

.meas tran vdout1_12ck950 FIND v(dout1_12) AT=960.05n

.meas tran vdout1_13ck950 FIND v(dout1_13) AT=960.05n

.meas tran vdout1_14ck950 FIND v(dout1_14) AT=960.05n

.meas tran vdout1_15ck950 FIND v(dout1_15) AT=960.05n

.meas tran vdout1_16ck950 FIND v(dout1_16) AT=960.05n

.meas tran vdout1_17ck950 FIND v(dout1_17) AT=960.05n

.meas tran vdout1_18ck950 FIND v(dout1_18) AT=960.05n

.meas tran vdout1_19ck950 FIND v(dout1_19) AT=960.05n

.meas tran vdout1_20ck950 FIND v(dout1_20) AT=960.05n

.meas tran vdout1_21ck950 FIND v(dout1_21) AT=960.05n

.meas tran vdout1_22ck950 FIND v(dout1_22) AT=960.05n

.meas tran vdout1_23ck950 FIND v(dout1_23) AT=960.05n

.meas tran vdout1_24ck950 FIND v(dout1_24) AT=960.05n

.meas tran vdout1_25ck950 FIND v(dout1_25) AT=960.05n

.meas tran vdout1_26ck950 FIND v(dout1_26) AT=960.05n

.meas tran vdout1_27ck950 FIND v(dout1_27) AT=960.05n

.meas tran vdout1_28ck950 FIND v(dout1_28) AT=960.05n

.meas tran vdout1_29ck950 FIND v(dout1_29) AT=960.05n

.meas tran vdout1_30ck950 FIND v(dout1_30) AT=960.05n

.meas tran vdout1_31ck950 FIND v(dout1_31) AT=960.05n

.meas tran vdout1_32ck950 FIND v(dout1_32) AT=960.05n

.meas tran vdout1_33ck950 FIND v(dout1_33) AT=960.05n

.meas tran vdout1_34ck950 FIND v(dout1_34) AT=960.05n

.meas tran vdout1_35ck950 FIND v(dout1_35) AT=960.05n

.meas tran vdout1_36ck950 FIND v(dout1_36) AT=960.05n

.meas tran vdout1_37ck950 FIND v(dout1_37) AT=960.05n

.meas tran vdout1_38ck950 FIND v(dout1_38) AT=960.05n

.meas tran vdout1_39ck950 FIND v(dout1_39) AT=960.05n

.meas tran vdout1_40ck950 FIND v(dout1_40) AT=960.05n

.meas tran vdout1_41ck950 FIND v(dout1_41) AT=960.05n

.meas tran vdout1_42ck950 FIND v(dout1_42) AT=960.05n

.meas tran vdout1_43ck950 FIND v(dout1_43) AT=960.05n

.meas tran vdout1_44ck950 FIND v(dout1_44) AT=960.05n

.meas tran vdout1_45ck950 FIND v(dout1_45) AT=960.05n

.meas tran vdout1_46ck950 FIND v(dout1_46) AT=960.05n

.meas tran vdout1_47ck950 FIND v(dout1_47) AT=960.05n

.meas tran vdout1_48ck950 FIND v(dout1_48) AT=960.05n

.meas tran vdout1_49ck950 FIND v(dout1_49) AT=960.05n

.meas tran vdout1_50ck950 FIND v(dout1_50) AT=960.05n

.meas tran vdout1_51ck950 FIND v(dout1_51) AT=960.05n

.meas tran vdout1_52ck950 FIND v(dout1_52) AT=960.05n

.meas tran vdout1_53ck950 FIND v(dout1_53) AT=960.05n

.meas tran vdout1_54ck950 FIND v(dout1_54) AT=960.05n

.meas tran vdout1_55ck950 FIND v(dout1_55) AT=960.05n

.meas tran vdout1_56ck950 FIND v(dout1_56) AT=960.05n

.meas tran vdout1_57ck950 FIND v(dout1_57) AT=960.05n

.meas tran vdout1_58ck950 FIND v(dout1_58) AT=960.05n

.meas tran vdout1_59ck950 FIND v(dout1_59) AT=960.05n

.meas tran vdout1_60ck950 FIND v(dout1_60) AT=960.05n

.meas tran vdout1_61ck950 FIND v(dout1_61) AT=960.05n

.meas tran vdout1_62ck950 FIND v(dout1_62) AT=960.05n

.meas tran vdout1_63ck950 FIND v(dout1_63) AT=960.05n

.meas tran vdout0_0ck960 FIND v(dout0_0) AT=970.05n

.meas tran vdout0_1ck960 FIND v(dout0_1) AT=970.05n

.meas tran vdout0_2ck960 FIND v(dout0_2) AT=970.05n

.meas tran vdout0_3ck960 FIND v(dout0_3) AT=970.05n

.meas tran vdout0_4ck960 FIND v(dout0_4) AT=970.05n

.meas tran vdout0_5ck960 FIND v(dout0_5) AT=970.05n

.meas tran vdout0_6ck960 FIND v(dout0_6) AT=970.05n

.meas tran vdout0_7ck960 FIND v(dout0_7) AT=970.05n

.meas tran vdout0_8ck960 FIND v(dout0_8) AT=970.05n

.meas tran vdout0_9ck960 FIND v(dout0_9) AT=970.05n

.meas tran vdout0_10ck960 FIND v(dout0_10) AT=970.05n

.meas tran vdout0_11ck960 FIND v(dout0_11) AT=970.05n

.meas tran vdout0_12ck960 FIND v(dout0_12) AT=970.05n

.meas tran vdout0_13ck960 FIND v(dout0_13) AT=970.05n

.meas tran vdout0_14ck960 FIND v(dout0_14) AT=970.05n

.meas tran vdout0_15ck960 FIND v(dout0_15) AT=970.05n

.meas tran vdout0_16ck960 FIND v(dout0_16) AT=970.05n

.meas tran vdout0_17ck960 FIND v(dout0_17) AT=970.05n

.meas tran vdout0_18ck960 FIND v(dout0_18) AT=970.05n

.meas tran vdout0_19ck960 FIND v(dout0_19) AT=970.05n

.meas tran vdout0_20ck960 FIND v(dout0_20) AT=970.05n

.meas tran vdout0_21ck960 FIND v(dout0_21) AT=970.05n

.meas tran vdout0_22ck960 FIND v(dout0_22) AT=970.05n

.meas tran vdout0_23ck960 FIND v(dout0_23) AT=970.05n

.meas tran vdout0_24ck960 FIND v(dout0_24) AT=970.05n

.meas tran vdout0_25ck960 FIND v(dout0_25) AT=970.05n

.meas tran vdout0_26ck960 FIND v(dout0_26) AT=970.05n

.meas tran vdout0_27ck960 FIND v(dout0_27) AT=970.05n

.meas tran vdout0_28ck960 FIND v(dout0_28) AT=970.05n

.meas tran vdout0_29ck960 FIND v(dout0_29) AT=970.05n

.meas tran vdout0_30ck960 FIND v(dout0_30) AT=970.05n

.meas tran vdout0_31ck960 FIND v(dout0_31) AT=970.05n

.meas tran vdout0_32ck960 FIND v(dout0_32) AT=970.05n

.meas tran vdout0_33ck960 FIND v(dout0_33) AT=970.05n

.meas tran vdout0_34ck960 FIND v(dout0_34) AT=970.05n

.meas tran vdout0_35ck960 FIND v(dout0_35) AT=970.05n

.meas tran vdout0_36ck960 FIND v(dout0_36) AT=970.05n

.meas tran vdout0_37ck960 FIND v(dout0_37) AT=970.05n

.meas tran vdout0_38ck960 FIND v(dout0_38) AT=970.05n

.meas tran vdout0_39ck960 FIND v(dout0_39) AT=970.05n

.meas tran vdout0_40ck960 FIND v(dout0_40) AT=970.05n

.meas tran vdout0_41ck960 FIND v(dout0_41) AT=970.05n

.meas tran vdout0_42ck960 FIND v(dout0_42) AT=970.05n

.meas tran vdout0_43ck960 FIND v(dout0_43) AT=970.05n

.meas tran vdout0_44ck960 FIND v(dout0_44) AT=970.05n

.meas tran vdout0_45ck960 FIND v(dout0_45) AT=970.05n

.meas tran vdout0_46ck960 FIND v(dout0_46) AT=970.05n

.meas tran vdout0_47ck960 FIND v(dout0_47) AT=970.05n

.meas tran vdout0_48ck960 FIND v(dout0_48) AT=970.05n

.meas tran vdout0_49ck960 FIND v(dout0_49) AT=970.05n

.meas tran vdout0_50ck960 FIND v(dout0_50) AT=970.05n

.meas tran vdout0_51ck960 FIND v(dout0_51) AT=970.05n

.meas tran vdout0_52ck960 FIND v(dout0_52) AT=970.05n

.meas tran vdout0_53ck960 FIND v(dout0_53) AT=970.05n

.meas tran vdout0_54ck960 FIND v(dout0_54) AT=970.05n

.meas tran vdout0_55ck960 FIND v(dout0_55) AT=970.05n

.meas tran vdout0_56ck960 FIND v(dout0_56) AT=970.05n

.meas tran vdout0_57ck960 FIND v(dout0_57) AT=970.05n

.meas tran vdout0_58ck960 FIND v(dout0_58) AT=970.05n

.meas tran vdout0_59ck960 FIND v(dout0_59) AT=970.05n

.meas tran vdout0_60ck960 FIND v(dout0_60) AT=970.05n

.meas tran vdout0_61ck960 FIND v(dout0_61) AT=970.05n

.meas tran vdout0_62ck960 FIND v(dout0_62) AT=970.05n

.meas tran vdout0_63ck960 FIND v(dout0_63) AT=970.05n

.meas tran vdout1_0ck960 FIND v(dout1_0) AT=970.05n

.meas tran vdout1_1ck960 FIND v(dout1_1) AT=970.05n

.meas tran vdout1_2ck960 FIND v(dout1_2) AT=970.05n

.meas tran vdout1_3ck960 FIND v(dout1_3) AT=970.05n

.meas tran vdout1_4ck960 FIND v(dout1_4) AT=970.05n

.meas tran vdout1_5ck960 FIND v(dout1_5) AT=970.05n

.meas tran vdout1_6ck960 FIND v(dout1_6) AT=970.05n

.meas tran vdout1_7ck960 FIND v(dout1_7) AT=970.05n

.meas tran vdout1_8ck960 FIND v(dout1_8) AT=970.05n

.meas tran vdout1_9ck960 FIND v(dout1_9) AT=970.05n

.meas tran vdout1_10ck960 FIND v(dout1_10) AT=970.05n

.meas tran vdout1_11ck960 FIND v(dout1_11) AT=970.05n

.meas tran vdout1_12ck960 FIND v(dout1_12) AT=970.05n

.meas tran vdout1_13ck960 FIND v(dout1_13) AT=970.05n

.meas tran vdout1_14ck960 FIND v(dout1_14) AT=970.05n

.meas tran vdout1_15ck960 FIND v(dout1_15) AT=970.05n

.meas tran vdout1_16ck960 FIND v(dout1_16) AT=970.05n

.meas tran vdout1_17ck960 FIND v(dout1_17) AT=970.05n

.meas tran vdout1_18ck960 FIND v(dout1_18) AT=970.05n

.meas tran vdout1_19ck960 FIND v(dout1_19) AT=970.05n

.meas tran vdout1_20ck960 FIND v(dout1_20) AT=970.05n

.meas tran vdout1_21ck960 FIND v(dout1_21) AT=970.05n

.meas tran vdout1_22ck960 FIND v(dout1_22) AT=970.05n

.meas tran vdout1_23ck960 FIND v(dout1_23) AT=970.05n

.meas tran vdout1_24ck960 FIND v(dout1_24) AT=970.05n

.meas tran vdout1_25ck960 FIND v(dout1_25) AT=970.05n

.meas tran vdout1_26ck960 FIND v(dout1_26) AT=970.05n

.meas tran vdout1_27ck960 FIND v(dout1_27) AT=970.05n

.meas tran vdout1_28ck960 FIND v(dout1_28) AT=970.05n

.meas tran vdout1_29ck960 FIND v(dout1_29) AT=970.05n

.meas tran vdout1_30ck960 FIND v(dout1_30) AT=970.05n

.meas tran vdout1_31ck960 FIND v(dout1_31) AT=970.05n

.meas tran vdout1_32ck960 FIND v(dout1_32) AT=970.05n

.meas tran vdout1_33ck960 FIND v(dout1_33) AT=970.05n

.meas tran vdout1_34ck960 FIND v(dout1_34) AT=970.05n

.meas tran vdout1_35ck960 FIND v(dout1_35) AT=970.05n

.meas tran vdout1_36ck960 FIND v(dout1_36) AT=970.05n

.meas tran vdout1_37ck960 FIND v(dout1_37) AT=970.05n

.meas tran vdout1_38ck960 FIND v(dout1_38) AT=970.05n

.meas tran vdout1_39ck960 FIND v(dout1_39) AT=970.05n

.meas tran vdout1_40ck960 FIND v(dout1_40) AT=970.05n

.meas tran vdout1_41ck960 FIND v(dout1_41) AT=970.05n

.meas tran vdout1_42ck960 FIND v(dout1_42) AT=970.05n

.meas tran vdout1_43ck960 FIND v(dout1_43) AT=970.05n

.meas tran vdout1_44ck960 FIND v(dout1_44) AT=970.05n

.meas tran vdout1_45ck960 FIND v(dout1_45) AT=970.05n

.meas tran vdout1_46ck960 FIND v(dout1_46) AT=970.05n

.meas tran vdout1_47ck960 FIND v(dout1_47) AT=970.05n

.meas tran vdout1_48ck960 FIND v(dout1_48) AT=970.05n

.meas tran vdout1_49ck960 FIND v(dout1_49) AT=970.05n

.meas tran vdout1_50ck960 FIND v(dout1_50) AT=970.05n

.meas tran vdout1_51ck960 FIND v(dout1_51) AT=970.05n

.meas tran vdout1_52ck960 FIND v(dout1_52) AT=970.05n

.meas tran vdout1_53ck960 FIND v(dout1_53) AT=970.05n

.meas tran vdout1_54ck960 FIND v(dout1_54) AT=970.05n

.meas tran vdout1_55ck960 FIND v(dout1_55) AT=970.05n

.meas tran vdout1_56ck960 FIND v(dout1_56) AT=970.05n

.meas tran vdout1_57ck960 FIND v(dout1_57) AT=970.05n

.meas tran vdout1_58ck960 FIND v(dout1_58) AT=970.05n

.meas tran vdout1_59ck960 FIND v(dout1_59) AT=970.05n

.meas tran vdout1_60ck960 FIND v(dout1_60) AT=970.05n

.meas tran vdout1_61ck960 FIND v(dout1_61) AT=970.05n

.meas tran vdout1_62ck960 FIND v(dout1_62) AT=970.05n

.meas tran vdout1_63ck960 FIND v(dout1_63) AT=970.05n

.meas tran vdout0_0ck980 FIND v(dout0_0) AT=990.05n

.meas tran vdout0_1ck980 FIND v(dout0_1) AT=990.05n

.meas tran vdout0_2ck980 FIND v(dout0_2) AT=990.05n

.meas tran vdout0_3ck980 FIND v(dout0_3) AT=990.05n

.meas tran vdout0_4ck980 FIND v(dout0_4) AT=990.05n

.meas tran vdout0_5ck980 FIND v(dout0_5) AT=990.05n

.meas tran vdout0_6ck980 FIND v(dout0_6) AT=990.05n

.meas tran vdout0_7ck980 FIND v(dout0_7) AT=990.05n

.meas tran vdout0_8ck980 FIND v(dout0_8) AT=990.05n

.meas tran vdout0_9ck980 FIND v(dout0_9) AT=990.05n

.meas tran vdout0_10ck980 FIND v(dout0_10) AT=990.05n

.meas tran vdout0_11ck980 FIND v(dout0_11) AT=990.05n

.meas tran vdout0_12ck980 FIND v(dout0_12) AT=990.05n

.meas tran vdout0_13ck980 FIND v(dout0_13) AT=990.05n

.meas tran vdout0_14ck980 FIND v(dout0_14) AT=990.05n

.meas tran vdout0_15ck980 FIND v(dout0_15) AT=990.05n

.meas tran vdout0_16ck980 FIND v(dout0_16) AT=990.05n

.meas tran vdout0_17ck980 FIND v(dout0_17) AT=990.05n

.meas tran vdout0_18ck980 FIND v(dout0_18) AT=990.05n

.meas tran vdout0_19ck980 FIND v(dout0_19) AT=990.05n

.meas tran vdout0_20ck980 FIND v(dout0_20) AT=990.05n

.meas tran vdout0_21ck980 FIND v(dout0_21) AT=990.05n

.meas tran vdout0_22ck980 FIND v(dout0_22) AT=990.05n

.meas tran vdout0_23ck980 FIND v(dout0_23) AT=990.05n

.meas tran vdout0_24ck980 FIND v(dout0_24) AT=990.05n

.meas tran vdout0_25ck980 FIND v(dout0_25) AT=990.05n

.meas tran vdout0_26ck980 FIND v(dout0_26) AT=990.05n

.meas tran vdout0_27ck980 FIND v(dout0_27) AT=990.05n

.meas tran vdout0_28ck980 FIND v(dout0_28) AT=990.05n

.meas tran vdout0_29ck980 FIND v(dout0_29) AT=990.05n

.meas tran vdout0_30ck980 FIND v(dout0_30) AT=990.05n

.meas tran vdout0_31ck980 FIND v(dout0_31) AT=990.05n

.meas tran vdout0_32ck980 FIND v(dout0_32) AT=990.05n

.meas tran vdout0_33ck980 FIND v(dout0_33) AT=990.05n

.meas tran vdout0_34ck980 FIND v(dout0_34) AT=990.05n

.meas tran vdout0_35ck980 FIND v(dout0_35) AT=990.05n

.meas tran vdout0_36ck980 FIND v(dout0_36) AT=990.05n

.meas tran vdout0_37ck980 FIND v(dout0_37) AT=990.05n

.meas tran vdout0_38ck980 FIND v(dout0_38) AT=990.05n

.meas tran vdout0_39ck980 FIND v(dout0_39) AT=990.05n

.meas tran vdout0_40ck980 FIND v(dout0_40) AT=990.05n

.meas tran vdout0_41ck980 FIND v(dout0_41) AT=990.05n

.meas tran vdout0_42ck980 FIND v(dout0_42) AT=990.05n

.meas tran vdout0_43ck980 FIND v(dout0_43) AT=990.05n

.meas tran vdout0_44ck980 FIND v(dout0_44) AT=990.05n

.meas tran vdout0_45ck980 FIND v(dout0_45) AT=990.05n

.meas tran vdout0_46ck980 FIND v(dout0_46) AT=990.05n

.meas tran vdout0_47ck980 FIND v(dout0_47) AT=990.05n

.meas tran vdout0_48ck980 FIND v(dout0_48) AT=990.05n

.meas tran vdout0_49ck980 FIND v(dout0_49) AT=990.05n

.meas tran vdout0_50ck980 FIND v(dout0_50) AT=990.05n

.meas tran vdout0_51ck980 FIND v(dout0_51) AT=990.05n

.meas tran vdout0_52ck980 FIND v(dout0_52) AT=990.05n

.meas tran vdout0_53ck980 FIND v(dout0_53) AT=990.05n

.meas tran vdout0_54ck980 FIND v(dout0_54) AT=990.05n

.meas tran vdout0_55ck980 FIND v(dout0_55) AT=990.05n

.meas tran vdout0_56ck980 FIND v(dout0_56) AT=990.05n

.meas tran vdout0_57ck980 FIND v(dout0_57) AT=990.05n

.meas tran vdout0_58ck980 FIND v(dout0_58) AT=990.05n

.meas tran vdout0_59ck980 FIND v(dout0_59) AT=990.05n

.meas tran vdout0_60ck980 FIND v(dout0_60) AT=990.05n

.meas tran vdout0_61ck980 FIND v(dout0_61) AT=990.05n

.meas tran vdout0_62ck980 FIND v(dout0_62) AT=990.05n

.meas tran vdout0_63ck980 FIND v(dout0_63) AT=990.05n

.meas tran vdout1_0ck980 FIND v(dout1_0) AT=990.05n

.meas tran vdout1_1ck980 FIND v(dout1_1) AT=990.05n

.meas tran vdout1_2ck980 FIND v(dout1_2) AT=990.05n

.meas tran vdout1_3ck980 FIND v(dout1_3) AT=990.05n

.meas tran vdout1_4ck980 FIND v(dout1_4) AT=990.05n

.meas tran vdout1_5ck980 FIND v(dout1_5) AT=990.05n

.meas tran vdout1_6ck980 FIND v(dout1_6) AT=990.05n

.meas tran vdout1_7ck980 FIND v(dout1_7) AT=990.05n

.meas tran vdout1_8ck980 FIND v(dout1_8) AT=990.05n

.meas tran vdout1_9ck980 FIND v(dout1_9) AT=990.05n

.meas tran vdout1_10ck980 FIND v(dout1_10) AT=990.05n

.meas tran vdout1_11ck980 FIND v(dout1_11) AT=990.05n

.meas tran vdout1_12ck980 FIND v(dout1_12) AT=990.05n

.meas tran vdout1_13ck980 FIND v(dout1_13) AT=990.05n

.meas tran vdout1_14ck980 FIND v(dout1_14) AT=990.05n

.meas tran vdout1_15ck980 FIND v(dout1_15) AT=990.05n

.meas tran vdout1_16ck980 FIND v(dout1_16) AT=990.05n

.meas tran vdout1_17ck980 FIND v(dout1_17) AT=990.05n

.meas tran vdout1_18ck980 FIND v(dout1_18) AT=990.05n

.meas tran vdout1_19ck980 FIND v(dout1_19) AT=990.05n

.meas tran vdout1_20ck980 FIND v(dout1_20) AT=990.05n

.meas tran vdout1_21ck980 FIND v(dout1_21) AT=990.05n

.meas tran vdout1_22ck980 FIND v(dout1_22) AT=990.05n

.meas tran vdout1_23ck980 FIND v(dout1_23) AT=990.05n

.meas tran vdout1_24ck980 FIND v(dout1_24) AT=990.05n

.meas tran vdout1_25ck980 FIND v(dout1_25) AT=990.05n

.meas tran vdout1_26ck980 FIND v(dout1_26) AT=990.05n

.meas tran vdout1_27ck980 FIND v(dout1_27) AT=990.05n

.meas tran vdout1_28ck980 FIND v(dout1_28) AT=990.05n

.meas tran vdout1_29ck980 FIND v(dout1_29) AT=990.05n

.meas tran vdout1_30ck980 FIND v(dout1_30) AT=990.05n

.meas tran vdout1_31ck980 FIND v(dout1_31) AT=990.05n

.meas tran vdout1_32ck980 FIND v(dout1_32) AT=990.05n

.meas tran vdout1_33ck980 FIND v(dout1_33) AT=990.05n

.meas tran vdout1_34ck980 FIND v(dout1_34) AT=990.05n

.meas tran vdout1_35ck980 FIND v(dout1_35) AT=990.05n

.meas tran vdout1_36ck980 FIND v(dout1_36) AT=990.05n

.meas tran vdout1_37ck980 FIND v(dout1_37) AT=990.05n

.meas tran vdout1_38ck980 FIND v(dout1_38) AT=990.05n

.meas tran vdout1_39ck980 FIND v(dout1_39) AT=990.05n

.meas tran vdout1_40ck980 FIND v(dout1_40) AT=990.05n

.meas tran vdout1_41ck980 FIND v(dout1_41) AT=990.05n

.meas tran vdout1_42ck980 FIND v(dout1_42) AT=990.05n

.meas tran vdout1_43ck980 FIND v(dout1_43) AT=990.05n

.meas tran vdout1_44ck980 FIND v(dout1_44) AT=990.05n

.meas tran vdout1_45ck980 FIND v(dout1_45) AT=990.05n

.meas tran vdout1_46ck980 FIND v(dout1_46) AT=990.05n

.meas tran vdout1_47ck980 FIND v(dout1_47) AT=990.05n

.meas tran vdout1_48ck980 FIND v(dout1_48) AT=990.05n

.meas tran vdout1_49ck980 FIND v(dout1_49) AT=990.05n

.meas tran vdout1_50ck980 FIND v(dout1_50) AT=990.05n

.meas tran vdout1_51ck980 FIND v(dout1_51) AT=990.05n

.meas tran vdout1_52ck980 FIND v(dout1_52) AT=990.05n

.meas tran vdout1_53ck980 FIND v(dout1_53) AT=990.05n

.meas tran vdout1_54ck980 FIND v(dout1_54) AT=990.05n

.meas tran vdout1_55ck980 FIND v(dout1_55) AT=990.05n

.meas tran vdout1_56ck980 FIND v(dout1_56) AT=990.05n

.meas tran vdout1_57ck980 FIND v(dout1_57) AT=990.05n

.meas tran vdout1_58ck980 FIND v(dout1_58) AT=990.05n

.meas tran vdout1_59ck980 FIND v(dout1_59) AT=990.05n

.meas tran vdout1_60ck980 FIND v(dout1_60) AT=990.05n

.meas tran vdout1_61ck980 FIND v(dout1_61) AT=990.05n

.meas tran vdout1_62ck980 FIND v(dout1_62) AT=990.05n

.meas tran vdout1_63ck980 FIND v(dout1_63) AT=990.05n

.meas tran vdout0_0ck1000 FIND v(dout0_0) AT=1010.05n

.meas tran vdout0_1ck1000 FIND v(dout0_1) AT=1010.05n

.meas tran vdout0_2ck1000 FIND v(dout0_2) AT=1010.05n

.meas tran vdout0_3ck1000 FIND v(dout0_3) AT=1010.05n

.meas tran vdout0_4ck1000 FIND v(dout0_4) AT=1010.05n

.meas tran vdout0_5ck1000 FIND v(dout0_5) AT=1010.05n

.meas tran vdout0_6ck1000 FIND v(dout0_6) AT=1010.05n

.meas tran vdout0_7ck1000 FIND v(dout0_7) AT=1010.05n

.meas tran vdout0_8ck1000 FIND v(dout0_8) AT=1010.05n

.meas tran vdout0_9ck1000 FIND v(dout0_9) AT=1010.05n

.meas tran vdout0_10ck1000 FIND v(dout0_10) AT=1010.05n

.meas tran vdout0_11ck1000 FIND v(dout0_11) AT=1010.05n

.meas tran vdout0_12ck1000 FIND v(dout0_12) AT=1010.05n

.meas tran vdout0_13ck1000 FIND v(dout0_13) AT=1010.05n

.meas tran vdout0_14ck1000 FIND v(dout0_14) AT=1010.05n

.meas tran vdout0_15ck1000 FIND v(dout0_15) AT=1010.05n

.meas tran vdout0_16ck1000 FIND v(dout0_16) AT=1010.05n

.meas tran vdout0_17ck1000 FIND v(dout0_17) AT=1010.05n

.meas tran vdout0_18ck1000 FIND v(dout0_18) AT=1010.05n

.meas tran vdout0_19ck1000 FIND v(dout0_19) AT=1010.05n

.meas tran vdout0_20ck1000 FIND v(dout0_20) AT=1010.05n

.meas tran vdout0_21ck1000 FIND v(dout0_21) AT=1010.05n

.meas tran vdout0_22ck1000 FIND v(dout0_22) AT=1010.05n

.meas tran vdout0_23ck1000 FIND v(dout0_23) AT=1010.05n

.meas tran vdout0_24ck1000 FIND v(dout0_24) AT=1010.05n

.meas tran vdout0_25ck1000 FIND v(dout0_25) AT=1010.05n

.meas tran vdout0_26ck1000 FIND v(dout0_26) AT=1010.05n

.meas tran vdout0_27ck1000 FIND v(dout0_27) AT=1010.05n

.meas tran vdout0_28ck1000 FIND v(dout0_28) AT=1010.05n

.meas tran vdout0_29ck1000 FIND v(dout0_29) AT=1010.05n

.meas tran vdout0_30ck1000 FIND v(dout0_30) AT=1010.05n

.meas tran vdout0_31ck1000 FIND v(dout0_31) AT=1010.05n

.meas tran vdout0_32ck1000 FIND v(dout0_32) AT=1010.05n

.meas tran vdout0_33ck1000 FIND v(dout0_33) AT=1010.05n

.meas tran vdout0_34ck1000 FIND v(dout0_34) AT=1010.05n

.meas tran vdout0_35ck1000 FIND v(dout0_35) AT=1010.05n

.meas tran vdout0_36ck1000 FIND v(dout0_36) AT=1010.05n

.meas tran vdout0_37ck1000 FIND v(dout0_37) AT=1010.05n

.meas tran vdout0_38ck1000 FIND v(dout0_38) AT=1010.05n

.meas tran vdout0_39ck1000 FIND v(dout0_39) AT=1010.05n

.meas tran vdout0_40ck1000 FIND v(dout0_40) AT=1010.05n

.meas tran vdout0_41ck1000 FIND v(dout0_41) AT=1010.05n

.meas tran vdout0_42ck1000 FIND v(dout0_42) AT=1010.05n

.meas tran vdout0_43ck1000 FIND v(dout0_43) AT=1010.05n

.meas tran vdout0_44ck1000 FIND v(dout0_44) AT=1010.05n

.meas tran vdout0_45ck1000 FIND v(dout0_45) AT=1010.05n

.meas tran vdout0_46ck1000 FIND v(dout0_46) AT=1010.05n

.meas tran vdout0_47ck1000 FIND v(dout0_47) AT=1010.05n

.meas tran vdout0_48ck1000 FIND v(dout0_48) AT=1010.05n

.meas tran vdout0_49ck1000 FIND v(dout0_49) AT=1010.05n

.meas tran vdout0_50ck1000 FIND v(dout0_50) AT=1010.05n

.meas tran vdout0_51ck1000 FIND v(dout0_51) AT=1010.05n

.meas tran vdout0_52ck1000 FIND v(dout0_52) AT=1010.05n

.meas tran vdout0_53ck1000 FIND v(dout0_53) AT=1010.05n

.meas tran vdout0_54ck1000 FIND v(dout0_54) AT=1010.05n

.meas tran vdout0_55ck1000 FIND v(dout0_55) AT=1010.05n

.meas tran vdout0_56ck1000 FIND v(dout0_56) AT=1010.05n

.meas tran vdout0_57ck1000 FIND v(dout0_57) AT=1010.05n

.meas tran vdout0_58ck1000 FIND v(dout0_58) AT=1010.05n

.meas tran vdout0_59ck1000 FIND v(dout0_59) AT=1010.05n

.meas tran vdout0_60ck1000 FIND v(dout0_60) AT=1010.05n

.meas tran vdout0_61ck1000 FIND v(dout0_61) AT=1010.05n

.meas tran vdout0_62ck1000 FIND v(dout0_62) AT=1010.05n

.meas tran vdout0_63ck1000 FIND v(dout0_63) AT=1010.05n

.meas tran vdout1_0ck1000 FIND v(dout1_0) AT=1010.05n

.meas tran vdout1_1ck1000 FIND v(dout1_1) AT=1010.05n

.meas tran vdout1_2ck1000 FIND v(dout1_2) AT=1010.05n

.meas tran vdout1_3ck1000 FIND v(dout1_3) AT=1010.05n

.meas tran vdout1_4ck1000 FIND v(dout1_4) AT=1010.05n

.meas tran vdout1_5ck1000 FIND v(dout1_5) AT=1010.05n

.meas tran vdout1_6ck1000 FIND v(dout1_6) AT=1010.05n

.meas tran vdout1_7ck1000 FIND v(dout1_7) AT=1010.05n

.meas tran vdout1_8ck1000 FIND v(dout1_8) AT=1010.05n

.meas tran vdout1_9ck1000 FIND v(dout1_9) AT=1010.05n

.meas tran vdout1_10ck1000 FIND v(dout1_10) AT=1010.05n

.meas tran vdout1_11ck1000 FIND v(dout1_11) AT=1010.05n

.meas tran vdout1_12ck1000 FIND v(dout1_12) AT=1010.05n

.meas tran vdout1_13ck1000 FIND v(dout1_13) AT=1010.05n

.meas tran vdout1_14ck1000 FIND v(dout1_14) AT=1010.05n

.meas tran vdout1_15ck1000 FIND v(dout1_15) AT=1010.05n

.meas tran vdout1_16ck1000 FIND v(dout1_16) AT=1010.05n

.meas tran vdout1_17ck1000 FIND v(dout1_17) AT=1010.05n

.meas tran vdout1_18ck1000 FIND v(dout1_18) AT=1010.05n

.meas tran vdout1_19ck1000 FIND v(dout1_19) AT=1010.05n

.meas tran vdout1_20ck1000 FIND v(dout1_20) AT=1010.05n

.meas tran vdout1_21ck1000 FIND v(dout1_21) AT=1010.05n

.meas tran vdout1_22ck1000 FIND v(dout1_22) AT=1010.05n

.meas tran vdout1_23ck1000 FIND v(dout1_23) AT=1010.05n

.meas tran vdout1_24ck1000 FIND v(dout1_24) AT=1010.05n

.meas tran vdout1_25ck1000 FIND v(dout1_25) AT=1010.05n

.meas tran vdout1_26ck1000 FIND v(dout1_26) AT=1010.05n

.meas tran vdout1_27ck1000 FIND v(dout1_27) AT=1010.05n

.meas tran vdout1_28ck1000 FIND v(dout1_28) AT=1010.05n

.meas tran vdout1_29ck1000 FIND v(dout1_29) AT=1010.05n

.meas tran vdout1_30ck1000 FIND v(dout1_30) AT=1010.05n

.meas tran vdout1_31ck1000 FIND v(dout1_31) AT=1010.05n

.meas tran vdout1_32ck1000 FIND v(dout1_32) AT=1010.05n

.meas tran vdout1_33ck1000 FIND v(dout1_33) AT=1010.05n

.meas tran vdout1_34ck1000 FIND v(dout1_34) AT=1010.05n

.meas tran vdout1_35ck1000 FIND v(dout1_35) AT=1010.05n

.meas tran vdout1_36ck1000 FIND v(dout1_36) AT=1010.05n

.meas tran vdout1_37ck1000 FIND v(dout1_37) AT=1010.05n

.meas tran vdout1_38ck1000 FIND v(dout1_38) AT=1010.05n

.meas tran vdout1_39ck1000 FIND v(dout1_39) AT=1010.05n

.meas tran vdout1_40ck1000 FIND v(dout1_40) AT=1010.05n

.meas tran vdout1_41ck1000 FIND v(dout1_41) AT=1010.05n

.meas tran vdout1_42ck1000 FIND v(dout1_42) AT=1010.05n

.meas tran vdout1_43ck1000 FIND v(dout1_43) AT=1010.05n

.meas tran vdout1_44ck1000 FIND v(dout1_44) AT=1010.05n

.meas tran vdout1_45ck1000 FIND v(dout1_45) AT=1010.05n

.meas tran vdout1_46ck1000 FIND v(dout1_46) AT=1010.05n

.meas tran vdout1_47ck1000 FIND v(dout1_47) AT=1010.05n

.meas tran vdout1_48ck1000 FIND v(dout1_48) AT=1010.05n

.meas tran vdout1_49ck1000 FIND v(dout1_49) AT=1010.05n

.meas tran vdout1_50ck1000 FIND v(dout1_50) AT=1010.05n

.meas tran vdout1_51ck1000 FIND v(dout1_51) AT=1010.05n

.meas tran vdout1_52ck1000 FIND v(dout1_52) AT=1010.05n

.meas tran vdout1_53ck1000 FIND v(dout1_53) AT=1010.05n

.meas tran vdout1_54ck1000 FIND v(dout1_54) AT=1010.05n

.meas tran vdout1_55ck1000 FIND v(dout1_55) AT=1010.05n

.meas tran vdout1_56ck1000 FIND v(dout1_56) AT=1010.05n

.meas tran vdout1_57ck1000 FIND v(dout1_57) AT=1010.05n

.meas tran vdout1_58ck1000 FIND v(dout1_58) AT=1010.05n

.meas tran vdout1_59ck1000 FIND v(dout1_59) AT=1010.05n

.meas tran vdout1_60ck1000 FIND v(dout1_60) AT=1010.05n

.meas tran vdout1_61ck1000 FIND v(dout1_61) AT=1010.05n

.meas tran vdout1_62ck1000 FIND v(dout1_62) AT=1010.05n

.meas tran vdout1_63ck1000 FIND v(dout1_63) AT=1010.05n

.meas tran vdout0_0ck1020 FIND v(dout0_0) AT=1030.05n

.meas tran vdout0_1ck1020 FIND v(dout0_1) AT=1030.05n

.meas tran vdout0_2ck1020 FIND v(dout0_2) AT=1030.05n

.meas tran vdout0_3ck1020 FIND v(dout0_3) AT=1030.05n

.meas tran vdout0_4ck1020 FIND v(dout0_4) AT=1030.05n

.meas tran vdout0_5ck1020 FIND v(dout0_5) AT=1030.05n

.meas tran vdout0_6ck1020 FIND v(dout0_6) AT=1030.05n

.meas tran vdout0_7ck1020 FIND v(dout0_7) AT=1030.05n

.meas tran vdout0_8ck1020 FIND v(dout0_8) AT=1030.05n

.meas tran vdout0_9ck1020 FIND v(dout0_9) AT=1030.05n

.meas tran vdout0_10ck1020 FIND v(dout0_10) AT=1030.05n

.meas tran vdout0_11ck1020 FIND v(dout0_11) AT=1030.05n

.meas tran vdout0_12ck1020 FIND v(dout0_12) AT=1030.05n

.meas tran vdout0_13ck1020 FIND v(dout0_13) AT=1030.05n

.meas tran vdout0_14ck1020 FIND v(dout0_14) AT=1030.05n

.meas tran vdout0_15ck1020 FIND v(dout0_15) AT=1030.05n

.meas tran vdout0_16ck1020 FIND v(dout0_16) AT=1030.05n

.meas tran vdout0_17ck1020 FIND v(dout0_17) AT=1030.05n

.meas tran vdout0_18ck1020 FIND v(dout0_18) AT=1030.05n

.meas tran vdout0_19ck1020 FIND v(dout0_19) AT=1030.05n

.meas tran vdout0_20ck1020 FIND v(dout0_20) AT=1030.05n

.meas tran vdout0_21ck1020 FIND v(dout0_21) AT=1030.05n

.meas tran vdout0_22ck1020 FIND v(dout0_22) AT=1030.05n

.meas tran vdout0_23ck1020 FIND v(dout0_23) AT=1030.05n

.meas tran vdout0_24ck1020 FIND v(dout0_24) AT=1030.05n

.meas tran vdout0_25ck1020 FIND v(dout0_25) AT=1030.05n

.meas tran vdout0_26ck1020 FIND v(dout0_26) AT=1030.05n

.meas tran vdout0_27ck1020 FIND v(dout0_27) AT=1030.05n

.meas tran vdout0_28ck1020 FIND v(dout0_28) AT=1030.05n

.meas tran vdout0_29ck1020 FIND v(dout0_29) AT=1030.05n

.meas tran vdout0_30ck1020 FIND v(dout0_30) AT=1030.05n

.meas tran vdout0_31ck1020 FIND v(dout0_31) AT=1030.05n

.meas tran vdout0_32ck1020 FIND v(dout0_32) AT=1030.05n

.meas tran vdout0_33ck1020 FIND v(dout0_33) AT=1030.05n

.meas tran vdout0_34ck1020 FIND v(dout0_34) AT=1030.05n

.meas tran vdout0_35ck1020 FIND v(dout0_35) AT=1030.05n

.meas tran vdout0_36ck1020 FIND v(dout0_36) AT=1030.05n

.meas tran vdout0_37ck1020 FIND v(dout0_37) AT=1030.05n

.meas tran vdout0_38ck1020 FIND v(dout0_38) AT=1030.05n

.meas tran vdout0_39ck1020 FIND v(dout0_39) AT=1030.05n

.meas tran vdout0_40ck1020 FIND v(dout0_40) AT=1030.05n

.meas tran vdout0_41ck1020 FIND v(dout0_41) AT=1030.05n

.meas tran vdout0_42ck1020 FIND v(dout0_42) AT=1030.05n

.meas tran vdout0_43ck1020 FIND v(dout0_43) AT=1030.05n

.meas tran vdout0_44ck1020 FIND v(dout0_44) AT=1030.05n

.meas tran vdout0_45ck1020 FIND v(dout0_45) AT=1030.05n

.meas tran vdout0_46ck1020 FIND v(dout0_46) AT=1030.05n

.meas tran vdout0_47ck1020 FIND v(dout0_47) AT=1030.05n

.meas tran vdout0_48ck1020 FIND v(dout0_48) AT=1030.05n

.meas tran vdout0_49ck1020 FIND v(dout0_49) AT=1030.05n

.meas tran vdout0_50ck1020 FIND v(dout0_50) AT=1030.05n

.meas tran vdout0_51ck1020 FIND v(dout0_51) AT=1030.05n

.meas tran vdout0_52ck1020 FIND v(dout0_52) AT=1030.05n

.meas tran vdout0_53ck1020 FIND v(dout0_53) AT=1030.05n

.meas tran vdout0_54ck1020 FIND v(dout0_54) AT=1030.05n

.meas tran vdout0_55ck1020 FIND v(dout0_55) AT=1030.05n

.meas tran vdout0_56ck1020 FIND v(dout0_56) AT=1030.05n

.meas tran vdout0_57ck1020 FIND v(dout0_57) AT=1030.05n

.meas tran vdout0_58ck1020 FIND v(dout0_58) AT=1030.05n

.meas tran vdout0_59ck1020 FIND v(dout0_59) AT=1030.05n

.meas tran vdout0_60ck1020 FIND v(dout0_60) AT=1030.05n

.meas tran vdout0_61ck1020 FIND v(dout0_61) AT=1030.05n

.meas tran vdout0_62ck1020 FIND v(dout0_62) AT=1030.05n

.meas tran vdout0_63ck1020 FIND v(dout0_63) AT=1030.05n

.meas tran vdout1_0ck1020 FIND v(dout1_0) AT=1030.05n

.meas tran vdout1_1ck1020 FIND v(dout1_1) AT=1030.05n

.meas tran vdout1_2ck1020 FIND v(dout1_2) AT=1030.05n

.meas tran vdout1_3ck1020 FIND v(dout1_3) AT=1030.05n

.meas tran vdout1_4ck1020 FIND v(dout1_4) AT=1030.05n

.meas tran vdout1_5ck1020 FIND v(dout1_5) AT=1030.05n

.meas tran vdout1_6ck1020 FIND v(dout1_6) AT=1030.05n

.meas tran vdout1_7ck1020 FIND v(dout1_7) AT=1030.05n

.meas tran vdout1_8ck1020 FIND v(dout1_8) AT=1030.05n

.meas tran vdout1_9ck1020 FIND v(dout1_9) AT=1030.05n

.meas tran vdout1_10ck1020 FIND v(dout1_10) AT=1030.05n

.meas tran vdout1_11ck1020 FIND v(dout1_11) AT=1030.05n

.meas tran vdout1_12ck1020 FIND v(dout1_12) AT=1030.05n

.meas tran vdout1_13ck1020 FIND v(dout1_13) AT=1030.05n

.meas tran vdout1_14ck1020 FIND v(dout1_14) AT=1030.05n

.meas tran vdout1_15ck1020 FIND v(dout1_15) AT=1030.05n

.meas tran vdout1_16ck1020 FIND v(dout1_16) AT=1030.05n

.meas tran vdout1_17ck1020 FIND v(dout1_17) AT=1030.05n

.meas tran vdout1_18ck1020 FIND v(dout1_18) AT=1030.05n

.meas tran vdout1_19ck1020 FIND v(dout1_19) AT=1030.05n

.meas tran vdout1_20ck1020 FIND v(dout1_20) AT=1030.05n

.meas tran vdout1_21ck1020 FIND v(dout1_21) AT=1030.05n

.meas tran vdout1_22ck1020 FIND v(dout1_22) AT=1030.05n

.meas tran vdout1_23ck1020 FIND v(dout1_23) AT=1030.05n

.meas tran vdout1_24ck1020 FIND v(dout1_24) AT=1030.05n

.meas tran vdout1_25ck1020 FIND v(dout1_25) AT=1030.05n

.meas tran vdout1_26ck1020 FIND v(dout1_26) AT=1030.05n

.meas tran vdout1_27ck1020 FIND v(dout1_27) AT=1030.05n

.meas tran vdout1_28ck1020 FIND v(dout1_28) AT=1030.05n

.meas tran vdout1_29ck1020 FIND v(dout1_29) AT=1030.05n

.meas tran vdout1_30ck1020 FIND v(dout1_30) AT=1030.05n

.meas tran vdout1_31ck1020 FIND v(dout1_31) AT=1030.05n

.meas tran vdout1_32ck1020 FIND v(dout1_32) AT=1030.05n

.meas tran vdout1_33ck1020 FIND v(dout1_33) AT=1030.05n

.meas tran vdout1_34ck1020 FIND v(dout1_34) AT=1030.05n

.meas tran vdout1_35ck1020 FIND v(dout1_35) AT=1030.05n

.meas tran vdout1_36ck1020 FIND v(dout1_36) AT=1030.05n

.meas tran vdout1_37ck1020 FIND v(dout1_37) AT=1030.05n

.meas tran vdout1_38ck1020 FIND v(dout1_38) AT=1030.05n

.meas tran vdout1_39ck1020 FIND v(dout1_39) AT=1030.05n

.meas tran vdout1_40ck1020 FIND v(dout1_40) AT=1030.05n

.meas tran vdout1_41ck1020 FIND v(dout1_41) AT=1030.05n

.meas tran vdout1_42ck1020 FIND v(dout1_42) AT=1030.05n

.meas tran vdout1_43ck1020 FIND v(dout1_43) AT=1030.05n

.meas tran vdout1_44ck1020 FIND v(dout1_44) AT=1030.05n

.meas tran vdout1_45ck1020 FIND v(dout1_45) AT=1030.05n

.meas tran vdout1_46ck1020 FIND v(dout1_46) AT=1030.05n

.meas tran vdout1_47ck1020 FIND v(dout1_47) AT=1030.05n

.meas tran vdout1_48ck1020 FIND v(dout1_48) AT=1030.05n

.meas tran vdout1_49ck1020 FIND v(dout1_49) AT=1030.05n

.meas tran vdout1_50ck1020 FIND v(dout1_50) AT=1030.05n

.meas tran vdout1_51ck1020 FIND v(dout1_51) AT=1030.05n

.meas tran vdout1_52ck1020 FIND v(dout1_52) AT=1030.05n

.meas tran vdout1_53ck1020 FIND v(dout1_53) AT=1030.05n

.meas tran vdout1_54ck1020 FIND v(dout1_54) AT=1030.05n

.meas tran vdout1_55ck1020 FIND v(dout1_55) AT=1030.05n

.meas tran vdout1_56ck1020 FIND v(dout1_56) AT=1030.05n

.meas tran vdout1_57ck1020 FIND v(dout1_57) AT=1030.05n

.meas tran vdout1_58ck1020 FIND v(dout1_58) AT=1030.05n

.meas tran vdout1_59ck1020 FIND v(dout1_59) AT=1030.05n

.meas tran vdout1_60ck1020 FIND v(dout1_60) AT=1030.05n

.meas tran vdout1_61ck1020 FIND v(dout1_61) AT=1030.05n

.meas tran vdout1_62ck1020 FIND v(dout1_62) AT=1030.05n

.meas tran vdout1_63ck1020 FIND v(dout1_63) AT=1030.05n

.meas tran vdout0_0ck1040 FIND v(dout0_0) AT=1050.05n

.meas tran vdout0_1ck1040 FIND v(dout0_1) AT=1050.05n

.meas tran vdout0_2ck1040 FIND v(dout0_2) AT=1050.05n

.meas tran vdout0_3ck1040 FIND v(dout0_3) AT=1050.05n

.meas tran vdout0_4ck1040 FIND v(dout0_4) AT=1050.05n

.meas tran vdout0_5ck1040 FIND v(dout0_5) AT=1050.05n

.meas tran vdout0_6ck1040 FIND v(dout0_6) AT=1050.05n

.meas tran vdout0_7ck1040 FIND v(dout0_7) AT=1050.05n

.meas tran vdout0_8ck1040 FIND v(dout0_8) AT=1050.05n

.meas tran vdout0_9ck1040 FIND v(dout0_9) AT=1050.05n

.meas tran vdout0_10ck1040 FIND v(dout0_10) AT=1050.05n

.meas tran vdout0_11ck1040 FIND v(dout0_11) AT=1050.05n

.meas tran vdout0_12ck1040 FIND v(dout0_12) AT=1050.05n

.meas tran vdout0_13ck1040 FIND v(dout0_13) AT=1050.05n

.meas tran vdout0_14ck1040 FIND v(dout0_14) AT=1050.05n

.meas tran vdout0_15ck1040 FIND v(dout0_15) AT=1050.05n

.meas tran vdout0_16ck1040 FIND v(dout0_16) AT=1050.05n

.meas tran vdout0_17ck1040 FIND v(dout0_17) AT=1050.05n

.meas tran vdout0_18ck1040 FIND v(dout0_18) AT=1050.05n

.meas tran vdout0_19ck1040 FIND v(dout0_19) AT=1050.05n

.meas tran vdout0_20ck1040 FIND v(dout0_20) AT=1050.05n

.meas tran vdout0_21ck1040 FIND v(dout0_21) AT=1050.05n

.meas tran vdout0_22ck1040 FIND v(dout0_22) AT=1050.05n

.meas tran vdout0_23ck1040 FIND v(dout0_23) AT=1050.05n

.meas tran vdout0_24ck1040 FIND v(dout0_24) AT=1050.05n

.meas tran vdout0_25ck1040 FIND v(dout0_25) AT=1050.05n

.meas tran vdout0_26ck1040 FIND v(dout0_26) AT=1050.05n

.meas tran vdout0_27ck1040 FIND v(dout0_27) AT=1050.05n

.meas tran vdout0_28ck1040 FIND v(dout0_28) AT=1050.05n

.meas tran vdout0_29ck1040 FIND v(dout0_29) AT=1050.05n

.meas tran vdout0_30ck1040 FIND v(dout0_30) AT=1050.05n

.meas tran vdout0_31ck1040 FIND v(dout0_31) AT=1050.05n

.meas tran vdout0_32ck1040 FIND v(dout0_32) AT=1050.05n

.meas tran vdout0_33ck1040 FIND v(dout0_33) AT=1050.05n

.meas tran vdout0_34ck1040 FIND v(dout0_34) AT=1050.05n

.meas tran vdout0_35ck1040 FIND v(dout0_35) AT=1050.05n

.meas tran vdout0_36ck1040 FIND v(dout0_36) AT=1050.05n

.meas tran vdout0_37ck1040 FIND v(dout0_37) AT=1050.05n

.meas tran vdout0_38ck1040 FIND v(dout0_38) AT=1050.05n

.meas tran vdout0_39ck1040 FIND v(dout0_39) AT=1050.05n

.meas tran vdout0_40ck1040 FIND v(dout0_40) AT=1050.05n

.meas tran vdout0_41ck1040 FIND v(dout0_41) AT=1050.05n

.meas tran vdout0_42ck1040 FIND v(dout0_42) AT=1050.05n

.meas tran vdout0_43ck1040 FIND v(dout0_43) AT=1050.05n

.meas tran vdout0_44ck1040 FIND v(dout0_44) AT=1050.05n

.meas tran vdout0_45ck1040 FIND v(dout0_45) AT=1050.05n

.meas tran vdout0_46ck1040 FIND v(dout0_46) AT=1050.05n

.meas tran vdout0_47ck1040 FIND v(dout0_47) AT=1050.05n

.meas tran vdout0_48ck1040 FIND v(dout0_48) AT=1050.05n

.meas tran vdout0_49ck1040 FIND v(dout0_49) AT=1050.05n

.meas tran vdout0_50ck1040 FIND v(dout0_50) AT=1050.05n

.meas tran vdout0_51ck1040 FIND v(dout0_51) AT=1050.05n

.meas tran vdout0_52ck1040 FIND v(dout0_52) AT=1050.05n

.meas tran vdout0_53ck1040 FIND v(dout0_53) AT=1050.05n

.meas tran vdout0_54ck1040 FIND v(dout0_54) AT=1050.05n

.meas tran vdout0_55ck1040 FIND v(dout0_55) AT=1050.05n

.meas tran vdout0_56ck1040 FIND v(dout0_56) AT=1050.05n

.meas tran vdout0_57ck1040 FIND v(dout0_57) AT=1050.05n

.meas tran vdout0_58ck1040 FIND v(dout0_58) AT=1050.05n

.meas tran vdout0_59ck1040 FIND v(dout0_59) AT=1050.05n

.meas tran vdout0_60ck1040 FIND v(dout0_60) AT=1050.05n

.meas tran vdout0_61ck1040 FIND v(dout0_61) AT=1050.05n

.meas tran vdout0_62ck1040 FIND v(dout0_62) AT=1050.05n

.meas tran vdout0_63ck1040 FIND v(dout0_63) AT=1050.05n

.meas tran vdout1_0ck1040 FIND v(dout1_0) AT=1050.05n

.meas tran vdout1_1ck1040 FIND v(dout1_1) AT=1050.05n

.meas tran vdout1_2ck1040 FIND v(dout1_2) AT=1050.05n

.meas tran vdout1_3ck1040 FIND v(dout1_3) AT=1050.05n

.meas tran vdout1_4ck1040 FIND v(dout1_4) AT=1050.05n

.meas tran vdout1_5ck1040 FIND v(dout1_5) AT=1050.05n

.meas tran vdout1_6ck1040 FIND v(dout1_6) AT=1050.05n

.meas tran vdout1_7ck1040 FIND v(dout1_7) AT=1050.05n

.meas tran vdout1_8ck1040 FIND v(dout1_8) AT=1050.05n

.meas tran vdout1_9ck1040 FIND v(dout1_9) AT=1050.05n

.meas tran vdout1_10ck1040 FIND v(dout1_10) AT=1050.05n

.meas tran vdout1_11ck1040 FIND v(dout1_11) AT=1050.05n

.meas tran vdout1_12ck1040 FIND v(dout1_12) AT=1050.05n

.meas tran vdout1_13ck1040 FIND v(dout1_13) AT=1050.05n

.meas tran vdout1_14ck1040 FIND v(dout1_14) AT=1050.05n

.meas tran vdout1_15ck1040 FIND v(dout1_15) AT=1050.05n

.meas tran vdout1_16ck1040 FIND v(dout1_16) AT=1050.05n

.meas tran vdout1_17ck1040 FIND v(dout1_17) AT=1050.05n

.meas tran vdout1_18ck1040 FIND v(dout1_18) AT=1050.05n

.meas tran vdout1_19ck1040 FIND v(dout1_19) AT=1050.05n

.meas tran vdout1_20ck1040 FIND v(dout1_20) AT=1050.05n

.meas tran vdout1_21ck1040 FIND v(dout1_21) AT=1050.05n

.meas tran vdout1_22ck1040 FIND v(dout1_22) AT=1050.05n

.meas tran vdout1_23ck1040 FIND v(dout1_23) AT=1050.05n

.meas tran vdout1_24ck1040 FIND v(dout1_24) AT=1050.05n

.meas tran vdout1_25ck1040 FIND v(dout1_25) AT=1050.05n

.meas tran vdout1_26ck1040 FIND v(dout1_26) AT=1050.05n

.meas tran vdout1_27ck1040 FIND v(dout1_27) AT=1050.05n

.meas tran vdout1_28ck1040 FIND v(dout1_28) AT=1050.05n

.meas tran vdout1_29ck1040 FIND v(dout1_29) AT=1050.05n

.meas tran vdout1_30ck1040 FIND v(dout1_30) AT=1050.05n

.meas tran vdout1_31ck1040 FIND v(dout1_31) AT=1050.05n

.meas tran vdout1_32ck1040 FIND v(dout1_32) AT=1050.05n

.meas tran vdout1_33ck1040 FIND v(dout1_33) AT=1050.05n

.meas tran vdout1_34ck1040 FIND v(dout1_34) AT=1050.05n

.meas tran vdout1_35ck1040 FIND v(dout1_35) AT=1050.05n

.meas tran vdout1_36ck1040 FIND v(dout1_36) AT=1050.05n

.meas tran vdout1_37ck1040 FIND v(dout1_37) AT=1050.05n

.meas tran vdout1_38ck1040 FIND v(dout1_38) AT=1050.05n

.meas tran vdout1_39ck1040 FIND v(dout1_39) AT=1050.05n

.meas tran vdout1_40ck1040 FIND v(dout1_40) AT=1050.05n

.meas tran vdout1_41ck1040 FIND v(dout1_41) AT=1050.05n

.meas tran vdout1_42ck1040 FIND v(dout1_42) AT=1050.05n

.meas tran vdout1_43ck1040 FIND v(dout1_43) AT=1050.05n

.meas tran vdout1_44ck1040 FIND v(dout1_44) AT=1050.05n

.meas tran vdout1_45ck1040 FIND v(dout1_45) AT=1050.05n

.meas tran vdout1_46ck1040 FIND v(dout1_46) AT=1050.05n

.meas tran vdout1_47ck1040 FIND v(dout1_47) AT=1050.05n

.meas tran vdout1_48ck1040 FIND v(dout1_48) AT=1050.05n

.meas tran vdout1_49ck1040 FIND v(dout1_49) AT=1050.05n

.meas tran vdout1_50ck1040 FIND v(dout1_50) AT=1050.05n

.meas tran vdout1_51ck1040 FIND v(dout1_51) AT=1050.05n

.meas tran vdout1_52ck1040 FIND v(dout1_52) AT=1050.05n

.meas tran vdout1_53ck1040 FIND v(dout1_53) AT=1050.05n

.meas tran vdout1_54ck1040 FIND v(dout1_54) AT=1050.05n

.meas tran vdout1_55ck1040 FIND v(dout1_55) AT=1050.05n

.meas tran vdout1_56ck1040 FIND v(dout1_56) AT=1050.05n

.meas tran vdout1_57ck1040 FIND v(dout1_57) AT=1050.05n

.meas tran vdout1_58ck1040 FIND v(dout1_58) AT=1050.05n

.meas tran vdout1_59ck1040 FIND v(dout1_59) AT=1050.05n

.meas tran vdout1_60ck1040 FIND v(dout1_60) AT=1050.05n

.meas tran vdout1_61ck1040 FIND v(dout1_61) AT=1050.05n

.meas tran vdout1_62ck1040 FIND v(dout1_62) AT=1050.05n

.meas tran vdout1_63ck1040 FIND v(dout1_63) AT=1050.05n

.meas tran vdout0_0ck1050 FIND v(dout0_0) AT=1060.05n

.meas tran vdout0_1ck1050 FIND v(dout0_1) AT=1060.05n

.meas tran vdout0_2ck1050 FIND v(dout0_2) AT=1060.05n

.meas tran vdout0_3ck1050 FIND v(dout0_3) AT=1060.05n

.meas tran vdout0_4ck1050 FIND v(dout0_4) AT=1060.05n

.meas tran vdout0_5ck1050 FIND v(dout0_5) AT=1060.05n

.meas tran vdout0_6ck1050 FIND v(dout0_6) AT=1060.05n

.meas tran vdout0_7ck1050 FIND v(dout0_7) AT=1060.05n

.meas tran vdout0_8ck1050 FIND v(dout0_8) AT=1060.05n

.meas tran vdout0_9ck1050 FIND v(dout0_9) AT=1060.05n

.meas tran vdout0_10ck1050 FIND v(dout0_10) AT=1060.05n

.meas tran vdout0_11ck1050 FIND v(dout0_11) AT=1060.05n

.meas tran vdout0_12ck1050 FIND v(dout0_12) AT=1060.05n

.meas tran vdout0_13ck1050 FIND v(dout0_13) AT=1060.05n

.meas tran vdout0_14ck1050 FIND v(dout0_14) AT=1060.05n

.meas tran vdout0_15ck1050 FIND v(dout0_15) AT=1060.05n

.meas tran vdout0_16ck1050 FIND v(dout0_16) AT=1060.05n

.meas tran vdout0_17ck1050 FIND v(dout0_17) AT=1060.05n

.meas tran vdout0_18ck1050 FIND v(dout0_18) AT=1060.05n

.meas tran vdout0_19ck1050 FIND v(dout0_19) AT=1060.05n

.meas tran vdout0_20ck1050 FIND v(dout0_20) AT=1060.05n

.meas tran vdout0_21ck1050 FIND v(dout0_21) AT=1060.05n

.meas tran vdout0_22ck1050 FIND v(dout0_22) AT=1060.05n

.meas tran vdout0_23ck1050 FIND v(dout0_23) AT=1060.05n

.meas tran vdout0_24ck1050 FIND v(dout0_24) AT=1060.05n

.meas tran vdout0_25ck1050 FIND v(dout0_25) AT=1060.05n

.meas tran vdout0_26ck1050 FIND v(dout0_26) AT=1060.05n

.meas tran vdout0_27ck1050 FIND v(dout0_27) AT=1060.05n

.meas tran vdout0_28ck1050 FIND v(dout0_28) AT=1060.05n

.meas tran vdout0_29ck1050 FIND v(dout0_29) AT=1060.05n

.meas tran vdout0_30ck1050 FIND v(dout0_30) AT=1060.05n

.meas tran vdout0_31ck1050 FIND v(dout0_31) AT=1060.05n

.meas tran vdout0_32ck1050 FIND v(dout0_32) AT=1060.05n

.meas tran vdout0_33ck1050 FIND v(dout0_33) AT=1060.05n

.meas tran vdout0_34ck1050 FIND v(dout0_34) AT=1060.05n

.meas tran vdout0_35ck1050 FIND v(dout0_35) AT=1060.05n

.meas tran vdout0_36ck1050 FIND v(dout0_36) AT=1060.05n

.meas tran vdout0_37ck1050 FIND v(dout0_37) AT=1060.05n

.meas tran vdout0_38ck1050 FIND v(dout0_38) AT=1060.05n

.meas tran vdout0_39ck1050 FIND v(dout0_39) AT=1060.05n

.meas tran vdout0_40ck1050 FIND v(dout0_40) AT=1060.05n

.meas tran vdout0_41ck1050 FIND v(dout0_41) AT=1060.05n

.meas tran vdout0_42ck1050 FIND v(dout0_42) AT=1060.05n

.meas tran vdout0_43ck1050 FIND v(dout0_43) AT=1060.05n

.meas tran vdout0_44ck1050 FIND v(dout0_44) AT=1060.05n

.meas tran vdout0_45ck1050 FIND v(dout0_45) AT=1060.05n

.meas tran vdout0_46ck1050 FIND v(dout0_46) AT=1060.05n

.meas tran vdout0_47ck1050 FIND v(dout0_47) AT=1060.05n

.meas tran vdout0_48ck1050 FIND v(dout0_48) AT=1060.05n

.meas tran vdout0_49ck1050 FIND v(dout0_49) AT=1060.05n

.meas tran vdout0_50ck1050 FIND v(dout0_50) AT=1060.05n

.meas tran vdout0_51ck1050 FIND v(dout0_51) AT=1060.05n

.meas tran vdout0_52ck1050 FIND v(dout0_52) AT=1060.05n

.meas tran vdout0_53ck1050 FIND v(dout0_53) AT=1060.05n

.meas tran vdout0_54ck1050 FIND v(dout0_54) AT=1060.05n

.meas tran vdout0_55ck1050 FIND v(dout0_55) AT=1060.05n

.meas tran vdout0_56ck1050 FIND v(dout0_56) AT=1060.05n

.meas tran vdout0_57ck1050 FIND v(dout0_57) AT=1060.05n

.meas tran vdout0_58ck1050 FIND v(dout0_58) AT=1060.05n

.meas tran vdout0_59ck1050 FIND v(dout0_59) AT=1060.05n

.meas tran vdout0_60ck1050 FIND v(dout0_60) AT=1060.05n

.meas tran vdout0_61ck1050 FIND v(dout0_61) AT=1060.05n

.meas tran vdout0_62ck1050 FIND v(dout0_62) AT=1060.05n

.meas tran vdout0_63ck1050 FIND v(dout0_63) AT=1060.05n

.meas tran vdout1_0ck1060 FIND v(dout1_0) AT=1070.05n

.meas tran vdout1_1ck1060 FIND v(dout1_1) AT=1070.05n

.meas tran vdout1_2ck1060 FIND v(dout1_2) AT=1070.05n

.meas tran vdout1_3ck1060 FIND v(dout1_3) AT=1070.05n

.meas tran vdout1_4ck1060 FIND v(dout1_4) AT=1070.05n

.meas tran vdout1_5ck1060 FIND v(dout1_5) AT=1070.05n

.meas tran vdout1_6ck1060 FIND v(dout1_6) AT=1070.05n

.meas tran vdout1_7ck1060 FIND v(dout1_7) AT=1070.05n

.meas tran vdout1_8ck1060 FIND v(dout1_8) AT=1070.05n

.meas tran vdout1_9ck1060 FIND v(dout1_9) AT=1070.05n

.meas tran vdout1_10ck1060 FIND v(dout1_10) AT=1070.05n

.meas tran vdout1_11ck1060 FIND v(dout1_11) AT=1070.05n

.meas tran vdout1_12ck1060 FIND v(dout1_12) AT=1070.05n

.meas tran vdout1_13ck1060 FIND v(dout1_13) AT=1070.05n

.meas tran vdout1_14ck1060 FIND v(dout1_14) AT=1070.05n

.meas tran vdout1_15ck1060 FIND v(dout1_15) AT=1070.05n

.meas tran vdout1_16ck1060 FIND v(dout1_16) AT=1070.05n

.meas tran vdout1_17ck1060 FIND v(dout1_17) AT=1070.05n

.meas tran vdout1_18ck1060 FIND v(dout1_18) AT=1070.05n

.meas tran vdout1_19ck1060 FIND v(dout1_19) AT=1070.05n

.meas tran vdout1_20ck1060 FIND v(dout1_20) AT=1070.05n

.meas tran vdout1_21ck1060 FIND v(dout1_21) AT=1070.05n

.meas tran vdout1_22ck1060 FIND v(dout1_22) AT=1070.05n

.meas tran vdout1_23ck1060 FIND v(dout1_23) AT=1070.05n

.meas tran vdout1_24ck1060 FIND v(dout1_24) AT=1070.05n

.meas tran vdout1_25ck1060 FIND v(dout1_25) AT=1070.05n

.meas tran vdout1_26ck1060 FIND v(dout1_26) AT=1070.05n

.meas tran vdout1_27ck1060 FIND v(dout1_27) AT=1070.05n

.meas tran vdout1_28ck1060 FIND v(dout1_28) AT=1070.05n

.meas tran vdout1_29ck1060 FIND v(dout1_29) AT=1070.05n

.meas tran vdout1_30ck1060 FIND v(dout1_30) AT=1070.05n

.meas tran vdout1_31ck1060 FIND v(dout1_31) AT=1070.05n

.meas tran vdout1_32ck1060 FIND v(dout1_32) AT=1070.05n

.meas tran vdout1_33ck1060 FIND v(dout1_33) AT=1070.05n

.meas tran vdout1_34ck1060 FIND v(dout1_34) AT=1070.05n

.meas tran vdout1_35ck1060 FIND v(dout1_35) AT=1070.05n

.meas tran vdout1_36ck1060 FIND v(dout1_36) AT=1070.05n

.meas tran vdout1_37ck1060 FIND v(dout1_37) AT=1070.05n

.meas tran vdout1_38ck1060 FIND v(dout1_38) AT=1070.05n

.meas tran vdout1_39ck1060 FIND v(dout1_39) AT=1070.05n

.meas tran vdout1_40ck1060 FIND v(dout1_40) AT=1070.05n

.meas tran vdout1_41ck1060 FIND v(dout1_41) AT=1070.05n

.meas tran vdout1_42ck1060 FIND v(dout1_42) AT=1070.05n

.meas tran vdout1_43ck1060 FIND v(dout1_43) AT=1070.05n

.meas tran vdout1_44ck1060 FIND v(dout1_44) AT=1070.05n

.meas tran vdout1_45ck1060 FIND v(dout1_45) AT=1070.05n

.meas tran vdout1_46ck1060 FIND v(dout1_46) AT=1070.05n

.meas tran vdout1_47ck1060 FIND v(dout1_47) AT=1070.05n

.meas tran vdout1_48ck1060 FIND v(dout1_48) AT=1070.05n

.meas tran vdout1_49ck1060 FIND v(dout1_49) AT=1070.05n

.meas tran vdout1_50ck1060 FIND v(dout1_50) AT=1070.05n

.meas tran vdout1_51ck1060 FIND v(dout1_51) AT=1070.05n

.meas tran vdout1_52ck1060 FIND v(dout1_52) AT=1070.05n

.meas tran vdout1_53ck1060 FIND v(dout1_53) AT=1070.05n

.meas tran vdout1_54ck1060 FIND v(dout1_54) AT=1070.05n

.meas tran vdout1_55ck1060 FIND v(dout1_55) AT=1070.05n

.meas tran vdout1_56ck1060 FIND v(dout1_56) AT=1070.05n

.meas tran vdout1_57ck1060 FIND v(dout1_57) AT=1070.05n

.meas tran vdout1_58ck1060 FIND v(dout1_58) AT=1070.05n

.meas tran vdout1_59ck1060 FIND v(dout1_59) AT=1070.05n

.meas tran vdout1_60ck1060 FIND v(dout1_60) AT=1070.05n

.meas tran vdout1_61ck1060 FIND v(dout1_61) AT=1070.05n

.meas tran vdout1_62ck1060 FIND v(dout1_62) AT=1070.05n

.meas tran vdout1_63ck1060 FIND v(dout1_63) AT=1070.05n

.meas tran vdout0_0ck1080 FIND v(dout0_0) AT=1090.05n

.meas tran vdout0_1ck1080 FIND v(dout0_1) AT=1090.05n

.meas tran vdout0_2ck1080 FIND v(dout0_2) AT=1090.05n

.meas tran vdout0_3ck1080 FIND v(dout0_3) AT=1090.05n

.meas tran vdout0_4ck1080 FIND v(dout0_4) AT=1090.05n

.meas tran vdout0_5ck1080 FIND v(dout0_5) AT=1090.05n

.meas tran vdout0_6ck1080 FIND v(dout0_6) AT=1090.05n

.meas tran vdout0_7ck1080 FIND v(dout0_7) AT=1090.05n

.meas tran vdout0_8ck1080 FIND v(dout0_8) AT=1090.05n

.meas tran vdout0_9ck1080 FIND v(dout0_9) AT=1090.05n

.meas tran vdout0_10ck1080 FIND v(dout0_10) AT=1090.05n

.meas tran vdout0_11ck1080 FIND v(dout0_11) AT=1090.05n

.meas tran vdout0_12ck1080 FIND v(dout0_12) AT=1090.05n

.meas tran vdout0_13ck1080 FIND v(dout0_13) AT=1090.05n

.meas tran vdout0_14ck1080 FIND v(dout0_14) AT=1090.05n

.meas tran vdout0_15ck1080 FIND v(dout0_15) AT=1090.05n

.meas tran vdout0_16ck1080 FIND v(dout0_16) AT=1090.05n

.meas tran vdout0_17ck1080 FIND v(dout0_17) AT=1090.05n

.meas tran vdout0_18ck1080 FIND v(dout0_18) AT=1090.05n

.meas tran vdout0_19ck1080 FIND v(dout0_19) AT=1090.05n

.meas tran vdout0_20ck1080 FIND v(dout0_20) AT=1090.05n

.meas tran vdout0_21ck1080 FIND v(dout0_21) AT=1090.05n

.meas tran vdout0_22ck1080 FIND v(dout0_22) AT=1090.05n

.meas tran vdout0_23ck1080 FIND v(dout0_23) AT=1090.05n

.meas tran vdout0_24ck1080 FIND v(dout0_24) AT=1090.05n

.meas tran vdout0_25ck1080 FIND v(dout0_25) AT=1090.05n

.meas tran vdout0_26ck1080 FIND v(dout0_26) AT=1090.05n

.meas tran vdout0_27ck1080 FIND v(dout0_27) AT=1090.05n

.meas tran vdout0_28ck1080 FIND v(dout0_28) AT=1090.05n

.meas tran vdout0_29ck1080 FIND v(dout0_29) AT=1090.05n

.meas tran vdout0_30ck1080 FIND v(dout0_30) AT=1090.05n

.meas tran vdout0_31ck1080 FIND v(dout0_31) AT=1090.05n

.meas tran vdout0_32ck1080 FIND v(dout0_32) AT=1090.05n

.meas tran vdout0_33ck1080 FIND v(dout0_33) AT=1090.05n

.meas tran vdout0_34ck1080 FIND v(dout0_34) AT=1090.05n

.meas tran vdout0_35ck1080 FIND v(dout0_35) AT=1090.05n

.meas tran vdout0_36ck1080 FIND v(dout0_36) AT=1090.05n

.meas tran vdout0_37ck1080 FIND v(dout0_37) AT=1090.05n

.meas tran vdout0_38ck1080 FIND v(dout0_38) AT=1090.05n

.meas tran vdout0_39ck1080 FIND v(dout0_39) AT=1090.05n

.meas tran vdout0_40ck1080 FIND v(dout0_40) AT=1090.05n

.meas tran vdout0_41ck1080 FIND v(dout0_41) AT=1090.05n

.meas tran vdout0_42ck1080 FIND v(dout0_42) AT=1090.05n

.meas tran vdout0_43ck1080 FIND v(dout0_43) AT=1090.05n

.meas tran vdout0_44ck1080 FIND v(dout0_44) AT=1090.05n

.meas tran vdout0_45ck1080 FIND v(dout0_45) AT=1090.05n

.meas tran vdout0_46ck1080 FIND v(dout0_46) AT=1090.05n

.meas tran vdout0_47ck1080 FIND v(dout0_47) AT=1090.05n

.meas tran vdout0_48ck1080 FIND v(dout0_48) AT=1090.05n

.meas tran vdout0_49ck1080 FIND v(dout0_49) AT=1090.05n

.meas tran vdout0_50ck1080 FIND v(dout0_50) AT=1090.05n

.meas tran vdout0_51ck1080 FIND v(dout0_51) AT=1090.05n

.meas tran vdout0_52ck1080 FIND v(dout0_52) AT=1090.05n

.meas tran vdout0_53ck1080 FIND v(dout0_53) AT=1090.05n

.meas tran vdout0_54ck1080 FIND v(dout0_54) AT=1090.05n

.meas tran vdout0_55ck1080 FIND v(dout0_55) AT=1090.05n

.meas tran vdout0_56ck1080 FIND v(dout0_56) AT=1090.05n

.meas tran vdout0_57ck1080 FIND v(dout0_57) AT=1090.05n

.meas tran vdout0_58ck1080 FIND v(dout0_58) AT=1090.05n

.meas tran vdout0_59ck1080 FIND v(dout0_59) AT=1090.05n

.meas tran vdout0_60ck1080 FIND v(dout0_60) AT=1090.05n

.meas tran vdout0_61ck1080 FIND v(dout0_61) AT=1090.05n

.meas tran vdout0_62ck1080 FIND v(dout0_62) AT=1090.05n

.meas tran vdout0_63ck1080 FIND v(dout0_63) AT=1090.05n

.meas tran vdout1_0ck1080 FIND v(dout1_0) AT=1090.05n

.meas tran vdout1_1ck1080 FIND v(dout1_1) AT=1090.05n

.meas tran vdout1_2ck1080 FIND v(dout1_2) AT=1090.05n

.meas tran vdout1_3ck1080 FIND v(dout1_3) AT=1090.05n

.meas tran vdout1_4ck1080 FIND v(dout1_4) AT=1090.05n

.meas tran vdout1_5ck1080 FIND v(dout1_5) AT=1090.05n

.meas tran vdout1_6ck1080 FIND v(dout1_6) AT=1090.05n

.meas tran vdout1_7ck1080 FIND v(dout1_7) AT=1090.05n

.meas tran vdout1_8ck1080 FIND v(dout1_8) AT=1090.05n

.meas tran vdout1_9ck1080 FIND v(dout1_9) AT=1090.05n

.meas tran vdout1_10ck1080 FIND v(dout1_10) AT=1090.05n

.meas tran vdout1_11ck1080 FIND v(dout1_11) AT=1090.05n

.meas tran vdout1_12ck1080 FIND v(dout1_12) AT=1090.05n

.meas tran vdout1_13ck1080 FIND v(dout1_13) AT=1090.05n

.meas tran vdout1_14ck1080 FIND v(dout1_14) AT=1090.05n

.meas tran vdout1_15ck1080 FIND v(dout1_15) AT=1090.05n

.meas tran vdout1_16ck1080 FIND v(dout1_16) AT=1090.05n

.meas tran vdout1_17ck1080 FIND v(dout1_17) AT=1090.05n

.meas tran vdout1_18ck1080 FIND v(dout1_18) AT=1090.05n

.meas tran vdout1_19ck1080 FIND v(dout1_19) AT=1090.05n

.meas tran vdout1_20ck1080 FIND v(dout1_20) AT=1090.05n

.meas tran vdout1_21ck1080 FIND v(dout1_21) AT=1090.05n

.meas tran vdout1_22ck1080 FIND v(dout1_22) AT=1090.05n

.meas tran vdout1_23ck1080 FIND v(dout1_23) AT=1090.05n

.meas tran vdout1_24ck1080 FIND v(dout1_24) AT=1090.05n

.meas tran vdout1_25ck1080 FIND v(dout1_25) AT=1090.05n

.meas tran vdout1_26ck1080 FIND v(dout1_26) AT=1090.05n

.meas tran vdout1_27ck1080 FIND v(dout1_27) AT=1090.05n

.meas tran vdout1_28ck1080 FIND v(dout1_28) AT=1090.05n

.meas tran vdout1_29ck1080 FIND v(dout1_29) AT=1090.05n

.meas tran vdout1_30ck1080 FIND v(dout1_30) AT=1090.05n

.meas tran vdout1_31ck1080 FIND v(dout1_31) AT=1090.05n

.meas tran vdout1_32ck1080 FIND v(dout1_32) AT=1090.05n

.meas tran vdout1_33ck1080 FIND v(dout1_33) AT=1090.05n

.meas tran vdout1_34ck1080 FIND v(dout1_34) AT=1090.05n

.meas tran vdout1_35ck1080 FIND v(dout1_35) AT=1090.05n

.meas tran vdout1_36ck1080 FIND v(dout1_36) AT=1090.05n

.meas tran vdout1_37ck1080 FIND v(dout1_37) AT=1090.05n

.meas tran vdout1_38ck1080 FIND v(dout1_38) AT=1090.05n

.meas tran vdout1_39ck1080 FIND v(dout1_39) AT=1090.05n

.meas tran vdout1_40ck1080 FIND v(dout1_40) AT=1090.05n

.meas tran vdout1_41ck1080 FIND v(dout1_41) AT=1090.05n

.meas tran vdout1_42ck1080 FIND v(dout1_42) AT=1090.05n

.meas tran vdout1_43ck1080 FIND v(dout1_43) AT=1090.05n

.meas tran vdout1_44ck1080 FIND v(dout1_44) AT=1090.05n

.meas tran vdout1_45ck1080 FIND v(dout1_45) AT=1090.05n

.meas tran vdout1_46ck1080 FIND v(dout1_46) AT=1090.05n

.meas tran vdout1_47ck1080 FIND v(dout1_47) AT=1090.05n

.meas tran vdout1_48ck1080 FIND v(dout1_48) AT=1090.05n

.meas tran vdout1_49ck1080 FIND v(dout1_49) AT=1090.05n

.meas tran vdout1_50ck1080 FIND v(dout1_50) AT=1090.05n

.meas tran vdout1_51ck1080 FIND v(dout1_51) AT=1090.05n

.meas tran vdout1_52ck1080 FIND v(dout1_52) AT=1090.05n

.meas tran vdout1_53ck1080 FIND v(dout1_53) AT=1090.05n

.meas tran vdout1_54ck1080 FIND v(dout1_54) AT=1090.05n

.meas tran vdout1_55ck1080 FIND v(dout1_55) AT=1090.05n

.meas tran vdout1_56ck1080 FIND v(dout1_56) AT=1090.05n

.meas tran vdout1_57ck1080 FIND v(dout1_57) AT=1090.05n

.meas tran vdout1_58ck1080 FIND v(dout1_58) AT=1090.05n

.meas tran vdout1_59ck1080 FIND v(dout1_59) AT=1090.05n

.meas tran vdout1_60ck1080 FIND v(dout1_60) AT=1090.05n

.meas tran vdout1_61ck1080 FIND v(dout1_61) AT=1090.05n

.meas tran vdout1_62ck1080 FIND v(dout1_62) AT=1090.05n

.meas tran vdout1_63ck1080 FIND v(dout1_63) AT=1090.05n

.meas tran vdout1_0ck1090 FIND v(dout1_0) AT=1100.05n

.meas tran vdout1_1ck1090 FIND v(dout1_1) AT=1100.05n

.meas tran vdout1_2ck1090 FIND v(dout1_2) AT=1100.05n

.meas tran vdout1_3ck1090 FIND v(dout1_3) AT=1100.05n

.meas tran vdout1_4ck1090 FIND v(dout1_4) AT=1100.05n

.meas tran vdout1_5ck1090 FIND v(dout1_5) AT=1100.05n

.meas tran vdout1_6ck1090 FIND v(dout1_6) AT=1100.05n

.meas tran vdout1_7ck1090 FIND v(dout1_7) AT=1100.05n

.meas tran vdout1_8ck1090 FIND v(dout1_8) AT=1100.05n

.meas tran vdout1_9ck1090 FIND v(dout1_9) AT=1100.05n

.meas tran vdout1_10ck1090 FIND v(dout1_10) AT=1100.05n

.meas tran vdout1_11ck1090 FIND v(dout1_11) AT=1100.05n

.meas tran vdout1_12ck1090 FIND v(dout1_12) AT=1100.05n

.meas tran vdout1_13ck1090 FIND v(dout1_13) AT=1100.05n

.meas tran vdout1_14ck1090 FIND v(dout1_14) AT=1100.05n

.meas tran vdout1_15ck1090 FIND v(dout1_15) AT=1100.05n

.meas tran vdout1_16ck1090 FIND v(dout1_16) AT=1100.05n

.meas tran vdout1_17ck1090 FIND v(dout1_17) AT=1100.05n

.meas tran vdout1_18ck1090 FIND v(dout1_18) AT=1100.05n

.meas tran vdout1_19ck1090 FIND v(dout1_19) AT=1100.05n

.meas tran vdout1_20ck1090 FIND v(dout1_20) AT=1100.05n

.meas tran vdout1_21ck1090 FIND v(dout1_21) AT=1100.05n

.meas tran vdout1_22ck1090 FIND v(dout1_22) AT=1100.05n

.meas tran vdout1_23ck1090 FIND v(dout1_23) AT=1100.05n

.meas tran vdout1_24ck1090 FIND v(dout1_24) AT=1100.05n

.meas tran vdout1_25ck1090 FIND v(dout1_25) AT=1100.05n

.meas tran vdout1_26ck1090 FIND v(dout1_26) AT=1100.05n

.meas tran vdout1_27ck1090 FIND v(dout1_27) AT=1100.05n

.meas tran vdout1_28ck1090 FIND v(dout1_28) AT=1100.05n

.meas tran vdout1_29ck1090 FIND v(dout1_29) AT=1100.05n

.meas tran vdout1_30ck1090 FIND v(dout1_30) AT=1100.05n

.meas tran vdout1_31ck1090 FIND v(dout1_31) AT=1100.05n

.meas tran vdout1_32ck1090 FIND v(dout1_32) AT=1100.05n

.meas tran vdout1_33ck1090 FIND v(dout1_33) AT=1100.05n

.meas tran vdout1_34ck1090 FIND v(dout1_34) AT=1100.05n

.meas tran vdout1_35ck1090 FIND v(dout1_35) AT=1100.05n

.meas tran vdout1_36ck1090 FIND v(dout1_36) AT=1100.05n

.meas tran vdout1_37ck1090 FIND v(dout1_37) AT=1100.05n

.meas tran vdout1_38ck1090 FIND v(dout1_38) AT=1100.05n

.meas tran vdout1_39ck1090 FIND v(dout1_39) AT=1100.05n

.meas tran vdout1_40ck1090 FIND v(dout1_40) AT=1100.05n

.meas tran vdout1_41ck1090 FIND v(dout1_41) AT=1100.05n

.meas tran vdout1_42ck1090 FIND v(dout1_42) AT=1100.05n

.meas tran vdout1_43ck1090 FIND v(dout1_43) AT=1100.05n

.meas tran vdout1_44ck1090 FIND v(dout1_44) AT=1100.05n

.meas tran vdout1_45ck1090 FIND v(dout1_45) AT=1100.05n

.meas tran vdout1_46ck1090 FIND v(dout1_46) AT=1100.05n

.meas tran vdout1_47ck1090 FIND v(dout1_47) AT=1100.05n

.meas tran vdout1_48ck1090 FIND v(dout1_48) AT=1100.05n

.meas tran vdout1_49ck1090 FIND v(dout1_49) AT=1100.05n

.meas tran vdout1_50ck1090 FIND v(dout1_50) AT=1100.05n

.meas tran vdout1_51ck1090 FIND v(dout1_51) AT=1100.05n

.meas tran vdout1_52ck1090 FIND v(dout1_52) AT=1100.05n

.meas tran vdout1_53ck1090 FIND v(dout1_53) AT=1100.05n

.meas tran vdout1_54ck1090 FIND v(dout1_54) AT=1100.05n

.meas tran vdout1_55ck1090 FIND v(dout1_55) AT=1100.05n

.meas tran vdout1_56ck1090 FIND v(dout1_56) AT=1100.05n

.meas tran vdout1_57ck1090 FIND v(dout1_57) AT=1100.05n

.meas tran vdout1_58ck1090 FIND v(dout1_58) AT=1100.05n

.meas tran vdout1_59ck1090 FIND v(dout1_59) AT=1100.05n

.meas tran vdout1_60ck1090 FIND v(dout1_60) AT=1100.05n

.meas tran vdout1_61ck1090 FIND v(dout1_61) AT=1100.05n

.meas tran vdout1_62ck1090 FIND v(dout1_62) AT=1100.05n

.meas tran vdout1_63ck1090 FIND v(dout1_63) AT=1100.05n

.meas tran vdout0_0ck1100 FIND v(dout0_0) AT=1110.05n

.meas tran vdout0_1ck1100 FIND v(dout0_1) AT=1110.05n

.meas tran vdout0_2ck1100 FIND v(dout0_2) AT=1110.05n

.meas tran vdout0_3ck1100 FIND v(dout0_3) AT=1110.05n

.meas tran vdout0_4ck1100 FIND v(dout0_4) AT=1110.05n

.meas tran vdout0_5ck1100 FIND v(dout0_5) AT=1110.05n

.meas tran vdout0_6ck1100 FIND v(dout0_6) AT=1110.05n

.meas tran vdout0_7ck1100 FIND v(dout0_7) AT=1110.05n

.meas tran vdout0_8ck1100 FIND v(dout0_8) AT=1110.05n

.meas tran vdout0_9ck1100 FIND v(dout0_9) AT=1110.05n

.meas tran vdout0_10ck1100 FIND v(dout0_10) AT=1110.05n

.meas tran vdout0_11ck1100 FIND v(dout0_11) AT=1110.05n

.meas tran vdout0_12ck1100 FIND v(dout0_12) AT=1110.05n

.meas tran vdout0_13ck1100 FIND v(dout0_13) AT=1110.05n

.meas tran vdout0_14ck1100 FIND v(dout0_14) AT=1110.05n

.meas tran vdout0_15ck1100 FIND v(dout0_15) AT=1110.05n

.meas tran vdout0_16ck1100 FIND v(dout0_16) AT=1110.05n

.meas tran vdout0_17ck1100 FIND v(dout0_17) AT=1110.05n

.meas tran vdout0_18ck1100 FIND v(dout0_18) AT=1110.05n

.meas tran vdout0_19ck1100 FIND v(dout0_19) AT=1110.05n

.meas tran vdout0_20ck1100 FIND v(dout0_20) AT=1110.05n

.meas tran vdout0_21ck1100 FIND v(dout0_21) AT=1110.05n

.meas tran vdout0_22ck1100 FIND v(dout0_22) AT=1110.05n

.meas tran vdout0_23ck1100 FIND v(dout0_23) AT=1110.05n

.meas tran vdout0_24ck1100 FIND v(dout0_24) AT=1110.05n

.meas tran vdout0_25ck1100 FIND v(dout0_25) AT=1110.05n

.meas tran vdout0_26ck1100 FIND v(dout0_26) AT=1110.05n

.meas tran vdout0_27ck1100 FIND v(dout0_27) AT=1110.05n

.meas tran vdout0_28ck1100 FIND v(dout0_28) AT=1110.05n

.meas tran vdout0_29ck1100 FIND v(dout0_29) AT=1110.05n

.meas tran vdout0_30ck1100 FIND v(dout0_30) AT=1110.05n

.meas tran vdout0_31ck1100 FIND v(dout0_31) AT=1110.05n

.meas tran vdout0_32ck1100 FIND v(dout0_32) AT=1110.05n

.meas tran vdout0_33ck1100 FIND v(dout0_33) AT=1110.05n

.meas tran vdout0_34ck1100 FIND v(dout0_34) AT=1110.05n

.meas tran vdout0_35ck1100 FIND v(dout0_35) AT=1110.05n

.meas tran vdout0_36ck1100 FIND v(dout0_36) AT=1110.05n

.meas tran vdout0_37ck1100 FIND v(dout0_37) AT=1110.05n

.meas tran vdout0_38ck1100 FIND v(dout0_38) AT=1110.05n

.meas tran vdout0_39ck1100 FIND v(dout0_39) AT=1110.05n

.meas tran vdout0_40ck1100 FIND v(dout0_40) AT=1110.05n

.meas tran vdout0_41ck1100 FIND v(dout0_41) AT=1110.05n

.meas tran vdout0_42ck1100 FIND v(dout0_42) AT=1110.05n

.meas tran vdout0_43ck1100 FIND v(dout0_43) AT=1110.05n

.meas tran vdout0_44ck1100 FIND v(dout0_44) AT=1110.05n

.meas tran vdout0_45ck1100 FIND v(dout0_45) AT=1110.05n

.meas tran vdout0_46ck1100 FIND v(dout0_46) AT=1110.05n

.meas tran vdout0_47ck1100 FIND v(dout0_47) AT=1110.05n

.meas tran vdout0_48ck1100 FIND v(dout0_48) AT=1110.05n

.meas tran vdout0_49ck1100 FIND v(dout0_49) AT=1110.05n

.meas tran vdout0_50ck1100 FIND v(dout0_50) AT=1110.05n

.meas tran vdout0_51ck1100 FIND v(dout0_51) AT=1110.05n

.meas tran vdout0_52ck1100 FIND v(dout0_52) AT=1110.05n

.meas tran vdout0_53ck1100 FIND v(dout0_53) AT=1110.05n

.meas tran vdout0_54ck1100 FIND v(dout0_54) AT=1110.05n

.meas tran vdout0_55ck1100 FIND v(dout0_55) AT=1110.05n

.meas tran vdout0_56ck1100 FIND v(dout0_56) AT=1110.05n

.meas tran vdout0_57ck1100 FIND v(dout0_57) AT=1110.05n

.meas tran vdout0_58ck1100 FIND v(dout0_58) AT=1110.05n

.meas tran vdout0_59ck1100 FIND v(dout0_59) AT=1110.05n

.meas tran vdout0_60ck1100 FIND v(dout0_60) AT=1110.05n

.meas tran vdout0_61ck1100 FIND v(dout0_61) AT=1110.05n

.meas tran vdout0_62ck1100 FIND v(dout0_62) AT=1110.05n

.meas tran vdout0_63ck1100 FIND v(dout0_63) AT=1110.05n

.meas tran vdout1_0ck1100 FIND v(dout1_0) AT=1110.05n

.meas tran vdout1_1ck1100 FIND v(dout1_1) AT=1110.05n

.meas tran vdout1_2ck1100 FIND v(dout1_2) AT=1110.05n

.meas tran vdout1_3ck1100 FIND v(dout1_3) AT=1110.05n

.meas tran vdout1_4ck1100 FIND v(dout1_4) AT=1110.05n

.meas tran vdout1_5ck1100 FIND v(dout1_5) AT=1110.05n

.meas tran vdout1_6ck1100 FIND v(dout1_6) AT=1110.05n

.meas tran vdout1_7ck1100 FIND v(dout1_7) AT=1110.05n

.meas tran vdout1_8ck1100 FIND v(dout1_8) AT=1110.05n

.meas tran vdout1_9ck1100 FIND v(dout1_9) AT=1110.05n

.meas tran vdout1_10ck1100 FIND v(dout1_10) AT=1110.05n

.meas tran vdout1_11ck1100 FIND v(dout1_11) AT=1110.05n

.meas tran vdout1_12ck1100 FIND v(dout1_12) AT=1110.05n

.meas tran vdout1_13ck1100 FIND v(dout1_13) AT=1110.05n

.meas tran vdout1_14ck1100 FIND v(dout1_14) AT=1110.05n

.meas tran vdout1_15ck1100 FIND v(dout1_15) AT=1110.05n

.meas tran vdout1_16ck1100 FIND v(dout1_16) AT=1110.05n

.meas tran vdout1_17ck1100 FIND v(dout1_17) AT=1110.05n

.meas tran vdout1_18ck1100 FIND v(dout1_18) AT=1110.05n

.meas tran vdout1_19ck1100 FIND v(dout1_19) AT=1110.05n

.meas tran vdout1_20ck1100 FIND v(dout1_20) AT=1110.05n

.meas tran vdout1_21ck1100 FIND v(dout1_21) AT=1110.05n

.meas tran vdout1_22ck1100 FIND v(dout1_22) AT=1110.05n

.meas tran vdout1_23ck1100 FIND v(dout1_23) AT=1110.05n

.meas tran vdout1_24ck1100 FIND v(dout1_24) AT=1110.05n

.meas tran vdout1_25ck1100 FIND v(dout1_25) AT=1110.05n

.meas tran vdout1_26ck1100 FIND v(dout1_26) AT=1110.05n

.meas tran vdout1_27ck1100 FIND v(dout1_27) AT=1110.05n

.meas tran vdout1_28ck1100 FIND v(dout1_28) AT=1110.05n

.meas tran vdout1_29ck1100 FIND v(dout1_29) AT=1110.05n

.meas tran vdout1_30ck1100 FIND v(dout1_30) AT=1110.05n

.meas tran vdout1_31ck1100 FIND v(dout1_31) AT=1110.05n

.meas tran vdout1_32ck1100 FIND v(dout1_32) AT=1110.05n

.meas tran vdout1_33ck1100 FIND v(dout1_33) AT=1110.05n

.meas tran vdout1_34ck1100 FIND v(dout1_34) AT=1110.05n

.meas tran vdout1_35ck1100 FIND v(dout1_35) AT=1110.05n

.meas tran vdout1_36ck1100 FIND v(dout1_36) AT=1110.05n

.meas tran vdout1_37ck1100 FIND v(dout1_37) AT=1110.05n

.meas tran vdout1_38ck1100 FIND v(dout1_38) AT=1110.05n

.meas tran vdout1_39ck1100 FIND v(dout1_39) AT=1110.05n

.meas tran vdout1_40ck1100 FIND v(dout1_40) AT=1110.05n

.meas tran vdout1_41ck1100 FIND v(dout1_41) AT=1110.05n

.meas tran vdout1_42ck1100 FIND v(dout1_42) AT=1110.05n

.meas tran vdout1_43ck1100 FIND v(dout1_43) AT=1110.05n

.meas tran vdout1_44ck1100 FIND v(dout1_44) AT=1110.05n

.meas tran vdout1_45ck1100 FIND v(dout1_45) AT=1110.05n

.meas tran vdout1_46ck1100 FIND v(dout1_46) AT=1110.05n

.meas tran vdout1_47ck1100 FIND v(dout1_47) AT=1110.05n

.meas tran vdout1_48ck1100 FIND v(dout1_48) AT=1110.05n

.meas tran vdout1_49ck1100 FIND v(dout1_49) AT=1110.05n

.meas tran vdout1_50ck1100 FIND v(dout1_50) AT=1110.05n

.meas tran vdout1_51ck1100 FIND v(dout1_51) AT=1110.05n

.meas tran vdout1_52ck1100 FIND v(dout1_52) AT=1110.05n

.meas tran vdout1_53ck1100 FIND v(dout1_53) AT=1110.05n

.meas tran vdout1_54ck1100 FIND v(dout1_54) AT=1110.05n

.meas tran vdout1_55ck1100 FIND v(dout1_55) AT=1110.05n

.meas tran vdout1_56ck1100 FIND v(dout1_56) AT=1110.05n

.meas tran vdout1_57ck1100 FIND v(dout1_57) AT=1110.05n

.meas tran vdout1_58ck1100 FIND v(dout1_58) AT=1110.05n

.meas tran vdout1_59ck1100 FIND v(dout1_59) AT=1110.05n

.meas tran vdout1_60ck1100 FIND v(dout1_60) AT=1110.05n

.meas tran vdout1_61ck1100 FIND v(dout1_61) AT=1110.05n

.meas tran vdout1_62ck1100 FIND v(dout1_62) AT=1110.05n

.meas tran vdout1_63ck1100 FIND v(dout1_63) AT=1110.05n

.meas tran vdout1_0ck1110 FIND v(dout1_0) AT=1120.05n

.meas tran vdout1_1ck1110 FIND v(dout1_1) AT=1120.05n

.meas tran vdout1_2ck1110 FIND v(dout1_2) AT=1120.05n

.meas tran vdout1_3ck1110 FIND v(dout1_3) AT=1120.05n

.meas tran vdout1_4ck1110 FIND v(dout1_4) AT=1120.05n

.meas tran vdout1_5ck1110 FIND v(dout1_5) AT=1120.05n

.meas tran vdout1_6ck1110 FIND v(dout1_6) AT=1120.05n

.meas tran vdout1_7ck1110 FIND v(dout1_7) AT=1120.05n

.meas tran vdout1_8ck1110 FIND v(dout1_8) AT=1120.05n

.meas tran vdout1_9ck1110 FIND v(dout1_9) AT=1120.05n

.meas tran vdout1_10ck1110 FIND v(dout1_10) AT=1120.05n

.meas tran vdout1_11ck1110 FIND v(dout1_11) AT=1120.05n

.meas tran vdout1_12ck1110 FIND v(dout1_12) AT=1120.05n

.meas tran vdout1_13ck1110 FIND v(dout1_13) AT=1120.05n

.meas tran vdout1_14ck1110 FIND v(dout1_14) AT=1120.05n

.meas tran vdout1_15ck1110 FIND v(dout1_15) AT=1120.05n

.meas tran vdout1_16ck1110 FIND v(dout1_16) AT=1120.05n

.meas tran vdout1_17ck1110 FIND v(dout1_17) AT=1120.05n

.meas tran vdout1_18ck1110 FIND v(dout1_18) AT=1120.05n

.meas tran vdout1_19ck1110 FIND v(dout1_19) AT=1120.05n

.meas tran vdout1_20ck1110 FIND v(dout1_20) AT=1120.05n

.meas tran vdout1_21ck1110 FIND v(dout1_21) AT=1120.05n

.meas tran vdout1_22ck1110 FIND v(dout1_22) AT=1120.05n

.meas tran vdout1_23ck1110 FIND v(dout1_23) AT=1120.05n

.meas tran vdout1_24ck1110 FIND v(dout1_24) AT=1120.05n

.meas tran vdout1_25ck1110 FIND v(dout1_25) AT=1120.05n

.meas tran vdout1_26ck1110 FIND v(dout1_26) AT=1120.05n

.meas tran vdout1_27ck1110 FIND v(dout1_27) AT=1120.05n

.meas tran vdout1_28ck1110 FIND v(dout1_28) AT=1120.05n

.meas tran vdout1_29ck1110 FIND v(dout1_29) AT=1120.05n

.meas tran vdout1_30ck1110 FIND v(dout1_30) AT=1120.05n

.meas tran vdout1_31ck1110 FIND v(dout1_31) AT=1120.05n

.meas tran vdout1_32ck1110 FIND v(dout1_32) AT=1120.05n

.meas tran vdout1_33ck1110 FIND v(dout1_33) AT=1120.05n

.meas tran vdout1_34ck1110 FIND v(dout1_34) AT=1120.05n

.meas tran vdout1_35ck1110 FIND v(dout1_35) AT=1120.05n

.meas tran vdout1_36ck1110 FIND v(dout1_36) AT=1120.05n

.meas tran vdout1_37ck1110 FIND v(dout1_37) AT=1120.05n

.meas tran vdout1_38ck1110 FIND v(dout1_38) AT=1120.05n

.meas tran vdout1_39ck1110 FIND v(dout1_39) AT=1120.05n

.meas tran vdout1_40ck1110 FIND v(dout1_40) AT=1120.05n

.meas tran vdout1_41ck1110 FIND v(dout1_41) AT=1120.05n

.meas tran vdout1_42ck1110 FIND v(dout1_42) AT=1120.05n

.meas tran vdout1_43ck1110 FIND v(dout1_43) AT=1120.05n

.meas tran vdout1_44ck1110 FIND v(dout1_44) AT=1120.05n

.meas tran vdout1_45ck1110 FIND v(dout1_45) AT=1120.05n

.meas tran vdout1_46ck1110 FIND v(dout1_46) AT=1120.05n

.meas tran vdout1_47ck1110 FIND v(dout1_47) AT=1120.05n

.meas tran vdout1_48ck1110 FIND v(dout1_48) AT=1120.05n

.meas tran vdout1_49ck1110 FIND v(dout1_49) AT=1120.05n

.meas tran vdout1_50ck1110 FIND v(dout1_50) AT=1120.05n

.meas tran vdout1_51ck1110 FIND v(dout1_51) AT=1120.05n

.meas tran vdout1_52ck1110 FIND v(dout1_52) AT=1120.05n

.meas tran vdout1_53ck1110 FIND v(dout1_53) AT=1120.05n

.meas tran vdout1_54ck1110 FIND v(dout1_54) AT=1120.05n

.meas tran vdout1_55ck1110 FIND v(dout1_55) AT=1120.05n

.meas tran vdout1_56ck1110 FIND v(dout1_56) AT=1120.05n

.meas tran vdout1_57ck1110 FIND v(dout1_57) AT=1120.05n

.meas tran vdout1_58ck1110 FIND v(dout1_58) AT=1120.05n

.meas tran vdout1_59ck1110 FIND v(dout1_59) AT=1120.05n

.meas tran vdout1_60ck1110 FIND v(dout1_60) AT=1120.05n

.meas tran vdout1_61ck1110 FIND v(dout1_61) AT=1120.05n

.meas tran vdout1_62ck1110 FIND v(dout1_62) AT=1120.05n

.meas tran vdout1_63ck1110 FIND v(dout1_63) AT=1120.05n

.meas tran vdout0_0ck1120 FIND v(dout0_0) AT=1130.05n

.meas tran vdout0_1ck1120 FIND v(dout0_1) AT=1130.05n

.meas tran vdout0_2ck1120 FIND v(dout0_2) AT=1130.05n

.meas tran vdout0_3ck1120 FIND v(dout0_3) AT=1130.05n

.meas tran vdout0_4ck1120 FIND v(dout0_4) AT=1130.05n

.meas tran vdout0_5ck1120 FIND v(dout0_5) AT=1130.05n

.meas tran vdout0_6ck1120 FIND v(dout0_6) AT=1130.05n

.meas tran vdout0_7ck1120 FIND v(dout0_7) AT=1130.05n

.meas tran vdout0_8ck1120 FIND v(dout0_8) AT=1130.05n

.meas tran vdout0_9ck1120 FIND v(dout0_9) AT=1130.05n

.meas tran vdout0_10ck1120 FIND v(dout0_10) AT=1130.05n

.meas tran vdout0_11ck1120 FIND v(dout0_11) AT=1130.05n

.meas tran vdout0_12ck1120 FIND v(dout0_12) AT=1130.05n

.meas tran vdout0_13ck1120 FIND v(dout0_13) AT=1130.05n

.meas tran vdout0_14ck1120 FIND v(dout0_14) AT=1130.05n

.meas tran vdout0_15ck1120 FIND v(dout0_15) AT=1130.05n

.meas tran vdout0_16ck1120 FIND v(dout0_16) AT=1130.05n

.meas tran vdout0_17ck1120 FIND v(dout0_17) AT=1130.05n

.meas tran vdout0_18ck1120 FIND v(dout0_18) AT=1130.05n

.meas tran vdout0_19ck1120 FIND v(dout0_19) AT=1130.05n

.meas tran vdout0_20ck1120 FIND v(dout0_20) AT=1130.05n

.meas tran vdout0_21ck1120 FIND v(dout0_21) AT=1130.05n

.meas tran vdout0_22ck1120 FIND v(dout0_22) AT=1130.05n

.meas tran vdout0_23ck1120 FIND v(dout0_23) AT=1130.05n

.meas tran vdout0_24ck1120 FIND v(dout0_24) AT=1130.05n

.meas tran vdout0_25ck1120 FIND v(dout0_25) AT=1130.05n

.meas tran vdout0_26ck1120 FIND v(dout0_26) AT=1130.05n

.meas tran vdout0_27ck1120 FIND v(dout0_27) AT=1130.05n

.meas tran vdout0_28ck1120 FIND v(dout0_28) AT=1130.05n

.meas tran vdout0_29ck1120 FIND v(dout0_29) AT=1130.05n

.meas tran vdout0_30ck1120 FIND v(dout0_30) AT=1130.05n

.meas tran vdout0_31ck1120 FIND v(dout0_31) AT=1130.05n

.meas tran vdout0_32ck1120 FIND v(dout0_32) AT=1130.05n

.meas tran vdout0_33ck1120 FIND v(dout0_33) AT=1130.05n

.meas tran vdout0_34ck1120 FIND v(dout0_34) AT=1130.05n

.meas tran vdout0_35ck1120 FIND v(dout0_35) AT=1130.05n

.meas tran vdout0_36ck1120 FIND v(dout0_36) AT=1130.05n

.meas tran vdout0_37ck1120 FIND v(dout0_37) AT=1130.05n

.meas tran vdout0_38ck1120 FIND v(dout0_38) AT=1130.05n

.meas tran vdout0_39ck1120 FIND v(dout0_39) AT=1130.05n

.meas tran vdout0_40ck1120 FIND v(dout0_40) AT=1130.05n

.meas tran vdout0_41ck1120 FIND v(dout0_41) AT=1130.05n

.meas tran vdout0_42ck1120 FIND v(dout0_42) AT=1130.05n

.meas tran vdout0_43ck1120 FIND v(dout0_43) AT=1130.05n

.meas tran vdout0_44ck1120 FIND v(dout0_44) AT=1130.05n

.meas tran vdout0_45ck1120 FIND v(dout0_45) AT=1130.05n

.meas tran vdout0_46ck1120 FIND v(dout0_46) AT=1130.05n

.meas tran vdout0_47ck1120 FIND v(dout0_47) AT=1130.05n

.meas tran vdout0_48ck1120 FIND v(dout0_48) AT=1130.05n

.meas tran vdout0_49ck1120 FIND v(dout0_49) AT=1130.05n

.meas tran vdout0_50ck1120 FIND v(dout0_50) AT=1130.05n

.meas tran vdout0_51ck1120 FIND v(dout0_51) AT=1130.05n

.meas tran vdout0_52ck1120 FIND v(dout0_52) AT=1130.05n

.meas tran vdout0_53ck1120 FIND v(dout0_53) AT=1130.05n

.meas tran vdout0_54ck1120 FIND v(dout0_54) AT=1130.05n

.meas tran vdout0_55ck1120 FIND v(dout0_55) AT=1130.05n

.meas tran vdout0_56ck1120 FIND v(dout0_56) AT=1130.05n

.meas tran vdout0_57ck1120 FIND v(dout0_57) AT=1130.05n

.meas tran vdout0_58ck1120 FIND v(dout0_58) AT=1130.05n

.meas tran vdout0_59ck1120 FIND v(dout0_59) AT=1130.05n

.meas tran vdout0_60ck1120 FIND v(dout0_60) AT=1130.05n

.meas tran vdout0_61ck1120 FIND v(dout0_61) AT=1130.05n

.meas tran vdout0_62ck1120 FIND v(dout0_62) AT=1130.05n

.meas tran vdout0_63ck1120 FIND v(dout0_63) AT=1130.05n

.meas tran vdout0_0ck1130 FIND v(dout0_0) AT=1140.05n

.meas tran vdout0_1ck1130 FIND v(dout0_1) AT=1140.05n

.meas tran vdout0_2ck1130 FIND v(dout0_2) AT=1140.05n

.meas tran vdout0_3ck1130 FIND v(dout0_3) AT=1140.05n

.meas tran vdout0_4ck1130 FIND v(dout0_4) AT=1140.05n

.meas tran vdout0_5ck1130 FIND v(dout0_5) AT=1140.05n

.meas tran vdout0_6ck1130 FIND v(dout0_6) AT=1140.05n

.meas tran vdout0_7ck1130 FIND v(dout0_7) AT=1140.05n

.meas tran vdout0_8ck1130 FIND v(dout0_8) AT=1140.05n

.meas tran vdout0_9ck1130 FIND v(dout0_9) AT=1140.05n

.meas tran vdout0_10ck1130 FIND v(dout0_10) AT=1140.05n

.meas tran vdout0_11ck1130 FIND v(dout0_11) AT=1140.05n

.meas tran vdout0_12ck1130 FIND v(dout0_12) AT=1140.05n

.meas tran vdout0_13ck1130 FIND v(dout0_13) AT=1140.05n

.meas tran vdout0_14ck1130 FIND v(dout0_14) AT=1140.05n

.meas tran vdout0_15ck1130 FIND v(dout0_15) AT=1140.05n

.meas tran vdout0_16ck1130 FIND v(dout0_16) AT=1140.05n

.meas tran vdout0_17ck1130 FIND v(dout0_17) AT=1140.05n

.meas tran vdout0_18ck1130 FIND v(dout0_18) AT=1140.05n

.meas tran vdout0_19ck1130 FIND v(dout0_19) AT=1140.05n

.meas tran vdout0_20ck1130 FIND v(dout0_20) AT=1140.05n

.meas tran vdout0_21ck1130 FIND v(dout0_21) AT=1140.05n

.meas tran vdout0_22ck1130 FIND v(dout0_22) AT=1140.05n

.meas tran vdout0_23ck1130 FIND v(dout0_23) AT=1140.05n

.meas tran vdout0_24ck1130 FIND v(dout0_24) AT=1140.05n

.meas tran vdout0_25ck1130 FIND v(dout0_25) AT=1140.05n

.meas tran vdout0_26ck1130 FIND v(dout0_26) AT=1140.05n

.meas tran vdout0_27ck1130 FIND v(dout0_27) AT=1140.05n

.meas tran vdout0_28ck1130 FIND v(dout0_28) AT=1140.05n

.meas tran vdout0_29ck1130 FIND v(dout0_29) AT=1140.05n

.meas tran vdout0_30ck1130 FIND v(dout0_30) AT=1140.05n

.meas tran vdout0_31ck1130 FIND v(dout0_31) AT=1140.05n

.meas tran vdout0_32ck1130 FIND v(dout0_32) AT=1140.05n

.meas tran vdout0_33ck1130 FIND v(dout0_33) AT=1140.05n

.meas tran vdout0_34ck1130 FIND v(dout0_34) AT=1140.05n

.meas tran vdout0_35ck1130 FIND v(dout0_35) AT=1140.05n

.meas tran vdout0_36ck1130 FIND v(dout0_36) AT=1140.05n

.meas tran vdout0_37ck1130 FIND v(dout0_37) AT=1140.05n

.meas tran vdout0_38ck1130 FIND v(dout0_38) AT=1140.05n

.meas tran vdout0_39ck1130 FIND v(dout0_39) AT=1140.05n

.meas tran vdout0_40ck1130 FIND v(dout0_40) AT=1140.05n

.meas tran vdout0_41ck1130 FIND v(dout0_41) AT=1140.05n

.meas tran vdout0_42ck1130 FIND v(dout0_42) AT=1140.05n

.meas tran vdout0_43ck1130 FIND v(dout0_43) AT=1140.05n

.meas tran vdout0_44ck1130 FIND v(dout0_44) AT=1140.05n

.meas tran vdout0_45ck1130 FIND v(dout0_45) AT=1140.05n

.meas tran vdout0_46ck1130 FIND v(dout0_46) AT=1140.05n

.meas tran vdout0_47ck1130 FIND v(dout0_47) AT=1140.05n

.meas tran vdout0_48ck1130 FIND v(dout0_48) AT=1140.05n

.meas tran vdout0_49ck1130 FIND v(dout0_49) AT=1140.05n

.meas tran vdout0_50ck1130 FIND v(dout0_50) AT=1140.05n

.meas tran vdout0_51ck1130 FIND v(dout0_51) AT=1140.05n

.meas tran vdout0_52ck1130 FIND v(dout0_52) AT=1140.05n

.meas tran vdout0_53ck1130 FIND v(dout0_53) AT=1140.05n

.meas tran vdout0_54ck1130 FIND v(dout0_54) AT=1140.05n

.meas tran vdout0_55ck1130 FIND v(dout0_55) AT=1140.05n

.meas tran vdout0_56ck1130 FIND v(dout0_56) AT=1140.05n

.meas tran vdout0_57ck1130 FIND v(dout0_57) AT=1140.05n

.meas tran vdout0_58ck1130 FIND v(dout0_58) AT=1140.05n

.meas tran vdout0_59ck1130 FIND v(dout0_59) AT=1140.05n

.meas tran vdout0_60ck1130 FIND v(dout0_60) AT=1140.05n

.meas tran vdout0_61ck1130 FIND v(dout0_61) AT=1140.05n

.meas tran vdout0_62ck1130 FIND v(dout0_62) AT=1140.05n

.meas tran vdout0_63ck1130 FIND v(dout0_63) AT=1140.05n

.meas tran vdout1_0ck1130 FIND v(dout1_0) AT=1140.05n

.meas tran vdout1_1ck1130 FIND v(dout1_1) AT=1140.05n

.meas tran vdout1_2ck1130 FIND v(dout1_2) AT=1140.05n

.meas tran vdout1_3ck1130 FIND v(dout1_3) AT=1140.05n

.meas tran vdout1_4ck1130 FIND v(dout1_4) AT=1140.05n

.meas tran vdout1_5ck1130 FIND v(dout1_5) AT=1140.05n

.meas tran vdout1_6ck1130 FIND v(dout1_6) AT=1140.05n

.meas tran vdout1_7ck1130 FIND v(dout1_7) AT=1140.05n

.meas tran vdout1_8ck1130 FIND v(dout1_8) AT=1140.05n

.meas tran vdout1_9ck1130 FIND v(dout1_9) AT=1140.05n

.meas tran vdout1_10ck1130 FIND v(dout1_10) AT=1140.05n

.meas tran vdout1_11ck1130 FIND v(dout1_11) AT=1140.05n

.meas tran vdout1_12ck1130 FIND v(dout1_12) AT=1140.05n

.meas tran vdout1_13ck1130 FIND v(dout1_13) AT=1140.05n

.meas tran vdout1_14ck1130 FIND v(dout1_14) AT=1140.05n

.meas tran vdout1_15ck1130 FIND v(dout1_15) AT=1140.05n

.meas tran vdout1_16ck1130 FIND v(dout1_16) AT=1140.05n

.meas tran vdout1_17ck1130 FIND v(dout1_17) AT=1140.05n

.meas tran vdout1_18ck1130 FIND v(dout1_18) AT=1140.05n

.meas tran vdout1_19ck1130 FIND v(dout1_19) AT=1140.05n

.meas tran vdout1_20ck1130 FIND v(dout1_20) AT=1140.05n

.meas tran vdout1_21ck1130 FIND v(dout1_21) AT=1140.05n

.meas tran vdout1_22ck1130 FIND v(dout1_22) AT=1140.05n

.meas tran vdout1_23ck1130 FIND v(dout1_23) AT=1140.05n

.meas tran vdout1_24ck1130 FIND v(dout1_24) AT=1140.05n

.meas tran vdout1_25ck1130 FIND v(dout1_25) AT=1140.05n

.meas tran vdout1_26ck1130 FIND v(dout1_26) AT=1140.05n

.meas tran vdout1_27ck1130 FIND v(dout1_27) AT=1140.05n

.meas tran vdout1_28ck1130 FIND v(dout1_28) AT=1140.05n

.meas tran vdout1_29ck1130 FIND v(dout1_29) AT=1140.05n

.meas tran vdout1_30ck1130 FIND v(dout1_30) AT=1140.05n

.meas tran vdout1_31ck1130 FIND v(dout1_31) AT=1140.05n

.meas tran vdout1_32ck1130 FIND v(dout1_32) AT=1140.05n

.meas tran vdout1_33ck1130 FIND v(dout1_33) AT=1140.05n

.meas tran vdout1_34ck1130 FIND v(dout1_34) AT=1140.05n

.meas tran vdout1_35ck1130 FIND v(dout1_35) AT=1140.05n

.meas tran vdout1_36ck1130 FIND v(dout1_36) AT=1140.05n

.meas tran vdout1_37ck1130 FIND v(dout1_37) AT=1140.05n

.meas tran vdout1_38ck1130 FIND v(dout1_38) AT=1140.05n

.meas tran vdout1_39ck1130 FIND v(dout1_39) AT=1140.05n

.meas tran vdout1_40ck1130 FIND v(dout1_40) AT=1140.05n

.meas tran vdout1_41ck1130 FIND v(dout1_41) AT=1140.05n

.meas tran vdout1_42ck1130 FIND v(dout1_42) AT=1140.05n

.meas tran vdout1_43ck1130 FIND v(dout1_43) AT=1140.05n

.meas tran vdout1_44ck1130 FIND v(dout1_44) AT=1140.05n

.meas tran vdout1_45ck1130 FIND v(dout1_45) AT=1140.05n

.meas tran vdout1_46ck1130 FIND v(dout1_46) AT=1140.05n

.meas tran vdout1_47ck1130 FIND v(dout1_47) AT=1140.05n

.meas tran vdout1_48ck1130 FIND v(dout1_48) AT=1140.05n

.meas tran vdout1_49ck1130 FIND v(dout1_49) AT=1140.05n

.meas tran vdout1_50ck1130 FIND v(dout1_50) AT=1140.05n

.meas tran vdout1_51ck1130 FIND v(dout1_51) AT=1140.05n

.meas tran vdout1_52ck1130 FIND v(dout1_52) AT=1140.05n

.meas tran vdout1_53ck1130 FIND v(dout1_53) AT=1140.05n

.meas tran vdout1_54ck1130 FIND v(dout1_54) AT=1140.05n

.meas tran vdout1_55ck1130 FIND v(dout1_55) AT=1140.05n

.meas tran vdout1_56ck1130 FIND v(dout1_56) AT=1140.05n

.meas tran vdout1_57ck1130 FIND v(dout1_57) AT=1140.05n

.meas tran vdout1_58ck1130 FIND v(dout1_58) AT=1140.05n

.meas tran vdout1_59ck1130 FIND v(dout1_59) AT=1140.05n

.meas tran vdout1_60ck1130 FIND v(dout1_60) AT=1140.05n

.meas tran vdout1_61ck1130 FIND v(dout1_61) AT=1140.05n

.meas tran vdout1_62ck1130 FIND v(dout1_62) AT=1140.05n

.meas tran vdout1_63ck1130 FIND v(dout1_63) AT=1140.05n

.meas tran vdout1_0ck1140 FIND v(dout1_0) AT=1150.05n

.meas tran vdout1_1ck1140 FIND v(dout1_1) AT=1150.05n

.meas tran vdout1_2ck1140 FIND v(dout1_2) AT=1150.05n

.meas tran vdout1_3ck1140 FIND v(dout1_3) AT=1150.05n

.meas tran vdout1_4ck1140 FIND v(dout1_4) AT=1150.05n

.meas tran vdout1_5ck1140 FIND v(dout1_5) AT=1150.05n

.meas tran vdout1_6ck1140 FIND v(dout1_6) AT=1150.05n

.meas tran vdout1_7ck1140 FIND v(dout1_7) AT=1150.05n

.meas tran vdout1_8ck1140 FIND v(dout1_8) AT=1150.05n

.meas tran vdout1_9ck1140 FIND v(dout1_9) AT=1150.05n

.meas tran vdout1_10ck1140 FIND v(dout1_10) AT=1150.05n

.meas tran vdout1_11ck1140 FIND v(dout1_11) AT=1150.05n

.meas tran vdout1_12ck1140 FIND v(dout1_12) AT=1150.05n

.meas tran vdout1_13ck1140 FIND v(dout1_13) AT=1150.05n

.meas tran vdout1_14ck1140 FIND v(dout1_14) AT=1150.05n

.meas tran vdout1_15ck1140 FIND v(dout1_15) AT=1150.05n

.meas tran vdout1_16ck1140 FIND v(dout1_16) AT=1150.05n

.meas tran vdout1_17ck1140 FIND v(dout1_17) AT=1150.05n

.meas tran vdout1_18ck1140 FIND v(dout1_18) AT=1150.05n

.meas tran vdout1_19ck1140 FIND v(dout1_19) AT=1150.05n

.meas tran vdout1_20ck1140 FIND v(dout1_20) AT=1150.05n

.meas tran vdout1_21ck1140 FIND v(dout1_21) AT=1150.05n

.meas tran vdout1_22ck1140 FIND v(dout1_22) AT=1150.05n

.meas tran vdout1_23ck1140 FIND v(dout1_23) AT=1150.05n

.meas tran vdout1_24ck1140 FIND v(dout1_24) AT=1150.05n

.meas tran vdout1_25ck1140 FIND v(dout1_25) AT=1150.05n

.meas tran vdout1_26ck1140 FIND v(dout1_26) AT=1150.05n

.meas tran vdout1_27ck1140 FIND v(dout1_27) AT=1150.05n

.meas tran vdout1_28ck1140 FIND v(dout1_28) AT=1150.05n

.meas tran vdout1_29ck1140 FIND v(dout1_29) AT=1150.05n

.meas tran vdout1_30ck1140 FIND v(dout1_30) AT=1150.05n

.meas tran vdout1_31ck1140 FIND v(dout1_31) AT=1150.05n

.meas tran vdout1_32ck1140 FIND v(dout1_32) AT=1150.05n

.meas tran vdout1_33ck1140 FIND v(dout1_33) AT=1150.05n

.meas tran vdout1_34ck1140 FIND v(dout1_34) AT=1150.05n

.meas tran vdout1_35ck1140 FIND v(dout1_35) AT=1150.05n

.meas tran vdout1_36ck1140 FIND v(dout1_36) AT=1150.05n

.meas tran vdout1_37ck1140 FIND v(dout1_37) AT=1150.05n

.meas tran vdout1_38ck1140 FIND v(dout1_38) AT=1150.05n

.meas tran vdout1_39ck1140 FIND v(dout1_39) AT=1150.05n

.meas tran vdout1_40ck1140 FIND v(dout1_40) AT=1150.05n

.meas tran vdout1_41ck1140 FIND v(dout1_41) AT=1150.05n

.meas tran vdout1_42ck1140 FIND v(dout1_42) AT=1150.05n

.meas tran vdout1_43ck1140 FIND v(dout1_43) AT=1150.05n

.meas tran vdout1_44ck1140 FIND v(dout1_44) AT=1150.05n

.meas tran vdout1_45ck1140 FIND v(dout1_45) AT=1150.05n

.meas tran vdout1_46ck1140 FIND v(dout1_46) AT=1150.05n

.meas tran vdout1_47ck1140 FIND v(dout1_47) AT=1150.05n

.meas tran vdout1_48ck1140 FIND v(dout1_48) AT=1150.05n

.meas tran vdout1_49ck1140 FIND v(dout1_49) AT=1150.05n

.meas tran vdout1_50ck1140 FIND v(dout1_50) AT=1150.05n

.meas tran vdout1_51ck1140 FIND v(dout1_51) AT=1150.05n

.meas tran vdout1_52ck1140 FIND v(dout1_52) AT=1150.05n

.meas tran vdout1_53ck1140 FIND v(dout1_53) AT=1150.05n

.meas tran vdout1_54ck1140 FIND v(dout1_54) AT=1150.05n

.meas tran vdout1_55ck1140 FIND v(dout1_55) AT=1150.05n

.meas tran vdout1_56ck1140 FIND v(dout1_56) AT=1150.05n

.meas tran vdout1_57ck1140 FIND v(dout1_57) AT=1150.05n

.meas tran vdout1_58ck1140 FIND v(dout1_58) AT=1150.05n

.meas tran vdout1_59ck1140 FIND v(dout1_59) AT=1150.05n

.meas tran vdout1_60ck1140 FIND v(dout1_60) AT=1150.05n

.meas tran vdout1_61ck1140 FIND v(dout1_61) AT=1150.05n

.meas tran vdout1_62ck1140 FIND v(dout1_62) AT=1150.05n

.meas tran vdout1_63ck1140 FIND v(dout1_63) AT=1150.05n

.meas tran vdout0_0ck1150 FIND v(dout0_0) AT=1160.05n

.meas tran vdout0_1ck1150 FIND v(dout0_1) AT=1160.05n

.meas tran vdout0_2ck1150 FIND v(dout0_2) AT=1160.05n

.meas tran vdout0_3ck1150 FIND v(dout0_3) AT=1160.05n

.meas tran vdout0_4ck1150 FIND v(dout0_4) AT=1160.05n

.meas tran vdout0_5ck1150 FIND v(dout0_5) AT=1160.05n

.meas tran vdout0_6ck1150 FIND v(dout0_6) AT=1160.05n

.meas tran vdout0_7ck1150 FIND v(dout0_7) AT=1160.05n

.meas tran vdout0_8ck1150 FIND v(dout0_8) AT=1160.05n

.meas tran vdout0_9ck1150 FIND v(dout0_9) AT=1160.05n

.meas tran vdout0_10ck1150 FIND v(dout0_10) AT=1160.05n

.meas tran vdout0_11ck1150 FIND v(dout0_11) AT=1160.05n

.meas tran vdout0_12ck1150 FIND v(dout0_12) AT=1160.05n

.meas tran vdout0_13ck1150 FIND v(dout0_13) AT=1160.05n

.meas tran vdout0_14ck1150 FIND v(dout0_14) AT=1160.05n

.meas tran vdout0_15ck1150 FIND v(dout0_15) AT=1160.05n

.meas tran vdout0_16ck1150 FIND v(dout0_16) AT=1160.05n

.meas tran vdout0_17ck1150 FIND v(dout0_17) AT=1160.05n

.meas tran vdout0_18ck1150 FIND v(dout0_18) AT=1160.05n

.meas tran vdout0_19ck1150 FIND v(dout0_19) AT=1160.05n

.meas tran vdout0_20ck1150 FIND v(dout0_20) AT=1160.05n

.meas tran vdout0_21ck1150 FIND v(dout0_21) AT=1160.05n

.meas tran vdout0_22ck1150 FIND v(dout0_22) AT=1160.05n

.meas tran vdout0_23ck1150 FIND v(dout0_23) AT=1160.05n

.meas tran vdout0_24ck1150 FIND v(dout0_24) AT=1160.05n

.meas tran vdout0_25ck1150 FIND v(dout0_25) AT=1160.05n

.meas tran vdout0_26ck1150 FIND v(dout0_26) AT=1160.05n

.meas tran vdout0_27ck1150 FIND v(dout0_27) AT=1160.05n

.meas tran vdout0_28ck1150 FIND v(dout0_28) AT=1160.05n

.meas tran vdout0_29ck1150 FIND v(dout0_29) AT=1160.05n

.meas tran vdout0_30ck1150 FIND v(dout0_30) AT=1160.05n

.meas tran vdout0_31ck1150 FIND v(dout0_31) AT=1160.05n

.meas tran vdout0_32ck1150 FIND v(dout0_32) AT=1160.05n

.meas tran vdout0_33ck1150 FIND v(dout0_33) AT=1160.05n

.meas tran vdout0_34ck1150 FIND v(dout0_34) AT=1160.05n

.meas tran vdout0_35ck1150 FIND v(dout0_35) AT=1160.05n

.meas tran vdout0_36ck1150 FIND v(dout0_36) AT=1160.05n

.meas tran vdout0_37ck1150 FIND v(dout0_37) AT=1160.05n

.meas tran vdout0_38ck1150 FIND v(dout0_38) AT=1160.05n

.meas tran vdout0_39ck1150 FIND v(dout0_39) AT=1160.05n

.meas tran vdout0_40ck1150 FIND v(dout0_40) AT=1160.05n

.meas tran vdout0_41ck1150 FIND v(dout0_41) AT=1160.05n

.meas tran vdout0_42ck1150 FIND v(dout0_42) AT=1160.05n

.meas tran vdout0_43ck1150 FIND v(dout0_43) AT=1160.05n

.meas tran vdout0_44ck1150 FIND v(dout0_44) AT=1160.05n

.meas tran vdout0_45ck1150 FIND v(dout0_45) AT=1160.05n

.meas tran vdout0_46ck1150 FIND v(dout0_46) AT=1160.05n

.meas tran vdout0_47ck1150 FIND v(dout0_47) AT=1160.05n

.meas tran vdout0_48ck1150 FIND v(dout0_48) AT=1160.05n

.meas tran vdout0_49ck1150 FIND v(dout0_49) AT=1160.05n

.meas tran vdout0_50ck1150 FIND v(dout0_50) AT=1160.05n

.meas tran vdout0_51ck1150 FIND v(dout0_51) AT=1160.05n

.meas tran vdout0_52ck1150 FIND v(dout0_52) AT=1160.05n

.meas tran vdout0_53ck1150 FIND v(dout0_53) AT=1160.05n

.meas tran vdout0_54ck1150 FIND v(dout0_54) AT=1160.05n

.meas tran vdout0_55ck1150 FIND v(dout0_55) AT=1160.05n

.meas tran vdout0_56ck1150 FIND v(dout0_56) AT=1160.05n

.meas tran vdout0_57ck1150 FIND v(dout0_57) AT=1160.05n

.meas tran vdout0_58ck1150 FIND v(dout0_58) AT=1160.05n

.meas tran vdout0_59ck1150 FIND v(dout0_59) AT=1160.05n

.meas tran vdout0_60ck1150 FIND v(dout0_60) AT=1160.05n

.meas tran vdout0_61ck1150 FIND v(dout0_61) AT=1160.05n

.meas tran vdout0_62ck1150 FIND v(dout0_62) AT=1160.05n

.meas tran vdout0_63ck1150 FIND v(dout0_63) AT=1160.05n

.meas tran vdout1_0ck1150 FIND v(dout1_0) AT=1160.05n

.meas tran vdout1_1ck1150 FIND v(dout1_1) AT=1160.05n

.meas tran vdout1_2ck1150 FIND v(dout1_2) AT=1160.05n

.meas tran vdout1_3ck1150 FIND v(dout1_3) AT=1160.05n

.meas tran vdout1_4ck1150 FIND v(dout1_4) AT=1160.05n

.meas tran vdout1_5ck1150 FIND v(dout1_5) AT=1160.05n

.meas tran vdout1_6ck1150 FIND v(dout1_6) AT=1160.05n

.meas tran vdout1_7ck1150 FIND v(dout1_7) AT=1160.05n

.meas tran vdout1_8ck1150 FIND v(dout1_8) AT=1160.05n

.meas tran vdout1_9ck1150 FIND v(dout1_9) AT=1160.05n

.meas tran vdout1_10ck1150 FIND v(dout1_10) AT=1160.05n

.meas tran vdout1_11ck1150 FIND v(dout1_11) AT=1160.05n

.meas tran vdout1_12ck1150 FIND v(dout1_12) AT=1160.05n

.meas tran vdout1_13ck1150 FIND v(dout1_13) AT=1160.05n

.meas tran vdout1_14ck1150 FIND v(dout1_14) AT=1160.05n

.meas tran vdout1_15ck1150 FIND v(dout1_15) AT=1160.05n

.meas tran vdout1_16ck1150 FIND v(dout1_16) AT=1160.05n

.meas tran vdout1_17ck1150 FIND v(dout1_17) AT=1160.05n

.meas tran vdout1_18ck1150 FIND v(dout1_18) AT=1160.05n

.meas tran vdout1_19ck1150 FIND v(dout1_19) AT=1160.05n

.meas tran vdout1_20ck1150 FIND v(dout1_20) AT=1160.05n

.meas tran vdout1_21ck1150 FIND v(dout1_21) AT=1160.05n

.meas tran vdout1_22ck1150 FIND v(dout1_22) AT=1160.05n

.meas tran vdout1_23ck1150 FIND v(dout1_23) AT=1160.05n

.meas tran vdout1_24ck1150 FIND v(dout1_24) AT=1160.05n

.meas tran vdout1_25ck1150 FIND v(dout1_25) AT=1160.05n

.meas tran vdout1_26ck1150 FIND v(dout1_26) AT=1160.05n

.meas tran vdout1_27ck1150 FIND v(dout1_27) AT=1160.05n

.meas tran vdout1_28ck1150 FIND v(dout1_28) AT=1160.05n

.meas tran vdout1_29ck1150 FIND v(dout1_29) AT=1160.05n

.meas tran vdout1_30ck1150 FIND v(dout1_30) AT=1160.05n

.meas tran vdout1_31ck1150 FIND v(dout1_31) AT=1160.05n

.meas tran vdout1_32ck1150 FIND v(dout1_32) AT=1160.05n

.meas tran vdout1_33ck1150 FIND v(dout1_33) AT=1160.05n

.meas tran vdout1_34ck1150 FIND v(dout1_34) AT=1160.05n

.meas tran vdout1_35ck1150 FIND v(dout1_35) AT=1160.05n

.meas tran vdout1_36ck1150 FIND v(dout1_36) AT=1160.05n

.meas tran vdout1_37ck1150 FIND v(dout1_37) AT=1160.05n

.meas tran vdout1_38ck1150 FIND v(dout1_38) AT=1160.05n

.meas tran vdout1_39ck1150 FIND v(dout1_39) AT=1160.05n

.meas tran vdout1_40ck1150 FIND v(dout1_40) AT=1160.05n

.meas tran vdout1_41ck1150 FIND v(dout1_41) AT=1160.05n

.meas tran vdout1_42ck1150 FIND v(dout1_42) AT=1160.05n

.meas tran vdout1_43ck1150 FIND v(dout1_43) AT=1160.05n

.meas tran vdout1_44ck1150 FIND v(dout1_44) AT=1160.05n

.meas tran vdout1_45ck1150 FIND v(dout1_45) AT=1160.05n

.meas tran vdout1_46ck1150 FIND v(dout1_46) AT=1160.05n

.meas tran vdout1_47ck1150 FIND v(dout1_47) AT=1160.05n

.meas tran vdout1_48ck1150 FIND v(dout1_48) AT=1160.05n

.meas tran vdout1_49ck1150 FIND v(dout1_49) AT=1160.05n

.meas tran vdout1_50ck1150 FIND v(dout1_50) AT=1160.05n

.meas tran vdout1_51ck1150 FIND v(dout1_51) AT=1160.05n

.meas tran vdout1_52ck1150 FIND v(dout1_52) AT=1160.05n

.meas tran vdout1_53ck1150 FIND v(dout1_53) AT=1160.05n

.meas tran vdout1_54ck1150 FIND v(dout1_54) AT=1160.05n

.meas tran vdout1_55ck1150 FIND v(dout1_55) AT=1160.05n

.meas tran vdout1_56ck1150 FIND v(dout1_56) AT=1160.05n

.meas tran vdout1_57ck1150 FIND v(dout1_57) AT=1160.05n

.meas tran vdout1_58ck1150 FIND v(dout1_58) AT=1160.05n

.meas tran vdout1_59ck1150 FIND v(dout1_59) AT=1160.05n

.meas tran vdout1_60ck1150 FIND v(dout1_60) AT=1160.05n

.meas tran vdout1_61ck1150 FIND v(dout1_61) AT=1160.05n

.meas tran vdout1_62ck1150 FIND v(dout1_62) AT=1160.05n

.meas tran vdout1_63ck1150 FIND v(dout1_63) AT=1160.05n

.meas tran vdout1_0ck1160 FIND v(dout1_0) AT=1170.05n

.meas tran vdout1_1ck1160 FIND v(dout1_1) AT=1170.05n

.meas tran vdout1_2ck1160 FIND v(dout1_2) AT=1170.05n

.meas tran vdout1_3ck1160 FIND v(dout1_3) AT=1170.05n

.meas tran vdout1_4ck1160 FIND v(dout1_4) AT=1170.05n

.meas tran vdout1_5ck1160 FIND v(dout1_5) AT=1170.05n

.meas tran vdout1_6ck1160 FIND v(dout1_6) AT=1170.05n

.meas tran vdout1_7ck1160 FIND v(dout1_7) AT=1170.05n

.meas tran vdout1_8ck1160 FIND v(dout1_8) AT=1170.05n

.meas tran vdout1_9ck1160 FIND v(dout1_9) AT=1170.05n

.meas tran vdout1_10ck1160 FIND v(dout1_10) AT=1170.05n

.meas tran vdout1_11ck1160 FIND v(dout1_11) AT=1170.05n

.meas tran vdout1_12ck1160 FIND v(dout1_12) AT=1170.05n

.meas tran vdout1_13ck1160 FIND v(dout1_13) AT=1170.05n

.meas tran vdout1_14ck1160 FIND v(dout1_14) AT=1170.05n

.meas tran vdout1_15ck1160 FIND v(dout1_15) AT=1170.05n

.meas tran vdout1_16ck1160 FIND v(dout1_16) AT=1170.05n

.meas tran vdout1_17ck1160 FIND v(dout1_17) AT=1170.05n

.meas tran vdout1_18ck1160 FIND v(dout1_18) AT=1170.05n

.meas tran vdout1_19ck1160 FIND v(dout1_19) AT=1170.05n

.meas tran vdout1_20ck1160 FIND v(dout1_20) AT=1170.05n

.meas tran vdout1_21ck1160 FIND v(dout1_21) AT=1170.05n

.meas tran vdout1_22ck1160 FIND v(dout1_22) AT=1170.05n

.meas tran vdout1_23ck1160 FIND v(dout1_23) AT=1170.05n

.meas tran vdout1_24ck1160 FIND v(dout1_24) AT=1170.05n

.meas tran vdout1_25ck1160 FIND v(dout1_25) AT=1170.05n

.meas tran vdout1_26ck1160 FIND v(dout1_26) AT=1170.05n

.meas tran vdout1_27ck1160 FIND v(dout1_27) AT=1170.05n

.meas tran vdout1_28ck1160 FIND v(dout1_28) AT=1170.05n

.meas tran vdout1_29ck1160 FIND v(dout1_29) AT=1170.05n

.meas tran vdout1_30ck1160 FIND v(dout1_30) AT=1170.05n

.meas tran vdout1_31ck1160 FIND v(dout1_31) AT=1170.05n

.meas tran vdout1_32ck1160 FIND v(dout1_32) AT=1170.05n

.meas tran vdout1_33ck1160 FIND v(dout1_33) AT=1170.05n

.meas tran vdout1_34ck1160 FIND v(dout1_34) AT=1170.05n

.meas tran vdout1_35ck1160 FIND v(dout1_35) AT=1170.05n

.meas tran vdout1_36ck1160 FIND v(dout1_36) AT=1170.05n

.meas tran vdout1_37ck1160 FIND v(dout1_37) AT=1170.05n

.meas tran vdout1_38ck1160 FIND v(dout1_38) AT=1170.05n

.meas tran vdout1_39ck1160 FIND v(dout1_39) AT=1170.05n

.meas tran vdout1_40ck1160 FIND v(dout1_40) AT=1170.05n

.meas tran vdout1_41ck1160 FIND v(dout1_41) AT=1170.05n

.meas tran vdout1_42ck1160 FIND v(dout1_42) AT=1170.05n

.meas tran vdout1_43ck1160 FIND v(dout1_43) AT=1170.05n

.meas tran vdout1_44ck1160 FIND v(dout1_44) AT=1170.05n

.meas tran vdout1_45ck1160 FIND v(dout1_45) AT=1170.05n

.meas tran vdout1_46ck1160 FIND v(dout1_46) AT=1170.05n

.meas tran vdout1_47ck1160 FIND v(dout1_47) AT=1170.05n

.meas tran vdout1_48ck1160 FIND v(dout1_48) AT=1170.05n

.meas tran vdout1_49ck1160 FIND v(dout1_49) AT=1170.05n

.meas tran vdout1_50ck1160 FIND v(dout1_50) AT=1170.05n

.meas tran vdout1_51ck1160 FIND v(dout1_51) AT=1170.05n

.meas tran vdout1_52ck1160 FIND v(dout1_52) AT=1170.05n

.meas tran vdout1_53ck1160 FIND v(dout1_53) AT=1170.05n

.meas tran vdout1_54ck1160 FIND v(dout1_54) AT=1170.05n

.meas tran vdout1_55ck1160 FIND v(dout1_55) AT=1170.05n

.meas tran vdout1_56ck1160 FIND v(dout1_56) AT=1170.05n

.meas tran vdout1_57ck1160 FIND v(dout1_57) AT=1170.05n

.meas tran vdout1_58ck1160 FIND v(dout1_58) AT=1170.05n

.meas tran vdout1_59ck1160 FIND v(dout1_59) AT=1170.05n

.meas tran vdout1_60ck1160 FIND v(dout1_60) AT=1170.05n

.meas tran vdout1_61ck1160 FIND v(dout1_61) AT=1170.05n

.meas tran vdout1_62ck1160 FIND v(dout1_62) AT=1170.05n

.meas tran vdout1_63ck1160 FIND v(dout1_63) AT=1170.05n

.meas tran vdout0_0ck1170 FIND v(dout0_0) AT=1180.05n

.meas tran vdout0_1ck1170 FIND v(dout0_1) AT=1180.05n

.meas tran vdout0_2ck1170 FIND v(dout0_2) AT=1180.05n

.meas tran vdout0_3ck1170 FIND v(dout0_3) AT=1180.05n

.meas tran vdout0_4ck1170 FIND v(dout0_4) AT=1180.05n

.meas tran vdout0_5ck1170 FIND v(dout0_5) AT=1180.05n

.meas tran vdout0_6ck1170 FIND v(dout0_6) AT=1180.05n

.meas tran vdout0_7ck1170 FIND v(dout0_7) AT=1180.05n

.meas tran vdout0_8ck1170 FIND v(dout0_8) AT=1180.05n

.meas tran vdout0_9ck1170 FIND v(dout0_9) AT=1180.05n

.meas tran vdout0_10ck1170 FIND v(dout0_10) AT=1180.05n

.meas tran vdout0_11ck1170 FIND v(dout0_11) AT=1180.05n

.meas tran vdout0_12ck1170 FIND v(dout0_12) AT=1180.05n

.meas tran vdout0_13ck1170 FIND v(dout0_13) AT=1180.05n

.meas tran vdout0_14ck1170 FIND v(dout0_14) AT=1180.05n

.meas tran vdout0_15ck1170 FIND v(dout0_15) AT=1180.05n

.meas tran vdout0_16ck1170 FIND v(dout0_16) AT=1180.05n

.meas tran vdout0_17ck1170 FIND v(dout0_17) AT=1180.05n

.meas tran vdout0_18ck1170 FIND v(dout0_18) AT=1180.05n

.meas tran vdout0_19ck1170 FIND v(dout0_19) AT=1180.05n

.meas tran vdout0_20ck1170 FIND v(dout0_20) AT=1180.05n

.meas tran vdout0_21ck1170 FIND v(dout0_21) AT=1180.05n

.meas tran vdout0_22ck1170 FIND v(dout0_22) AT=1180.05n

.meas tran vdout0_23ck1170 FIND v(dout0_23) AT=1180.05n

.meas tran vdout0_24ck1170 FIND v(dout0_24) AT=1180.05n

.meas tran vdout0_25ck1170 FIND v(dout0_25) AT=1180.05n

.meas tran vdout0_26ck1170 FIND v(dout0_26) AT=1180.05n

.meas tran vdout0_27ck1170 FIND v(dout0_27) AT=1180.05n

.meas tran vdout0_28ck1170 FIND v(dout0_28) AT=1180.05n

.meas tran vdout0_29ck1170 FIND v(dout0_29) AT=1180.05n

.meas tran vdout0_30ck1170 FIND v(dout0_30) AT=1180.05n

.meas tran vdout0_31ck1170 FIND v(dout0_31) AT=1180.05n

.meas tran vdout0_32ck1170 FIND v(dout0_32) AT=1180.05n

.meas tran vdout0_33ck1170 FIND v(dout0_33) AT=1180.05n

.meas tran vdout0_34ck1170 FIND v(dout0_34) AT=1180.05n

.meas tran vdout0_35ck1170 FIND v(dout0_35) AT=1180.05n

.meas tran vdout0_36ck1170 FIND v(dout0_36) AT=1180.05n

.meas tran vdout0_37ck1170 FIND v(dout0_37) AT=1180.05n

.meas tran vdout0_38ck1170 FIND v(dout0_38) AT=1180.05n

.meas tran vdout0_39ck1170 FIND v(dout0_39) AT=1180.05n

.meas tran vdout0_40ck1170 FIND v(dout0_40) AT=1180.05n

.meas tran vdout0_41ck1170 FIND v(dout0_41) AT=1180.05n

.meas tran vdout0_42ck1170 FIND v(dout0_42) AT=1180.05n

.meas tran vdout0_43ck1170 FIND v(dout0_43) AT=1180.05n

.meas tran vdout0_44ck1170 FIND v(dout0_44) AT=1180.05n

.meas tran vdout0_45ck1170 FIND v(dout0_45) AT=1180.05n

.meas tran vdout0_46ck1170 FIND v(dout0_46) AT=1180.05n

.meas tran vdout0_47ck1170 FIND v(dout0_47) AT=1180.05n

.meas tran vdout0_48ck1170 FIND v(dout0_48) AT=1180.05n

.meas tran vdout0_49ck1170 FIND v(dout0_49) AT=1180.05n

.meas tran vdout0_50ck1170 FIND v(dout0_50) AT=1180.05n

.meas tran vdout0_51ck1170 FIND v(dout0_51) AT=1180.05n

.meas tran vdout0_52ck1170 FIND v(dout0_52) AT=1180.05n

.meas tran vdout0_53ck1170 FIND v(dout0_53) AT=1180.05n

.meas tran vdout0_54ck1170 FIND v(dout0_54) AT=1180.05n

.meas tran vdout0_55ck1170 FIND v(dout0_55) AT=1180.05n

.meas tran vdout0_56ck1170 FIND v(dout0_56) AT=1180.05n

.meas tran vdout0_57ck1170 FIND v(dout0_57) AT=1180.05n

.meas tran vdout0_58ck1170 FIND v(dout0_58) AT=1180.05n

.meas tran vdout0_59ck1170 FIND v(dout0_59) AT=1180.05n

.meas tran vdout0_60ck1170 FIND v(dout0_60) AT=1180.05n

.meas tran vdout0_61ck1170 FIND v(dout0_61) AT=1180.05n

.meas tran vdout0_62ck1170 FIND v(dout0_62) AT=1180.05n

.meas tran vdout0_63ck1170 FIND v(dout0_63) AT=1180.05n

.meas tran vdout1_0ck1170 FIND v(dout1_0) AT=1180.05n

.meas tran vdout1_1ck1170 FIND v(dout1_1) AT=1180.05n

.meas tran vdout1_2ck1170 FIND v(dout1_2) AT=1180.05n

.meas tran vdout1_3ck1170 FIND v(dout1_3) AT=1180.05n

.meas tran vdout1_4ck1170 FIND v(dout1_4) AT=1180.05n

.meas tran vdout1_5ck1170 FIND v(dout1_5) AT=1180.05n

.meas tran vdout1_6ck1170 FIND v(dout1_6) AT=1180.05n

.meas tran vdout1_7ck1170 FIND v(dout1_7) AT=1180.05n

.meas tran vdout1_8ck1170 FIND v(dout1_8) AT=1180.05n

.meas tran vdout1_9ck1170 FIND v(dout1_9) AT=1180.05n

.meas tran vdout1_10ck1170 FIND v(dout1_10) AT=1180.05n

.meas tran vdout1_11ck1170 FIND v(dout1_11) AT=1180.05n

.meas tran vdout1_12ck1170 FIND v(dout1_12) AT=1180.05n

.meas tran vdout1_13ck1170 FIND v(dout1_13) AT=1180.05n

.meas tran vdout1_14ck1170 FIND v(dout1_14) AT=1180.05n

.meas tran vdout1_15ck1170 FIND v(dout1_15) AT=1180.05n

.meas tran vdout1_16ck1170 FIND v(dout1_16) AT=1180.05n

.meas tran vdout1_17ck1170 FIND v(dout1_17) AT=1180.05n

.meas tran vdout1_18ck1170 FIND v(dout1_18) AT=1180.05n

.meas tran vdout1_19ck1170 FIND v(dout1_19) AT=1180.05n

.meas tran vdout1_20ck1170 FIND v(dout1_20) AT=1180.05n

.meas tran vdout1_21ck1170 FIND v(dout1_21) AT=1180.05n

.meas tran vdout1_22ck1170 FIND v(dout1_22) AT=1180.05n

.meas tran vdout1_23ck1170 FIND v(dout1_23) AT=1180.05n

.meas tran vdout1_24ck1170 FIND v(dout1_24) AT=1180.05n

.meas tran vdout1_25ck1170 FIND v(dout1_25) AT=1180.05n

.meas tran vdout1_26ck1170 FIND v(dout1_26) AT=1180.05n

.meas tran vdout1_27ck1170 FIND v(dout1_27) AT=1180.05n

.meas tran vdout1_28ck1170 FIND v(dout1_28) AT=1180.05n

.meas tran vdout1_29ck1170 FIND v(dout1_29) AT=1180.05n

.meas tran vdout1_30ck1170 FIND v(dout1_30) AT=1180.05n

.meas tran vdout1_31ck1170 FIND v(dout1_31) AT=1180.05n

.meas tran vdout1_32ck1170 FIND v(dout1_32) AT=1180.05n

.meas tran vdout1_33ck1170 FIND v(dout1_33) AT=1180.05n

.meas tran vdout1_34ck1170 FIND v(dout1_34) AT=1180.05n

.meas tran vdout1_35ck1170 FIND v(dout1_35) AT=1180.05n

.meas tran vdout1_36ck1170 FIND v(dout1_36) AT=1180.05n

.meas tran vdout1_37ck1170 FIND v(dout1_37) AT=1180.05n

.meas tran vdout1_38ck1170 FIND v(dout1_38) AT=1180.05n

.meas tran vdout1_39ck1170 FIND v(dout1_39) AT=1180.05n

.meas tran vdout1_40ck1170 FIND v(dout1_40) AT=1180.05n

.meas tran vdout1_41ck1170 FIND v(dout1_41) AT=1180.05n

.meas tran vdout1_42ck1170 FIND v(dout1_42) AT=1180.05n

.meas tran vdout1_43ck1170 FIND v(dout1_43) AT=1180.05n

.meas tran vdout1_44ck1170 FIND v(dout1_44) AT=1180.05n

.meas tran vdout1_45ck1170 FIND v(dout1_45) AT=1180.05n

.meas tran vdout1_46ck1170 FIND v(dout1_46) AT=1180.05n

.meas tran vdout1_47ck1170 FIND v(dout1_47) AT=1180.05n

.meas tran vdout1_48ck1170 FIND v(dout1_48) AT=1180.05n

.meas tran vdout1_49ck1170 FIND v(dout1_49) AT=1180.05n

.meas tran vdout1_50ck1170 FIND v(dout1_50) AT=1180.05n

.meas tran vdout1_51ck1170 FIND v(dout1_51) AT=1180.05n

.meas tran vdout1_52ck1170 FIND v(dout1_52) AT=1180.05n

.meas tran vdout1_53ck1170 FIND v(dout1_53) AT=1180.05n

.meas tran vdout1_54ck1170 FIND v(dout1_54) AT=1180.05n

.meas tran vdout1_55ck1170 FIND v(dout1_55) AT=1180.05n

.meas tran vdout1_56ck1170 FIND v(dout1_56) AT=1180.05n

.meas tran vdout1_57ck1170 FIND v(dout1_57) AT=1180.05n

.meas tran vdout1_58ck1170 FIND v(dout1_58) AT=1180.05n

.meas tran vdout1_59ck1170 FIND v(dout1_59) AT=1180.05n

.meas tran vdout1_60ck1170 FIND v(dout1_60) AT=1180.05n

.meas tran vdout1_61ck1170 FIND v(dout1_61) AT=1180.05n

.meas tran vdout1_62ck1170 FIND v(dout1_62) AT=1180.05n

.meas tran vdout1_63ck1170 FIND v(dout1_63) AT=1180.05n

.meas tran vdout0_0ck1180 FIND v(dout0_0) AT=1190.05n

.meas tran vdout0_1ck1180 FIND v(dout0_1) AT=1190.05n

.meas tran vdout0_2ck1180 FIND v(dout0_2) AT=1190.05n

.meas tran vdout0_3ck1180 FIND v(dout0_3) AT=1190.05n

.meas tran vdout0_4ck1180 FIND v(dout0_4) AT=1190.05n

.meas tran vdout0_5ck1180 FIND v(dout0_5) AT=1190.05n

.meas tran vdout0_6ck1180 FIND v(dout0_6) AT=1190.05n

.meas tran vdout0_7ck1180 FIND v(dout0_7) AT=1190.05n

.meas tran vdout0_8ck1180 FIND v(dout0_8) AT=1190.05n

.meas tran vdout0_9ck1180 FIND v(dout0_9) AT=1190.05n

.meas tran vdout0_10ck1180 FIND v(dout0_10) AT=1190.05n

.meas tran vdout0_11ck1180 FIND v(dout0_11) AT=1190.05n

.meas tran vdout0_12ck1180 FIND v(dout0_12) AT=1190.05n

.meas tran vdout0_13ck1180 FIND v(dout0_13) AT=1190.05n

.meas tran vdout0_14ck1180 FIND v(dout0_14) AT=1190.05n

.meas tran vdout0_15ck1180 FIND v(dout0_15) AT=1190.05n

.meas tran vdout0_16ck1180 FIND v(dout0_16) AT=1190.05n

.meas tran vdout0_17ck1180 FIND v(dout0_17) AT=1190.05n

.meas tran vdout0_18ck1180 FIND v(dout0_18) AT=1190.05n

.meas tran vdout0_19ck1180 FIND v(dout0_19) AT=1190.05n

.meas tran vdout0_20ck1180 FIND v(dout0_20) AT=1190.05n

.meas tran vdout0_21ck1180 FIND v(dout0_21) AT=1190.05n

.meas tran vdout0_22ck1180 FIND v(dout0_22) AT=1190.05n

.meas tran vdout0_23ck1180 FIND v(dout0_23) AT=1190.05n

.meas tran vdout0_24ck1180 FIND v(dout0_24) AT=1190.05n

.meas tran vdout0_25ck1180 FIND v(dout0_25) AT=1190.05n

.meas tran vdout0_26ck1180 FIND v(dout0_26) AT=1190.05n

.meas tran vdout0_27ck1180 FIND v(dout0_27) AT=1190.05n

.meas tran vdout0_28ck1180 FIND v(dout0_28) AT=1190.05n

.meas tran vdout0_29ck1180 FIND v(dout0_29) AT=1190.05n

.meas tran vdout0_30ck1180 FIND v(dout0_30) AT=1190.05n

.meas tran vdout0_31ck1180 FIND v(dout0_31) AT=1190.05n

.meas tran vdout0_32ck1180 FIND v(dout0_32) AT=1190.05n

.meas tran vdout0_33ck1180 FIND v(dout0_33) AT=1190.05n

.meas tran vdout0_34ck1180 FIND v(dout0_34) AT=1190.05n

.meas tran vdout0_35ck1180 FIND v(dout0_35) AT=1190.05n

.meas tran vdout0_36ck1180 FIND v(dout0_36) AT=1190.05n

.meas tran vdout0_37ck1180 FIND v(dout0_37) AT=1190.05n

.meas tran vdout0_38ck1180 FIND v(dout0_38) AT=1190.05n

.meas tran vdout0_39ck1180 FIND v(dout0_39) AT=1190.05n

.meas tran vdout0_40ck1180 FIND v(dout0_40) AT=1190.05n

.meas tran vdout0_41ck1180 FIND v(dout0_41) AT=1190.05n

.meas tran vdout0_42ck1180 FIND v(dout0_42) AT=1190.05n

.meas tran vdout0_43ck1180 FIND v(dout0_43) AT=1190.05n

.meas tran vdout0_44ck1180 FIND v(dout0_44) AT=1190.05n

.meas tran vdout0_45ck1180 FIND v(dout0_45) AT=1190.05n

.meas tran vdout0_46ck1180 FIND v(dout0_46) AT=1190.05n

.meas tran vdout0_47ck1180 FIND v(dout0_47) AT=1190.05n

.meas tran vdout0_48ck1180 FIND v(dout0_48) AT=1190.05n

.meas tran vdout0_49ck1180 FIND v(dout0_49) AT=1190.05n

.meas tran vdout0_50ck1180 FIND v(dout0_50) AT=1190.05n

.meas tran vdout0_51ck1180 FIND v(dout0_51) AT=1190.05n

.meas tran vdout0_52ck1180 FIND v(dout0_52) AT=1190.05n

.meas tran vdout0_53ck1180 FIND v(dout0_53) AT=1190.05n

.meas tran vdout0_54ck1180 FIND v(dout0_54) AT=1190.05n

.meas tran vdout0_55ck1180 FIND v(dout0_55) AT=1190.05n

.meas tran vdout0_56ck1180 FIND v(dout0_56) AT=1190.05n

.meas tran vdout0_57ck1180 FIND v(dout0_57) AT=1190.05n

.meas tran vdout0_58ck1180 FIND v(dout0_58) AT=1190.05n

.meas tran vdout0_59ck1180 FIND v(dout0_59) AT=1190.05n

.meas tran vdout0_60ck1180 FIND v(dout0_60) AT=1190.05n

.meas tran vdout0_61ck1180 FIND v(dout0_61) AT=1190.05n

.meas tran vdout0_62ck1180 FIND v(dout0_62) AT=1190.05n

.meas tran vdout0_63ck1180 FIND v(dout0_63) AT=1190.05n

.meas tran vdout0_0ck1200 FIND v(dout0_0) AT=1210.05n

.meas tran vdout0_1ck1200 FIND v(dout0_1) AT=1210.05n

.meas tran vdout0_2ck1200 FIND v(dout0_2) AT=1210.05n

.meas tran vdout0_3ck1200 FIND v(dout0_3) AT=1210.05n

.meas tran vdout0_4ck1200 FIND v(dout0_4) AT=1210.05n

.meas tran vdout0_5ck1200 FIND v(dout0_5) AT=1210.05n

.meas tran vdout0_6ck1200 FIND v(dout0_6) AT=1210.05n

.meas tran vdout0_7ck1200 FIND v(dout0_7) AT=1210.05n

.meas tran vdout0_8ck1200 FIND v(dout0_8) AT=1210.05n

.meas tran vdout0_9ck1200 FIND v(dout0_9) AT=1210.05n

.meas tran vdout0_10ck1200 FIND v(dout0_10) AT=1210.05n

.meas tran vdout0_11ck1200 FIND v(dout0_11) AT=1210.05n

.meas tran vdout0_12ck1200 FIND v(dout0_12) AT=1210.05n

.meas tran vdout0_13ck1200 FIND v(dout0_13) AT=1210.05n

.meas tran vdout0_14ck1200 FIND v(dout0_14) AT=1210.05n

.meas tran vdout0_15ck1200 FIND v(dout0_15) AT=1210.05n

.meas tran vdout0_16ck1200 FIND v(dout0_16) AT=1210.05n

.meas tran vdout0_17ck1200 FIND v(dout0_17) AT=1210.05n

.meas tran vdout0_18ck1200 FIND v(dout0_18) AT=1210.05n

.meas tran vdout0_19ck1200 FIND v(dout0_19) AT=1210.05n

.meas tran vdout0_20ck1200 FIND v(dout0_20) AT=1210.05n

.meas tran vdout0_21ck1200 FIND v(dout0_21) AT=1210.05n

.meas tran vdout0_22ck1200 FIND v(dout0_22) AT=1210.05n

.meas tran vdout0_23ck1200 FIND v(dout0_23) AT=1210.05n

.meas tran vdout0_24ck1200 FIND v(dout0_24) AT=1210.05n

.meas tran vdout0_25ck1200 FIND v(dout0_25) AT=1210.05n

.meas tran vdout0_26ck1200 FIND v(dout0_26) AT=1210.05n

.meas tran vdout0_27ck1200 FIND v(dout0_27) AT=1210.05n

.meas tran vdout0_28ck1200 FIND v(dout0_28) AT=1210.05n

.meas tran vdout0_29ck1200 FIND v(dout0_29) AT=1210.05n

.meas tran vdout0_30ck1200 FIND v(dout0_30) AT=1210.05n

.meas tran vdout0_31ck1200 FIND v(dout0_31) AT=1210.05n

.meas tran vdout0_32ck1200 FIND v(dout0_32) AT=1210.05n

.meas tran vdout0_33ck1200 FIND v(dout0_33) AT=1210.05n

.meas tran vdout0_34ck1200 FIND v(dout0_34) AT=1210.05n

.meas tran vdout0_35ck1200 FIND v(dout0_35) AT=1210.05n

.meas tran vdout0_36ck1200 FIND v(dout0_36) AT=1210.05n

.meas tran vdout0_37ck1200 FIND v(dout0_37) AT=1210.05n

.meas tran vdout0_38ck1200 FIND v(dout0_38) AT=1210.05n

.meas tran vdout0_39ck1200 FIND v(dout0_39) AT=1210.05n

.meas tran vdout0_40ck1200 FIND v(dout0_40) AT=1210.05n

.meas tran vdout0_41ck1200 FIND v(dout0_41) AT=1210.05n

.meas tran vdout0_42ck1200 FIND v(dout0_42) AT=1210.05n

.meas tran vdout0_43ck1200 FIND v(dout0_43) AT=1210.05n

.meas tran vdout0_44ck1200 FIND v(dout0_44) AT=1210.05n

.meas tran vdout0_45ck1200 FIND v(dout0_45) AT=1210.05n

.meas tran vdout0_46ck1200 FIND v(dout0_46) AT=1210.05n

.meas tran vdout0_47ck1200 FIND v(dout0_47) AT=1210.05n

.meas tran vdout0_48ck1200 FIND v(dout0_48) AT=1210.05n

.meas tran vdout0_49ck1200 FIND v(dout0_49) AT=1210.05n

.meas tran vdout0_50ck1200 FIND v(dout0_50) AT=1210.05n

.meas tran vdout0_51ck1200 FIND v(dout0_51) AT=1210.05n

.meas tran vdout0_52ck1200 FIND v(dout0_52) AT=1210.05n

.meas tran vdout0_53ck1200 FIND v(dout0_53) AT=1210.05n

.meas tran vdout0_54ck1200 FIND v(dout0_54) AT=1210.05n

.meas tran vdout0_55ck1200 FIND v(dout0_55) AT=1210.05n

.meas tran vdout0_56ck1200 FIND v(dout0_56) AT=1210.05n

.meas tran vdout0_57ck1200 FIND v(dout0_57) AT=1210.05n

.meas tran vdout0_58ck1200 FIND v(dout0_58) AT=1210.05n

.meas tran vdout0_59ck1200 FIND v(dout0_59) AT=1210.05n

.meas tran vdout0_60ck1200 FIND v(dout0_60) AT=1210.05n

.meas tran vdout0_61ck1200 FIND v(dout0_61) AT=1210.05n

.meas tran vdout0_62ck1200 FIND v(dout0_62) AT=1210.05n

.meas tran vdout0_63ck1200 FIND v(dout0_63) AT=1210.05n

.meas tran vdout1_0ck1200 FIND v(dout1_0) AT=1210.05n

.meas tran vdout1_1ck1200 FIND v(dout1_1) AT=1210.05n

.meas tran vdout1_2ck1200 FIND v(dout1_2) AT=1210.05n

.meas tran vdout1_3ck1200 FIND v(dout1_3) AT=1210.05n

.meas tran vdout1_4ck1200 FIND v(dout1_4) AT=1210.05n

.meas tran vdout1_5ck1200 FIND v(dout1_5) AT=1210.05n

.meas tran vdout1_6ck1200 FIND v(dout1_6) AT=1210.05n

.meas tran vdout1_7ck1200 FIND v(dout1_7) AT=1210.05n

.meas tran vdout1_8ck1200 FIND v(dout1_8) AT=1210.05n

.meas tran vdout1_9ck1200 FIND v(dout1_9) AT=1210.05n

.meas tran vdout1_10ck1200 FIND v(dout1_10) AT=1210.05n

.meas tran vdout1_11ck1200 FIND v(dout1_11) AT=1210.05n

.meas tran vdout1_12ck1200 FIND v(dout1_12) AT=1210.05n

.meas tran vdout1_13ck1200 FIND v(dout1_13) AT=1210.05n

.meas tran vdout1_14ck1200 FIND v(dout1_14) AT=1210.05n

.meas tran vdout1_15ck1200 FIND v(dout1_15) AT=1210.05n

.meas tran vdout1_16ck1200 FIND v(dout1_16) AT=1210.05n

.meas tran vdout1_17ck1200 FIND v(dout1_17) AT=1210.05n

.meas tran vdout1_18ck1200 FIND v(dout1_18) AT=1210.05n

.meas tran vdout1_19ck1200 FIND v(dout1_19) AT=1210.05n

.meas tran vdout1_20ck1200 FIND v(dout1_20) AT=1210.05n

.meas tran vdout1_21ck1200 FIND v(dout1_21) AT=1210.05n

.meas tran vdout1_22ck1200 FIND v(dout1_22) AT=1210.05n

.meas tran vdout1_23ck1200 FIND v(dout1_23) AT=1210.05n

.meas tran vdout1_24ck1200 FIND v(dout1_24) AT=1210.05n

.meas tran vdout1_25ck1200 FIND v(dout1_25) AT=1210.05n

.meas tran vdout1_26ck1200 FIND v(dout1_26) AT=1210.05n

.meas tran vdout1_27ck1200 FIND v(dout1_27) AT=1210.05n

.meas tran vdout1_28ck1200 FIND v(dout1_28) AT=1210.05n

.meas tran vdout1_29ck1200 FIND v(dout1_29) AT=1210.05n

.meas tran vdout1_30ck1200 FIND v(dout1_30) AT=1210.05n

.meas tran vdout1_31ck1200 FIND v(dout1_31) AT=1210.05n

.meas tran vdout1_32ck1200 FIND v(dout1_32) AT=1210.05n

.meas tran vdout1_33ck1200 FIND v(dout1_33) AT=1210.05n

.meas tran vdout1_34ck1200 FIND v(dout1_34) AT=1210.05n

.meas tran vdout1_35ck1200 FIND v(dout1_35) AT=1210.05n

.meas tran vdout1_36ck1200 FIND v(dout1_36) AT=1210.05n

.meas tran vdout1_37ck1200 FIND v(dout1_37) AT=1210.05n

.meas tran vdout1_38ck1200 FIND v(dout1_38) AT=1210.05n

.meas tran vdout1_39ck1200 FIND v(dout1_39) AT=1210.05n

.meas tran vdout1_40ck1200 FIND v(dout1_40) AT=1210.05n

.meas tran vdout1_41ck1200 FIND v(dout1_41) AT=1210.05n

.meas tran vdout1_42ck1200 FIND v(dout1_42) AT=1210.05n

.meas tran vdout1_43ck1200 FIND v(dout1_43) AT=1210.05n

.meas tran vdout1_44ck1200 FIND v(dout1_44) AT=1210.05n

.meas tran vdout1_45ck1200 FIND v(dout1_45) AT=1210.05n

.meas tran vdout1_46ck1200 FIND v(dout1_46) AT=1210.05n

.meas tran vdout1_47ck1200 FIND v(dout1_47) AT=1210.05n

.meas tran vdout1_48ck1200 FIND v(dout1_48) AT=1210.05n

.meas tran vdout1_49ck1200 FIND v(dout1_49) AT=1210.05n

.meas tran vdout1_50ck1200 FIND v(dout1_50) AT=1210.05n

.meas tran vdout1_51ck1200 FIND v(dout1_51) AT=1210.05n

.meas tran vdout1_52ck1200 FIND v(dout1_52) AT=1210.05n

.meas tran vdout1_53ck1200 FIND v(dout1_53) AT=1210.05n

.meas tran vdout1_54ck1200 FIND v(dout1_54) AT=1210.05n

.meas tran vdout1_55ck1200 FIND v(dout1_55) AT=1210.05n

.meas tran vdout1_56ck1200 FIND v(dout1_56) AT=1210.05n

.meas tran vdout1_57ck1200 FIND v(dout1_57) AT=1210.05n

.meas tran vdout1_58ck1200 FIND v(dout1_58) AT=1210.05n

.meas tran vdout1_59ck1200 FIND v(dout1_59) AT=1210.05n

.meas tran vdout1_60ck1200 FIND v(dout1_60) AT=1210.05n

.meas tran vdout1_61ck1200 FIND v(dout1_61) AT=1210.05n

.meas tran vdout1_62ck1200 FIND v(dout1_62) AT=1210.05n

.meas tran vdout1_63ck1200 FIND v(dout1_63) AT=1210.05n

.meas tran vdout0_0ck1220 FIND v(dout0_0) AT=1230.05n

.meas tran vdout0_1ck1220 FIND v(dout0_1) AT=1230.05n

.meas tran vdout0_2ck1220 FIND v(dout0_2) AT=1230.05n

.meas tran vdout0_3ck1220 FIND v(dout0_3) AT=1230.05n

.meas tran vdout0_4ck1220 FIND v(dout0_4) AT=1230.05n

.meas tran vdout0_5ck1220 FIND v(dout0_5) AT=1230.05n

.meas tran vdout0_6ck1220 FIND v(dout0_6) AT=1230.05n

.meas tran vdout0_7ck1220 FIND v(dout0_7) AT=1230.05n

.meas tran vdout0_8ck1220 FIND v(dout0_8) AT=1230.05n

.meas tran vdout0_9ck1220 FIND v(dout0_9) AT=1230.05n

.meas tran vdout0_10ck1220 FIND v(dout0_10) AT=1230.05n

.meas tran vdout0_11ck1220 FIND v(dout0_11) AT=1230.05n

.meas tran vdout0_12ck1220 FIND v(dout0_12) AT=1230.05n

.meas tran vdout0_13ck1220 FIND v(dout0_13) AT=1230.05n

.meas tran vdout0_14ck1220 FIND v(dout0_14) AT=1230.05n

.meas tran vdout0_15ck1220 FIND v(dout0_15) AT=1230.05n

.meas tran vdout0_16ck1220 FIND v(dout0_16) AT=1230.05n

.meas tran vdout0_17ck1220 FIND v(dout0_17) AT=1230.05n

.meas tran vdout0_18ck1220 FIND v(dout0_18) AT=1230.05n

.meas tran vdout0_19ck1220 FIND v(dout0_19) AT=1230.05n

.meas tran vdout0_20ck1220 FIND v(dout0_20) AT=1230.05n

.meas tran vdout0_21ck1220 FIND v(dout0_21) AT=1230.05n

.meas tran vdout0_22ck1220 FIND v(dout0_22) AT=1230.05n

.meas tran vdout0_23ck1220 FIND v(dout0_23) AT=1230.05n

.meas tran vdout0_24ck1220 FIND v(dout0_24) AT=1230.05n

.meas tran vdout0_25ck1220 FIND v(dout0_25) AT=1230.05n

.meas tran vdout0_26ck1220 FIND v(dout0_26) AT=1230.05n

.meas tran vdout0_27ck1220 FIND v(dout0_27) AT=1230.05n

.meas tran vdout0_28ck1220 FIND v(dout0_28) AT=1230.05n

.meas tran vdout0_29ck1220 FIND v(dout0_29) AT=1230.05n

.meas tran vdout0_30ck1220 FIND v(dout0_30) AT=1230.05n

.meas tran vdout0_31ck1220 FIND v(dout0_31) AT=1230.05n

.meas tran vdout0_32ck1220 FIND v(dout0_32) AT=1230.05n

.meas tran vdout0_33ck1220 FIND v(dout0_33) AT=1230.05n

.meas tran vdout0_34ck1220 FIND v(dout0_34) AT=1230.05n

.meas tran vdout0_35ck1220 FIND v(dout0_35) AT=1230.05n

.meas tran vdout0_36ck1220 FIND v(dout0_36) AT=1230.05n

.meas tran vdout0_37ck1220 FIND v(dout0_37) AT=1230.05n

.meas tran vdout0_38ck1220 FIND v(dout0_38) AT=1230.05n

.meas tran vdout0_39ck1220 FIND v(dout0_39) AT=1230.05n

.meas tran vdout0_40ck1220 FIND v(dout0_40) AT=1230.05n

.meas tran vdout0_41ck1220 FIND v(dout0_41) AT=1230.05n

.meas tran vdout0_42ck1220 FIND v(dout0_42) AT=1230.05n

.meas tran vdout0_43ck1220 FIND v(dout0_43) AT=1230.05n

.meas tran vdout0_44ck1220 FIND v(dout0_44) AT=1230.05n

.meas tran vdout0_45ck1220 FIND v(dout0_45) AT=1230.05n

.meas tran vdout0_46ck1220 FIND v(dout0_46) AT=1230.05n

.meas tran vdout0_47ck1220 FIND v(dout0_47) AT=1230.05n

.meas tran vdout0_48ck1220 FIND v(dout0_48) AT=1230.05n

.meas tran vdout0_49ck1220 FIND v(dout0_49) AT=1230.05n

.meas tran vdout0_50ck1220 FIND v(dout0_50) AT=1230.05n

.meas tran vdout0_51ck1220 FIND v(dout0_51) AT=1230.05n

.meas tran vdout0_52ck1220 FIND v(dout0_52) AT=1230.05n

.meas tran vdout0_53ck1220 FIND v(dout0_53) AT=1230.05n

.meas tran vdout0_54ck1220 FIND v(dout0_54) AT=1230.05n

.meas tran vdout0_55ck1220 FIND v(dout0_55) AT=1230.05n

.meas tran vdout0_56ck1220 FIND v(dout0_56) AT=1230.05n

.meas tran vdout0_57ck1220 FIND v(dout0_57) AT=1230.05n

.meas tran vdout0_58ck1220 FIND v(dout0_58) AT=1230.05n

.meas tran vdout0_59ck1220 FIND v(dout0_59) AT=1230.05n

.meas tran vdout0_60ck1220 FIND v(dout0_60) AT=1230.05n

.meas tran vdout0_61ck1220 FIND v(dout0_61) AT=1230.05n

.meas tran vdout0_62ck1220 FIND v(dout0_62) AT=1230.05n

.meas tran vdout0_63ck1220 FIND v(dout0_63) AT=1230.05n

.meas tran vdout1_0ck1220 FIND v(dout1_0) AT=1230.05n

.meas tran vdout1_1ck1220 FIND v(dout1_1) AT=1230.05n

.meas tran vdout1_2ck1220 FIND v(dout1_2) AT=1230.05n

.meas tran vdout1_3ck1220 FIND v(dout1_3) AT=1230.05n

.meas tran vdout1_4ck1220 FIND v(dout1_4) AT=1230.05n

.meas tran vdout1_5ck1220 FIND v(dout1_5) AT=1230.05n

.meas tran vdout1_6ck1220 FIND v(dout1_6) AT=1230.05n

.meas tran vdout1_7ck1220 FIND v(dout1_7) AT=1230.05n

.meas tran vdout1_8ck1220 FIND v(dout1_8) AT=1230.05n

.meas tran vdout1_9ck1220 FIND v(dout1_9) AT=1230.05n

.meas tran vdout1_10ck1220 FIND v(dout1_10) AT=1230.05n

.meas tran vdout1_11ck1220 FIND v(dout1_11) AT=1230.05n

.meas tran vdout1_12ck1220 FIND v(dout1_12) AT=1230.05n

.meas tran vdout1_13ck1220 FIND v(dout1_13) AT=1230.05n

.meas tran vdout1_14ck1220 FIND v(dout1_14) AT=1230.05n

.meas tran vdout1_15ck1220 FIND v(dout1_15) AT=1230.05n

.meas tran vdout1_16ck1220 FIND v(dout1_16) AT=1230.05n

.meas tran vdout1_17ck1220 FIND v(dout1_17) AT=1230.05n

.meas tran vdout1_18ck1220 FIND v(dout1_18) AT=1230.05n

.meas tran vdout1_19ck1220 FIND v(dout1_19) AT=1230.05n

.meas tran vdout1_20ck1220 FIND v(dout1_20) AT=1230.05n

.meas tran vdout1_21ck1220 FIND v(dout1_21) AT=1230.05n

.meas tran vdout1_22ck1220 FIND v(dout1_22) AT=1230.05n

.meas tran vdout1_23ck1220 FIND v(dout1_23) AT=1230.05n

.meas tran vdout1_24ck1220 FIND v(dout1_24) AT=1230.05n

.meas tran vdout1_25ck1220 FIND v(dout1_25) AT=1230.05n

.meas tran vdout1_26ck1220 FIND v(dout1_26) AT=1230.05n

.meas tran vdout1_27ck1220 FIND v(dout1_27) AT=1230.05n

.meas tran vdout1_28ck1220 FIND v(dout1_28) AT=1230.05n

.meas tran vdout1_29ck1220 FIND v(dout1_29) AT=1230.05n

.meas tran vdout1_30ck1220 FIND v(dout1_30) AT=1230.05n

.meas tran vdout1_31ck1220 FIND v(dout1_31) AT=1230.05n

.meas tran vdout1_32ck1220 FIND v(dout1_32) AT=1230.05n

.meas tran vdout1_33ck1220 FIND v(dout1_33) AT=1230.05n

.meas tran vdout1_34ck1220 FIND v(dout1_34) AT=1230.05n

.meas tran vdout1_35ck1220 FIND v(dout1_35) AT=1230.05n

.meas tran vdout1_36ck1220 FIND v(dout1_36) AT=1230.05n

.meas tran vdout1_37ck1220 FIND v(dout1_37) AT=1230.05n

.meas tran vdout1_38ck1220 FIND v(dout1_38) AT=1230.05n

.meas tran vdout1_39ck1220 FIND v(dout1_39) AT=1230.05n

.meas tran vdout1_40ck1220 FIND v(dout1_40) AT=1230.05n

.meas tran vdout1_41ck1220 FIND v(dout1_41) AT=1230.05n

.meas tran vdout1_42ck1220 FIND v(dout1_42) AT=1230.05n

.meas tran vdout1_43ck1220 FIND v(dout1_43) AT=1230.05n

.meas tran vdout1_44ck1220 FIND v(dout1_44) AT=1230.05n

.meas tran vdout1_45ck1220 FIND v(dout1_45) AT=1230.05n

.meas tran vdout1_46ck1220 FIND v(dout1_46) AT=1230.05n

.meas tran vdout1_47ck1220 FIND v(dout1_47) AT=1230.05n

.meas tran vdout1_48ck1220 FIND v(dout1_48) AT=1230.05n

.meas tran vdout1_49ck1220 FIND v(dout1_49) AT=1230.05n

.meas tran vdout1_50ck1220 FIND v(dout1_50) AT=1230.05n

.meas tran vdout1_51ck1220 FIND v(dout1_51) AT=1230.05n

.meas tran vdout1_52ck1220 FIND v(dout1_52) AT=1230.05n

.meas tran vdout1_53ck1220 FIND v(dout1_53) AT=1230.05n

.meas tran vdout1_54ck1220 FIND v(dout1_54) AT=1230.05n

.meas tran vdout1_55ck1220 FIND v(dout1_55) AT=1230.05n

.meas tran vdout1_56ck1220 FIND v(dout1_56) AT=1230.05n

.meas tran vdout1_57ck1220 FIND v(dout1_57) AT=1230.05n

.meas tran vdout1_58ck1220 FIND v(dout1_58) AT=1230.05n

.meas tran vdout1_59ck1220 FIND v(dout1_59) AT=1230.05n

.meas tran vdout1_60ck1220 FIND v(dout1_60) AT=1230.05n

.meas tran vdout1_61ck1220 FIND v(dout1_61) AT=1230.05n

.meas tran vdout1_62ck1220 FIND v(dout1_62) AT=1230.05n

.meas tran vdout1_63ck1220 FIND v(dout1_63) AT=1230.05n

.meas tran vdout0_0ck1230 FIND v(dout0_0) AT=1240.05n

.meas tran vdout0_1ck1230 FIND v(dout0_1) AT=1240.05n

.meas tran vdout0_2ck1230 FIND v(dout0_2) AT=1240.05n

.meas tran vdout0_3ck1230 FIND v(dout0_3) AT=1240.05n

.meas tran vdout0_4ck1230 FIND v(dout0_4) AT=1240.05n

.meas tran vdout0_5ck1230 FIND v(dout0_5) AT=1240.05n

.meas tran vdout0_6ck1230 FIND v(dout0_6) AT=1240.05n

.meas tran vdout0_7ck1230 FIND v(dout0_7) AT=1240.05n

.meas tran vdout0_8ck1230 FIND v(dout0_8) AT=1240.05n

.meas tran vdout0_9ck1230 FIND v(dout0_9) AT=1240.05n

.meas tran vdout0_10ck1230 FIND v(dout0_10) AT=1240.05n

.meas tran vdout0_11ck1230 FIND v(dout0_11) AT=1240.05n

.meas tran vdout0_12ck1230 FIND v(dout0_12) AT=1240.05n

.meas tran vdout0_13ck1230 FIND v(dout0_13) AT=1240.05n

.meas tran vdout0_14ck1230 FIND v(dout0_14) AT=1240.05n

.meas tran vdout0_15ck1230 FIND v(dout0_15) AT=1240.05n

.meas tran vdout0_16ck1230 FIND v(dout0_16) AT=1240.05n

.meas tran vdout0_17ck1230 FIND v(dout0_17) AT=1240.05n

.meas tran vdout0_18ck1230 FIND v(dout0_18) AT=1240.05n

.meas tran vdout0_19ck1230 FIND v(dout0_19) AT=1240.05n

.meas tran vdout0_20ck1230 FIND v(dout0_20) AT=1240.05n

.meas tran vdout0_21ck1230 FIND v(dout0_21) AT=1240.05n

.meas tran vdout0_22ck1230 FIND v(dout0_22) AT=1240.05n

.meas tran vdout0_23ck1230 FIND v(dout0_23) AT=1240.05n

.meas tran vdout0_24ck1230 FIND v(dout0_24) AT=1240.05n

.meas tran vdout0_25ck1230 FIND v(dout0_25) AT=1240.05n

.meas tran vdout0_26ck1230 FIND v(dout0_26) AT=1240.05n

.meas tran vdout0_27ck1230 FIND v(dout0_27) AT=1240.05n

.meas tran vdout0_28ck1230 FIND v(dout0_28) AT=1240.05n

.meas tran vdout0_29ck1230 FIND v(dout0_29) AT=1240.05n

.meas tran vdout0_30ck1230 FIND v(dout0_30) AT=1240.05n

.meas tran vdout0_31ck1230 FIND v(dout0_31) AT=1240.05n

.meas tran vdout0_32ck1230 FIND v(dout0_32) AT=1240.05n

.meas tran vdout0_33ck1230 FIND v(dout0_33) AT=1240.05n

.meas tran vdout0_34ck1230 FIND v(dout0_34) AT=1240.05n

.meas tran vdout0_35ck1230 FIND v(dout0_35) AT=1240.05n

.meas tran vdout0_36ck1230 FIND v(dout0_36) AT=1240.05n

.meas tran vdout0_37ck1230 FIND v(dout0_37) AT=1240.05n

.meas tran vdout0_38ck1230 FIND v(dout0_38) AT=1240.05n

.meas tran vdout0_39ck1230 FIND v(dout0_39) AT=1240.05n

.meas tran vdout0_40ck1230 FIND v(dout0_40) AT=1240.05n

.meas tran vdout0_41ck1230 FIND v(dout0_41) AT=1240.05n

.meas tran vdout0_42ck1230 FIND v(dout0_42) AT=1240.05n

.meas tran vdout0_43ck1230 FIND v(dout0_43) AT=1240.05n

.meas tran vdout0_44ck1230 FIND v(dout0_44) AT=1240.05n

.meas tran vdout0_45ck1230 FIND v(dout0_45) AT=1240.05n

.meas tran vdout0_46ck1230 FIND v(dout0_46) AT=1240.05n

.meas tran vdout0_47ck1230 FIND v(dout0_47) AT=1240.05n

.meas tran vdout0_48ck1230 FIND v(dout0_48) AT=1240.05n

.meas tran vdout0_49ck1230 FIND v(dout0_49) AT=1240.05n

.meas tran vdout0_50ck1230 FIND v(dout0_50) AT=1240.05n

.meas tran vdout0_51ck1230 FIND v(dout0_51) AT=1240.05n

.meas tran vdout0_52ck1230 FIND v(dout0_52) AT=1240.05n

.meas tran vdout0_53ck1230 FIND v(dout0_53) AT=1240.05n

.meas tran vdout0_54ck1230 FIND v(dout0_54) AT=1240.05n

.meas tran vdout0_55ck1230 FIND v(dout0_55) AT=1240.05n

.meas tran vdout0_56ck1230 FIND v(dout0_56) AT=1240.05n

.meas tran vdout0_57ck1230 FIND v(dout0_57) AT=1240.05n

.meas tran vdout0_58ck1230 FIND v(dout0_58) AT=1240.05n

.meas tran vdout0_59ck1230 FIND v(dout0_59) AT=1240.05n

.meas tran vdout0_60ck1230 FIND v(dout0_60) AT=1240.05n

.meas tran vdout0_61ck1230 FIND v(dout0_61) AT=1240.05n

.meas tran vdout0_62ck1230 FIND v(dout0_62) AT=1240.05n

.meas tran vdout0_63ck1230 FIND v(dout0_63) AT=1240.05n

.meas tran vdout1_0ck1240 FIND v(dout1_0) AT=1250.05n

.meas tran vdout1_1ck1240 FIND v(dout1_1) AT=1250.05n

.meas tran vdout1_2ck1240 FIND v(dout1_2) AT=1250.05n

.meas tran vdout1_3ck1240 FIND v(dout1_3) AT=1250.05n

.meas tran vdout1_4ck1240 FIND v(dout1_4) AT=1250.05n

.meas tran vdout1_5ck1240 FIND v(dout1_5) AT=1250.05n

.meas tran vdout1_6ck1240 FIND v(dout1_6) AT=1250.05n

.meas tran vdout1_7ck1240 FIND v(dout1_7) AT=1250.05n

.meas tran vdout1_8ck1240 FIND v(dout1_8) AT=1250.05n

.meas tran vdout1_9ck1240 FIND v(dout1_9) AT=1250.05n

.meas tran vdout1_10ck1240 FIND v(dout1_10) AT=1250.05n

.meas tran vdout1_11ck1240 FIND v(dout1_11) AT=1250.05n

.meas tran vdout1_12ck1240 FIND v(dout1_12) AT=1250.05n

.meas tran vdout1_13ck1240 FIND v(dout1_13) AT=1250.05n

.meas tran vdout1_14ck1240 FIND v(dout1_14) AT=1250.05n

.meas tran vdout1_15ck1240 FIND v(dout1_15) AT=1250.05n

.meas tran vdout1_16ck1240 FIND v(dout1_16) AT=1250.05n

.meas tran vdout1_17ck1240 FIND v(dout1_17) AT=1250.05n

.meas tran vdout1_18ck1240 FIND v(dout1_18) AT=1250.05n

.meas tran vdout1_19ck1240 FIND v(dout1_19) AT=1250.05n

.meas tran vdout1_20ck1240 FIND v(dout1_20) AT=1250.05n

.meas tran vdout1_21ck1240 FIND v(dout1_21) AT=1250.05n

.meas tran vdout1_22ck1240 FIND v(dout1_22) AT=1250.05n

.meas tran vdout1_23ck1240 FIND v(dout1_23) AT=1250.05n

.meas tran vdout1_24ck1240 FIND v(dout1_24) AT=1250.05n

.meas tran vdout1_25ck1240 FIND v(dout1_25) AT=1250.05n

.meas tran vdout1_26ck1240 FIND v(dout1_26) AT=1250.05n

.meas tran vdout1_27ck1240 FIND v(dout1_27) AT=1250.05n

.meas tran vdout1_28ck1240 FIND v(dout1_28) AT=1250.05n

.meas tran vdout1_29ck1240 FIND v(dout1_29) AT=1250.05n

.meas tran vdout1_30ck1240 FIND v(dout1_30) AT=1250.05n

.meas tran vdout1_31ck1240 FIND v(dout1_31) AT=1250.05n

.meas tran vdout1_32ck1240 FIND v(dout1_32) AT=1250.05n

.meas tran vdout1_33ck1240 FIND v(dout1_33) AT=1250.05n

.meas tran vdout1_34ck1240 FIND v(dout1_34) AT=1250.05n

.meas tran vdout1_35ck1240 FIND v(dout1_35) AT=1250.05n

.meas tran vdout1_36ck1240 FIND v(dout1_36) AT=1250.05n

.meas tran vdout1_37ck1240 FIND v(dout1_37) AT=1250.05n

.meas tran vdout1_38ck1240 FIND v(dout1_38) AT=1250.05n

.meas tran vdout1_39ck1240 FIND v(dout1_39) AT=1250.05n

.meas tran vdout1_40ck1240 FIND v(dout1_40) AT=1250.05n

.meas tran vdout1_41ck1240 FIND v(dout1_41) AT=1250.05n

.meas tran vdout1_42ck1240 FIND v(dout1_42) AT=1250.05n

.meas tran vdout1_43ck1240 FIND v(dout1_43) AT=1250.05n

.meas tran vdout1_44ck1240 FIND v(dout1_44) AT=1250.05n

.meas tran vdout1_45ck1240 FIND v(dout1_45) AT=1250.05n

.meas tran vdout1_46ck1240 FIND v(dout1_46) AT=1250.05n

.meas tran vdout1_47ck1240 FIND v(dout1_47) AT=1250.05n

.meas tran vdout1_48ck1240 FIND v(dout1_48) AT=1250.05n

.meas tran vdout1_49ck1240 FIND v(dout1_49) AT=1250.05n

.meas tran vdout1_50ck1240 FIND v(dout1_50) AT=1250.05n

.meas tran vdout1_51ck1240 FIND v(dout1_51) AT=1250.05n

.meas tran vdout1_52ck1240 FIND v(dout1_52) AT=1250.05n

.meas tran vdout1_53ck1240 FIND v(dout1_53) AT=1250.05n

.meas tran vdout1_54ck1240 FIND v(dout1_54) AT=1250.05n

.meas tran vdout1_55ck1240 FIND v(dout1_55) AT=1250.05n

.meas tran vdout1_56ck1240 FIND v(dout1_56) AT=1250.05n

.meas tran vdout1_57ck1240 FIND v(dout1_57) AT=1250.05n

.meas tran vdout1_58ck1240 FIND v(dout1_58) AT=1250.05n

.meas tran vdout1_59ck1240 FIND v(dout1_59) AT=1250.05n

.meas tran vdout1_60ck1240 FIND v(dout1_60) AT=1250.05n

.meas tran vdout1_61ck1240 FIND v(dout1_61) AT=1250.05n

.meas tran vdout1_62ck1240 FIND v(dout1_62) AT=1250.05n

.meas tran vdout1_63ck1240 FIND v(dout1_63) AT=1250.05n

.meas tran vdout1_0ck1250 FIND v(dout1_0) AT=1260.05n

.meas tran vdout1_1ck1250 FIND v(dout1_1) AT=1260.05n

.meas tran vdout1_2ck1250 FIND v(dout1_2) AT=1260.05n

.meas tran vdout1_3ck1250 FIND v(dout1_3) AT=1260.05n

.meas tran vdout1_4ck1250 FIND v(dout1_4) AT=1260.05n

.meas tran vdout1_5ck1250 FIND v(dout1_5) AT=1260.05n

.meas tran vdout1_6ck1250 FIND v(dout1_6) AT=1260.05n

.meas tran vdout1_7ck1250 FIND v(dout1_7) AT=1260.05n

.meas tran vdout1_8ck1250 FIND v(dout1_8) AT=1260.05n

.meas tran vdout1_9ck1250 FIND v(dout1_9) AT=1260.05n

.meas tran vdout1_10ck1250 FIND v(dout1_10) AT=1260.05n

.meas tran vdout1_11ck1250 FIND v(dout1_11) AT=1260.05n

.meas tran vdout1_12ck1250 FIND v(dout1_12) AT=1260.05n

.meas tran vdout1_13ck1250 FIND v(dout1_13) AT=1260.05n

.meas tran vdout1_14ck1250 FIND v(dout1_14) AT=1260.05n

.meas tran vdout1_15ck1250 FIND v(dout1_15) AT=1260.05n

.meas tran vdout1_16ck1250 FIND v(dout1_16) AT=1260.05n

.meas tran vdout1_17ck1250 FIND v(dout1_17) AT=1260.05n

.meas tran vdout1_18ck1250 FIND v(dout1_18) AT=1260.05n

.meas tran vdout1_19ck1250 FIND v(dout1_19) AT=1260.05n

.meas tran vdout1_20ck1250 FIND v(dout1_20) AT=1260.05n

.meas tran vdout1_21ck1250 FIND v(dout1_21) AT=1260.05n

.meas tran vdout1_22ck1250 FIND v(dout1_22) AT=1260.05n

.meas tran vdout1_23ck1250 FIND v(dout1_23) AT=1260.05n

.meas tran vdout1_24ck1250 FIND v(dout1_24) AT=1260.05n

.meas tran vdout1_25ck1250 FIND v(dout1_25) AT=1260.05n

.meas tran vdout1_26ck1250 FIND v(dout1_26) AT=1260.05n

.meas tran vdout1_27ck1250 FIND v(dout1_27) AT=1260.05n

.meas tran vdout1_28ck1250 FIND v(dout1_28) AT=1260.05n

.meas tran vdout1_29ck1250 FIND v(dout1_29) AT=1260.05n

.meas tran vdout1_30ck1250 FIND v(dout1_30) AT=1260.05n

.meas tran vdout1_31ck1250 FIND v(dout1_31) AT=1260.05n

.meas tran vdout1_32ck1250 FIND v(dout1_32) AT=1260.05n

.meas tran vdout1_33ck1250 FIND v(dout1_33) AT=1260.05n

.meas tran vdout1_34ck1250 FIND v(dout1_34) AT=1260.05n

.meas tran vdout1_35ck1250 FIND v(dout1_35) AT=1260.05n

.meas tran vdout1_36ck1250 FIND v(dout1_36) AT=1260.05n

.meas tran vdout1_37ck1250 FIND v(dout1_37) AT=1260.05n

.meas tran vdout1_38ck1250 FIND v(dout1_38) AT=1260.05n

.meas tran vdout1_39ck1250 FIND v(dout1_39) AT=1260.05n

.meas tran vdout1_40ck1250 FIND v(dout1_40) AT=1260.05n

.meas tran vdout1_41ck1250 FIND v(dout1_41) AT=1260.05n

.meas tran vdout1_42ck1250 FIND v(dout1_42) AT=1260.05n

.meas tran vdout1_43ck1250 FIND v(dout1_43) AT=1260.05n

.meas tran vdout1_44ck1250 FIND v(dout1_44) AT=1260.05n

.meas tran vdout1_45ck1250 FIND v(dout1_45) AT=1260.05n

.meas tran vdout1_46ck1250 FIND v(dout1_46) AT=1260.05n

.meas tran vdout1_47ck1250 FIND v(dout1_47) AT=1260.05n

.meas tran vdout1_48ck1250 FIND v(dout1_48) AT=1260.05n

.meas tran vdout1_49ck1250 FIND v(dout1_49) AT=1260.05n

.meas tran vdout1_50ck1250 FIND v(dout1_50) AT=1260.05n

.meas tran vdout1_51ck1250 FIND v(dout1_51) AT=1260.05n

.meas tran vdout1_52ck1250 FIND v(dout1_52) AT=1260.05n

.meas tran vdout1_53ck1250 FIND v(dout1_53) AT=1260.05n

.meas tran vdout1_54ck1250 FIND v(dout1_54) AT=1260.05n

.meas tran vdout1_55ck1250 FIND v(dout1_55) AT=1260.05n

.meas tran vdout1_56ck1250 FIND v(dout1_56) AT=1260.05n

.meas tran vdout1_57ck1250 FIND v(dout1_57) AT=1260.05n

.meas tran vdout1_58ck1250 FIND v(dout1_58) AT=1260.05n

.meas tran vdout1_59ck1250 FIND v(dout1_59) AT=1260.05n

.meas tran vdout1_60ck1250 FIND v(dout1_60) AT=1260.05n

.meas tran vdout1_61ck1250 FIND v(dout1_61) AT=1260.05n

.meas tran vdout1_62ck1250 FIND v(dout1_62) AT=1260.05n

.meas tran vdout1_63ck1250 FIND v(dout1_63) AT=1260.05n

.meas tran vdout0_0ck1260 FIND v(dout0_0) AT=1270.05n

.meas tran vdout0_1ck1260 FIND v(dout0_1) AT=1270.05n

.meas tran vdout0_2ck1260 FIND v(dout0_2) AT=1270.05n

.meas tran vdout0_3ck1260 FIND v(dout0_3) AT=1270.05n

.meas tran vdout0_4ck1260 FIND v(dout0_4) AT=1270.05n

.meas tran vdout0_5ck1260 FIND v(dout0_5) AT=1270.05n

.meas tran vdout0_6ck1260 FIND v(dout0_6) AT=1270.05n

.meas tran vdout0_7ck1260 FIND v(dout0_7) AT=1270.05n

.meas tran vdout0_8ck1260 FIND v(dout0_8) AT=1270.05n

.meas tran vdout0_9ck1260 FIND v(dout0_9) AT=1270.05n

.meas tran vdout0_10ck1260 FIND v(dout0_10) AT=1270.05n

.meas tran vdout0_11ck1260 FIND v(dout0_11) AT=1270.05n

.meas tran vdout0_12ck1260 FIND v(dout0_12) AT=1270.05n

.meas tran vdout0_13ck1260 FIND v(dout0_13) AT=1270.05n

.meas tran vdout0_14ck1260 FIND v(dout0_14) AT=1270.05n

.meas tran vdout0_15ck1260 FIND v(dout0_15) AT=1270.05n

.meas tran vdout0_16ck1260 FIND v(dout0_16) AT=1270.05n

.meas tran vdout0_17ck1260 FIND v(dout0_17) AT=1270.05n

.meas tran vdout0_18ck1260 FIND v(dout0_18) AT=1270.05n

.meas tran vdout0_19ck1260 FIND v(dout0_19) AT=1270.05n

.meas tran vdout0_20ck1260 FIND v(dout0_20) AT=1270.05n

.meas tran vdout0_21ck1260 FIND v(dout0_21) AT=1270.05n

.meas tran vdout0_22ck1260 FIND v(dout0_22) AT=1270.05n

.meas tran vdout0_23ck1260 FIND v(dout0_23) AT=1270.05n

.meas tran vdout0_24ck1260 FIND v(dout0_24) AT=1270.05n

.meas tran vdout0_25ck1260 FIND v(dout0_25) AT=1270.05n

.meas tran vdout0_26ck1260 FIND v(dout0_26) AT=1270.05n

.meas tran vdout0_27ck1260 FIND v(dout0_27) AT=1270.05n

.meas tran vdout0_28ck1260 FIND v(dout0_28) AT=1270.05n

.meas tran vdout0_29ck1260 FIND v(dout0_29) AT=1270.05n

.meas tran vdout0_30ck1260 FIND v(dout0_30) AT=1270.05n

.meas tran vdout0_31ck1260 FIND v(dout0_31) AT=1270.05n

.meas tran vdout0_32ck1260 FIND v(dout0_32) AT=1270.05n

.meas tran vdout0_33ck1260 FIND v(dout0_33) AT=1270.05n

.meas tran vdout0_34ck1260 FIND v(dout0_34) AT=1270.05n

.meas tran vdout0_35ck1260 FIND v(dout0_35) AT=1270.05n

.meas tran vdout0_36ck1260 FIND v(dout0_36) AT=1270.05n

.meas tran vdout0_37ck1260 FIND v(dout0_37) AT=1270.05n

.meas tran vdout0_38ck1260 FIND v(dout0_38) AT=1270.05n

.meas tran vdout0_39ck1260 FIND v(dout0_39) AT=1270.05n

.meas tran vdout0_40ck1260 FIND v(dout0_40) AT=1270.05n

.meas tran vdout0_41ck1260 FIND v(dout0_41) AT=1270.05n

.meas tran vdout0_42ck1260 FIND v(dout0_42) AT=1270.05n

.meas tran vdout0_43ck1260 FIND v(dout0_43) AT=1270.05n

.meas tran vdout0_44ck1260 FIND v(dout0_44) AT=1270.05n

.meas tran vdout0_45ck1260 FIND v(dout0_45) AT=1270.05n

.meas tran vdout0_46ck1260 FIND v(dout0_46) AT=1270.05n

.meas tran vdout0_47ck1260 FIND v(dout0_47) AT=1270.05n

.meas tran vdout0_48ck1260 FIND v(dout0_48) AT=1270.05n

.meas tran vdout0_49ck1260 FIND v(dout0_49) AT=1270.05n

.meas tran vdout0_50ck1260 FIND v(dout0_50) AT=1270.05n

.meas tran vdout0_51ck1260 FIND v(dout0_51) AT=1270.05n

.meas tran vdout0_52ck1260 FIND v(dout0_52) AT=1270.05n

.meas tran vdout0_53ck1260 FIND v(dout0_53) AT=1270.05n

.meas tran vdout0_54ck1260 FIND v(dout0_54) AT=1270.05n

.meas tran vdout0_55ck1260 FIND v(dout0_55) AT=1270.05n

.meas tran vdout0_56ck1260 FIND v(dout0_56) AT=1270.05n

.meas tran vdout0_57ck1260 FIND v(dout0_57) AT=1270.05n

.meas tran vdout0_58ck1260 FIND v(dout0_58) AT=1270.05n

.meas tran vdout0_59ck1260 FIND v(dout0_59) AT=1270.05n

.meas tran vdout0_60ck1260 FIND v(dout0_60) AT=1270.05n

.meas tran vdout0_61ck1260 FIND v(dout0_61) AT=1270.05n

.meas tran vdout0_62ck1260 FIND v(dout0_62) AT=1270.05n

.meas tran vdout0_63ck1260 FIND v(dout0_63) AT=1270.05n

.meas tran vdout1_0ck1260 FIND v(dout1_0) AT=1270.05n

.meas tran vdout1_1ck1260 FIND v(dout1_1) AT=1270.05n

.meas tran vdout1_2ck1260 FIND v(dout1_2) AT=1270.05n

.meas tran vdout1_3ck1260 FIND v(dout1_3) AT=1270.05n

.meas tran vdout1_4ck1260 FIND v(dout1_4) AT=1270.05n

.meas tran vdout1_5ck1260 FIND v(dout1_5) AT=1270.05n

.meas tran vdout1_6ck1260 FIND v(dout1_6) AT=1270.05n

.meas tran vdout1_7ck1260 FIND v(dout1_7) AT=1270.05n

.meas tran vdout1_8ck1260 FIND v(dout1_8) AT=1270.05n

.meas tran vdout1_9ck1260 FIND v(dout1_9) AT=1270.05n

.meas tran vdout1_10ck1260 FIND v(dout1_10) AT=1270.05n

.meas tran vdout1_11ck1260 FIND v(dout1_11) AT=1270.05n

.meas tran vdout1_12ck1260 FIND v(dout1_12) AT=1270.05n

.meas tran vdout1_13ck1260 FIND v(dout1_13) AT=1270.05n

.meas tran vdout1_14ck1260 FIND v(dout1_14) AT=1270.05n

.meas tran vdout1_15ck1260 FIND v(dout1_15) AT=1270.05n

.meas tran vdout1_16ck1260 FIND v(dout1_16) AT=1270.05n

.meas tran vdout1_17ck1260 FIND v(dout1_17) AT=1270.05n

.meas tran vdout1_18ck1260 FIND v(dout1_18) AT=1270.05n

.meas tran vdout1_19ck1260 FIND v(dout1_19) AT=1270.05n

.meas tran vdout1_20ck1260 FIND v(dout1_20) AT=1270.05n

.meas tran vdout1_21ck1260 FIND v(dout1_21) AT=1270.05n

.meas tran vdout1_22ck1260 FIND v(dout1_22) AT=1270.05n

.meas tran vdout1_23ck1260 FIND v(dout1_23) AT=1270.05n

.meas tran vdout1_24ck1260 FIND v(dout1_24) AT=1270.05n

.meas tran vdout1_25ck1260 FIND v(dout1_25) AT=1270.05n

.meas tran vdout1_26ck1260 FIND v(dout1_26) AT=1270.05n

.meas tran vdout1_27ck1260 FIND v(dout1_27) AT=1270.05n

.meas tran vdout1_28ck1260 FIND v(dout1_28) AT=1270.05n

.meas tran vdout1_29ck1260 FIND v(dout1_29) AT=1270.05n

.meas tran vdout1_30ck1260 FIND v(dout1_30) AT=1270.05n

.meas tran vdout1_31ck1260 FIND v(dout1_31) AT=1270.05n

.meas tran vdout1_32ck1260 FIND v(dout1_32) AT=1270.05n

.meas tran vdout1_33ck1260 FIND v(dout1_33) AT=1270.05n

.meas tran vdout1_34ck1260 FIND v(dout1_34) AT=1270.05n

.meas tran vdout1_35ck1260 FIND v(dout1_35) AT=1270.05n

.meas tran vdout1_36ck1260 FIND v(dout1_36) AT=1270.05n

.meas tran vdout1_37ck1260 FIND v(dout1_37) AT=1270.05n

.meas tran vdout1_38ck1260 FIND v(dout1_38) AT=1270.05n

.meas tran vdout1_39ck1260 FIND v(dout1_39) AT=1270.05n

.meas tran vdout1_40ck1260 FIND v(dout1_40) AT=1270.05n

.meas tran vdout1_41ck1260 FIND v(dout1_41) AT=1270.05n

.meas tran vdout1_42ck1260 FIND v(dout1_42) AT=1270.05n

.meas tran vdout1_43ck1260 FIND v(dout1_43) AT=1270.05n

.meas tran vdout1_44ck1260 FIND v(dout1_44) AT=1270.05n

.meas tran vdout1_45ck1260 FIND v(dout1_45) AT=1270.05n

.meas tran vdout1_46ck1260 FIND v(dout1_46) AT=1270.05n

.meas tran vdout1_47ck1260 FIND v(dout1_47) AT=1270.05n

.meas tran vdout1_48ck1260 FIND v(dout1_48) AT=1270.05n

.meas tran vdout1_49ck1260 FIND v(dout1_49) AT=1270.05n

.meas tran vdout1_50ck1260 FIND v(dout1_50) AT=1270.05n

.meas tran vdout1_51ck1260 FIND v(dout1_51) AT=1270.05n

.meas tran vdout1_52ck1260 FIND v(dout1_52) AT=1270.05n

.meas tran vdout1_53ck1260 FIND v(dout1_53) AT=1270.05n

.meas tran vdout1_54ck1260 FIND v(dout1_54) AT=1270.05n

.meas tran vdout1_55ck1260 FIND v(dout1_55) AT=1270.05n

.meas tran vdout1_56ck1260 FIND v(dout1_56) AT=1270.05n

.meas tran vdout1_57ck1260 FIND v(dout1_57) AT=1270.05n

.meas tran vdout1_58ck1260 FIND v(dout1_58) AT=1270.05n

.meas tran vdout1_59ck1260 FIND v(dout1_59) AT=1270.05n

.meas tran vdout1_60ck1260 FIND v(dout1_60) AT=1270.05n

.meas tran vdout1_61ck1260 FIND v(dout1_61) AT=1270.05n

.meas tran vdout1_62ck1260 FIND v(dout1_62) AT=1270.05n

.meas tran vdout1_63ck1260 FIND v(dout1_63) AT=1270.05n

.meas tran vdout0_0ck1270 FIND v(dout0_0) AT=1280.05n

.meas tran vdout0_1ck1270 FIND v(dout0_1) AT=1280.05n

.meas tran vdout0_2ck1270 FIND v(dout0_2) AT=1280.05n

.meas tran vdout0_3ck1270 FIND v(dout0_3) AT=1280.05n

.meas tran vdout0_4ck1270 FIND v(dout0_4) AT=1280.05n

.meas tran vdout0_5ck1270 FIND v(dout0_5) AT=1280.05n

.meas tran vdout0_6ck1270 FIND v(dout0_6) AT=1280.05n

.meas tran vdout0_7ck1270 FIND v(dout0_7) AT=1280.05n

.meas tran vdout0_8ck1270 FIND v(dout0_8) AT=1280.05n

.meas tran vdout0_9ck1270 FIND v(dout0_9) AT=1280.05n

.meas tran vdout0_10ck1270 FIND v(dout0_10) AT=1280.05n

.meas tran vdout0_11ck1270 FIND v(dout0_11) AT=1280.05n

.meas tran vdout0_12ck1270 FIND v(dout0_12) AT=1280.05n

.meas tran vdout0_13ck1270 FIND v(dout0_13) AT=1280.05n

.meas tran vdout0_14ck1270 FIND v(dout0_14) AT=1280.05n

.meas tran vdout0_15ck1270 FIND v(dout0_15) AT=1280.05n

.meas tran vdout0_16ck1270 FIND v(dout0_16) AT=1280.05n

.meas tran vdout0_17ck1270 FIND v(dout0_17) AT=1280.05n

.meas tran vdout0_18ck1270 FIND v(dout0_18) AT=1280.05n

.meas tran vdout0_19ck1270 FIND v(dout0_19) AT=1280.05n

.meas tran vdout0_20ck1270 FIND v(dout0_20) AT=1280.05n

.meas tran vdout0_21ck1270 FIND v(dout0_21) AT=1280.05n

.meas tran vdout0_22ck1270 FIND v(dout0_22) AT=1280.05n

.meas tran vdout0_23ck1270 FIND v(dout0_23) AT=1280.05n

.meas tran vdout0_24ck1270 FIND v(dout0_24) AT=1280.05n

.meas tran vdout0_25ck1270 FIND v(dout0_25) AT=1280.05n

.meas tran vdout0_26ck1270 FIND v(dout0_26) AT=1280.05n

.meas tran vdout0_27ck1270 FIND v(dout0_27) AT=1280.05n

.meas tran vdout0_28ck1270 FIND v(dout0_28) AT=1280.05n

.meas tran vdout0_29ck1270 FIND v(dout0_29) AT=1280.05n

.meas tran vdout0_30ck1270 FIND v(dout0_30) AT=1280.05n

.meas tran vdout0_31ck1270 FIND v(dout0_31) AT=1280.05n

.meas tran vdout0_32ck1270 FIND v(dout0_32) AT=1280.05n

.meas tran vdout0_33ck1270 FIND v(dout0_33) AT=1280.05n

.meas tran vdout0_34ck1270 FIND v(dout0_34) AT=1280.05n

.meas tran vdout0_35ck1270 FIND v(dout0_35) AT=1280.05n

.meas tran vdout0_36ck1270 FIND v(dout0_36) AT=1280.05n

.meas tran vdout0_37ck1270 FIND v(dout0_37) AT=1280.05n

.meas tran vdout0_38ck1270 FIND v(dout0_38) AT=1280.05n

.meas tran vdout0_39ck1270 FIND v(dout0_39) AT=1280.05n

.meas tran vdout0_40ck1270 FIND v(dout0_40) AT=1280.05n

.meas tran vdout0_41ck1270 FIND v(dout0_41) AT=1280.05n

.meas tran vdout0_42ck1270 FIND v(dout0_42) AT=1280.05n

.meas tran vdout0_43ck1270 FIND v(dout0_43) AT=1280.05n

.meas tran vdout0_44ck1270 FIND v(dout0_44) AT=1280.05n

.meas tran vdout0_45ck1270 FIND v(dout0_45) AT=1280.05n

.meas tran vdout0_46ck1270 FIND v(dout0_46) AT=1280.05n

.meas tran vdout0_47ck1270 FIND v(dout0_47) AT=1280.05n

.meas tran vdout0_48ck1270 FIND v(dout0_48) AT=1280.05n

.meas tran vdout0_49ck1270 FIND v(dout0_49) AT=1280.05n

.meas tran vdout0_50ck1270 FIND v(dout0_50) AT=1280.05n

.meas tran vdout0_51ck1270 FIND v(dout0_51) AT=1280.05n

.meas tran vdout0_52ck1270 FIND v(dout0_52) AT=1280.05n

.meas tran vdout0_53ck1270 FIND v(dout0_53) AT=1280.05n

.meas tran vdout0_54ck1270 FIND v(dout0_54) AT=1280.05n

.meas tran vdout0_55ck1270 FIND v(dout0_55) AT=1280.05n

.meas tran vdout0_56ck1270 FIND v(dout0_56) AT=1280.05n

.meas tran vdout0_57ck1270 FIND v(dout0_57) AT=1280.05n

.meas tran vdout0_58ck1270 FIND v(dout0_58) AT=1280.05n

.meas tran vdout0_59ck1270 FIND v(dout0_59) AT=1280.05n

.meas tran vdout0_60ck1270 FIND v(dout0_60) AT=1280.05n

.meas tran vdout0_61ck1270 FIND v(dout0_61) AT=1280.05n

.meas tran vdout0_62ck1270 FIND v(dout0_62) AT=1280.05n

.meas tran vdout0_63ck1270 FIND v(dout0_63) AT=1280.05n

.meas tran vdout0_0ck1280 FIND v(dout0_0) AT=1290.05n

.meas tran vdout0_1ck1280 FIND v(dout0_1) AT=1290.05n

.meas tran vdout0_2ck1280 FIND v(dout0_2) AT=1290.05n

.meas tran vdout0_3ck1280 FIND v(dout0_3) AT=1290.05n

.meas tran vdout0_4ck1280 FIND v(dout0_4) AT=1290.05n

.meas tran vdout0_5ck1280 FIND v(dout0_5) AT=1290.05n

.meas tran vdout0_6ck1280 FIND v(dout0_6) AT=1290.05n

.meas tran vdout0_7ck1280 FIND v(dout0_7) AT=1290.05n

.meas tran vdout0_8ck1280 FIND v(dout0_8) AT=1290.05n

.meas tran vdout0_9ck1280 FIND v(dout0_9) AT=1290.05n

.meas tran vdout0_10ck1280 FIND v(dout0_10) AT=1290.05n

.meas tran vdout0_11ck1280 FIND v(dout0_11) AT=1290.05n

.meas tran vdout0_12ck1280 FIND v(dout0_12) AT=1290.05n

.meas tran vdout0_13ck1280 FIND v(dout0_13) AT=1290.05n

.meas tran vdout0_14ck1280 FIND v(dout0_14) AT=1290.05n

.meas tran vdout0_15ck1280 FIND v(dout0_15) AT=1290.05n

.meas tran vdout0_16ck1280 FIND v(dout0_16) AT=1290.05n

.meas tran vdout0_17ck1280 FIND v(dout0_17) AT=1290.05n

.meas tran vdout0_18ck1280 FIND v(dout0_18) AT=1290.05n

.meas tran vdout0_19ck1280 FIND v(dout0_19) AT=1290.05n

.meas tran vdout0_20ck1280 FIND v(dout0_20) AT=1290.05n

.meas tran vdout0_21ck1280 FIND v(dout0_21) AT=1290.05n

.meas tran vdout0_22ck1280 FIND v(dout0_22) AT=1290.05n

.meas tran vdout0_23ck1280 FIND v(dout0_23) AT=1290.05n

.meas tran vdout0_24ck1280 FIND v(dout0_24) AT=1290.05n

.meas tran vdout0_25ck1280 FIND v(dout0_25) AT=1290.05n

.meas tran vdout0_26ck1280 FIND v(dout0_26) AT=1290.05n

.meas tran vdout0_27ck1280 FIND v(dout0_27) AT=1290.05n

.meas tran vdout0_28ck1280 FIND v(dout0_28) AT=1290.05n

.meas tran vdout0_29ck1280 FIND v(dout0_29) AT=1290.05n

.meas tran vdout0_30ck1280 FIND v(dout0_30) AT=1290.05n

.meas tran vdout0_31ck1280 FIND v(dout0_31) AT=1290.05n

.meas tran vdout0_32ck1280 FIND v(dout0_32) AT=1290.05n

.meas tran vdout0_33ck1280 FIND v(dout0_33) AT=1290.05n

.meas tran vdout0_34ck1280 FIND v(dout0_34) AT=1290.05n

.meas tran vdout0_35ck1280 FIND v(dout0_35) AT=1290.05n

.meas tran vdout0_36ck1280 FIND v(dout0_36) AT=1290.05n

.meas tran vdout0_37ck1280 FIND v(dout0_37) AT=1290.05n

.meas tran vdout0_38ck1280 FIND v(dout0_38) AT=1290.05n

.meas tran vdout0_39ck1280 FIND v(dout0_39) AT=1290.05n

.meas tran vdout0_40ck1280 FIND v(dout0_40) AT=1290.05n

.meas tran vdout0_41ck1280 FIND v(dout0_41) AT=1290.05n

.meas tran vdout0_42ck1280 FIND v(dout0_42) AT=1290.05n

.meas tran vdout0_43ck1280 FIND v(dout0_43) AT=1290.05n

.meas tran vdout0_44ck1280 FIND v(dout0_44) AT=1290.05n

.meas tran vdout0_45ck1280 FIND v(dout0_45) AT=1290.05n

.meas tran vdout0_46ck1280 FIND v(dout0_46) AT=1290.05n

.meas tran vdout0_47ck1280 FIND v(dout0_47) AT=1290.05n

.meas tran vdout0_48ck1280 FIND v(dout0_48) AT=1290.05n

.meas tran vdout0_49ck1280 FIND v(dout0_49) AT=1290.05n

.meas tran vdout0_50ck1280 FIND v(dout0_50) AT=1290.05n

.meas tran vdout0_51ck1280 FIND v(dout0_51) AT=1290.05n

.meas tran vdout0_52ck1280 FIND v(dout0_52) AT=1290.05n

.meas tran vdout0_53ck1280 FIND v(dout0_53) AT=1290.05n

.meas tran vdout0_54ck1280 FIND v(dout0_54) AT=1290.05n

.meas tran vdout0_55ck1280 FIND v(dout0_55) AT=1290.05n

.meas tran vdout0_56ck1280 FIND v(dout0_56) AT=1290.05n

.meas tran vdout0_57ck1280 FIND v(dout0_57) AT=1290.05n

.meas tran vdout0_58ck1280 FIND v(dout0_58) AT=1290.05n

.meas tran vdout0_59ck1280 FIND v(dout0_59) AT=1290.05n

.meas tran vdout0_60ck1280 FIND v(dout0_60) AT=1290.05n

.meas tran vdout0_61ck1280 FIND v(dout0_61) AT=1290.05n

.meas tran vdout0_62ck1280 FIND v(dout0_62) AT=1290.05n

.meas tran vdout0_63ck1280 FIND v(dout0_63) AT=1290.05n

.meas tran vdout1_0ck1280 FIND v(dout1_0) AT=1290.05n

.meas tran vdout1_1ck1280 FIND v(dout1_1) AT=1290.05n

.meas tran vdout1_2ck1280 FIND v(dout1_2) AT=1290.05n

.meas tran vdout1_3ck1280 FIND v(dout1_3) AT=1290.05n

.meas tran vdout1_4ck1280 FIND v(dout1_4) AT=1290.05n

.meas tran vdout1_5ck1280 FIND v(dout1_5) AT=1290.05n

.meas tran vdout1_6ck1280 FIND v(dout1_6) AT=1290.05n

.meas tran vdout1_7ck1280 FIND v(dout1_7) AT=1290.05n

.meas tran vdout1_8ck1280 FIND v(dout1_8) AT=1290.05n

.meas tran vdout1_9ck1280 FIND v(dout1_9) AT=1290.05n

.meas tran vdout1_10ck1280 FIND v(dout1_10) AT=1290.05n

.meas tran vdout1_11ck1280 FIND v(dout1_11) AT=1290.05n

.meas tran vdout1_12ck1280 FIND v(dout1_12) AT=1290.05n

.meas tran vdout1_13ck1280 FIND v(dout1_13) AT=1290.05n

.meas tran vdout1_14ck1280 FIND v(dout1_14) AT=1290.05n

.meas tran vdout1_15ck1280 FIND v(dout1_15) AT=1290.05n

.meas tran vdout1_16ck1280 FIND v(dout1_16) AT=1290.05n

.meas tran vdout1_17ck1280 FIND v(dout1_17) AT=1290.05n

.meas tran vdout1_18ck1280 FIND v(dout1_18) AT=1290.05n

.meas tran vdout1_19ck1280 FIND v(dout1_19) AT=1290.05n

.meas tran vdout1_20ck1280 FIND v(dout1_20) AT=1290.05n

.meas tran vdout1_21ck1280 FIND v(dout1_21) AT=1290.05n

.meas tran vdout1_22ck1280 FIND v(dout1_22) AT=1290.05n

.meas tran vdout1_23ck1280 FIND v(dout1_23) AT=1290.05n

.meas tran vdout1_24ck1280 FIND v(dout1_24) AT=1290.05n

.meas tran vdout1_25ck1280 FIND v(dout1_25) AT=1290.05n

.meas tran vdout1_26ck1280 FIND v(dout1_26) AT=1290.05n

.meas tran vdout1_27ck1280 FIND v(dout1_27) AT=1290.05n

.meas tran vdout1_28ck1280 FIND v(dout1_28) AT=1290.05n

.meas tran vdout1_29ck1280 FIND v(dout1_29) AT=1290.05n

.meas tran vdout1_30ck1280 FIND v(dout1_30) AT=1290.05n

.meas tran vdout1_31ck1280 FIND v(dout1_31) AT=1290.05n

.meas tran vdout1_32ck1280 FIND v(dout1_32) AT=1290.05n

.meas tran vdout1_33ck1280 FIND v(dout1_33) AT=1290.05n

.meas tran vdout1_34ck1280 FIND v(dout1_34) AT=1290.05n

.meas tran vdout1_35ck1280 FIND v(dout1_35) AT=1290.05n

.meas tran vdout1_36ck1280 FIND v(dout1_36) AT=1290.05n

.meas tran vdout1_37ck1280 FIND v(dout1_37) AT=1290.05n

.meas tran vdout1_38ck1280 FIND v(dout1_38) AT=1290.05n

.meas tran vdout1_39ck1280 FIND v(dout1_39) AT=1290.05n

.meas tran vdout1_40ck1280 FIND v(dout1_40) AT=1290.05n

.meas tran vdout1_41ck1280 FIND v(dout1_41) AT=1290.05n

.meas tran vdout1_42ck1280 FIND v(dout1_42) AT=1290.05n

.meas tran vdout1_43ck1280 FIND v(dout1_43) AT=1290.05n

.meas tran vdout1_44ck1280 FIND v(dout1_44) AT=1290.05n

.meas tran vdout1_45ck1280 FIND v(dout1_45) AT=1290.05n

.meas tran vdout1_46ck1280 FIND v(dout1_46) AT=1290.05n

.meas tran vdout1_47ck1280 FIND v(dout1_47) AT=1290.05n

.meas tran vdout1_48ck1280 FIND v(dout1_48) AT=1290.05n

.meas tran vdout1_49ck1280 FIND v(dout1_49) AT=1290.05n

.meas tran vdout1_50ck1280 FIND v(dout1_50) AT=1290.05n

.meas tran vdout1_51ck1280 FIND v(dout1_51) AT=1290.05n

.meas tran vdout1_52ck1280 FIND v(dout1_52) AT=1290.05n

.meas tran vdout1_53ck1280 FIND v(dout1_53) AT=1290.05n

.meas tran vdout1_54ck1280 FIND v(dout1_54) AT=1290.05n

.meas tran vdout1_55ck1280 FIND v(dout1_55) AT=1290.05n

.meas tran vdout1_56ck1280 FIND v(dout1_56) AT=1290.05n

.meas tran vdout1_57ck1280 FIND v(dout1_57) AT=1290.05n

.meas tran vdout1_58ck1280 FIND v(dout1_58) AT=1290.05n

.meas tran vdout1_59ck1280 FIND v(dout1_59) AT=1290.05n

.meas tran vdout1_60ck1280 FIND v(dout1_60) AT=1290.05n

.meas tran vdout1_61ck1280 FIND v(dout1_61) AT=1290.05n

.meas tran vdout1_62ck1280 FIND v(dout1_62) AT=1290.05n

.meas tran vdout1_63ck1280 FIND v(dout1_63) AT=1290.05n

.meas tran vdout1_0ck1290 FIND v(dout1_0) AT=1300.05n

.meas tran vdout1_1ck1290 FIND v(dout1_1) AT=1300.05n

.meas tran vdout1_2ck1290 FIND v(dout1_2) AT=1300.05n

.meas tran vdout1_3ck1290 FIND v(dout1_3) AT=1300.05n

.meas tran vdout1_4ck1290 FIND v(dout1_4) AT=1300.05n

.meas tran vdout1_5ck1290 FIND v(dout1_5) AT=1300.05n

.meas tran vdout1_6ck1290 FIND v(dout1_6) AT=1300.05n

.meas tran vdout1_7ck1290 FIND v(dout1_7) AT=1300.05n

.meas tran vdout1_8ck1290 FIND v(dout1_8) AT=1300.05n

.meas tran vdout1_9ck1290 FIND v(dout1_9) AT=1300.05n

.meas tran vdout1_10ck1290 FIND v(dout1_10) AT=1300.05n

.meas tran vdout1_11ck1290 FIND v(dout1_11) AT=1300.05n

.meas tran vdout1_12ck1290 FIND v(dout1_12) AT=1300.05n

.meas tran vdout1_13ck1290 FIND v(dout1_13) AT=1300.05n

.meas tran vdout1_14ck1290 FIND v(dout1_14) AT=1300.05n

.meas tran vdout1_15ck1290 FIND v(dout1_15) AT=1300.05n

.meas tran vdout1_16ck1290 FIND v(dout1_16) AT=1300.05n

.meas tran vdout1_17ck1290 FIND v(dout1_17) AT=1300.05n

.meas tran vdout1_18ck1290 FIND v(dout1_18) AT=1300.05n

.meas tran vdout1_19ck1290 FIND v(dout1_19) AT=1300.05n

.meas tran vdout1_20ck1290 FIND v(dout1_20) AT=1300.05n

.meas tran vdout1_21ck1290 FIND v(dout1_21) AT=1300.05n

.meas tran vdout1_22ck1290 FIND v(dout1_22) AT=1300.05n

.meas tran vdout1_23ck1290 FIND v(dout1_23) AT=1300.05n

.meas tran vdout1_24ck1290 FIND v(dout1_24) AT=1300.05n

.meas tran vdout1_25ck1290 FIND v(dout1_25) AT=1300.05n

.meas tran vdout1_26ck1290 FIND v(dout1_26) AT=1300.05n

.meas tran vdout1_27ck1290 FIND v(dout1_27) AT=1300.05n

.meas tran vdout1_28ck1290 FIND v(dout1_28) AT=1300.05n

.meas tran vdout1_29ck1290 FIND v(dout1_29) AT=1300.05n

.meas tran vdout1_30ck1290 FIND v(dout1_30) AT=1300.05n

.meas tran vdout1_31ck1290 FIND v(dout1_31) AT=1300.05n

.meas tran vdout1_32ck1290 FIND v(dout1_32) AT=1300.05n

.meas tran vdout1_33ck1290 FIND v(dout1_33) AT=1300.05n

.meas tran vdout1_34ck1290 FIND v(dout1_34) AT=1300.05n

.meas tran vdout1_35ck1290 FIND v(dout1_35) AT=1300.05n

.meas tran vdout1_36ck1290 FIND v(dout1_36) AT=1300.05n

.meas tran vdout1_37ck1290 FIND v(dout1_37) AT=1300.05n

.meas tran vdout1_38ck1290 FIND v(dout1_38) AT=1300.05n

.meas tran vdout1_39ck1290 FIND v(dout1_39) AT=1300.05n

.meas tran vdout1_40ck1290 FIND v(dout1_40) AT=1300.05n

.meas tran vdout1_41ck1290 FIND v(dout1_41) AT=1300.05n

.meas tran vdout1_42ck1290 FIND v(dout1_42) AT=1300.05n

.meas tran vdout1_43ck1290 FIND v(dout1_43) AT=1300.05n

.meas tran vdout1_44ck1290 FIND v(dout1_44) AT=1300.05n

.meas tran vdout1_45ck1290 FIND v(dout1_45) AT=1300.05n

.meas tran vdout1_46ck1290 FIND v(dout1_46) AT=1300.05n

.meas tran vdout1_47ck1290 FIND v(dout1_47) AT=1300.05n

.meas tran vdout1_48ck1290 FIND v(dout1_48) AT=1300.05n

.meas tran vdout1_49ck1290 FIND v(dout1_49) AT=1300.05n

.meas tran vdout1_50ck1290 FIND v(dout1_50) AT=1300.05n

.meas tran vdout1_51ck1290 FIND v(dout1_51) AT=1300.05n

.meas tran vdout1_52ck1290 FIND v(dout1_52) AT=1300.05n

.meas tran vdout1_53ck1290 FIND v(dout1_53) AT=1300.05n

.meas tran vdout1_54ck1290 FIND v(dout1_54) AT=1300.05n

.meas tran vdout1_55ck1290 FIND v(dout1_55) AT=1300.05n

.meas tran vdout1_56ck1290 FIND v(dout1_56) AT=1300.05n

.meas tran vdout1_57ck1290 FIND v(dout1_57) AT=1300.05n

.meas tran vdout1_58ck1290 FIND v(dout1_58) AT=1300.05n

.meas tran vdout1_59ck1290 FIND v(dout1_59) AT=1300.05n

.meas tran vdout1_60ck1290 FIND v(dout1_60) AT=1300.05n

.meas tran vdout1_61ck1290 FIND v(dout1_61) AT=1300.05n

.meas tran vdout1_62ck1290 FIND v(dout1_62) AT=1300.05n

.meas tran vdout1_63ck1290 FIND v(dout1_63) AT=1300.05n

.meas tran vdout0_0ck1320 FIND v(dout0_0) AT=1330.05n

.meas tran vdout0_1ck1320 FIND v(dout0_1) AT=1330.05n

.meas tran vdout0_2ck1320 FIND v(dout0_2) AT=1330.05n

.meas tran vdout0_3ck1320 FIND v(dout0_3) AT=1330.05n

.meas tran vdout0_4ck1320 FIND v(dout0_4) AT=1330.05n

.meas tran vdout0_5ck1320 FIND v(dout0_5) AT=1330.05n

.meas tran vdout0_6ck1320 FIND v(dout0_6) AT=1330.05n

.meas tran vdout0_7ck1320 FIND v(dout0_7) AT=1330.05n

.meas tran vdout0_8ck1320 FIND v(dout0_8) AT=1330.05n

.meas tran vdout0_9ck1320 FIND v(dout0_9) AT=1330.05n

.meas tran vdout0_10ck1320 FIND v(dout0_10) AT=1330.05n

.meas tran vdout0_11ck1320 FIND v(dout0_11) AT=1330.05n

.meas tran vdout0_12ck1320 FIND v(dout0_12) AT=1330.05n

.meas tran vdout0_13ck1320 FIND v(dout0_13) AT=1330.05n

.meas tran vdout0_14ck1320 FIND v(dout0_14) AT=1330.05n

.meas tran vdout0_15ck1320 FIND v(dout0_15) AT=1330.05n

.meas tran vdout0_16ck1320 FIND v(dout0_16) AT=1330.05n

.meas tran vdout0_17ck1320 FIND v(dout0_17) AT=1330.05n

.meas tran vdout0_18ck1320 FIND v(dout0_18) AT=1330.05n

.meas tran vdout0_19ck1320 FIND v(dout0_19) AT=1330.05n

.meas tran vdout0_20ck1320 FIND v(dout0_20) AT=1330.05n

.meas tran vdout0_21ck1320 FIND v(dout0_21) AT=1330.05n

.meas tran vdout0_22ck1320 FIND v(dout0_22) AT=1330.05n

.meas tran vdout0_23ck1320 FIND v(dout0_23) AT=1330.05n

.meas tran vdout0_24ck1320 FIND v(dout0_24) AT=1330.05n

.meas tran vdout0_25ck1320 FIND v(dout0_25) AT=1330.05n

.meas tran vdout0_26ck1320 FIND v(dout0_26) AT=1330.05n

.meas tran vdout0_27ck1320 FIND v(dout0_27) AT=1330.05n

.meas tran vdout0_28ck1320 FIND v(dout0_28) AT=1330.05n

.meas tran vdout0_29ck1320 FIND v(dout0_29) AT=1330.05n

.meas tran vdout0_30ck1320 FIND v(dout0_30) AT=1330.05n

.meas tran vdout0_31ck1320 FIND v(dout0_31) AT=1330.05n

.meas tran vdout0_32ck1320 FIND v(dout0_32) AT=1330.05n

.meas tran vdout0_33ck1320 FIND v(dout0_33) AT=1330.05n

.meas tran vdout0_34ck1320 FIND v(dout0_34) AT=1330.05n

.meas tran vdout0_35ck1320 FIND v(dout0_35) AT=1330.05n

.meas tran vdout0_36ck1320 FIND v(dout0_36) AT=1330.05n

.meas tran vdout0_37ck1320 FIND v(dout0_37) AT=1330.05n

.meas tran vdout0_38ck1320 FIND v(dout0_38) AT=1330.05n

.meas tran vdout0_39ck1320 FIND v(dout0_39) AT=1330.05n

.meas tran vdout0_40ck1320 FIND v(dout0_40) AT=1330.05n

.meas tran vdout0_41ck1320 FIND v(dout0_41) AT=1330.05n

.meas tran vdout0_42ck1320 FIND v(dout0_42) AT=1330.05n

.meas tran vdout0_43ck1320 FIND v(dout0_43) AT=1330.05n

.meas tran vdout0_44ck1320 FIND v(dout0_44) AT=1330.05n

.meas tran vdout0_45ck1320 FIND v(dout0_45) AT=1330.05n

.meas tran vdout0_46ck1320 FIND v(dout0_46) AT=1330.05n

.meas tran vdout0_47ck1320 FIND v(dout0_47) AT=1330.05n

.meas tran vdout0_48ck1320 FIND v(dout0_48) AT=1330.05n

.meas tran vdout0_49ck1320 FIND v(dout0_49) AT=1330.05n

.meas tran vdout0_50ck1320 FIND v(dout0_50) AT=1330.05n

.meas tran vdout0_51ck1320 FIND v(dout0_51) AT=1330.05n

.meas tran vdout0_52ck1320 FIND v(dout0_52) AT=1330.05n

.meas tran vdout0_53ck1320 FIND v(dout0_53) AT=1330.05n

.meas tran vdout0_54ck1320 FIND v(dout0_54) AT=1330.05n

.meas tran vdout0_55ck1320 FIND v(dout0_55) AT=1330.05n

.meas tran vdout0_56ck1320 FIND v(dout0_56) AT=1330.05n

.meas tran vdout0_57ck1320 FIND v(dout0_57) AT=1330.05n

.meas tran vdout0_58ck1320 FIND v(dout0_58) AT=1330.05n

.meas tran vdout0_59ck1320 FIND v(dout0_59) AT=1330.05n

.meas tran vdout0_60ck1320 FIND v(dout0_60) AT=1330.05n

.meas tran vdout0_61ck1320 FIND v(dout0_61) AT=1330.05n

.meas tran vdout0_62ck1320 FIND v(dout0_62) AT=1330.05n

.meas tran vdout0_63ck1320 FIND v(dout0_63) AT=1330.05n

.meas tran vdout0_0ck1350 FIND v(dout0_0) AT=1360.05n

.meas tran vdout0_1ck1350 FIND v(dout0_1) AT=1360.05n

.meas tran vdout0_2ck1350 FIND v(dout0_2) AT=1360.05n

.meas tran vdout0_3ck1350 FIND v(dout0_3) AT=1360.05n

.meas tran vdout0_4ck1350 FIND v(dout0_4) AT=1360.05n

.meas tran vdout0_5ck1350 FIND v(dout0_5) AT=1360.05n

.meas tran vdout0_6ck1350 FIND v(dout0_6) AT=1360.05n

.meas tran vdout0_7ck1350 FIND v(dout0_7) AT=1360.05n

.meas tran vdout0_8ck1350 FIND v(dout0_8) AT=1360.05n

.meas tran vdout0_9ck1350 FIND v(dout0_9) AT=1360.05n

.meas tran vdout0_10ck1350 FIND v(dout0_10) AT=1360.05n

.meas tran vdout0_11ck1350 FIND v(dout0_11) AT=1360.05n

.meas tran vdout0_12ck1350 FIND v(dout0_12) AT=1360.05n

.meas tran vdout0_13ck1350 FIND v(dout0_13) AT=1360.05n

.meas tran vdout0_14ck1350 FIND v(dout0_14) AT=1360.05n

.meas tran vdout0_15ck1350 FIND v(dout0_15) AT=1360.05n

.meas tran vdout0_16ck1350 FIND v(dout0_16) AT=1360.05n

.meas tran vdout0_17ck1350 FIND v(dout0_17) AT=1360.05n

.meas tran vdout0_18ck1350 FIND v(dout0_18) AT=1360.05n

.meas tran vdout0_19ck1350 FIND v(dout0_19) AT=1360.05n

.meas tran vdout0_20ck1350 FIND v(dout0_20) AT=1360.05n

.meas tran vdout0_21ck1350 FIND v(dout0_21) AT=1360.05n

.meas tran vdout0_22ck1350 FIND v(dout0_22) AT=1360.05n

.meas tran vdout0_23ck1350 FIND v(dout0_23) AT=1360.05n

.meas tran vdout0_24ck1350 FIND v(dout0_24) AT=1360.05n

.meas tran vdout0_25ck1350 FIND v(dout0_25) AT=1360.05n

.meas tran vdout0_26ck1350 FIND v(dout0_26) AT=1360.05n

.meas tran vdout0_27ck1350 FIND v(dout0_27) AT=1360.05n

.meas tran vdout0_28ck1350 FIND v(dout0_28) AT=1360.05n

.meas tran vdout0_29ck1350 FIND v(dout0_29) AT=1360.05n

.meas tran vdout0_30ck1350 FIND v(dout0_30) AT=1360.05n

.meas tran vdout0_31ck1350 FIND v(dout0_31) AT=1360.05n

.meas tran vdout0_32ck1350 FIND v(dout0_32) AT=1360.05n

.meas tran vdout0_33ck1350 FIND v(dout0_33) AT=1360.05n

.meas tran vdout0_34ck1350 FIND v(dout0_34) AT=1360.05n

.meas tran vdout0_35ck1350 FIND v(dout0_35) AT=1360.05n

.meas tran vdout0_36ck1350 FIND v(dout0_36) AT=1360.05n

.meas tran vdout0_37ck1350 FIND v(dout0_37) AT=1360.05n

.meas tran vdout0_38ck1350 FIND v(dout0_38) AT=1360.05n

.meas tran vdout0_39ck1350 FIND v(dout0_39) AT=1360.05n

.meas tran vdout0_40ck1350 FIND v(dout0_40) AT=1360.05n

.meas tran vdout0_41ck1350 FIND v(dout0_41) AT=1360.05n

.meas tran vdout0_42ck1350 FIND v(dout0_42) AT=1360.05n

.meas tran vdout0_43ck1350 FIND v(dout0_43) AT=1360.05n

.meas tran vdout0_44ck1350 FIND v(dout0_44) AT=1360.05n

.meas tran vdout0_45ck1350 FIND v(dout0_45) AT=1360.05n

.meas tran vdout0_46ck1350 FIND v(dout0_46) AT=1360.05n

.meas tran vdout0_47ck1350 FIND v(dout0_47) AT=1360.05n

.meas tran vdout0_48ck1350 FIND v(dout0_48) AT=1360.05n

.meas tran vdout0_49ck1350 FIND v(dout0_49) AT=1360.05n

.meas tran vdout0_50ck1350 FIND v(dout0_50) AT=1360.05n

.meas tran vdout0_51ck1350 FIND v(dout0_51) AT=1360.05n

.meas tran vdout0_52ck1350 FIND v(dout0_52) AT=1360.05n

.meas tran vdout0_53ck1350 FIND v(dout0_53) AT=1360.05n

.meas tran vdout0_54ck1350 FIND v(dout0_54) AT=1360.05n

.meas tran vdout0_55ck1350 FIND v(dout0_55) AT=1360.05n

.meas tran vdout0_56ck1350 FIND v(dout0_56) AT=1360.05n

.meas tran vdout0_57ck1350 FIND v(dout0_57) AT=1360.05n

.meas tran vdout0_58ck1350 FIND v(dout0_58) AT=1360.05n

.meas tran vdout0_59ck1350 FIND v(dout0_59) AT=1360.05n

.meas tran vdout0_60ck1350 FIND v(dout0_60) AT=1360.05n

.meas tran vdout0_61ck1350 FIND v(dout0_61) AT=1360.05n

.meas tran vdout0_62ck1350 FIND v(dout0_62) AT=1360.05n

.meas tran vdout0_63ck1350 FIND v(dout0_63) AT=1360.05n

.meas tran vdout1_0ck1350 FIND v(dout1_0) AT=1360.05n

.meas tran vdout1_1ck1350 FIND v(dout1_1) AT=1360.05n

.meas tran vdout1_2ck1350 FIND v(dout1_2) AT=1360.05n

.meas tran vdout1_3ck1350 FIND v(dout1_3) AT=1360.05n

.meas tran vdout1_4ck1350 FIND v(dout1_4) AT=1360.05n

.meas tran vdout1_5ck1350 FIND v(dout1_5) AT=1360.05n

.meas tran vdout1_6ck1350 FIND v(dout1_6) AT=1360.05n

.meas tran vdout1_7ck1350 FIND v(dout1_7) AT=1360.05n

.meas tran vdout1_8ck1350 FIND v(dout1_8) AT=1360.05n

.meas tran vdout1_9ck1350 FIND v(dout1_9) AT=1360.05n

.meas tran vdout1_10ck1350 FIND v(dout1_10) AT=1360.05n

.meas tran vdout1_11ck1350 FIND v(dout1_11) AT=1360.05n

.meas tran vdout1_12ck1350 FIND v(dout1_12) AT=1360.05n

.meas tran vdout1_13ck1350 FIND v(dout1_13) AT=1360.05n

.meas tran vdout1_14ck1350 FIND v(dout1_14) AT=1360.05n

.meas tran vdout1_15ck1350 FIND v(dout1_15) AT=1360.05n

.meas tran vdout1_16ck1350 FIND v(dout1_16) AT=1360.05n

.meas tran vdout1_17ck1350 FIND v(dout1_17) AT=1360.05n

.meas tran vdout1_18ck1350 FIND v(dout1_18) AT=1360.05n

.meas tran vdout1_19ck1350 FIND v(dout1_19) AT=1360.05n

.meas tran vdout1_20ck1350 FIND v(dout1_20) AT=1360.05n

.meas tran vdout1_21ck1350 FIND v(dout1_21) AT=1360.05n

.meas tran vdout1_22ck1350 FIND v(dout1_22) AT=1360.05n

.meas tran vdout1_23ck1350 FIND v(dout1_23) AT=1360.05n

.meas tran vdout1_24ck1350 FIND v(dout1_24) AT=1360.05n

.meas tran vdout1_25ck1350 FIND v(dout1_25) AT=1360.05n

.meas tran vdout1_26ck1350 FIND v(dout1_26) AT=1360.05n

.meas tran vdout1_27ck1350 FIND v(dout1_27) AT=1360.05n

.meas tran vdout1_28ck1350 FIND v(dout1_28) AT=1360.05n

.meas tran vdout1_29ck1350 FIND v(dout1_29) AT=1360.05n

.meas tran vdout1_30ck1350 FIND v(dout1_30) AT=1360.05n

.meas tran vdout1_31ck1350 FIND v(dout1_31) AT=1360.05n

.meas tran vdout1_32ck1350 FIND v(dout1_32) AT=1360.05n

.meas tran vdout1_33ck1350 FIND v(dout1_33) AT=1360.05n

.meas tran vdout1_34ck1350 FIND v(dout1_34) AT=1360.05n

.meas tran vdout1_35ck1350 FIND v(dout1_35) AT=1360.05n

.meas tran vdout1_36ck1350 FIND v(dout1_36) AT=1360.05n

.meas tran vdout1_37ck1350 FIND v(dout1_37) AT=1360.05n

.meas tran vdout1_38ck1350 FIND v(dout1_38) AT=1360.05n

.meas tran vdout1_39ck1350 FIND v(dout1_39) AT=1360.05n

.meas tran vdout1_40ck1350 FIND v(dout1_40) AT=1360.05n

.meas tran vdout1_41ck1350 FIND v(dout1_41) AT=1360.05n

.meas tran vdout1_42ck1350 FIND v(dout1_42) AT=1360.05n

.meas tran vdout1_43ck1350 FIND v(dout1_43) AT=1360.05n

.meas tran vdout1_44ck1350 FIND v(dout1_44) AT=1360.05n

.meas tran vdout1_45ck1350 FIND v(dout1_45) AT=1360.05n

.meas tran vdout1_46ck1350 FIND v(dout1_46) AT=1360.05n

.meas tran vdout1_47ck1350 FIND v(dout1_47) AT=1360.05n

.meas tran vdout1_48ck1350 FIND v(dout1_48) AT=1360.05n

.meas tran vdout1_49ck1350 FIND v(dout1_49) AT=1360.05n

.meas tran vdout1_50ck1350 FIND v(dout1_50) AT=1360.05n

.meas tran vdout1_51ck1350 FIND v(dout1_51) AT=1360.05n

.meas tran vdout1_52ck1350 FIND v(dout1_52) AT=1360.05n

.meas tran vdout1_53ck1350 FIND v(dout1_53) AT=1360.05n

.meas tran vdout1_54ck1350 FIND v(dout1_54) AT=1360.05n

.meas tran vdout1_55ck1350 FIND v(dout1_55) AT=1360.05n

.meas tran vdout1_56ck1350 FIND v(dout1_56) AT=1360.05n

.meas tran vdout1_57ck1350 FIND v(dout1_57) AT=1360.05n

.meas tran vdout1_58ck1350 FIND v(dout1_58) AT=1360.05n

.meas tran vdout1_59ck1350 FIND v(dout1_59) AT=1360.05n

.meas tran vdout1_60ck1350 FIND v(dout1_60) AT=1360.05n

.meas tran vdout1_61ck1350 FIND v(dout1_61) AT=1360.05n

.meas tran vdout1_62ck1350 FIND v(dout1_62) AT=1360.05n

.meas tran vdout1_63ck1350 FIND v(dout1_63) AT=1360.05n

.meas tran vdout0_0ck1370 FIND v(dout0_0) AT=1380.05n

.meas tran vdout0_1ck1370 FIND v(dout0_1) AT=1380.05n

.meas tran vdout0_2ck1370 FIND v(dout0_2) AT=1380.05n

.meas tran vdout0_3ck1370 FIND v(dout0_3) AT=1380.05n

.meas tran vdout0_4ck1370 FIND v(dout0_4) AT=1380.05n

.meas tran vdout0_5ck1370 FIND v(dout0_5) AT=1380.05n

.meas tran vdout0_6ck1370 FIND v(dout0_6) AT=1380.05n

.meas tran vdout0_7ck1370 FIND v(dout0_7) AT=1380.05n

.meas tran vdout0_8ck1370 FIND v(dout0_8) AT=1380.05n

.meas tran vdout0_9ck1370 FIND v(dout0_9) AT=1380.05n

.meas tran vdout0_10ck1370 FIND v(dout0_10) AT=1380.05n

.meas tran vdout0_11ck1370 FIND v(dout0_11) AT=1380.05n

.meas tran vdout0_12ck1370 FIND v(dout0_12) AT=1380.05n

.meas tran vdout0_13ck1370 FIND v(dout0_13) AT=1380.05n

.meas tran vdout0_14ck1370 FIND v(dout0_14) AT=1380.05n

.meas tran vdout0_15ck1370 FIND v(dout0_15) AT=1380.05n

.meas tran vdout0_16ck1370 FIND v(dout0_16) AT=1380.05n

.meas tran vdout0_17ck1370 FIND v(dout0_17) AT=1380.05n

.meas tran vdout0_18ck1370 FIND v(dout0_18) AT=1380.05n

.meas tran vdout0_19ck1370 FIND v(dout0_19) AT=1380.05n

.meas tran vdout0_20ck1370 FIND v(dout0_20) AT=1380.05n

.meas tran vdout0_21ck1370 FIND v(dout0_21) AT=1380.05n

.meas tran vdout0_22ck1370 FIND v(dout0_22) AT=1380.05n

.meas tran vdout0_23ck1370 FIND v(dout0_23) AT=1380.05n

.meas tran vdout0_24ck1370 FIND v(dout0_24) AT=1380.05n

.meas tran vdout0_25ck1370 FIND v(dout0_25) AT=1380.05n

.meas tran vdout0_26ck1370 FIND v(dout0_26) AT=1380.05n

.meas tran vdout0_27ck1370 FIND v(dout0_27) AT=1380.05n

.meas tran vdout0_28ck1370 FIND v(dout0_28) AT=1380.05n

.meas tran vdout0_29ck1370 FIND v(dout0_29) AT=1380.05n

.meas tran vdout0_30ck1370 FIND v(dout0_30) AT=1380.05n

.meas tran vdout0_31ck1370 FIND v(dout0_31) AT=1380.05n

.meas tran vdout0_32ck1370 FIND v(dout0_32) AT=1380.05n

.meas tran vdout0_33ck1370 FIND v(dout0_33) AT=1380.05n

.meas tran vdout0_34ck1370 FIND v(dout0_34) AT=1380.05n

.meas tran vdout0_35ck1370 FIND v(dout0_35) AT=1380.05n

.meas tran vdout0_36ck1370 FIND v(dout0_36) AT=1380.05n

.meas tran vdout0_37ck1370 FIND v(dout0_37) AT=1380.05n

.meas tran vdout0_38ck1370 FIND v(dout0_38) AT=1380.05n

.meas tran vdout0_39ck1370 FIND v(dout0_39) AT=1380.05n

.meas tran vdout0_40ck1370 FIND v(dout0_40) AT=1380.05n

.meas tran vdout0_41ck1370 FIND v(dout0_41) AT=1380.05n

.meas tran vdout0_42ck1370 FIND v(dout0_42) AT=1380.05n

.meas tran vdout0_43ck1370 FIND v(dout0_43) AT=1380.05n

.meas tran vdout0_44ck1370 FIND v(dout0_44) AT=1380.05n

.meas tran vdout0_45ck1370 FIND v(dout0_45) AT=1380.05n

.meas tran vdout0_46ck1370 FIND v(dout0_46) AT=1380.05n

.meas tran vdout0_47ck1370 FIND v(dout0_47) AT=1380.05n

.meas tran vdout0_48ck1370 FIND v(dout0_48) AT=1380.05n

.meas tran vdout0_49ck1370 FIND v(dout0_49) AT=1380.05n

.meas tran vdout0_50ck1370 FIND v(dout0_50) AT=1380.05n

.meas tran vdout0_51ck1370 FIND v(dout0_51) AT=1380.05n

.meas tran vdout0_52ck1370 FIND v(dout0_52) AT=1380.05n

.meas tran vdout0_53ck1370 FIND v(dout0_53) AT=1380.05n

.meas tran vdout0_54ck1370 FIND v(dout0_54) AT=1380.05n

.meas tran vdout0_55ck1370 FIND v(dout0_55) AT=1380.05n

.meas tran vdout0_56ck1370 FIND v(dout0_56) AT=1380.05n

.meas tran vdout0_57ck1370 FIND v(dout0_57) AT=1380.05n

.meas tran vdout0_58ck1370 FIND v(dout0_58) AT=1380.05n

.meas tran vdout0_59ck1370 FIND v(dout0_59) AT=1380.05n

.meas tran vdout0_60ck1370 FIND v(dout0_60) AT=1380.05n

.meas tran vdout0_61ck1370 FIND v(dout0_61) AT=1380.05n

.meas tran vdout0_62ck1370 FIND v(dout0_62) AT=1380.05n

.meas tran vdout0_63ck1370 FIND v(dout0_63) AT=1380.05n

.meas tran vdout1_0ck1370 FIND v(dout1_0) AT=1380.05n

.meas tran vdout1_1ck1370 FIND v(dout1_1) AT=1380.05n

.meas tran vdout1_2ck1370 FIND v(dout1_2) AT=1380.05n

.meas tran vdout1_3ck1370 FIND v(dout1_3) AT=1380.05n

.meas tran vdout1_4ck1370 FIND v(dout1_4) AT=1380.05n

.meas tran vdout1_5ck1370 FIND v(dout1_5) AT=1380.05n

.meas tran vdout1_6ck1370 FIND v(dout1_6) AT=1380.05n

.meas tran vdout1_7ck1370 FIND v(dout1_7) AT=1380.05n

.meas tran vdout1_8ck1370 FIND v(dout1_8) AT=1380.05n

.meas tran vdout1_9ck1370 FIND v(dout1_9) AT=1380.05n

.meas tran vdout1_10ck1370 FIND v(dout1_10) AT=1380.05n

.meas tran vdout1_11ck1370 FIND v(dout1_11) AT=1380.05n

.meas tran vdout1_12ck1370 FIND v(dout1_12) AT=1380.05n

.meas tran vdout1_13ck1370 FIND v(dout1_13) AT=1380.05n

.meas tran vdout1_14ck1370 FIND v(dout1_14) AT=1380.05n

.meas tran vdout1_15ck1370 FIND v(dout1_15) AT=1380.05n

.meas tran vdout1_16ck1370 FIND v(dout1_16) AT=1380.05n

.meas tran vdout1_17ck1370 FIND v(dout1_17) AT=1380.05n

.meas tran vdout1_18ck1370 FIND v(dout1_18) AT=1380.05n

.meas tran vdout1_19ck1370 FIND v(dout1_19) AT=1380.05n

.meas tran vdout1_20ck1370 FIND v(dout1_20) AT=1380.05n

.meas tran vdout1_21ck1370 FIND v(dout1_21) AT=1380.05n

.meas tran vdout1_22ck1370 FIND v(dout1_22) AT=1380.05n

.meas tran vdout1_23ck1370 FIND v(dout1_23) AT=1380.05n

.meas tran vdout1_24ck1370 FIND v(dout1_24) AT=1380.05n

.meas tran vdout1_25ck1370 FIND v(dout1_25) AT=1380.05n

.meas tran vdout1_26ck1370 FIND v(dout1_26) AT=1380.05n

.meas tran vdout1_27ck1370 FIND v(dout1_27) AT=1380.05n

.meas tran vdout1_28ck1370 FIND v(dout1_28) AT=1380.05n

.meas tran vdout1_29ck1370 FIND v(dout1_29) AT=1380.05n

.meas tran vdout1_30ck1370 FIND v(dout1_30) AT=1380.05n

.meas tran vdout1_31ck1370 FIND v(dout1_31) AT=1380.05n

.meas tran vdout1_32ck1370 FIND v(dout1_32) AT=1380.05n

.meas tran vdout1_33ck1370 FIND v(dout1_33) AT=1380.05n

.meas tran vdout1_34ck1370 FIND v(dout1_34) AT=1380.05n

.meas tran vdout1_35ck1370 FIND v(dout1_35) AT=1380.05n

.meas tran vdout1_36ck1370 FIND v(dout1_36) AT=1380.05n

.meas tran vdout1_37ck1370 FIND v(dout1_37) AT=1380.05n

.meas tran vdout1_38ck1370 FIND v(dout1_38) AT=1380.05n

.meas tran vdout1_39ck1370 FIND v(dout1_39) AT=1380.05n

.meas tran vdout1_40ck1370 FIND v(dout1_40) AT=1380.05n

.meas tran vdout1_41ck1370 FIND v(dout1_41) AT=1380.05n

.meas tran vdout1_42ck1370 FIND v(dout1_42) AT=1380.05n

.meas tran vdout1_43ck1370 FIND v(dout1_43) AT=1380.05n

.meas tran vdout1_44ck1370 FIND v(dout1_44) AT=1380.05n

.meas tran vdout1_45ck1370 FIND v(dout1_45) AT=1380.05n

.meas tran vdout1_46ck1370 FIND v(dout1_46) AT=1380.05n

.meas tran vdout1_47ck1370 FIND v(dout1_47) AT=1380.05n

.meas tran vdout1_48ck1370 FIND v(dout1_48) AT=1380.05n

.meas tran vdout1_49ck1370 FIND v(dout1_49) AT=1380.05n

.meas tran vdout1_50ck1370 FIND v(dout1_50) AT=1380.05n

.meas tran vdout1_51ck1370 FIND v(dout1_51) AT=1380.05n

.meas tran vdout1_52ck1370 FIND v(dout1_52) AT=1380.05n

.meas tran vdout1_53ck1370 FIND v(dout1_53) AT=1380.05n

.meas tran vdout1_54ck1370 FIND v(dout1_54) AT=1380.05n

.meas tran vdout1_55ck1370 FIND v(dout1_55) AT=1380.05n

.meas tran vdout1_56ck1370 FIND v(dout1_56) AT=1380.05n

.meas tran vdout1_57ck1370 FIND v(dout1_57) AT=1380.05n

.meas tran vdout1_58ck1370 FIND v(dout1_58) AT=1380.05n

.meas tran vdout1_59ck1370 FIND v(dout1_59) AT=1380.05n

.meas tran vdout1_60ck1370 FIND v(dout1_60) AT=1380.05n

.meas tran vdout1_61ck1370 FIND v(dout1_61) AT=1380.05n

.meas tran vdout1_62ck1370 FIND v(dout1_62) AT=1380.05n

.meas tran vdout1_63ck1370 FIND v(dout1_63) AT=1380.05n

.meas tran vdout1_0ck1400 FIND v(dout1_0) AT=1410.05n

.meas tran vdout1_1ck1400 FIND v(dout1_1) AT=1410.05n

.meas tran vdout1_2ck1400 FIND v(dout1_2) AT=1410.05n

.meas tran vdout1_3ck1400 FIND v(dout1_3) AT=1410.05n

.meas tran vdout1_4ck1400 FIND v(dout1_4) AT=1410.05n

.meas tran vdout1_5ck1400 FIND v(dout1_5) AT=1410.05n

.meas tran vdout1_6ck1400 FIND v(dout1_6) AT=1410.05n

.meas tran vdout1_7ck1400 FIND v(dout1_7) AT=1410.05n

.meas tran vdout1_8ck1400 FIND v(dout1_8) AT=1410.05n

.meas tran vdout1_9ck1400 FIND v(dout1_9) AT=1410.05n

.meas tran vdout1_10ck1400 FIND v(dout1_10) AT=1410.05n

.meas tran vdout1_11ck1400 FIND v(dout1_11) AT=1410.05n

.meas tran vdout1_12ck1400 FIND v(dout1_12) AT=1410.05n

.meas tran vdout1_13ck1400 FIND v(dout1_13) AT=1410.05n

.meas tran vdout1_14ck1400 FIND v(dout1_14) AT=1410.05n

.meas tran vdout1_15ck1400 FIND v(dout1_15) AT=1410.05n

.meas tran vdout1_16ck1400 FIND v(dout1_16) AT=1410.05n

.meas tran vdout1_17ck1400 FIND v(dout1_17) AT=1410.05n

.meas tran vdout1_18ck1400 FIND v(dout1_18) AT=1410.05n

.meas tran vdout1_19ck1400 FIND v(dout1_19) AT=1410.05n

.meas tran vdout1_20ck1400 FIND v(dout1_20) AT=1410.05n

.meas tran vdout1_21ck1400 FIND v(dout1_21) AT=1410.05n

.meas tran vdout1_22ck1400 FIND v(dout1_22) AT=1410.05n

.meas tran vdout1_23ck1400 FIND v(dout1_23) AT=1410.05n

.meas tran vdout1_24ck1400 FIND v(dout1_24) AT=1410.05n

.meas tran vdout1_25ck1400 FIND v(dout1_25) AT=1410.05n

.meas tran vdout1_26ck1400 FIND v(dout1_26) AT=1410.05n

.meas tran vdout1_27ck1400 FIND v(dout1_27) AT=1410.05n

.meas tran vdout1_28ck1400 FIND v(dout1_28) AT=1410.05n

.meas tran vdout1_29ck1400 FIND v(dout1_29) AT=1410.05n

.meas tran vdout1_30ck1400 FIND v(dout1_30) AT=1410.05n

.meas tran vdout1_31ck1400 FIND v(dout1_31) AT=1410.05n

.meas tran vdout1_32ck1400 FIND v(dout1_32) AT=1410.05n

.meas tran vdout1_33ck1400 FIND v(dout1_33) AT=1410.05n

.meas tran vdout1_34ck1400 FIND v(dout1_34) AT=1410.05n

.meas tran vdout1_35ck1400 FIND v(dout1_35) AT=1410.05n

.meas tran vdout1_36ck1400 FIND v(dout1_36) AT=1410.05n

.meas tran vdout1_37ck1400 FIND v(dout1_37) AT=1410.05n

.meas tran vdout1_38ck1400 FIND v(dout1_38) AT=1410.05n

.meas tran vdout1_39ck1400 FIND v(dout1_39) AT=1410.05n

.meas tran vdout1_40ck1400 FIND v(dout1_40) AT=1410.05n

.meas tran vdout1_41ck1400 FIND v(dout1_41) AT=1410.05n

.meas tran vdout1_42ck1400 FIND v(dout1_42) AT=1410.05n

.meas tran vdout1_43ck1400 FIND v(dout1_43) AT=1410.05n

.meas tran vdout1_44ck1400 FIND v(dout1_44) AT=1410.05n

.meas tran vdout1_45ck1400 FIND v(dout1_45) AT=1410.05n

.meas tran vdout1_46ck1400 FIND v(dout1_46) AT=1410.05n

.meas tran vdout1_47ck1400 FIND v(dout1_47) AT=1410.05n

.meas tran vdout1_48ck1400 FIND v(dout1_48) AT=1410.05n

.meas tran vdout1_49ck1400 FIND v(dout1_49) AT=1410.05n

.meas tran vdout1_50ck1400 FIND v(dout1_50) AT=1410.05n

.meas tran vdout1_51ck1400 FIND v(dout1_51) AT=1410.05n

.meas tran vdout1_52ck1400 FIND v(dout1_52) AT=1410.05n

.meas tran vdout1_53ck1400 FIND v(dout1_53) AT=1410.05n

.meas tran vdout1_54ck1400 FIND v(dout1_54) AT=1410.05n

.meas tran vdout1_55ck1400 FIND v(dout1_55) AT=1410.05n

.meas tran vdout1_56ck1400 FIND v(dout1_56) AT=1410.05n

.meas tran vdout1_57ck1400 FIND v(dout1_57) AT=1410.05n

.meas tran vdout1_58ck1400 FIND v(dout1_58) AT=1410.05n

.meas tran vdout1_59ck1400 FIND v(dout1_59) AT=1410.05n

.meas tran vdout1_60ck1400 FIND v(dout1_60) AT=1410.05n

.meas tran vdout1_61ck1400 FIND v(dout1_61) AT=1410.05n

.meas tran vdout1_62ck1400 FIND v(dout1_62) AT=1410.05n

.meas tran vdout1_63ck1400 FIND v(dout1_63) AT=1410.05n

.meas tran vdout0_0ck1410 FIND v(dout0_0) AT=1420.05n

.meas tran vdout0_1ck1410 FIND v(dout0_1) AT=1420.05n

.meas tran vdout0_2ck1410 FIND v(dout0_2) AT=1420.05n

.meas tran vdout0_3ck1410 FIND v(dout0_3) AT=1420.05n

.meas tran vdout0_4ck1410 FIND v(dout0_4) AT=1420.05n

.meas tran vdout0_5ck1410 FIND v(dout0_5) AT=1420.05n

.meas tran vdout0_6ck1410 FIND v(dout0_6) AT=1420.05n

.meas tran vdout0_7ck1410 FIND v(dout0_7) AT=1420.05n

.meas tran vdout0_8ck1410 FIND v(dout0_8) AT=1420.05n

.meas tran vdout0_9ck1410 FIND v(dout0_9) AT=1420.05n

.meas tran vdout0_10ck1410 FIND v(dout0_10) AT=1420.05n

.meas tran vdout0_11ck1410 FIND v(dout0_11) AT=1420.05n

.meas tran vdout0_12ck1410 FIND v(dout0_12) AT=1420.05n

.meas tran vdout0_13ck1410 FIND v(dout0_13) AT=1420.05n

.meas tran vdout0_14ck1410 FIND v(dout0_14) AT=1420.05n

.meas tran vdout0_15ck1410 FIND v(dout0_15) AT=1420.05n

.meas tran vdout0_16ck1410 FIND v(dout0_16) AT=1420.05n

.meas tran vdout0_17ck1410 FIND v(dout0_17) AT=1420.05n

.meas tran vdout0_18ck1410 FIND v(dout0_18) AT=1420.05n

.meas tran vdout0_19ck1410 FIND v(dout0_19) AT=1420.05n

.meas tran vdout0_20ck1410 FIND v(dout0_20) AT=1420.05n

.meas tran vdout0_21ck1410 FIND v(dout0_21) AT=1420.05n

.meas tran vdout0_22ck1410 FIND v(dout0_22) AT=1420.05n

.meas tran vdout0_23ck1410 FIND v(dout0_23) AT=1420.05n

.meas tran vdout0_24ck1410 FIND v(dout0_24) AT=1420.05n

.meas tran vdout0_25ck1410 FIND v(dout0_25) AT=1420.05n

.meas tran vdout0_26ck1410 FIND v(dout0_26) AT=1420.05n

.meas tran vdout0_27ck1410 FIND v(dout0_27) AT=1420.05n

.meas tran vdout0_28ck1410 FIND v(dout0_28) AT=1420.05n

.meas tran vdout0_29ck1410 FIND v(dout0_29) AT=1420.05n

.meas tran vdout0_30ck1410 FIND v(dout0_30) AT=1420.05n

.meas tran vdout0_31ck1410 FIND v(dout0_31) AT=1420.05n

.meas tran vdout0_32ck1410 FIND v(dout0_32) AT=1420.05n

.meas tran vdout0_33ck1410 FIND v(dout0_33) AT=1420.05n

.meas tran vdout0_34ck1410 FIND v(dout0_34) AT=1420.05n

.meas tran vdout0_35ck1410 FIND v(dout0_35) AT=1420.05n

.meas tran vdout0_36ck1410 FIND v(dout0_36) AT=1420.05n

.meas tran vdout0_37ck1410 FIND v(dout0_37) AT=1420.05n

.meas tran vdout0_38ck1410 FIND v(dout0_38) AT=1420.05n

.meas tran vdout0_39ck1410 FIND v(dout0_39) AT=1420.05n

.meas tran vdout0_40ck1410 FIND v(dout0_40) AT=1420.05n

.meas tran vdout0_41ck1410 FIND v(dout0_41) AT=1420.05n

.meas tran vdout0_42ck1410 FIND v(dout0_42) AT=1420.05n

.meas tran vdout0_43ck1410 FIND v(dout0_43) AT=1420.05n

.meas tran vdout0_44ck1410 FIND v(dout0_44) AT=1420.05n

.meas tran vdout0_45ck1410 FIND v(dout0_45) AT=1420.05n

.meas tran vdout0_46ck1410 FIND v(dout0_46) AT=1420.05n

.meas tran vdout0_47ck1410 FIND v(dout0_47) AT=1420.05n

.meas tran vdout0_48ck1410 FIND v(dout0_48) AT=1420.05n

.meas tran vdout0_49ck1410 FIND v(dout0_49) AT=1420.05n

.meas tran vdout0_50ck1410 FIND v(dout0_50) AT=1420.05n

.meas tran vdout0_51ck1410 FIND v(dout0_51) AT=1420.05n

.meas tran vdout0_52ck1410 FIND v(dout0_52) AT=1420.05n

.meas tran vdout0_53ck1410 FIND v(dout0_53) AT=1420.05n

.meas tran vdout0_54ck1410 FIND v(dout0_54) AT=1420.05n

.meas tran vdout0_55ck1410 FIND v(dout0_55) AT=1420.05n

.meas tran vdout0_56ck1410 FIND v(dout0_56) AT=1420.05n

.meas tran vdout0_57ck1410 FIND v(dout0_57) AT=1420.05n

.meas tran vdout0_58ck1410 FIND v(dout0_58) AT=1420.05n

.meas tran vdout0_59ck1410 FIND v(dout0_59) AT=1420.05n

.meas tran vdout0_60ck1410 FIND v(dout0_60) AT=1420.05n

.meas tran vdout0_61ck1410 FIND v(dout0_61) AT=1420.05n

.meas tran vdout0_62ck1410 FIND v(dout0_62) AT=1420.05n

.meas tran vdout0_63ck1410 FIND v(dout0_63) AT=1420.05n

.meas tran vdout1_0ck1410 FIND v(dout1_0) AT=1420.05n

.meas tran vdout1_1ck1410 FIND v(dout1_1) AT=1420.05n

.meas tran vdout1_2ck1410 FIND v(dout1_2) AT=1420.05n

.meas tran vdout1_3ck1410 FIND v(dout1_3) AT=1420.05n

.meas tran vdout1_4ck1410 FIND v(dout1_4) AT=1420.05n

.meas tran vdout1_5ck1410 FIND v(dout1_5) AT=1420.05n

.meas tran vdout1_6ck1410 FIND v(dout1_6) AT=1420.05n

.meas tran vdout1_7ck1410 FIND v(dout1_7) AT=1420.05n

.meas tran vdout1_8ck1410 FIND v(dout1_8) AT=1420.05n

.meas tran vdout1_9ck1410 FIND v(dout1_9) AT=1420.05n

.meas tran vdout1_10ck1410 FIND v(dout1_10) AT=1420.05n

.meas tran vdout1_11ck1410 FIND v(dout1_11) AT=1420.05n

.meas tran vdout1_12ck1410 FIND v(dout1_12) AT=1420.05n

.meas tran vdout1_13ck1410 FIND v(dout1_13) AT=1420.05n

.meas tran vdout1_14ck1410 FIND v(dout1_14) AT=1420.05n

.meas tran vdout1_15ck1410 FIND v(dout1_15) AT=1420.05n

.meas tran vdout1_16ck1410 FIND v(dout1_16) AT=1420.05n

.meas tran vdout1_17ck1410 FIND v(dout1_17) AT=1420.05n

.meas tran vdout1_18ck1410 FIND v(dout1_18) AT=1420.05n

.meas tran vdout1_19ck1410 FIND v(dout1_19) AT=1420.05n

.meas tran vdout1_20ck1410 FIND v(dout1_20) AT=1420.05n

.meas tran vdout1_21ck1410 FIND v(dout1_21) AT=1420.05n

.meas tran vdout1_22ck1410 FIND v(dout1_22) AT=1420.05n

.meas tran vdout1_23ck1410 FIND v(dout1_23) AT=1420.05n

.meas tran vdout1_24ck1410 FIND v(dout1_24) AT=1420.05n

.meas tran vdout1_25ck1410 FIND v(dout1_25) AT=1420.05n

.meas tran vdout1_26ck1410 FIND v(dout1_26) AT=1420.05n

.meas tran vdout1_27ck1410 FIND v(dout1_27) AT=1420.05n

.meas tran vdout1_28ck1410 FIND v(dout1_28) AT=1420.05n

.meas tran vdout1_29ck1410 FIND v(dout1_29) AT=1420.05n

.meas tran vdout1_30ck1410 FIND v(dout1_30) AT=1420.05n

.meas tran vdout1_31ck1410 FIND v(dout1_31) AT=1420.05n

.meas tran vdout1_32ck1410 FIND v(dout1_32) AT=1420.05n

.meas tran vdout1_33ck1410 FIND v(dout1_33) AT=1420.05n

.meas tran vdout1_34ck1410 FIND v(dout1_34) AT=1420.05n

.meas tran vdout1_35ck1410 FIND v(dout1_35) AT=1420.05n

.meas tran vdout1_36ck1410 FIND v(dout1_36) AT=1420.05n

.meas tran vdout1_37ck1410 FIND v(dout1_37) AT=1420.05n

.meas tran vdout1_38ck1410 FIND v(dout1_38) AT=1420.05n

.meas tran vdout1_39ck1410 FIND v(dout1_39) AT=1420.05n

.meas tran vdout1_40ck1410 FIND v(dout1_40) AT=1420.05n

.meas tran vdout1_41ck1410 FIND v(dout1_41) AT=1420.05n

.meas tran vdout1_42ck1410 FIND v(dout1_42) AT=1420.05n

.meas tran vdout1_43ck1410 FIND v(dout1_43) AT=1420.05n

.meas tran vdout1_44ck1410 FIND v(dout1_44) AT=1420.05n

.meas tran vdout1_45ck1410 FIND v(dout1_45) AT=1420.05n

.meas tran vdout1_46ck1410 FIND v(dout1_46) AT=1420.05n

.meas tran vdout1_47ck1410 FIND v(dout1_47) AT=1420.05n

.meas tran vdout1_48ck1410 FIND v(dout1_48) AT=1420.05n

.meas tran vdout1_49ck1410 FIND v(dout1_49) AT=1420.05n

.meas tran vdout1_50ck1410 FIND v(dout1_50) AT=1420.05n

.meas tran vdout1_51ck1410 FIND v(dout1_51) AT=1420.05n

.meas tran vdout1_52ck1410 FIND v(dout1_52) AT=1420.05n

.meas tran vdout1_53ck1410 FIND v(dout1_53) AT=1420.05n

.meas tran vdout1_54ck1410 FIND v(dout1_54) AT=1420.05n

.meas tran vdout1_55ck1410 FIND v(dout1_55) AT=1420.05n

.meas tran vdout1_56ck1410 FIND v(dout1_56) AT=1420.05n

.meas tran vdout1_57ck1410 FIND v(dout1_57) AT=1420.05n

.meas tran vdout1_58ck1410 FIND v(dout1_58) AT=1420.05n

.meas tran vdout1_59ck1410 FIND v(dout1_59) AT=1420.05n

.meas tran vdout1_60ck1410 FIND v(dout1_60) AT=1420.05n

.meas tran vdout1_61ck1410 FIND v(dout1_61) AT=1420.05n

.meas tran vdout1_62ck1410 FIND v(dout1_62) AT=1420.05n

.meas tran vdout1_63ck1410 FIND v(dout1_63) AT=1420.05n

.meas tran vdout0_0ck1420 FIND v(dout0_0) AT=1430.05n

.meas tran vdout0_1ck1420 FIND v(dout0_1) AT=1430.05n

.meas tran vdout0_2ck1420 FIND v(dout0_2) AT=1430.05n

.meas tran vdout0_3ck1420 FIND v(dout0_3) AT=1430.05n

.meas tran vdout0_4ck1420 FIND v(dout0_4) AT=1430.05n

.meas tran vdout0_5ck1420 FIND v(dout0_5) AT=1430.05n

.meas tran vdout0_6ck1420 FIND v(dout0_6) AT=1430.05n

.meas tran vdout0_7ck1420 FIND v(dout0_7) AT=1430.05n

.meas tran vdout0_8ck1420 FIND v(dout0_8) AT=1430.05n

.meas tran vdout0_9ck1420 FIND v(dout0_9) AT=1430.05n

.meas tran vdout0_10ck1420 FIND v(dout0_10) AT=1430.05n

.meas tran vdout0_11ck1420 FIND v(dout0_11) AT=1430.05n

.meas tran vdout0_12ck1420 FIND v(dout0_12) AT=1430.05n

.meas tran vdout0_13ck1420 FIND v(dout0_13) AT=1430.05n

.meas tran vdout0_14ck1420 FIND v(dout0_14) AT=1430.05n

.meas tran vdout0_15ck1420 FIND v(dout0_15) AT=1430.05n

.meas tran vdout0_16ck1420 FIND v(dout0_16) AT=1430.05n

.meas tran vdout0_17ck1420 FIND v(dout0_17) AT=1430.05n

.meas tran vdout0_18ck1420 FIND v(dout0_18) AT=1430.05n

.meas tran vdout0_19ck1420 FIND v(dout0_19) AT=1430.05n

.meas tran vdout0_20ck1420 FIND v(dout0_20) AT=1430.05n

.meas tran vdout0_21ck1420 FIND v(dout0_21) AT=1430.05n

.meas tran vdout0_22ck1420 FIND v(dout0_22) AT=1430.05n

.meas tran vdout0_23ck1420 FIND v(dout0_23) AT=1430.05n

.meas tran vdout0_24ck1420 FIND v(dout0_24) AT=1430.05n

.meas tran vdout0_25ck1420 FIND v(dout0_25) AT=1430.05n

.meas tran vdout0_26ck1420 FIND v(dout0_26) AT=1430.05n

.meas tran vdout0_27ck1420 FIND v(dout0_27) AT=1430.05n

.meas tran vdout0_28ck1420 FIND v(dout0_28) AT=1430.05n

.meas tran vdout0_29ck1420 FIND v(dout0_29) AT=1430.05n

.meas tran vdout0_30ck1420 FIND v(dout0_30) AT=1430.05n

.meas tran vdout0_31ck1420 FIND v(dout0_31) AT=1430.05n

.meas tran vdout0_32ck1420 FIND v(dout0_32) AT=1430.05n

.meas tran vdout0_33ck1420 FIND v(dout0_33) AT=1430.05n

.meas tran vdout0_34ck1420 FIND v(dout0_34) AT=1430.05n

.meas tran vdout0_35ck1420 FIND v(dout0_35) AT=1430.05n

.meas tran vdout0_36ck1420 FIND v(dout0_36) AT=1430.05n

.meas tran vdout0_37ck1420 FIND v(dout0_37) AT=1430.05n

.meas tran vdout0_38ck1420 FIND v(dout0_38) AT=1430.05n

.meas tran vdout0_39ck1420 FIND v(dout0_39) AT=1430.05n

.meas tran vdout0_40ck1420 FIND v(dout0_40) AT=1430.05n

.meas tran vdout0_41ck1420 FIND v(dout0_41) AT=1430.05n

.meas tran vdout0_42ck1420 FIND v(dout0_42) AT=1430.05n

.meas tran vdout0_43ck1420 FIND v(dout0_43) AT=1430.05n

.meas tran vdout0_44ck1420 FIND v(dout0_44) AT=1430.05n

.meas tran vdout0_45ck1420 FIND v(dout0_45) AT=1430.05n

.meas tran vdout0_46ck1420 FIND v(dout0_46) AT=1430.05n

.meas tran vdout0_47ck1420 FIND v(dout0_47) AT=1430.05n

.meas tran vdout0_48ck1420 FIND v(dout0_48) AT=1430.05n

.meas tran vdout0_49ck1420 FIND v(dout0_49) AT=1430.05n

.meas tran vdout0_50ck1420 FIND v(dout0_50) AT=1430.05n

.meas tran vdout0_51ck1420 FIND v(dout0_51) AT=1430.05n

.meas tran vdout0_52ck1420 FIND v(dout0_52) AT=1430.05n

.meas tran vdout0_53ck1420 FIND v(dout0_53) AT=1430.05n

.meas tran vdout0_54ck1420 FIND v(dout0_54) AT=1430.05n

.meas tran vdout0_55ck1420 FIND v(dout0_55) AT=1430.05n

.meas tran vdout0_56ck1420 FIND v(dout0_56) AT=1430.05n

.meas tran vdout0_57ck1420 FIND v(dout0_57) AT=1430.05n

.meas tran vdout0_58ck1420 FIND v(dout0_58) AT=1430.05n

.meas tran vdout0_59ck1420 FIND v(dout0_59) AT=1430.05n

.meas tran vdout0_60ck1420 FIND v(dout0_60) AT=1430.05n

.meas tran vdout0_61ck1420 FIND v(dout0_61) AT=1430.05n

.meas tran vdout0_62ck1420 FIND v(dout0_62) AT=1430.05n

.meas tran vdout0_63ck1420 FIND v(dout0_63) AT=1430.05n

.meas tran vdout0_0ck1430 FIND v(dout0_0) AT=1440.05n

.meas tran vdout0_1ck1430 FIND v(dout0_1) AT=1440.05n

.meas tran vdout0_2ck1430 FIND v(dout0_2) AT=1440.05n

.meas tran vdout0_3ck1430 FIND v(dout0_3) AT=1440.05n

.meas tran vdout0_4ck1430 FIND v(dout0_4) AT=1440.05n

.meas tran vdout0_5ck1430 FIND v(dout0_5) AT=1440.05n

.meas tran vdout0_6ck1430 FIND v(dout0_6) AT=1440.05n

.meas tran vdout0_7ck1430 FIND v(dout0_7) AT=1440.05n

.meas tran vdout0_8ck1430 FIND v(dout0_8) AT=1440.05n

.meas tran vdout0_9ck1430 FIND v(dout0_9) AT=1440.05n

.meas tran vdout0_10ck1430 FIND v(dout0_10) AT=1440.05n

.meas tran vdout0_11ck1430 FIND v(dout0_11) AT=1440.05n

.meas tran vdout0_12ck1430 FIND v(dout0_12) AT=1440.05n

.meas tran vdout0_13ck1430 FIND v(dout0_13) AT=1440.05n

.meas tran vdout0_14ck1430 FIND v(dout0_14) AT=1440.05n

.meas tran vdout0_15ck1430 FIND v(dout0_15) AT=1440.05n

.meas tran vdout0_16ck1430 FIND v(dout0_16) AT=1440.05n

.meas tran vdout0_17ck1430 FIND v(dout0_17) AT=1440.05n

.meas tran vdout0_18ck1430 FIND v(dout0_18) AT=1440.05n

.meas tran vdout0_19ck1430 FIND v(dout0_19) AT=1440.05n

.meas tran vdout0_20ck1430 FIND v(dout0_20) AT=1440.05n

.meas tran vdout0_21ck1430 FIND v(dout0_21) AT=1440.05n

.meas tran vdout0_22ck1430 FIND v(dout0_22) AT=1440.05n

.meas tran vdout0_23ck1430 FIND v(dout0_23) AT=1440.05n

.meas tran vdout0_24ck1430 FIND v(dout0_24) AT=1440.05n

.meas tran vdout0_25ck1430 FIND v(dout0_25) AT=1440.05n

.meas tran vdout0_26ck1430 FIND v(dout0_26) AT=1440.05n

.meas tran vdout0_27ck1430 FIND v(dout0_27) AT=1440.05n

.meas tran vdout0_28ck1430 FIND v(dout0_28) AT=1440.05n

.meas tran vdout0_29ck1430 FIND v(dout0_29) AT=1440.05n

.meas tran vdout0_30ck1430 FIND v(dout0_30) AT=1440.05n

.meas tran vdout0_31ck1430 FIND v(dout0_31) AT=1440.05n

.meas tran vdout0_32ck1430 FIND v(dout0_32) AT=1440.05n

.meas tran vdout0_33ck1430 FIND v(dout0_33) AT=1440.05n

.meas tran vdout0_34ck1430 FIND v(dout0_34) AT=1440.05n

.meas tran vdout0_35ck1430 FIND v(dout0_35) AT=1440.05n

.meas tran vdout0_36ck1430 FIND v(dout0_36) AT=1440.05n

.meas tran vdout0_37ck1430 FIND v(dout0_37) AT=1440.05n

.meas tran vdout0_38ck1430 FIND v(dout0_38) AT=1440.05n

.meas tran vdout0_39ck1430 FIND v(dout0_39) AT=1440.05n

.meas tran vdout0_40ck1430 FIND v(dout0_40) AT=1440.05n

.meas tran vdout0_41ck1430 FIND v(dout0_41) AT=1440.05n

.meas tran vdout0_42ck1430 FIND v(dout0_42) AT=1440.05n

.meas tran vdout0_43ck1430 FIND v(dout0_43) AT=1440.05n

.meas tran vdout0_44ck1430 FIND v(dout0_44) AT=1440.05n

.meas tran vdout0_45ck1430 FIND v(dout0_45) AT=1440.05n

.meas tran vdout0_46ck1430 FIND v(dout0_46) AT=1440.05n

.meas tran vdout0_47ck1430 FIND v(dout0_47) AT=1440.05n

.meas tran vdout0_48ck1430 FIND v(dout0_48) AT=1440.05n

.meas tran vdout0_49ck1430 FIND v(dout0_49) AT=1440.05n

.meas tran vdout0_50ck1430 FIND v(dout0_50) AT=1440.05n

.meas tran vdout0_51ck1430 FIND v(dout0_51) AT=1440.05n

.meas tran vdout0_52ck1430 FIND v(dout0_52) AT=1440.05n

.meas tran vdout0_53ck1430 FIND v(dout0_53) AT=1440.05n

.meas tran vdout0_54ck1430 FIND v(dout0_54) AT=1440.05n

.meas tran vdout0_55ck1430 FIND v(dout0_55) AT=1440.05n

.meas tran vdout0_56ck1430 FIND v(dout0_56) AT=1440.05n

.meas tran vdout0_57ck1430 FIND v(dout0_57) AT=1440.05n

.meas tran vdout0_58ck1430 FIND v(dout0_58) AT=1440.05n

.meas tran vdout0_59ck1430 FIND v(dout0_59) AT=1440.05n

.meas tran vdout0_60ck1430 FIND v(dout0_60) AT=1440.05n

.meas tran vdout0_61ck1430 FIND v(dout0_61) AT=1440.05n

.meas tran vdout0_62ck1430 FIND v(dout0_62) AT=1440.05n

.meas tran vdout0_63ck1430 FIND v(dout0_63) AT=1440.05n

.meas tran vdout1_0ck1430 FIND v(dout1_0) AT=1440.05n

.meas tran vdout1_1ck1430 FIND v(dout1_1) AT=1440.05n

.meas tran vdout1_2ck1430 FIND v(dout1_2) AT=1440.05n

.meas tran vdout1_3ck1430 FIND v(dout1_3) AT=1440.05n

.meas tran vdout1_4ck1430 FIND v(dout1_4) AT=1440.05n

.meas tran vdout1_5ck1430 FIND v(dout1_5) AT=1440.05n

.meas tran vdout1_6ck1430 FIND v(dout1_6) AT=1440.05n

.meas tran vdout1_7ck1430 FIND v(dout1_7) AT=1440.05n

.meas tran vdout1_8ck1430 FIND v(dout1_8) AT=1440.05n

.meas tran vdout1_9ck1430 FIND v(dout1_9) AT=1440.05n

.meas tran vdout1_10ck1430 FIND v(dout1_10) AT=1440.05n

.meas tran vdout1_11ck1430 FIND v(dout1_11) AT=1440.05n

.meas tran vdout1_12ck1430 FIND v(dout1_12) AT=1440.05n

.meas tran vdout1_13ck1430 FIND v(dout1_13) AT=1440.05n

.meas tran vdout1_14ck1430 FIND v(dout1_14) AT=1440.05n

.meas tran vdout1_15ck1430 FIND v(dout1_15) AT=1440.05n

.meas tran vdout1_16ck1430 FIND v(dout1_16) AT=1440.05n

.meas tran vdout1_17ck1430 FIND v(dout1_17) AT=1440.05n

.meas tran vdout1_18ck1430 FIND v(dout1_18) AT=1440.05n

.meas tran vdout1_19ck1430 FIND v(dout1_19) AT=1440.05n

.meas tran vdout1_20ck1430 FIND v(dout1_20) AT=1440.05n

.meas tran vdout1_21ck1430 FIND v(dout1_21) AT=1440.05n

.meas tran vdout1_22ck1430 FIND v(dout1_22) AT=1440.05n

.meas tran vdout1_23ck1430 FIND v(dout1_23) AT=1440.05n

.meas tran vdout1_24ck1430 FIND v(dout1_24) AT=1440.05n

.meas tran vdout1_25ck1430 FIND v(dout1_25) AT=1440.05n

.meas tran vdout1_26ck1430 FIND v(dout1_26) AT=1440.05n

.meas tran vdout1_27ck1430 FIND v(dout1_27) AT=1440.05n

.meas tran vdout1_28ck1430 FIND v(dout1_28) AT=1440.05n

.meas tran vdout1_29ck1430 FIND v(dout1_29) AT=1440.05n

.meas tran vdout1_30ck1430 FIND v(dout1_30) AT=1440.05n

.meas tran vdout1_31ck1430 FIND v(dout1_31) AT=1440.05n

.meas tran vdout1_32ck1430 FIND v(dout1_32) AT=1440.05n

.meas tran vdout1_33ck1430 FIND v(dout1_33) AT=1440.05n

.meas tran vdout1_34ck1430 FIND v(dout1_34) AT=1440.05n

.meas tran vdout1_35ck1430 FIND v(dout1_35) AT=1440.05n

.meas tran vdout1_36ck1430 FIND v(dout1_36) AT=1440.05n

.meas tran vdout1_37ck1430 FIND v(dout1_37) AT=1440.05n

.meas tran vdout1_38ck1430 FIND v(dout1_38) AT=1440.05n

.meas tran vdout1_39ck1430 FIND v(dout1_39) AT=1440.05n

.meas tran vdout1_40ck1430 FIND v(dout1_40) AT=1440.05n

.meas tran vdout1_41ck1430 FIND v(dout1_41) AT=1440.05n

.meas tran vdout1_42ck1430 FIND v(dout1_42) AT=1440.05n

.meas tran vdout1_43ck1430 FIND v(dout1_43) AT=1440.05n

.meas tran vdout1_44ck1430 FIND v(dout1_44) AT=1440.05n

.meas tran vdout1_45ck1430 FIND v(dout1_45) AT=1440.05n

.meas tran vdout1_46ck1430 FIND v(dout1_46) AT=1440.05n

.meas tran vdout1_47ck1430 FIND v(dout1_47) AT=1440.05n

.meas tran vdout1_48ck1430 FIND v(dout1_48) AT=1440.05n

.meas tran vdout1_49ck1430 FIND v(dout1_49) AT=1440.05n

.meas tran vdout1_50ck1430 FIND v(dout1_50) AT=1440.05n

.meas tran vdout1_51ck1430 FIND v(dout1_51) AT=1440.05n

.meas tran vdout1_52ck1430 FIND v(dout1_52) AT=1440.05n

.meas tran vdout1_53ck1430 FIND v(dout1_53) AT=1440.05n

.meas tran vdout1_54ck1430 FIND v(dout1_54) AT=1440.05n

.meas tran vdout1_55ck1430 FIND v(dout1_55) AT=1440.05n

.meas tran vdout1_56ck1430 FIND v(dout1_56) AT=1440.05n

.meas tran vdout1_57ck1430 FIND v(dout1_57) AT=1440.05n

.meas tran vdout1_58ck1430 FIND v(dout1_58) AT=1440.05n

.meas tran vdout1_59ck1430 FIND v(dout1_59) AT=1440.05n

.meas tran vdout1_60ck1430 FIND v(dout1_60) AT=1440.05n

.meas tran vdout1_61ck1430 FIND v(dout1_61) AT=1440.05n

.meas tran vdout1_62ck1430 FIND v(dout1_62) AT=1440.05n

.meas tran vdout1_63ck1430 FIND v(dout1_63) AT=1440.05n

.meas tran vdout1_0ck1440 FIND v(dout1_0) AT=1450.05n

.meas tran vdout1_1ck1440 FIND v(dout1_1) AT=1450.05n

.meas tran vdout1_2ck1440 FIND v(dout1_2) AT=1450.05n

.meas tran vdout1_3ck1440 FIND v(dout1_3) AT=1450.05n

.meas tran vdout1_4ck1440 FIND v(dout1_4) AT=1450.05n

.meas tran vdout1_5ck1440 FIND v(dout1_5) AT=1450.05n

.meas tran vdout1_6ck1440 FIND v(dout1_6) AT=1450.05n

.meas tran vdout1_7ck1440 FIND v(dout1_7) AT=1450.05n

.meas tran vdout1_8ck1440 FIND v(dout1_8) AT=1450.05n

.meas tran vdout1_9ck1440 FIND v(dout1_9) AT=1450.05n

.meas tran vdout1_10ck1440 FIND v(dout1_10) AT=1450.05n

.meas tran vdout1_11ck1440 FIND v(dout1_11) AT=1450.05n

.meas tran vdout1_12ck1440 FIND v(dout1_12) AT=1450.05n

.meas tran vdout1_13ck1440 FIND v(dout1_13) AT=1450.05n

.meas tran vdout1_14ck1440 FIND v(dout1_14) AT=1450.05n

.meas tran vdout1_15ck1440 FIND v(dout1_15) AT=1450.05n

.meas tran vdout1_16ck1440 FIND v(dout1_16) AT=1450.05n

.meas tran vdout1_17ck1440 FIND v(dout1_17) AT=1450.05n

.meas tran vdout1_18ck1440 FIND v(dout1_18) AT=1450.05n

.meas tran vdout1_19ck1440 FIND v(dout1_19) AT=1450.05n

.meas tran vdout1_20ck1440 FIND v(dout1_20) AT=1450.05n

.meas tran vdout1_21ck1440 FIND v(dout1_21) AT=1450.05n

.meas tran vdout1_22ck1440 FIND v(dout1_22) AT=1450.05n

.meas tran vdout1_23ck1440 FIND v(dout1_23) AT=1450.05n

.meas tran vdout1_24ck1440 FIND v(dout1_24) AT=1450.05n

.meas tran vdout1_25ck1440 FIND v(dout1_25) AT=1450.05n

.meas tran vdout1_26ck1440 FIND v(dout1_26) AT=1450.05n

.meas tran vdout1_27ck1440 FIND v(dout1_27) AT=1450.05n

.meas tran vdout1_28ck1440 FIND v(dout1_28) AT=1450.05n

.meas tran vdout1_29ck1440 FIND v(dout1_29) AT=1450.05n

.meas tran vdout1_30ck1440 FIND v(dout1_30) AT=1450.05n

.meas tran vdout1_31ck1440 FIND v(dout1_31) AT=1450.05n

.meas tran vdout1_32ck1440 FIND v(dout1_32) AT=1450.05n

.meas tran vdout1_33ck1440 FIND v(dout1_33) AT=1450.05n

.meas tran vdout1_34ck1440 FIND v(dout1_34) AT=1450.05n

.meas tran vdout1_35ck1440 FIND v(dout1_35) AT=1450.05n

.meas tran vdout1_36ck1440 FIND v(dout1_36) AT=1450.05n

.meas tran vdout1_37ck1440 FIND v(dout1_37) AT=1450.05n

.meas tran vdout1_38ck1440 FIND v(dout1_38) AT=1450.05n

.meas tran vdout1_39ck1440 FIND v(dout1_39) AT=1450.05n

.meas tran vdout1_40ck1440 FIND v(dout1_40) AT=1450.05n

.meas tran vdout1_41ck1440 FIND v(dout1_41) AT=1450.05n

.meas tran vdout1_42ck1440 FIND v(dout1_42) AT=1450.05n

.meas tran vdout1_43ck1440 FIND v(dout1_43) AT=1450.05n

.meas tran vdout1_44ck1440 FIND v(dout1_44) AT=1450.05n

.meas tran vdout1_45ck1440 FIND v(dout1_45) AT=1450.05n

.meas tran vdout1_46ck1440 FIND v(dout1_46) AT=1450.05n

.meas tran vdout1_47ck1440 FIND v(dout1_47) AT=1450.05n

.meas tran vdout1_48ck1440 FIND v(dout1_48) AT=1450.05n

.meas tran vdout1_49ck1440 FIND v(dout1_49) AT=1450.05n

.meas tran vdout1_50ck1440 FIND v(dout1_50) AT=1450.05n

.meas tran vdout1_51ck1440 FIND v(dout1_51) AT=1450.05n

.meas tran vdout1_52ck1440 FIND v(dout1_52) AT=1450.05n

.meas tran vdout1_53ck1440 FIND v(dout1_53) AT=1450.05n

.meas tran vdout1_54ck1440 FIND v(dout1_54) AT=1450.05n

.meas tran vdout1_55ck1440 FIND v(dout1_55) AT=1450.05n

.meas tran vdout1_56ck1440 FIND v(dout1_56) AT=1450.05n

.meas tran vdout1_57ck1440 FIND v(dout1_57) AT=1450.05n

.meas tran vdout1_58ck1440 FIND v(dout1_58) AT=1450.05n

.meas tran vdout1_59ck1440 FIND v(dout1_59) AT=1450.05n

.meas tran vdout1_60ck1440 FIND v(dout1_60) AT=1450.05n

.meas tran vdout1_61ck1440 FIND v(dout1_61) AT=1450.05n

.meas tran vdout1_62ck1440 FIND v(dout1_62) AT=1450.05n

.meas tran vdout1_63ck1440 FIND v(dout1_63) AT=1450.05n

.meas tran vdout0_0ck1450 FIND v(dout0_0) AT=1460.05n

.meas tran vdout0_1ck1450 FIND v(dout0_1) AT=1460.05n

.meas tran vdout0_2ck1450 FIND v(dout0_2) AT=1460.05n

.meas tran vdout0_3ck1450 FIND v(dout0_3) AT=1460.05n

.meas tran vdout0_4ck1450 FIND v(dout0_4) AT=1460.05n

.meas tran vdout0_5ck1450 FIND v(dout0_5) AT=1460.05n

.meas tran vdout0_6ck1450 FIND v(dout0_6) AT=1460.05n

.meas tran vdout0_7ck1450 FIND v(dout0_7) AT=1460.05n

.meas tran vdout0_8ck1450 FIND v(dout0_8) AT=1460.05n

.meas tran vdout0_9ck1450 FIND v(dout0_9) AT=1460.05n

.meas tran vdout0_10ck1450 FIND v(dout0_10) AT=1460.05n

.meas tran vdout0_11ck1450 FIND v(dout0_11) AT=1460.05n

.meas tran vdout0_12ck1450 FIND v(dout0_12) AT=1460.05n

.meas tran vdout0_13ck1450 FIND v(dout0_13) AT=1460.05n

.meas tran vdout0_14ck1450 FIND v(dout0_14) AT=1460.05n

.meas tran vdout0_15ck1450 FIND v(dout0_15) AT=1460.05n

.meas tran vdout0_16ck1450 FIND v(dout0_16) AT=1460.05n

.meas tran vdout0_17ck1450 FIND v(dout0_17) AT=1460.05n

.meas tran vdout0_18ck1450 FIND v(dout0_18) AT=1460.05n

.meas tran vdout0_19ck1450 FIND v(dout0_19) AT=1460.05n

.meas tran vdout0_20ck1450 FIND v(dout0_20) AT=1460.05n

.meas tran vdout0_21ck1450 FIND v(dout0_21) AT=1460.05n

.meas tran vdout0_22ck1450 FIND v(dout0_22) AT=1460.05n

.meas tran vdout0_23ck1450 FIND v(dout0_23) AT=1460.05n

.meas tran vdout0_24ck1450 FIND v(dout0_24) AT=1460.05n

.meas tran vdout0_25ck1450 FIND v(dout0_25) AT=1460.05n

.meas tran vdout0_26ck1450 FIND v(dout0_26) AT=1460.05n

.meas tran vdout0_27ck1450 FIND v(dout0_27) AT=1460.05n

.meas tran vdout0_28ck1450 FIND v(dout0_28) AT=1460.05n

.meas tran vdout0_29ck1450 FIND v(dout0_29) AT=1460.05n

.meas tran vdout0_30ck1450 FIND v(dout0_30) AT=1460.05n

.meas tran vdout0_31ck1450 FIND v(dout0_31) AT=1460.05n

.meas tran vdout0_32ck1450 FIND v(dout0_32) AT=1460.05n

.meas tran vdout0_33ck1450 FIND v(dout0_33) AT=1460.05n

.meas tran vdout0_34ck1450 FIND v(dout0_34) AT=1460.05n

.meas tran vdout0_35ck1450 FIND v(dout0_35) AT=1460.05n

.meas tran vdout0_36ck1450 FIND v(dout0_36) AT=1460.05n

.meas tran vdout0_37ck1450 FIND v(dout0_37) AT=1460.05n

.meas tran vdout0_38ck1450 FIND v(dout0_38) AT=1460.05n

.meas tran vdout0_39ck1450 FIND v(dout0_39) AT=1460.05n

.meas tran vdout0_40ck1450 FIND v(dout0_40) AT=1460.05n

.meas tran vdout0_41ck1450 FIND v(dout0_41) AT=1460.05n

.meas tran vdout0_42ck1450 FIND v(dout0_42) AT=1460.05n

.meas tran vdout0_43ck1450 FIND v(dout0_43) AT=1460.05n

.meas tran vdout0_44ck1450 FIND v(dout0_44) AT=1460.05n

.meas tran vdout0_45ck1450 FIND v(dout0_45) AT=1460.05n

.meas tran vdout0_46ck1450 FIND v(dout0_46) AT=1460.05n

.meas tran vdout0_47ck1450 FIND v(dout0_47) AT=1460.05n

.meas tran vdout0_48ck1450 FIND v(dout0_48) AT=1460.05n

.meas tran vdout0_49ck1450 FIND v(dout0_49) AT=1460.05n

.meas tran vdout0_50ck1450 FIND v(dout0_50) AT=1460.05n

.meas tran vdout0_51ck1450 FIND v(dout0_51) AT=1460.05n

.meas tran vdout0_52ck1450 FIND v(dout0_52) AT=1460.05n

.meas tran vdout0_53ck1450 FIND v(dout0_53) AT=1460.05n

.meas tran vdout0_54ck1450 FIND v(dout0_54) AT=1460.05n

.meas tran vdout0_55ck1450 FIND v(dout0_55) AT=1460.05n

.meas tran vdout0_56ck1450 FIND v(dout0_56) AT=1460.05n

.meas tran vdout0_57ck1450 FIND v(dout0_57) AT=1460.05n

.meas tran vdout0_58ck1450 FIND v(dout0_58) AT=1460.05n

.meas tran vdout0_59ck1450 FIND v(dout0_59) AT=1460.05n

.meas tran vdout0_60ck1450 FIND v(dout0_60) AT=1460.05n

.meas tran vdout0_61ck1450 FIND v(dout0_61) AT=1460.05n

.meas tran vdout0_62ck1450 FIND v(dout0_62) AT=1460.05n

.meas tran vdout0_63ck1450 FIND v(dout0_63) AT=1460.05n

.meas tran vdout1_0ck1450 FIND v(dout1_0) AT=1460.05n

.meas tran vdout1_1ck1450 FIND v(dout1_1) AT=1460.05n

.meas tran vdout1_2ck1450 FIND v(dout1_2) AT=1460.05n

.meas tran vdout1_3ck1450 FIND v(dout1_3) AT=1460.05n

.meas tran vdout1_4ck1450 FIND v(dout1_4) AT=1460.05n

.meas tran vdout1_5ck1450 FIND v(dout1_5) AT=1460.05n

.meas tran vdout1_6ck1450 FIND v(dout1_6) AT=1460.05n

.meas tran vdout1_7ck1450 FIND v(dout1_7) AT=1460.05n

.meas tran vdout1_8ck1450 FIND v(dout1_8) AT=1460.05n

.meas tran vdout1_9ck1450 FIND v(dout1_9) AT=1460.05n

.meas tran vdout1_10ck1450 FIND v(dout1_10) AT=1460.05n

.meas tran vdout1_11ck1450 FIND v(dout1_11) AT=1460.05n

.meas tran vdout1_12ck1450 FIND v(dout1_12) AT=1460.05n

.meas tran vdout1_13ck1450 FIND v(dout1_13) AT=1460.05n

.meas tran vdout1_14ck1450 FIND v(dout1_14) AT=1460.05n

.meas tran vdout1_15ck1450 FIND v(dout1_15) AT=1460.05n

.meas tran vdout1_16ck1450 FIND v(dout1_16) AT=1460.05n

.meas tran vdout1_17ck1450 FIND v(dout1_17) AT=1460.05n

.meas tran vdout1_18ck1450 FIND v(dout1_18) AT=1460.05n

.meas tran vdout1_19ck1450 FIND v(dout1_19) AT=1460.05n

.meas tran vdout1_20ck1450 FIND v(dout1_20) AT=1460.05n

.meas tran vdout1_21ck1450 FIND v(dout1_21) AT=1460.05n

.meas tran vdout1_22ck1450 FIND v(dout1_22) AT=1460.05n

.meas tran vdout1_23ck1450 FIND v(dout1_23) AT=1460.05n

.meas tran vdout1_24ck1450 FIND v(dout1_24) AT=1460.05n

.meas tran vdout1_25ck1450 FIND v(dout1_25) AT=1460.05n

.meas tran vdout1_26ck1450 FIND v(dout1_26) AT=1460.05n

.meas tran vdout1_27ck1450 FIND v(dout1_27) AT=1460.05n

.meas tran vdout1_28ck1450 FIND v(dout1_28) AT=1460.05n

.meas tran vdout1_29ck1450 FIND v(dout1_29) AT=1460.05n

.meas tran vdout1_30ck1450 FIND v(dout1_30) AT=1460.05n

.meas tran vdout1_31ck1450 FIND v(dout1_31) AT=1460.05n

.meas tran vdout1_32ck1450 FIND v(dout1_32) AT=1460.05n

.meas tran vdout1_33ck1450 FIND v(dout1_33) AT=1460.05n

.meas tran vdout1_34ck1450 FIND v(dout1_34) AT=1460.05n

.meas tran vdout1_35ck1450 FIND v(dout1_35) AT=1460.05n

.meas tran vdout1_36ck1450 FIND v(dout1_36) AT=1460.05n

.meas tran vdout1_37ck1450 FIND v(dout1_37) AT=1460.05n

.meas tran vdout1_38ck1450 FIND v(dout1_38) AT=1460.05n

.meas tran vdout1_39ck1450 FIND v(dout1_39) AT=1460.05n

.meas tran vdout1_40ck1450 FIND v(dout1_40) AT=1460.05n

.meas tran vdout1_41ck1450 FIND v(dout1_41) AT=1460.05n

.meas tran vdout1_42ck1450 FIND v(dout1_42) AT=1460.05n

.meas tran vdout1_43ck1450 FIND v(dout1_43) AT=1460.05n

.meas tran vdout1_44ck1450 FIND v(dout1_44) AT=1460.05n

.meas tran vdout1_45ck1450 FIND v(dout1_45) AT=1460.05n

.meas tran vdout1_46ck1450 FIND v(dout1_46) AT=1460.05n

.meas tran vdout1_47ck1450 FIND v(dout1_47) AT=1460.05n

.meas tran vdout1_48ck1450 FIND v(dout1_48) AT=1460.05n

.meas tran vdout1_49ck1450 FIND v(dout1_49) AT=1460.05n

.meas tran vdout1_50ck1450 FIND v(dout1_50) AT=1460.05n

.meas tran vdout1_51ck1450 FIND v(dout1_51) AT=1460.05n

.meas tran vdout1_52ck1450 FIND v(dout1_52) AT=1460.05n

.meas tran vdout1_53ck1450 FIND v(dout1_53) AT=1460.05n

.meas tran vdout1_54ck1450 FIND v(dout1_54) AT=1460.05n

.meas tran vdout1_55ck1450 FIND v(dout1_55) AT=1460.05n

.meas tran vdout1_56ck1450 FIND v(dout1_56) AT=1460.05n

.meas tran vdout1_57ck1450 FIND v(dout1_57) AT=1460.05n

.meas tran vdout1_58ck1450 FIND v(dout1_58) AT=1460.05n

.meas tran vdout1_59ck1450 FIND v(dout1_59) AT=1460.05n

.meas tran vdout1_60ck1450 FIND v(dout1_60) AT=1460.05n

.meas tran vdout1_61ck1450 FIND v(dout1_61) AT=1460.05n

.meas tran vdout1_62ck1450 FIND v(dout1_62) AT=1460.05n

.meas tran vdout1_63ck1450 FIND v(dout1_63) AT=1460.05n

.meas tran vdout0_0ck1470 FIND v(dout0_0) AT=1480.05n

.meas tran vdout0_1ck1470 FIND v(dout0_1) AT=1480.05n

.meas tran vdout0_2ck1470 FIND v(dout0_2) AT=1480.05n

.meas tran vdout0_3ck1470 FIND v(dout0_3) AT=1480.05n

.meas tran vdout0_4ck1470 FIND v(dout0_4) AT=1480.05n

.meas tran vdout0_5ck1470 FIND v(dout0_5) AT=1480.05n

.meas tran vdout0_6ck1470 FIND v(dout0_6) AT=1480.05n

.meas tran vdout0_7ck1470 FIND v(dout0_7) AT=1480.05n

.meas tran vdout0_8ck1470 FIND v(dout0_8) AT=1480.05n

.meas tran vdout0_9ck1470 FIND v(dout0_9) AT=1480.05n

.meas tran vdout0_10ck1470 FIND v(dout0_10) AT=1480.05n

.meas tran vdout0_11ck1470 FIND v(dout0_11) AT=1480.05n

.meas tran vdout0_12ck1470 FIND v(dout0_12) AT=1480.05n

.meas tran vdout0_13ck1470 FIND v(dout0_13) AT=1480.05n

.meas tran vdout0_14ck1470 FIND v(dout0_14) AT=1480.05n

.meas tran vdout0_15ck1470 FIND v(dout0_15) AT=1480.05n

.meas tran vdout0_16ck1470 FIND v(dout0_16) AT=1480.05n

.meas tran vdout0_17ck1470 FIND v(dout0_17) AT=1480.05n

.meas tran vdout0_18ck1470 FIND v(dout0_18) AT=1480.05n

.meas tran vdout0_19ck1470 FIND v(dout0_19) AT=1480.05n

.meas tran vdout0_20ck1470 FIND v(dout0_20) AT=1480.05n

.meas tran vdout0_21ck1470 FIND v(dout0_21) AT=1480.05n

.meas tran vdout0_22ck1470 FIND v(dout0_22) AT=1480.05n

.meas tran vdout0_23ck1470 FIND v(dout0_23) AT=1480.05n

.meas tran vdout0_24ck1470 FIND v(dout0_24) AT=1480.05n

.meas tran vdout0_25ck1470 FIND v(dout0_25) AT=1480.05n

.meas tran vdout0_26ck1470 FIND v(dout0_26) AT=1480.05n

.meas tran vdout0_27ck1470 FIND v(dout0_27) AT=1480.05n

.meas tran vdout0_28ck1470 FIND v(dout0_28) AT=1480.05n

.meas tran vdout0_29ck1470 FIND v(dout0_29) AT=1480.05n

.meas tran vdout0_30ck1470 FIND v(dout0_30) AT=1480.05n

.meas tran vdout0_31ck1470 FIND v(dout0_31) AT=1480.05n

.meas tran vdout0_32ck1470 FIND v(dout0_32) AT=1480.05n

.meas tran vdout0_33ck1470 FIND v(dout0_33) AT=1480.05n

.meas tran vdout0_34ck1470 FIND v(dout0_34) AT=1480.05n

.meas tran vdout0_35ck1470 FIND v(dout0_35) AT=1480.05n

.meas tran vdout0_36ck1470 FIND v(dout0_36) AT=1480.05n

.meas tran vdout0_37ck1470 FIND v(dout0_37) AT=1480.05n

.meas tran vdout0_38ck1470 FIND v(dout0_38) AT=1480.05n

.meas tran vdout0_39ck1470 FIND v(dout0_39) AT=1480.05n

.meas tran vdout0_40ck1470 FIND v(dout0_40) AT=1480.05n

.meas tran vdout0_41ck1470 FIND v(dout0_41) AT=1480.05n

.meas tran vdout0_42ck1470 FIND v(dout0_42) AT=1480.05n

.meas tran vdout0_43ck1470 FIND v(dout0_43) AT=1480.05n

.meas tran vdout0_44ck1470 FIND v(dout0_44) AT=1480.05n

.meas tran vdout0_45ck1470 FIND v(dout0_45) AT=1480.05n

.meas tran vdout0_46ck1470 FIND v(dout0_46) AT=1480.05n

.meas tran vdout0_47ck1470 FIND v(dout0_47) AT=1480.05n

.meas tran vdout0_48ck1470 FIND v(dout0_48) AT=1480.05n

.meas tran vdout0_49ck1470 FIND v(dout0_49) AT=1480.05n

.meas tran vdout0_50ck1470 FIND v(dout0_50) AT=1480.05n

.meas tran vdout0_51ck1470 FIND v(dout0_51) AT=1480.05n

.meas tran vdout0_52ck1470 FIND v(dout0_52) AT=1480.05n

.meas tran vdout0_53ck1470 FIND v(dout0_53) AT=1480.05n

.meas tran vdout0_54ck1470 FIND v(dout0_54) AT=1480.05n

.meas tran vdout0_55ck1470 FIND v(dout0_55) AT=1480.05n

.meas tran vdout0_56ck1470 FIND v(dout0_56) AT=1480.05n

.meas tran vdout0_57ck1470 FIND v(dout0_57) AT=1480.05n

.meas tran vdout0_58ck1470 FIND v(dout0_58) AT=1480.05n

.meas tran vdout0_59ck1470 FIND v(dout0_59) AT=1480.05n

.meas tran vdout0_60ck1470 FIND v(dout0_60) AT=1480.05n

.meas tran vdout0_61ck1470 FIND v(dout0_61) AT=1480.05n

.meas tran vdout0_62ck1470 FIND v(dout0_62) AT=1480.05n

.meas tran vdout0_63ck1470 FIND v(dout0_63) AT=1480.05n

.meas tran vdout1_0ck1470 FIND v(dout1_0) AT=1480.05n

.meas tran vdout1_1ck1470 FIND v(dout1_1) AT=1480.05n

.meas tran vdout1_2ck1470 FIND v(dout1_2) AT=1480.05n

.meas tran vdout1_3ck1470 FIND v(dout1_3) AT=1480.05n

.meas tran vdout1_4ck1470 FIND v(dout1_4) AT=1480.05n

.meas tran vdout1_5ck1470 FIND v(dout1_5) AT=1480.05n

.meas tran vdout1_6ck1470 FIND v(dout1_6) AT=1480.05n

.meas tran vdout1_7ck1470 FIND v(dout1_7) AT=1480.05n

.meas tran vdout1_8ck1470 FIND v(dout1_8) AT=1480.05n

.meas tran vdout1_9ck1470 FIND v(dout1_9) AT=1480.05n

.meas tran vdout1_10ck1470 FIND v(dout1_10) AT=1480.05n

.meas tran vdout1_11ck1470 FIND v(dout1_11) AT=1480.05n

.meas tran vdout1_12ck1470 FIND v(dout1_12) AT=1480.05n

.meas tran vdout1_13ck1470 FIND v(dout1_13) AT=1480.05n

.meas tran vdout1_14ck1470 FIND v(dout1_14) AT=1480.05n

.meas tran vdout1_15ck1470 FIND v(dout1_15) AT=1480.05n

.meas tran vdout1_16ck1470 FIND v(dout1_16) AT=1480.05n

.meas tran vdout1_17ck1470 FIND v(dout1_17) AT=1480.05n

.meas tran vdout1_18ck1470 FIND v(dout1_18) AT=1480.05n

.meas tran vdout1_19ck1470 FIND v(dout1_19) AT=1480.05n

.meas tran vdout1_20ck1470 FIND v(dout1_20) AT=1480.05n

.meas tran vdout1_21ck1470 FIND v(dout1_21) AT=1480.05n

.meas tran vdout1_22ck1470 FIND v(dout1_22) AT=1480.05n

.meas tran vdout1_23ck1470 FIND v(dout1_23) AT=1480.05n

.meas tran vdout1_24ck1470 FIND v(dout1_24) AT=1480.05n

.meas tran vdout1_25ck1470 FIND v(dout1_25) AT=1480.05n

.meas tran vdout1_26ck1470 FIND v(dout1_26) AT=1480.05n

.meas tran vdout1_27ck1470 FIND v(dout1_27) AT=1480.05n

.meas tran vdout1_28ck1470 FIND v(dout1_28) AT=1480.05n

.meas tran vdout1_29ck1470 FIND v(dout1_29) AT=1480.05n

.meas tran vdout1_30ck1470 FIND v(dout1_30) AT=1480.05n

.meas tran vdout1_31ck1470 FIND v(dout1_31) AT=1480.05n

.meas tran vdout1_32ck1470 FIND v(dout1_32) AT=1480.05n

.meas tran vdout1_33ck1470 FIND v(dout1_33) AT=1480.05n

.meas tran vdout1_34ck1470 FIND v(dout1_34) AT=1480.05n

.meas tran vdout1_35ck1470 FIND v(dout1_35) AT=1480.05n

.meas tran vdout1_36ck1470 FIND v(dout1_36) AT=1480.05n

.meas tran vdout1_37ck1470 FIND v(dout1_37) AT=1480.05n

.meas tran vdout1_38ck1470 FIND v(dout1_38) AT=1480.05n

.meas tran vdout1_39ck1470 FIND v(dout1_39) AT=1480.05n

.meas tran vdout1_40ck1470 FIND v(dout1_40) AT=1480.05n

.meas tran vdout1_41ck1470 FIND v(dout1_41) AT=1480.05n

.meas tran vdout1_42ck1470 FIND v(dout1_42) AT=1480.05n

.meas tran vdout1_43ck1470 FIND v(dout1_43) AT=1480.05n

.meas tran vdout1_44ck1470 FIND v(dout1_44) AT=1480.05n

.meas tran vdout1_45ck1470 FIND v(dout1_45) AT=1480.05n

.meas tran vdout1_46ck1470 FIND v(dout1_46) AT=1480.05n

.meas tran vdout1_47ck1470 FIND v(dout1_47) AT=1480.05n

.meas tran vdout1_48ck1470 FIND v(dout1_48) AT=1480.05n

.meas tran vdout1_49ck1470 FIND v(dout1_49) AT=1480.05n

.meas tran vdout1_50ck1470 FIND v(dout1_50) AT=1480.05n

.meas tran vdout1_51ck1470 FIND v(dout1_51) AT=1480.05n

.meas tran vdout1_52ck1470 FIND v(dout1_52) AT=1480.05n

.meas tran vdout1_53ck1470 FIND v(dout1_53) AT=1480.05n

.meas tran vdout1_54ck1470 FIND v(dout1_54) AT=1480.05n

.meas tran vdout1_55ck1470 FIND v(dout1_55) AT=1480.05n

.meas tran vdout1_56ck1470 FIND v(dout1_56) AT=1480.05n

.meas tran vdout1_57ck1470 FIND v(dout1_57) AT=1480.05n

.meas tran vdout1_58ck1470 FIND v(dout1_58) AT=1480.05n

.meas tran vdout1_59ck1470 FIND v(dout1_59) AT=1480.05n

.meas tran vdout1_60ck1470 FIND v(dout1_60) AT=1480.05n

.meas tran vdout1_61ck1470 FIND v(dout1_61) AT=1480.05n

.meas tran vdout1_62ck1470 FIND v(dout1_62) AT=1480.05n

.meas tran vdout1_63ck1470 FIND v(dout1_63) AT=1480.05n

.meas tran vdout0_0ck1480 FIND v(dout0_0) AT=1490.05n

.meas tran vdout0_1ck1480 FIND v(dout0_1) AT=1490.05n

.meas tran vdout0_2ck1480 FIND v(dout0_2) AT=1490.05n

.meas tran vdout0_3ck1480 FIND v(dout0_3) AT=1490.05n

.meas tran vdout0_4ck1480 FIND v(dout0_4) AT=1490.05n

.meas tran vdout0_5ck1480 FIND v(dout0_5) AT=1490.05n

.meas tran vdout0_6ck1480 FIND v(dout0_6) AT=1490.05n

.meas tran vdout0_7ck1480 FIND v(dout0_7) AT=1490.05n

.meas tran vdout0_8ck1480 FIND v(dout0_8) AT=1490.05n

.meas tran vdout0_9ck1480 FIND v(dout0_9) AT=1490.05n

.meas tran vdout0_10ck1480 FIND v(dout0_10) AT=1490.05n

.meas tran vdout0_11ck1480 FIND v(dout0_11) AT=1490.05n

.meas tran vdout0_12ck1480 FIND v(dout0_12) AT=1490.05n

.meas tran vdout0_13ck1480 FIND v(dout0_13) AT=1490.05n

.meas tran vdout0_14ck1480 FIND v(dout0_14) AT=1490.05n

.meas tran vdout0_15ck1480 FIND v(dout0_15) AT=1490.05n

.meas tran vdout0_16ck1480 FIND v(dout0_16) AT=1490.05n

.meas tran vdout0_17ck1480 FIND v(dout0_17) AT=1490.05n

.meas tran vdout0_18ck1480 FIND v(dout0_18) AT=1490.05n

.meas tran vdout0_19ck1480 FIND v(dout0_19) AT=1490.05n

.meas tran vdout0_20ck1480 FIND v(dout0_20) AT=1490.05n

.meas tran vdout0_21ck1480 FIND v(dout0_21) AT=1490.05n

.meas tran vdout0_22ck1480 FIND v(dout0_22) AT=1490.05n

.meas tran vdout0_23ck1480 FIND v(dout0_23) AT=1490.05n

.meas tran vdout0_24ck1480 FIND v(dout0_24) AT=1490.05n

.meas tran vdout0_25ck1480 FIND v(dout0_25) AT=1490.05n

.meas tran vdout0_26ck1480 FIND v(dout0_26) AT=1490.05n

.meas tran vdout0_27ck1480 FIND v(dout0_27) AT=1490.05n

.meas tran vdout0_28ck1480 FIND v(dout0_28) AT=1490.05n

.meas tran vdout0_29ck1480 FIND v(dout0_29) AT=1490.05n

.meas tran vdout0_30ck1480 FIND v(dout0_30) AT=1490.05n

.meas tran vdout0_31ck1480 FIND v(dout0_31) AT=1490.05n

.meas tran vdout0_32ck1480 FIND v(dout0_32) AT=1490.05n

.meas tran vdout0_33ck1480 FIND v(dout0_33) AT=1490.05n

.meas tran vdout0_34ck1480 FIND v(dout0_34) AT=1490.05n

.meas tran vdout0_35ck1480 FIND v(dout0_35) AT=1490.05n

.meas tran vdout0_36ck1480 FIND v(dout0_36) AT=1490.05n

.meas tran vdout0_37ck1480 FIND v(dout0_37) AT=1490.05n

.meas tran vdout0_38ck1480 FIND v(dout0_38) AT=1490.05n

.meas tran vdout0_39ck1480 FIND v(dout0_39) AT=1490.05n

.meas tran vdout0_40ck1480 FIND v(dout0_40) AT=1490.05n

.meas tran vdout0_41ck1480 FIND v(dout0_41) AT=1490.05n

.meas tran vdout0_42ck1480 FIND v(dout0_42) AT=1490.05n

.meas tran vdout0_43ck1480 FIND v(dout0_43) AT=1490.05n

.meas tran vdout0_44ck1480 FIND v(dout0_44) AT=1490.05n

.meas tran vdout0_45ck1480 FIND v(dout0_45) AT=1490.05n

.meas tran vdout0_46ck1480 FIND v(dout0_46) AT=1490.05n

.meas tran vdout0_47ck1480 FIND v(dout0_47) AT=1490.05n

.meas tran vdout0_48ck1480 FIND v(dout0_48) AT=1490.05n

.meas tran vdout0_49ck1480 FIND v(dout0_49) AT=1490.05n

.meas tran vdout0_50ck1480 FIND v(dout0_50) AT=1490.05n

.meas tran vdout0_51ck1480 FIND v(dout0_51) AT=1490.05n

.meas tran vdout0_52ck1480 FIND v(dout0_52) AT=1490.05n

.meas tran vdout0_53ck1480 FIND v(dout0_53) AT=1490.05n

.meas tran vdout0_54ck1480 FIND v(dout0_54) AT=1490.05n

.meas tran vdout0_55ck1480 FIND v(dout0_55) AT=1490.05n

.meas tran vdout0_56ck1480 FIND v(dout0_56) AT=1490.05n

.meas tran vdout0_57ck1480 FIND v(dout0_57) AT=1490.05n

.meas tran vdout0_58ck1480 FIND v(dout0_58) AT=1490.05n

.meas tran vdout0_59ck1480 FIND v(dout0_59) AT=1490.05n

.meas tran vdout0_60ck1480 FIND v(dout0_60) AT=1490.05n

.meas tran vdout0_61ck1480 FIND v(dout0_61) AT=1490.05n

.meas tran vdout0_62ck1480 FIND v(dout0_62) AT=1490.05n

.meas tran vdout0_63ck1480 FIND v(dout0_63) AT=1490.05n

.meas tran vdout0_0ck1510 FIND v(dout0_0) AT=1520.05n

.meas tran vdout0_1ck1510 FIND v(dout0_1) AT=1520.05n

.meas tran vdout0_2ck1510 FIND v(dout0_2) AT=1520.05n

.meas tran vdout0_3ck1510 FIND v(dout0_3) AT=1520.05n

.meas tran vdout0_4ck1510 FIND v(dout0_4) AT=1520.05n

.meas tran vdout0_5ck1510 FIND v(dout0_5) AT=1520.05n

.meas tran vdout0_6ck1510 FIND v(dout0_6) AT=1520.05n

.meas tran vdout0_7ck1510 FIND v(dout0_7) AT=1520.05n

.meas tran vdout0_8ck1510 FIND v(dout0_8) AT=1520.05n

.meas tran vdout0_9ck1510 FIND v(dout0_9) AT=1520.05n

.meas tran vdout0_10ck1510 FIND v(dout0_10) AT=1520.05n

.meas tran vdout0_11ck1510 FIND v(dout0_11) AT=1520.05n

.meas tran vdout0_12ck1510 FIND v(dout0_12) AT=1520.05n

.meas tran vdout0_13ck1510 FIND v(dout0_13) AT=1520.05n

.meas tran vdout0_14ck1510 FIND v(dout0_14) AT=1520.05n

.meas tran vdout0_15ck1510 FIND v(dout0_15) AT=1520.05n

.meas tran vdout0_16ck1510 FIND v(dout0_16) AT=1520.05n

.meas tran vdout0_17ck1510 FIND v(dout0_17) AT=1520.05n

.meas tran vdout0_18ck1510 FIND v(dout0_18) AT=1520.05n

.meas tran vdout0_19ck1510 FIND v(dout0_19) AT=1520.05n

.meas tran vdout0_20ck1510 FIND v(dout0_20) AT=1520.05n

.meas tran vdout0_21ck1510 FIND v(dout0_21) AT=1520.05n

.meas tran vdout0_22ck1510 FIND v(dout0_22) AT=1520.05n

.meas tran vdout0_23ck1510 FIND v(dout0_23) AT=1520.05n

.meas tran vdout0_24ck1510 FIND v(dout0_24) AT=1520.05n

.meas tran vdout0_25ck1510 FIND v(dout0_25) AT=1520.05n

.meas tran vdout0_26ck1510 FIND v(dout0_26) AT=1520.05n

.meas tran vdout0_27ck1510 FIND v(dout0_27) AT=1520.05n

.meas tran vdout0_28ck1510 FIND v(dout0_28) AT=1520.05n

.meas tran vdout0_29ck1510 FIND v(dout0_29) AT=1520.05n

.meas tran vdout0_30ck1510 FIND v(dout0_30) AT=1520.05n

.meas tran vdout0_31ck1510 FIND v(dout0_31) AT=1520.05n

.meas tran vdout0_32ck1510 FIND v(dout0_32) AT=1520.05n

.meas tran vdout0_33ck1510 FIND v(dout0_33) AT=1520.05n

.meas tran vdout0_34ck1510 FIND v(dout0_34) AT=1520.05n

.meas tran vdout0_35ck1510 FIND v(dout0_35) AT=1520.05n

.meas tran vdout0_36ck1510 FIND v(dout0_36) AT=1520.05n

.meas tran vdout0_37ck1510 FIND v(dout0_37) AT=1520.05n

.meas tran vdout0_38ck1510 FIND v(dout0_38) AT=1520.05n

.meas tran vdout0_39ck1510 FIND v(dout0_39) AT=1520.05n

.meas tran vdout0_40ck1510 FIND v(dout0_40) AT=1520.05n

.meas tran vdout0_41ck1510 FIND v(dout0_41) AT=1520.05n

.meas tran vdout0_42ck1510 FIND v(dout0_42) AT=1520.05n

.meas tran vdout0_43ck1510 FIND v(dout0_43) AT=1520.05n

.meas tran vdout0_44ck1510 FIND v(dout0_44) AT=1520.05n

.meas tran vdout0_45ck1510 FIND v(dout0_45) AT=1520.05n

.meas tran vdout0_46ck1510 FIND v(dout0_46) AT=1520.05n

.meas tran vdout0_47ck1510 FIND v(dout0_47) AT=1520.05n

.meas tran vdout0_48ck1510 FIND v(dout0_48) AT=1520.05n

.meas tran vdout0_49ck1510 FIND v(dout0_49) AT=1520.05n

.meas tran vdout0_50ck1510 FIND v(dout0_50) AT=1520.05n

.meas tran vdout0_51ck1510 FIND v(dout0_51) AT=1520.05n

.meas tran vdout0_52ck1510 FIND v(dout0_52) AT=1520.05n

.meas tran vdout0_53ck1510 FIND v(dout0_53) AT=1520.05n

.meas tran vdout0_54ck1510 FIND v(dout0_54) AT=1520.05n

.meas tran vdout0_55ck1510 FIND v(dout0_55) AT=1520.05n

.meas tran vdout0_56ck1510 FIND v(dout0_56) AT=1520.05n

.meas tran vdout0_57ck1510 FIND v(dout0_57) AT=1520.05n

.meas tran vdout0_58ck1510 FIND v(dout0_58) AT=1520.05n

.meas tran vdout0_59ck1510 FIND v(dout0_59) AT=1520.05n

.meas tran vdout0_60ck1510 FIND v(dout0_60) AT=1520.05n

.meas tran vdout0_61ck1510 FIND v(dout0_61) AT=1520.05n

.meas tran vdout0_62ck1510 FIND v(dout0_62) AT=1520.05n

.meas tran vdout0_63ck1510 FIND v(dout0_63) AT=1520.05n

.meas tran vdout0_0ck1520 FIND v(dout0_0) AT=1530.05n

.meas tran vdout0_1ck1520 FIND v(dout0_1) AT=1530.05n

.meas tran vdout0_2ck1520 FIND v(dout0_2) AT=1530.05n

.meas tran vdout0_3ck1520 FIND v(dout0_3) AT=1530.05n

.meas tran vdout0_4ck1520 FIND v(dout0_4) AT=1530.05n

.meas tran vdout0_5ck1520 FIND v(dout0_5) AT=1530.05n

.meas tran vdout0_6ck1520 FIND v(dout0_6) AT=1530.05n

.meas tran vdout0_7ck1520 FIND v(dout0_7) AT=1530.05n

.meas tran vdout0_8ck1520 FIND v(dout0_8) AT=1530.05n

.meas tran vdout0_9ck1520 FIND v(dout0_9) AT=1530.05n

.meas tran vdout0_10ck1520 FIND v(dout0_10) AT=1530.05n

.meas tran vdout0_11ck1520 FIND v(dout0_11) AT=1530.05n

.meas tran vdout0_12ck1520 FIND v(dout0_12) AT=1530.05n

.meas tran vdout0_13ck1520 FIND v(dout0_13) AT=1530.05n

.meas tran vdout0_14ck1520 FIND v(dout0_14) AT=1530.05n

.meas tran vdout0_15ck1520 FIND v(dout0_15) AT=1530.05n

.meas tran vdout0_16ck1520 FIND v(dout0_16) AT=1530.05n

.meas tran vdout0_17ck1520 FIND v(dout0_17) AT=1530.05n

.meas tran vdout0_18ck1520 FIND v(dout0_18) AT=1530.05n

.meas tran vdout0_19ck1520 FIND v(dout0_19) AT=1530.05n

.meas tran vdout0_20ck1520 FIND v(dout0_20) AT=1530.05n

.meas tran vdout0_21ck1520 FIND v(dout0_21) AT=1530.05n

.meas tran vdout0_22ck1520 FIND v(dout0_22) AT=1530.05n

.meas tran vdout0_23ck1520 FIND v(dout0_23) AT=1530.05n

.meas tran vdout0_24ck1520 FIND v(dout0_24) AT=1530.05n

.meas tran vdout0_25ck1520 FIND v(dout0_25) AT=1530.05n

.meas tran vdout0_26ck1520 FIND v(dout0_26) AT=1530.05n

.meas tran vdout0_27ck1520 FIND v(dout0_27) AT=1530.05n

.meas tran vdout0_28ck1520 FIND v(dout0_28) AT=1530.05n

.meas tran vdout0_29ck1520 FIND v(dout0_29) AT=1530.05n

.meas tran vdout0_30ck1520 FIND v(dout0_30) AT=1530.05n

.meas tran vdout0_31ck1520 FIND v(dout0_31) AT=1530.05n

.meas tran vdout0_32ck1520 FIND v(dout0_32) AT=1530.05n

.meas tran vdout0_33ck1520 FIND v(dout0_33) AT=1530.05n

.meas tran vdout0_34ck1520 FIND v(dout0_34) AT=1530.05n

.meas tran vdout0_35ck1520 FIND v(dout0_35) AT=1530.05n

.meas tran vdout0_36ck1520 FIND v(dout0_36) AT=1530.05n

.meas tran vdout0_37ck1520 FIND v(dout0_37) AT=1530.05n

.meas tran vdout0_38ck1520 FIND v(dout0_38) AT=1530.05n

.meas tran vdout0_39ck1520 FIND v(dout0_39) AT=1530.05n

.meas tran vdout0_40ck1520 FIND v(dout0_40) AT=1530.05n

.meas tran vdout0_41ck1520 FIND v(dout0_41) AT=1530.05n

.meas tran vdout0_42ck1520 FIND v(dout0_42) AT=1530.05n

.meas tran vdout0_43ck1520 FIND v(dout0_43) AT=1530.05n

.meas tran vdout0_44ck1520 FIND v(dout0_44) AT=1530.05n

.meas tran vdout0_45ck1520 FIND v(dout0_45) AT=1530.05n

.meas tran vdout0_46ck1520 FIND v(dout0_46) AT=1530.05n

.meas tran vdout0_47ck1520 FIND v(dout0_47) AT=1530.05n

.meas tran vdout0_48ck1520 FIND v(dout0_48) AT=1530.05n

.meas tran vdout0_49ck1520 FIND v(dout0_49) AT=1530.05n

.meas tran vdout0_50ck1520 FIND v(dout0_50) AT=1530.05n

.meas tran vdout0_51ck1520 FIND v(dout0_51) AT=1530.05n

.meas tran vdout0_52ck1520 FIND v(dout0_52) AT=1530.05n

.meas tran vdout0_53ck1520 FIND v(dout0_53) AT=1530.05n

.meas tran vdout0_54ck1520 FIND v(dout0_54) AT=1530.05n

.meas tran vdout0_55ck1520 FIND v(dout0_55) AT=1530.05n

.meas tran vdout0_56ck1520 FIND v(dout0_56) AT=1530.05n

.meas tran vdout0_57ck1520 FIND v(dout0_57) AT=1530.05n

.meas tran vdout0_58ck1520 FIND v(dout0_58) AT=1530.05n

.meas tran vdout0_59ck1520 FIND v(dout0_59) AT=1530.05n

.meas tran vdout0_60ck1520 FIND v(dout0_60) AT=1530.05n

.meas tran vdout0_61ck1520 FIND v(dout0_61) AT=1530.05n

.meas tran vdout0_62ck1520 FIND v(dout0_62) AT=1530.05n

.meas tran vdout0_63ck1520 FIND v(dout0_63) AT=1530.05n

.meas tran vdout0_0ck1530 FIND v(dout0_0) AT=1540.05n

.meas tran vdout0_1ck1530 FIND v(dout0_1) AT=1540.05n

.meas tran vdout0_2ck1530 FIND v(dout0_2) AT=1540.05n

.meas tran vdout0_3ck1530 FIND v(dout0_3) AT=1540.05n

.meas tran vdout0_4ck1530 FIND v(dout0_4) AT=1540.05n

.meas tran vdout0_5ck1530 FIND v(dout0_5) AT=1540.05n

.meas tran vdout0_6ck1530 FIND v(dout0_6) AT=1540.05n

.meas tran vdout0_7ck1530 FIND v(dout0_7) AT=1540.05n

.meas tran vdout0_8ck1530 FIND v(dout0_8) AT=1540.05n

.meas tran vdout0_9ck1530 FIND v(dout0_9) AT=1540.05n

.meas tran vdout0_10ck1530 FIND v(dout0_10) AT=1540.05n

.meas tran vdout0_11ck1530 FIND v(dout0_11) AT=1540.05n

.meas tran vdout0_12ck1530 FIND v(dout0_12) AT=1540.05n

.meas tran vdout0_13ck1530 FIND v(dout0_13) AT=1540.05n

.meas tran vdout0_14ck1530 FIND v(dout0_14) AT=1540.05n

.meas tran vdout0_15ck1530 FIND v(dout0_15) AT=1540.05n

.meas tran vdout0_16ck1530 FIND v(dout0_16) AT=1540.05n

.meas tran vdout0_17ck1530 FIND v(dout0_17) AT=1540.05n

.meas tran vdout0_18ck1530 FIND v(dout0_18) AT=1540.05n

.meas tran vdout0_19ck1530 FIND v(dout0_19) AT=1540.05n

.meas tran vdout0_20ck1530 FIND v(dout0_20) AT=1540.05n

.meas tran vdout0_21ck1530 FIND v(dout0_21) AT=1540.05n

.meas tran vdout0_22ck1530 FIND v(dout0_22) AT=1540.05n

.meas tran vdout0_23ck1530 FIND v(dout0_23) AT=1540.05n

.meas tran vdout0_24ck1530 FIND v(dout0_24) AT=1540.05n

.meas tran vdout0_25ck1530 FIND v(dout0_25) AT=1540.05n

.meas tran vdout0_26ck1530 FIND v(dout0_26) AT=1540.05n

.meas tran vdout0_27ck1530 FIND v(dout0_27) AT=1540.05n

.meas tran vdout0_28ck1530 FIND v(dout0_28) AT=1540.05n

.meas tran vdout0_29ck1530 FIND v(dout0_29) AT=1540.05n

.meas tran vdout0_30ck1530 FIND v(dout0_30) AT=1540.05n

.meas tran vdout0_31ck1530 FIND v(dout0_31) AT=1540.05n

.meas tran vdout0_32ck1530 FIND v(dout0_32) AT=1540.05n

.meas tran vdout0_33ck1530 FIND v(dout0_33) AT=1540.05n

.meas tran vdout0_34ck1530 FIND v(dout0_34) AT=1540.05n

.meas tran vdout0_35ck1530 FIND v(dout0_35) AT=1540.05n

.meas tran vdout0_36ck1530 FIND v(dout0_36) AT=1540.05n

.meas tran vdout0_37ck1530 FIND v(dout0_37) AT=1540.05n

.meas tran vdout0_38ck1530 FIND v(dout0_38) AT=1540.05n

.meas tran vdout0_39ck1530 FIND v(dout0_39) AT=1540.05n

.meas tran vdout0_40ck1530 FIND v(dout0_40) AT=1540.05n

.meas tran vdout0_41ck1530 FIND v(dout0_41) AT=1540.05n

.meas tran vdout0_42ck1530 FIND v(dout0_42) AT=1540.05n

.meas tran vdout0_43ck1530 FIND v(dout0_43) AT=1540.05n

.meas tran vdout0_44ck1530 FIND v(dout0_44) AT=1540.05n

.meas tran vdout0_45ck1530 FIND v(dout0_45) AT=1540.05n

.meas tran vdout0_46ck1530 FIND v(dout0_46) AT=1540.05n

.meas tran vdout0_47ck1530 FIND v(dout0_47) AT=1540.05n

.meas tran vdout0_48ck1530 FIND v(dout0_48) AT=1540.05n

.meas tran vdout0_49ck1530 FIND v(dout0_49) AT=1540.05n

.meas tran vdout0_50ck1530 FIND v(dout0_50) AT=1540.05n

.meas tran vdout0_51ck1530 FIND v(dout0_51) AT=1540.05n

.meas tran vdout0_52ck1530 FIND v(dout0_52) AT=1540.05n

.meas tran vdout0_53ck1530 FIND v(dout0_53) AT=1540.05n

.meas tran vdout0_54ck1530 FIND v(dout0_54) AT=1540.05n

.meas tran vdout0_55ck1530 FIND v(dout0_55) AT=1540.05n

.meas tran vdout0_56ck1530 FIND v(dout0_56) AT=1540.05n

.meas tran vdout0_57ck1530 FIND v(dout0_57) AT=1540.05n

.meas tran vdout0_58ck1530 FIND v(dout0_58) AT=1540.05n

.meas tran vdout0_59ck1530 FIND v(dout0_59) AT=1540.05n

.meas tran vdout0_60ck1530 FIND v(dout0_60) AT=1540.05n

.meas tran vdout0_61ck1530 FIND v(dout0_61) AT=1540.05n

.meas tran vdout0_62ck1530 FIND v(dout0_62) AT=1540.05n

.meas tran vdout0_63ck1530 FIND v(dout0_63) AT=1540.05n

.meas tran vdout1_0ck1540 FIND v(dout1_0) AT=1550.05n

.meas tran vdout1_1ck1540 FIND v(dout1_1) AT=1550.05n

.meas tran vdout1_2ck1540 FIND v(dout1_2) AT=1550.05n

.meas tran vdout1_3ck1540 FIND v(dout1_3) AT=1550.05n

.meas tran vdout1_4ck1540 FIND v(dout1_4) AT=1550.05n

.meas tran vdout1_5ck1540 FIND v(dout1_5) AT=1550.05n

.meas tran vdout1_6ck1540 FIND v(dout1_6) AT=1550.05n

.meas tran vdout1_7ck1540 FIND v(dout1_7) AT=1550.05n

.meas tran vdout1_8ck1540 FIND v(dout1_8) AT=1550.05n

.meas tran vdout1_9ck1540 FIND v(dout1_9) AT=1550.05n

.meas tran vdout1_10ck1540 FIND v(dout1_10) AT=1550.05n

.meas tran vdout1_11ck1540 FIND v(dout1_11) AT=1550.05n

.meas tran vdout1_12ck1540 FIND v(dout1_12) AT=1550.05n

.meas tran vdout1_13ck1540 FIND v(dout1_13) AT=1550.05n

.meas tran vdout1_14ck1540 FIND v(dout1_14) AT=1550.05n

.meas tran vdout1_15ck1540 FIND v(dout1_15) AT=1550.05n

.meas tran vdout1_16ck1540 FIND v(dout1_16) AT=1550.05n

.meas tran vdout1_17ck1540 FIND v(dout1_17) AT=1550.05n

.meas tran vdout1_18ck1540 FIND v(dout1_18) AT=1550.05n

.meas tran vdout1_19ck1540 FIND v(dout1_19) AT=1550.05n

.meas tran vdout1_20ck1540 FIND v(dout1_20) AT=1550.05n

.meas tran vdout1_21ck1540 FIND v(dout1_21) AT=1550.05n

.meas tran vdout1_22ck1540 FIND v(dout1_22) AT=1550.05n

.meas tran vdout1_23ck1540 FIND v(dout1_23) AT=1550.05n

.meas tran vdout1_24ck1540 FIND v(dout1_24) AT=1550.05n

.meas tran vdout1_25ck1540 FIND v(dout1_25) AT=1550.05n

.meas tran vdout1_26ck1540 FIND v(dout1_26) AT=1550.05n

.meas tran vdout1_27ck1540 FIND v(dout1_27) AT=1550.05n

.meas tran vdout1_28ck1540 FIND v(dout1_28) AT=1550.05n

.meas tran vdout1_29ck1540 FIND v(dout1_29) AT=1550.05n

.meas tran vdout1_30ck1540 FIND v(dout1_30) AT=1550.05n

.meas tran vdout1_31ck1540 FIND v(dout1_31) AT=1550.05n

.meas tran vdout1_32ck1540 FIND v(dout1_32) AT=1550.05n

.meas tran vdout1_33ck1540 FIND v(dout1_33) AT=1550.05n

.meas tran vdout1_34ck1540 FIND v(dout1_34) AT=1550.05n

.meas tran vdout1_35ck1540 FIND v(dout1_35) AT=1550.05n

.meas tran vdout1_36ck1540 FIND v(dout1_36) AT=1550.05n

.meas tran vdout1_37ck1540 FIND v(dout1_37) AT=1550.05n

.meas tran vdout1_38ck1540 FIND v(dout1_38) AT=1550.05n

.meas tran vdout1_39ck1540 FIND v(dout1_39) AT=1550.05n

.meas tran vdout1_40ck1540 FIND v(dout1_40) AT=1550.05n

.meas tran vdout1_41ck1540 FIND v(dout1_41) AT=1550.05n

.meas tran vdout1_42ck1540 FIND v(dout1_42) AT=1550.05n

.meas tran vdout1_43ck1540 FIND v(dout1_43) AT=1550.05n

.meas tran vdout1_44ck1540 FIND v(dout1_44) AT=1550.05n

.meas tran vdout1_45ck1540 FIND v(dout1_45) AT=1550.05n

.meas tran vdout1_46ck1540 FIND v(dout1_46) AT=1550.05n

.meas tran vdout1_47ck1540 FIND v(dout1_47) AT=1550.05n

.meas tran vdout1_48ck1540 FIND v(dout1_48) AT=1550.05n

.meas tran vdout1_49ck1540 FIND v(dout1_49) AT=1550.05n

.meas tran vdout1_50ck1540 FIND v(dout1_50) AT=1550.05n

.meas tran vdout1_51ck1540 FIND v(dout1_51) AT=1550.05n

.meas tran vdout1_52ck1540 FIND v(dout1_52) AT=1550.05n

.meas tran vdout1_53ck1540 FIND v(dout1_53) AT=1550.05n

.meas tran vdout1_54ck1540 FIND v(dout1_54) AT=1550.05n

.meas tran vdout1_55ck1540 FIND v(dout1_55) AT=1550.05n

.meas tran vdout1_56ck1540 FIND v(dout1_56) AT=1550.05n

.meas tran vdout1_57ck1540 FIND v(dout1_57) AT=1550.05n

.meas tran vdout1_58ck1540 FIND v(dout1_58) AT=1550.05n

.meas tran vdout1_59ck1540 FIND v(dout1_59) AT=1550.05n

.meas tran vdout1_60ck1540 FIND v(dout1_60) AT=1550.05n

.meas tran vdout1_61ck1540 FIND v(dout1_61) AT=1550.05n

.meas tran vdout1_62ck1540 FIND v(dout1_62) AT=1550.05n

.meas tran vdout1_63ck1540 FIND v(dout1_63) AT=1550.05n

.meas tran vdout0_0ck1560 FIND v(dout0_0) AT=1570.05n

.meas tran vdout0_1ck1560 FIND v(dout0_1) AT=1570.05n

.meas tran vdout0_2ck1560 FIND v(dout0_2) AT=1570.05n

.meas tran vdout0_3ck1560 FIND v(dout0_3) AT=1570.05n

.meas tran vdout0_4ck1560 FIND v(dout0_4) AT=1570.05n

.meas tran vdout0_5ck1560 FIND v(dout0_5) AT=1570.05n

.meas tran vdout0_6ck1560 FIND v(dout0_6) AT=1570.05n

.meas tran vdout0_7ck1560 FIND v(dout0_7) AT=1570.05n

.meas tran vdout0_8ck1560 FIND v(dout0_8) AT=1570.05n

.meas tran vdout0_9ck1560 FIND v(dout0_9) AT=1570.05n

.meas tran vdout0_10ck1560 FIND v(dout0_10) AT=1570.05n

.meas tran vdout0_11ck1560 FIND v(dout0_11) AT=1570.05n

.meas tran vdout0_12ck1560 FIND v(dout0_12) AT=1570.05n

.meas tran vdout0_13ck1560 FIND v(dout0_13) AT=1570.05n

.meas tran vdout0_14ck1560 FIND v(dout0_14) AT=1570.05n

.meas tran vdout0_15ck1560 FIND v(dout0_15) AT=1570.05n

.meas tran vdout0_16ck1560 FIND v(dout0_16) AT=1570.05n

.meas tran vdout0_17ck1560 FIND v(dout0_17) AT=1570.05n

.meas tran vdout0_18ck1560 FIND v(dout0_18) AT=1570.05n

.meas tran vdout0_19ck1560 FIND v(dout0_19) AT=1570.05n

.meas tran vdout0_20ck1560 FIND v(dout0_20) AT=1570.05n

.meas tran vdout0_21ck1560 FIND v(dout0_21) AT=1570.05n

.meas tran vdout0_22ck1560 FIND v(dout0_22) AT=1570.05n

.meas tran vdout0_23ck1560 FIND v(dout0_23) AT=1570.05n

.meas tran vdout0_24ck1560 FIND v(dout0_24) AT=1570.05n

.meas tran vdout0_25ck1560 FIND v(dout0_25) AT=1570.05n

.meas tran vdout0_26ck1560 FIND v(dout0_26) AT=1570.05n

.meas tran vdout0_27ck1560 FIND v(dout0_27) AT=1570.05n

.meas tran vdout0_28ck1560 FIND v(dout0_28) AT=1570.05n

.meas tran vdout0_29ck1560 FIND v(dout0_29) AT=1570.05n

.meas tran vdout0_30ck1560 FIND v(dout0_30) AT=1570.05n

.meas tran vdout0_31ck1560 FIND v(dout0_31) AT=1570.05n

.meas tran vdout0_32ck1560 FIND v(dout0_32) AT=1570.05n

.meas tran vdout0_33ck1560 FIND v(dout0_33) AT=1570.05n

.meas tran vdout0_34ck1560 FIND v(dout0_34) AT=1570.05n

.meas tran vdout0_35ck1560 FIND v(dout0_35) AT=1570.05n

.meas tran vdout0_36ck1560 FIND v(dout0_36) AT=1570.05n

.meas tran vdout0_37ck1560 FIND v(dout0_37) AT=1570.05n

.meas tran vdout0_38ck1560 FIND v(dout0_38) AT=1570.05n

.meas tran vdout0_39ck1560 FIND v(dout0_39) AT=1570.05n

.meas tran vdout0_40ck1560 FIND v(dout0_40) AT=1570.05n

.meas tran vdout0_41ck1560 FIND v(dout0_41) AT=1570.05n

.meas tran vdout0_42ck1560 FIND v(dout0_42) AT=1570.05n

.meas tran vdout0_43ck1560 FIND v(dout0_43) AT=1570.05n

.meas tran vdout0_44ck1560 FIND v(dout0_44) AT=1570.05n

.meas tran vdout0_45ck1560 FIND v(dout0_45) AT=1570.05n

.meas tran vdout0_46ck1560 FIND v(dout0_46) AT=1570.05n

.meas tran vdout0_47ck1560 FIND v(dout0_47) AT=1570.05n

.meas tran vdout0_48ck1560 FIND v(dout0_48) AT=1570.05n

.meas tran vdout0_49ck1560 FIND v(dout0_49) AT=1570.05n

.meas tran vdout0_50ck1560 FIND v(dout0_50) AT=1570.05n

.meas tran vdout0_51ck1560 FIND v(dout0_51) AT=1570.05n

.meas tran vdout0_52ck1560 FIND v(dout0_52) AT=1570.05n

.meas tran vdout0_53ck1560 FIND v(dout0_53) AT=1570.05n

.meas tran vdout0_54ck1560 FIND v(dout0_54) AT=1570.05n

.meas tran vdout0_55ck1560 FIND v(dout0_55) AT=1570.05n

.meas tran vdout0_56ck1560 FIND v(dout0_56) AT=1570.05n

.meas tran vdout0_57ck1560 FIND v(dout0_57) AT=1570.05n

.meas tran vdout0_58ck1560 FIND v(dout0_58) AT=1570.05n

.meas tran vdout0_59ck1560 FIND v(dout0_59) AT=1570.05n

.meas tran vdout0_60ck1560 FIND v(dout0_60) AT=1570.05n

.meas tran vdout0_61ck1560 FIND v(dout0_61) AT=1570.05n

.meas tran vdout0_62ck1560 FIND v(dout0_62) AT=1570.05n

.meas tran vdout0_63ck1560 FIND v(dout0_63) AT=1570.05n

.meas tran vdout1_0ck1560 FIND v(dout1_0) AT=1570.05n

.meas tran vdout1_1ck1560 FIND v(dout1_1) AT=1570.05n

.meas tran vdout1_2ck1560 FIND v(dout1_2) AT=1570.05n

.meas tran vdout1_3ck1560 FIND v(dout1_3) AT=1570.05n

.meas tran vdout1_4ck1560 FIND v(dout1_4) AT=1570.05n

.meas tran vdout1_5ck1560 FIND v(dout1_5) AT=1570.05n

.meas tran vdout1_6ck1560 FIND v(dout1_6) AT=1570.05n

.meas tran vdout1_7ck1560 FIND v(dout1_7) AT=1570.05n

.meas tran vdout1_8ck1560 FIND v(dout1_8) AT=1570.05n

.meas tran vdout1_9ck1560 FIND v(dout1_9) AT=1570.05n

.meas tran vdout1_10ck1560 FIND v(dout1_10) AT=1570.05n

.meas tran vdout1_11ck1560 FIND v(dout1_11) AT=1570.05n

.meas tran vdout1_12ck1560 FIND v(dout1_12) AT=1570.05n

.meas tran vdout1_13ck1560 FIND v(dout1_13) AT=1570.05n

.meas tran vdout1_14ck1560 FIND v(dout1_14) AT=1570.05n

.meas tran vdout1_15ck1560 FIND v(dout1_15) AT=1570.05n

.meas tran vdout1_16ck1560 FIND v(dout1_16) AT=1570.05n

.meas tran vdout1_17ck1560 FIND v(dout1_17) AT=1570.05n

.meas tran vdout1_18ck1560 FIND v(dout1_18) AT=1570.05n

.meas tran vdout1_19ck1560 FIND v(dout1_19) AT=1570.05n

.meas tran vdout1_20ck1560 FIND v(dout1_20) AT=1570.05n

.meas tran vdout1_21ck1560 FIND v(dout1_21) AT=1570.05n

.meas tran vdout1_22ck1560 FIND v(dout1_22) AT=1570.05n

.meas tran vdout1_23ck1560 FIND v(dout1_23) AT=1570.05n

.meas tran vdout1_24ck1560 FIND v(dout1_24) AT=1570.05n

.meas tran vdout1_25ck1560 FIND v(dout1_25) AT=1570.05n

.meas tran vdout1_26ck1560 FIND v(dout1_26) AT=1570.05n

.meas tran vdout1_27ck1560 FIND v(dout1_27) AT=1570.05n

.meas tran vdout1_28ck1560 FIND v(dout1_28) AT=1570.05n

.meas tran vdout1_29ck1560 FIND v(dout1_29) AT=1570.05n

.meas tran vdout1_30ck1560 FIND v(dout1_30) AT=1570.05n

.meas tran vdout1_31ck1560 FIND v(dout1_31) AT=1570.05n

.meas tran vdout1_32ck1560 FIND v(dout1_32) AT=1570.05n

.meas tran vdout1_33ck1560 FIND v(dout1_33) AT=1570.05n

.meas tran vdout1_34ck1560 FIND v(dout1_34) AT=1570.05n

.meas tran vdout1_35ck1560 FIND v(dout1_35) AT=1570.05n

.meas tran vdout1_36ck1560 FIND v(dout1_36) AT=1570.05n

.meas tran vdout1_37ck1560 FIND v(dout1_37) AT=1570.05n

.meas tran vdout1_38ck1560 FIND v(dout1_38) AT=1570.05n

.meas tran vdout1_39ck1560 FIND v(dout1_39) AT=1570.05n

.meas tran vdout1_40ck1560 FIND v(dout1_40) AT=1570.05n

.meas tran vdout1_41ck1560 FIND v(dout1_41) AT=1570.05n

.meas tran vdout1_42ck1560 FIND v(dout1_42) AT=1570.05n

.meas tran vdout1_43ck1560 FIND v(dout1_43) AT=1570.05n

.meas tran vdout1_44ck1560 FIND v(dout1_44) AT=1570.05n

.meas tran vdout1_45ck1560 FIND v(dout1_45) AT=1570.05n

.meas tran vdout1_46ck1560 FIND v(dout1_46) AT=1570.05n

.meas tran vdout1_47ck1560 FIND v(dout1_47) AT=1570.05n

.meas tran vdout1_48ck1560 FIND v(dout1_48) AT=1570.05n

.meas tran vdout1_49ck1560 FIND v(dout1_49) AT=1570.05n

.meas tran vdout1_50ck1560 FIND v(dout1_50) AT=1570.05n

.meas tran vdout1_51ck1560 FIND v(dout1_51) AT=1570.05n

.meas tran vdout1_52ck1560 FIND v(dout1_52) AT=1570.05n

.meas tran vdout1_53ck1560 FIND v(dout1_53) AT=1570.05n

.meas tran vdout1_54ck1560 FIND v(dout1_54) AT=1570.05n

.meas tran vdout1_55ck1560 FIND v(dout1_55) AT=1570.05n

.meas tran vdout1_56ck1560 FIND v(dout1_56) AT=1570.05n

.meas tran vdout1_57ck1560 FIND v(dout1_57) AT=1570.05n

.meas tran vdout1_58ck1560 FIND v(dout1_58) AT=1570.05n

.meas tran vdout1_59ck1560 FIND v(dout1_59) AT=1570.05n

.meas tran vdout1_60ck1560 FIND v(dout1_60) AT=1570.05n

.meas tran vdout1_61ck1560 FIND v(dout1_61) AT=1570.05n

.meas tran vdout1_62ck1560 FIND v(dout1_62) AT=1570.05n

.meas tran vdout1_63ck1560 FIND v(dout1_63) AT=1570.05n

.meas tran vdout1_0ck1570 FIND v(dout1_0) AT=1580.05n

.meas tran vdout1_1ck1570 FIND v(dout1_1) AT=1580.05n

.meas tran vdout1_2ck1570 FIND v(dout1_2) AT=1580.05n

.meas tran vdout1_3ck1570 FIND v(dout1_3) AT=1580.05n

.meas tran vdout1_4ck1570 FIND v(dout1_4) AT=1580.05n

.meas tran vdout1_5ck1570 FIND v(dout1_5) AT=1580.05n

.meas tran vdout1_6ck1570 FIND v(dout1_6) AT=1580.05n

.meas tran vdout1_7ck1570 FIND v(dout1_7) AT=1580.05n

.meas tran vdout1_8ck1570 FIND v(dout1_8) AT=1580.05n

.meas tran vdout1_9ck1570 FIND v(dout1_9) AT=1580.05n

.meas tran vdout1_10ck1570 FIND v(dout1_10) AT=1580.05n

.meas tran vdout1_11ck1570 FIND v(dout1_11) AT=1580.05n

.meas tran vdout1_12ck1570 FIND v(dout1_12) AT=1580.05n

.meas tran vdout1_13ck1570 FIND v(dout1_13) AT=1580.05n

.meas tran vdout1_14ck1570 FIND v(dout1_14) AT=1580.05n

.meas tran vdout1_15ck1570 FIND v(dout1_15) AT=1580.05n

.meas tran vdout1_16ck1570 FIND v(dout1_16) AT=1580.05n

.meas tran vdout1_17ck1570 FIND v(dout1_17) AT=1580.05n

.meas tran vdout1_18ck1570 FIND v(dout1_18) AT=1580.05n

.meas tran vdout1_19ck1570 FIND v(dout1_19) AT=1580.05n

.meas tran vdout1_20ck1570 FIND v(dout1_20) AT=1580.05n

.meas tran vdout1_21ck1570 FIND v(dout1_21) AT=1580.05n

.meas tran vdout1_22ck1570 FIND v(dout1_22) AT=1580.05n

.meas tran vdout1_23ck1570 FIND v(dout1_23) AT=1580.05n

.meas tran vdout1_24ck1570 FIND v(dout1_24) AT=1580.05n

.meas tran vdout1_25ck1570 FIND v(dout1_25) AT=1580.05n

.meas tran vdout1_26ck1570 FIND v(dout1_26) AT=1580.05n

.meas tran vdout1_27ck1570 FIND v(dout1_27) AT=1580.05n

.meas tran vdout1_28ck1570 FIND v(dout1_28) AT=1580.05n

.meas tran vdout1_29ck1570 FIND v(dout1_29) AT=1580.05n

.meas tran vdout1_30ck1570 FIND v(dout1_30) AT=1580.05n

.meas tran vdout1_31ck1570 FIND v(dout1_31) AT=1580.05n

.meas tran vdout1_32ck1570 FIND v(dout1_32) AT=1580.05n

.meas tran vdout1_33ck1570 FIND v(dout1_33) AT=1580.05n

.meas tran vdout1_34ck1570 FIND v(dout1_34) AT=1580.05n

.meas tran vdout1_35ck1570 FIND v(dout1_35) AT=1580.05n

.meas tran vdout1_36ck1570 FIND v(dout1_36) AT=1580.05n

.meas tran vdout1_37ck1570 FIND v(dout1_37) AT=1580.05n

.meas tran vdout1_38ck1570 FIND v(dout1_38) AT=1580.05n

.meas tran vdout1_39ck1570 FIND v(dout1_39) AT=1580.05n

.meas tran vdout1_40ck1570 FIND v(dout1_40) AT=1580.05n

.meas tran vdout1_41ck1570 FIND v(dout1_41) AT=1580.05n

.meas tran vdout1_42ck1570 FIND v(dout1_42) AT=1580.05n

.meas tran vdout1_43ck1570 FIND v(dout1_43) AT=1580.05n

.meas tran vdout1_44ck1570 FIND v(dout1_44) AT=1580.05n

.meas tran vdout1_45ck1570 FIND v(dout1_45) AT=1580.05n

.meas tran vdout1_46ck1570 FIND v(dout1_46) AT=1580.05n

.meas tran vdout1_47ck1570 FIND v(dout1_47) AT=1580.05n

.meas tran vdout1_48ck1570 FIND v(dout1_48) AT=1580.05n

.meas tran vdout1_49ck1570 FIND v(dout1_49) AT=1580.05n

.meas tran vdout1_50ck1570 FIND v(dout1_50) AT=1580.05n

.meas tran vdout1_51ck1570 FIND v(dout1_51) AT=1580.05n

.meas tran vdout1_52ck1570 FIND v(dout1_52) AT=1580.05n

.meas tran vdout1_53ck1570 FIND v(dout1_53) AT=1580.05n

.meas tran vdout1_54ck1570 FIND v(dout1_54) AT=1580.05n

.meas tran vdout1_55ck1570 FIND v(dout1_55) AT=1580.05n

.meas tran vdout1_56ck1570 FIND v(dout1_56) AT=1580.05n

.meas tran vdout1_57ck1570 FIND v(dout1_57) AT=1580.05n

.meas tran vdout1_58ck1570 FIND v(dout1_58) AT=1580.05n

.meas tran vdout1_59ck1570 FIND v(dout1_59) AT=1580.05n

.meas tran vdout1_60ck1570 FIND v(dout1_60) AT=1580.05n

.meas tran vdout1_61ck1570 FIND v(dout1_61) AT=1580.05n

.meas tran vdout1_62ck1570 FIND v(dout1_62) AT=1580.05n

.meas tran vdout1_63ck1570 FIND v(dout1_63) AT=1580.05n

.meas tran vdout1_0ck1590 FIND v(dout1_0) AT=1600.05n

.meas tran vdout1_1ck1590 FIND v(dout1_1) AT=1600.05n

.meas tran vdout1_2ck1590 FIND v(dout1_2) AT=1600.05n

.meas tran vdout1_3ck1590 FIND v(dout1_3) AT=1600.05n

.meas tran vdout1_4ck1590 FIND v(dout1_4) AT=1600.05n

.meas tran vdout1_5ck1590 FIND v(dout1_5) AT=1600.05n

.meas tran vdout1_6ck1590 FIND v(dout1_6) AT=1600.05n

.meas tran vdout1_7ck1590 FIND v(dout1_7) AT=1600.05n

.meas tran vdout1_8ck1590 FIND v(dout1_8) AT=1600.05n

.meas tran vdout1_9ck1590 FIND v(dout1_9) AT=1600.05n

.meas tran vdout1_10ck1590 FIND v(dout1_10) AT=1600.05n

.meas tran vdout1_11ck1590 FIND v(dout1_11) AT=1600.05n

.meas tran vdout1_12ck1590 FIND v(dout1_12) AT=1600.05n

.meas tran vdout1_13ck1590 FIND v(dout1_13) AT=1600.05n

.meas tran vdout1_14ck1590 FIND v(dout1_14) AT=1600.05n

.meas tran vdout1_15ck1590 FIND v(dout1_15) AT=1600.05n

.meas tran vdout1_16ck1590 FIND v(dout1_16) AT=1600.05n

.meas tran vdout1_17ck1590 FIND v(dout1_17) AT=1600.05n

.meas tran vdout1_18ck1590 FIND v(dout1_18) AT=1600.05n

.meas tran vdout1_19ck1590 FIND v(dout1_19) AT=1600.05n

.meas tran vdout1_20ck1590 FIND v(dout1_20) AT=1600.05n

.meas tran vdout1_21ck1590 FIND v(dout1_21) AT=1600.05n

.meas tran vdout1_22ck1590 FIND v(dout1_22) AT=1600.05n

.meas tran vdout1_23ck1590 FIND v(dout1_23) AT=1600.05n

.meas tran vdout1_24ck1590 FIND v(dout1_24) AT=1600.05n

.meas tran vdout1_25ck1590 FIND v(dout1_25) AT=1600.05n

.meas tran vdout1_26ck1590 FIND v(dout1_26) AT=1600.05n

.meas tran vdout1_27ck1590 FIND v(dout1_27) AT=1600.05n

.meas tran vdout1_28ck1590 FIND v(dout1_28) AT=1600.05n

.meas tran vdout1_29ck1590 FIND v(dout1_29) AT=1600.05n

.meas tran vdout1_30ck1590 FIND v(dout1_30) AT=1600.05n

.meas tran vdout1_31ck1590 FIND v(dout1_31) AT=1600.05n

.meas tran vdout1_32ck1590 FIND v(dout1_32) AT=1600.05n

.meas tran vdout1_33ck1590 FIND v(dout1_33) AT=1600.05n

.meas tran vdout1_34ck1590 FIND v(dout1_34) AT=1600.05n

.meas tran vdout1_35ck1590 FIND v(dout1_35) AT=1600.05n

.meas tran vdout1_36ck1590 FIND v(dout1_36) AT=1600.05n

.meas tran vdout1_37ck1590 FIND v(dout1_37) AT=1600.05n

.meas tran vdout1_38ck1590 FIND v(dout1_38) AT=1600.05n

.meas tran vdout1_39ck1590 FIND v(dout1_39) AT=1600.05n

.meas tran vdout1_40ck1590 FIND v(dout1_40) AT=1600.05n

.meas tran vdout1_41ck1590 FIND v(dout1_41) AT=1600.05n

.meas tran vdout1_42ck1590 FIND v(dout1_42) AT=1600.05n

.meas tran vdout1_43ck1590 FIND v(dout1_43) AT=1600.05n

.meas tran vdout1_44ck1590 FIND v(dout1_44) AT=1600.05n

.meas tran vdout1_45ck1590 FIND v(dout1_45) AT=1600.05n

.meas tran vdout1_46ck1590 FIND v(dout1_46) AT=1600.05n

.meas tran vdout1_47ck1590 FIND v(dout1_47) AT=1600.05n

.meas tran vdout1_48ck1590 FIND v(dout1_48) AT=1600.05n

.meas tran vdout1_49ck1590 FIND v(dout1_49) AT=1600.05n

.meas tran vdout1_50ck1590 FIND v(dout1_50) AT=1600.05n

.meas tran vdout1_51ck1590 FIND v(dout1_51) AT=1600.05n

.meas tran vdout1_52ck1590 FIND v(dout1_52) AT=1600.05n

.meas tran vdout1_53ck1590 FIND v(dout1_53) AT=1600.05n

.meas tran vdout1_54ck1590 FIND v(dout1_54) AT=1600.05n

.meas tran vdout1_55ck1590 FIND v(dout1_55) AT=1600.05n

.meas tran vdout1_56ck1590 FIND v(dout1_56) AT=1600.05n

.meas tran vdout1_57ck1590 FIND v(dout1_57) AT=1600.05n

.meas tran vdout1_58ck1590 FIND v(dout1_58) AT=1600.05n

.meas tran vdout1_59ck1590 FIND v(dout1_59) AT=1600.05n

.meas tran vdout1_60ck1590 FIND v(dout1_60) AT=1600.05n

.meas tran vdout1_61ck1590 FIND v(dout1_61) AT=1600.05n

.meas tran vdout1_62ck1590 FIND v(dout1_62) AT=1600.05n

.meas tran vdout1_63ck1590 FIND v(dout1_63) AT=1600.05n

.meas tran vdout0_0ck1600 FIND v(dout0_0) AT=1610.05n

.meas tran vdout0_1ck1600 FIND v(dout0_1) AT=1610.05n

.meas tran vdout0_2ck1600 FIND v(dout0_2) AT=1610.05n

.meas tran vdout0_3ck1600 FIND v(dout0_3) AT=1610.05n

.meas tran vdout0_4ck1600 FIND v(dout0_4) AT=1610.05n

.meas tran vdout0_5ck1600 FIND v(dout0_5) AT=1610.05n

.meas tran vdout0_6ck1600 FIND v(dout0_6) AT=1610.05n

.meas tran vdout0_7ck1600 FIND v(dout0_7) AT=1610.05n

.meas tran vdout0_8ck1600 FIND v(dout0_8) AT=1610.05n

.meas tran vdout0_9ck1600 FIND v(dout0_9) AT=1610.05n

.meas tran vdout0_10ck1600 FIND v(dout0_10) AT=1610.05n

.meas tran vdout0_11ck1600 FIND v(dout0_11) AT=1610.05n

.meas tran vdout0_12ck1600 FIND v(dout0_12) AT=1610.05n

.meas tran vdout0_13ck1600 FIND v(dout0_13) AT=1610.05n

.meas tran vdout0_14ck1600 FIND v(dout0_14) AT=1610.05n

.meas tran vdout0_15ck1600 FIND v(dout0_15) AT=1610.05n

.meas tran vdout0_16ck1600 FIND v(dout0_16) AT=1610.05n

.meas tran vdout0_17ck1600 FIND v(dout0_17) AT=1610.05n

.meas tran vdout0_18ck1600 FIND v(dout0_18) AT=1610.05n

.meas tran vdout0_19ck1600 FIND v(dout0_19) AT=1610.05n

.meas tran vdout0_20ck1600 FIND v(dout0_20) AT=1610.05n

.meas tran vdout0_21ck1600 FIND v(dout0_21) AT=1610.05n

.meas tran vdout0_22ck1600 FIND v(dout0_22) AT=1610.05n

.meas tran vdout0_23ck1600 FIND v(dout0_23) AT=1610.05n

.meas tran vdout0_24ck1600 FIND v(dout0_24) AT=1610.05n

.meas tran vdout0_25ck1600 FIND v(dout0_25) AT=1610.05n

.meas tran vdout0_26ck1600 FIND v(dout0_26) AT=1610.05n

.meas tran vdout0_27ck1600 FIND v(dout0_27) AT=1610.05n

.meas tran vdout0_28ck1600 FIND v(dout0_28) AT=1610.05n

.meas tran vdout0_29ck1600 FIND v(dout0_29) AT=1610.05n

.meas tran vdout0_30ck1600 FIND v(dout0_30) AT=1610.05n

.meas tran vdout0_31ck1600 FIND v(dout0_31) AT=1610.05n

.meas tran vdout0_32ck1600 FIND v(dout0_32) AT=1610.05n

.meas tran vdout0_33ck1600 FIND v(dout0_33) AT=1610.05n

.meas tran vdout0_34ck1600 FIND v(dout0_34) AT=1610.05n

.meas tran vdout0_35ck1600 FIND v(dout0_35) AT=1610.05n

.meas tran vdout0_36ck1600 FIND v(dout0_36) AT=1610.05n

.meas tran vdout0_37ck1600 FIND v(dout0_37) AT=1610.05n

.meas tran vdout0_38ck1600 FIND v(dout0_38) AT=1610.05n

.meas tran vdout0_39ck1600 FIND v(dout0_39) AT=1610.05n

.meas tran vdout0_40ck1600 FIND v(dout0_40) AT=1610.05n

.meas tran vdout0_41ck1600 FIND v(dout0_41) AT=1610.05n

.meas tran vdout0_42ck1600 FIND v(dout0_42) AT=1610.05n

.meas tran vdout0_43ck1600 FIND v(dout0_43) AT=1610.05n

.meas tran vdout0_44ck1600 FIND v(dout0_44) AT=1610.05n

.meas tran vdout0_45ck1600 FIND v(dout0_45) AT=1610.05n

.meas tran vdout0_46ck1600 FIND v(dout0_46) AT=1610.05n

.meas tran vdout0_47ck1600 FIND v(dout0_47) AT=1610.05n

.meas tran vdout0_48ck1600 FIND v(dout0_48) AT=1610.05n

.meas tran vdout0_49ck1600 FIND v(dout0_49) AT=1610.05n

.meas tran vdout0_50ck1600 FIND v(dout0_50) AT=1610.05n

.meas tran vdout0_51ck1600 FIND v(dout0_51) AT=1610.05n

.meas tran vdout0_52ck1600 FIND v(dout0_52) AT=1610.05n

.meas tran vdout0_53ck1600 FIND v(dout0_53) AT=1610.05n

.meas tran vdout0_54ck1600 FIND v(dout0_54) AT=1610.05n

.meas tran vdout0_55ck1600 FIND v(dout0_55) AT=1610.05n

.meas tran vdout0_56ck1600 FIND v(dout0_56) AT=1610.05n

.meas tran vdout0_57ck1600 FIND v(dout0_57) AT=1610.05n

.meas tran vdout0_58ck1600 FIND v(dout0_58) AT=1610.05n

.meas tran vdout0_59ck1600 FIND v(dout0_59) AT=1610.05n

.meas tran vdout0_60ck1600 FIND v(dout0_60) AT=1610.05n

.meas tran vdout0_61ck1600 FIND v(dout0_61) AT=1610.05n

.meas tran vdout0_62ck1600 FIND v(dout0_62) AT=1610.05n

.meas tran vdout0_63ck1600 FIND v(dout0_63) AT=1610.05n

.meas tran vdout1_0ck1600 FIND v(dout1_0) AT=1610.05n

.meas tran vdout1_1ck1600 FIND v(dout1_1) AT=1610.05n

.meas tran vdout1_2ck1600 FIND v(dout1_2) AT=1610.05n

.meas tran vdout1_3ck1600 FIND v(dout1_3) AT=1610.05n

.meas tran vdout1_4ck1600 FIND v(dout1_4) AT=1610.05n

.meas tran vdout1_5ck1600 FIND v(dout1_5) AT=1610.05n

.meas tran vdout1_6ck1600 FIND v(dout1_6) AT=1610.05n

.meas tran vdout1_7ck1600 FIND v(dout1_7) AT=1610.05n

.meas tran vdout1_8ck1600 FIND v(dout1_8) AT=1610.05n

.meas tran vdout1_9ck1600 FIND v(dout1_9) AT=1610.05n

.meas tran vdout1_10ck1600 FIND v(dout1_10) AT=1610.05n

.meas tran vdout1_11ck1600 FIND v(dout1_11) AT=1610.05n

.meas tran vdout1_12ck1600 FIND v(dout1_12) AT=1610.05n

.meas tran vdout1_13ck1600 FIND v(dout1_13) AT=1610.05n

.meas tran vdout1_14ck1600 FIND v(dout1_14) AT=1610.05n

.meas tran vdout1_15ck1600 FIND v(dout1_15) AT=1610.05n

.meas tran vdout1_16ck1600 FIND v(dout1_16) AT=1610.05n

.meas tran vdout1_17ck1600 FIND v(dout1_17) AT=1610.05n

.meas tran vdout1_18ck1600 FIND v(dout1_18) AT=1610.05n

.meas tran vdout1_19ck1600 FIND v(dout1_19) AT=1610.05n

.meas tran vdout1_20ck1600 FIND v(dout1_20) AT=1610.05n

.meas tran vdout1_21ck1600 FIND v(dout1_21) AT=1610.05n

.meas tran vdout1_22ck1600 FIND v(dout1_22) AT=1610.05n

.meas tran vdout1_23ck1600 FIND v(dout1_23) AT=1610.05n

.meas tran vdout1_24ck1600 FIND v(dout1_24) AT=1610.05n

.meas tran vdout1_25ck1600 FIND v(dout1_25) AT=1610.05n

.meas tran vdout1_26ck1600 FIND v(dout1_26) AT=1610.05n

.meas tran vdout1_27ck1600 FIND v(dout1_27) AT=1610.05n

.meas tran vdout1_28ck1600 FIND v(dout1_28) AT=1610.05n

.meas tran vdout1_29ck1600 FIND v(dout1_29) AT=1610.05n

.meas tran vdout1_30ck1600 FIND v(dout1_30) AT=1610.05n

.meas tran vdout1_31ck1600 FIND v(dout1_31) AT=1610.05n

.meas tran vdout1_32ck1600 FIND v(dout1_32) AT=1610.05n

.meas tran vdout1_33ck1600 FIND v(dout1_33) AT=1610.05n

.meas tran vdout1_34ck1600 FIND v(dout1_34) AT=1610.05n

.meas tran vdout1_35ck1600 FIND v(dout1_35) AT=1610.05n

.meas tran vdout1_36ck1600 FIND v(dout1_36) AT=1610.05n

.meas tran vdout1_37ck1600 FIND v(dout1_37) AT=1610.05n

.meas tran vdout1_38ck1600 FIND v(dout1_38) AT=1610.05n

.meas tran vdout1_39ck1600 FIND v(dout1_39) AT=1610.05n

.meas tran vdout1_40ck1600 FIND v(dout1_40) AT=1610.05n

.meas tran vdout1_41ck1600 FIND v(dout1_41) AT=1610.05n

.meas tran vdout1_42ck1600 FIND v(dout1_42) AT=1610.05n

.meas tran vdout1_43ck1600 FIND v(dout1_43) AT=1610.05n

.meas tran vdout1_44ck1600 FIND v(dout1_44) AT=1610.05n

.meas tran vdout1_45ck1600 FIND v(dout1_45) AT=1610.05n

.meas tran vdout1_46ck1600 FIND v(dout1_46) AT=1610.05n

.meas tran vdout1_47ck1600 FIND v(dout1_47) AT=1610.05n

.meas tran vdout1_48ck1600 FIND v(dout1_48) AT=1610.05n

.meas tran vdout1_49ck1600 FIND v(dout1_49) AT=1610.05n

.meas tran vdout1_50ck1600 FIND v(dout1_50) AT=1610.05n

.meas tran vdout1_51ck1600 FIND v(dout1_51) AT=1610.05n

.meas tran vdout1_52ck1600 FIND v(dout1_52) AT=1610.05n

.meas tran vdout1_53ck1600 FIND v(dout1_53) AT=1610.05n

.meas tran vdout1_54ck1600 FIND v(dout1_54) AT=1610.05n

.meas tran vdout1_55ck1600 FIND v(dout1_55) AT=1610.05n

.meas tran vdout1_56ck1600 FIND v(dout1_56) AT=1610.05n

.meas tran vdout1_57ck1600 FIND v(dout1_57) AT=1610.05n

.meas tran vdout1_58ck1600 FIND v(dout1_58) AT=1610.05n

.meas tran vdout1_59ck1600 FIND v(dout1_59) AT=1610.05n

.meas tran vdout1_60ck1600 FIND v(dout1_60) AT=1610.05n

.meas tran vdout1_61ck1600 FIND v(dout1_61) AT=1610.05n

.meas tran vdout1_62ck1600 FIND v(dout1_62) AT=1610.05n

.meas tran vdout1_63ck1600 FIND v(dout1_63) AT=1610.05n

.meas tran vdout0_0ck1610 FIND v(dout0_0) AT=1620.05n

.meas tran vdout0_1ck1610 FIND v(dout0_1) AT=1620.05n

.meas tran vdout0_2ck1610 FIND v(dout0_2) AT=1620.05n

.meas tran vdout0_3ck1610 FIND v(dout0_3) AT=1620.05n

.meas tran vdout0_4ck1610 FIND v(dout0_4) AT=1620.05n

.meas tran vdout0_5ck1610 FIND v(dout0_5) AT=1620.05n

.meas tran vdout0_6ck1610 FIND v(dout0_6) AT=1620.05n

.meas tran vdout0_7ck1610 FIND v(dout0_7) AT=1620.05n

.meas tran vdout0_8ck1610 FIND v(dout0_8) AT=1620.05n

.meas tran vdout0_9ck1610 FIND v(dout0_9) AT=1620.05n

.meas tran vdout0_10ck1610 FIND v(dout0_10) AT=1620.05n

.meas tran vdout0_11ck1610 FIND v(dout0_11) AT=1620.05n

.meas tran vdout0_12ck1610 FIND v(dout0_12) AT=1620.05n

.meas tran vdout0_13ck1610 FIND v(dout0_13) AT=1620.05n

.meas tran vdout0_14ck1610 FIND v(dout0_14) AT=1620.05n

.meas tran vdout0_15ck1610 FIND v(dout0_15) AT=1620.05n

.meas tran vdout0_16ck1610 FIND v(dout0_16) AT=1620.05n

.meas tran vdout0_17ck1610 FIND v(dout0_17) AT=1620.05n

.meas tran vdout0_18ck1610 FIND v(dout0_18) AT=1620.05n

.meas tran vdout0_19ck1610 FIND v(dout0_19) AT=1620.05n

.meas tran vdout0_20ck1610 FIND v(dout0_20) AT=1620.05n

.meas tran vdout0_21ck1610 FIND v(dout0_21) AT=1620.05n

.meas tran vdout0_22ck1610 FIND v(dout0_22) AT=1620.05n

.meas tran vdout0_23ck1610 FIND v(dout0_23) AT=1620.05n

.meas tran vdout0_24ck1610 FIND v(dout0_24) AT=1620.05n

.meas tran vdout0_25ck1610 FIND v(dout0_25) AT=1620.05n

.meas tran vdout0_26ck1610 FIND v(dout0_26) AT=1620.05n

.meas tran vdout0_27ck1610 FIND v(dout0_27) AT=1620.05n

.meas tran vdout0_28ck1610 FIND v(dout0_28) AT=1620.05n

.meas tran vdout0_29ck1610 FIND v(dout0_29) AT=1620.05n

.meas tran vdout0_30ck1610 FIND v(dout0_30) AT=1620.05n

.meas tran vdout0_31ck1610 FIND v(dout0_31) AT=1620.05n

.meas tran vdout0_32ck1610 FIND v(dout0_32) AT=1620.05n

.meas tran vdout0_33ck1610 FIND v(dout0_33) AT=1620.05n

.meas tran vdout0_34ck1610 FIND v(dout0_34) AT=1620.05n

.meas tran vdout0_35ck1610 FIND v(dout0_35) AT=1620.05n

.meas tran vdout0_36ck1610 FIND v(dout0_36) AT=1620.05n

.meas tran vdout0_37ck1610 FIND v(dout0_37) AT=1620.05n

.meas tran vdout0_38ck1610 FIND v(dout0_38) AT=1620.05n

.meas tran vdout0_39ck1610 FIND v(dout0_39) AT=1620.05n

.meas tran vdout0_40ck1610 FIND v(dout0_40) AT=1620.05n

.meas tran vdout0_41ck1610 FIND v(dout0_41) AT=1620.05n

.meas tran vdout0_42ck1610 FIND v(dout0_42) AT=1620.05n

.meas tran vdout0_43ck1610 FIND v(dout0_43) AT=1620.05n

.meas tran vdout0_44ck1610 FIND v(dout0_44) AT=1620.05n

.meas tran vdout0_45ck1610 FIND v(dout0_45) AT=1620.05n

.meas tran vdout0_46ck1610 FIND v(dout0_46) AT=1620.05n

.meas tran vdout0_47ck1610 FIND v(dout0_47) AT=1620.05n

.meas tran vdout0_48ck1610 FIND v(dout0_48) AT=1620.05n

.meas tran vdout0_49ck1610 FIND v(dout0_49) AT=1620.05n

.meas tran vdout0_50ck1610 FIND v(dout0_50) AT=1620.05n

.meas tran vdout0_51ck1610 FIND v(dout0_51) AT=1620.05n

.meas tran vdout0_52ck1610 FIND v(dout0_52) AT=1620.05n

.meas tran vdout0_53ck1610 FIND v(dout0_53) AT=1620.05n

.meas tran vdout0_54ck1610 FIND v(dout0_54) AT=1620.05n

.meas tran vdout0_55ck1610 FIND v(dout0_55) AT=1620.05n

.meas tran vdout0_56ck1610 FIND v(dout0_56) AT=1620.05n

.meas tran vdout0_57ck1610 FIND v(dout0_57) AT=1620.05n

.meas tran vdout0_58ck1610 FIND v(dout0_58) AT=1620.05n

.meas tran vdout0_59ck1610 FIND v(dout0_59) AT=1620.05n

.meas tran vdout0_60ck1610 FIND v(dout0_60) AT=1620.05n

.meas tran vdout0_61ck1610 FIND v(dout0_61) AT=1620.05n

.meas tran vdout0_62ck1610 FIND v(dout0_62) AT=1620.05n

.meas tran vdout0_63ck1610 FIND v(dout0_63) AT=1620.05n

.meas tran vdout1_0ck1610 FIND v(dout1_0) AT=1620.05n

.meas tran vdout1_1ck1610 FIND v(dout1_1) AT=1620.05n

.meas tran vdout1_2ck1610 FIND v(dout1_2) AT=1620.05n

.meas tran vdout1_3ck1610 FIND v(dout1_3) AT=1620.05n

.meas tran vdout1_4ck1610 FIND v(dout1_4) AT=1620.05n

.meas tran vdout1_5ck1610 FIND v(dout1_5) AT=1620.05n

.meas tran vdout1_6ck1610 FIND v(dout1_6) AT=1620.05n

.meas tran vdout1_7ck1610 FIND v(dout1_7) AT=1620.05n

.meas tran vdout1_8ck1610 FIND v(dout1_8) AT=1620.05n

.meas tran vdout1_9ck1610 FIND v(dout1_9) AT=1620.05n

.meas tran vdout1_10ck1610 FIND v(dout1_10) AT=1620.05n

.meas tran vdout1_11ck1610 FIND v(dout1_11) AT=1620.05n

.meas tran vdout1_12ck1610 FIND v(dout1_12) AT=1620.05n

.meas tran vdout1_13ck1610 FIND v(dout1_13) AT=1620.05n

.meas tran vdout1_14ck1610 FIND v(dout1_14) AT=1620.05n

.meas tran vdout1_15ck1610 FIND v(dout1_15) AT=1620.05n

.meas tran vdout1_16ck1610 FIND v(dout1_16) AT=1620.05n

.meas tran vdout1_17ck1610 FIND v(dout1_17) AT=1620.05n

.meas tran vdout1_18ck1610 FIND v(dout1_18) AT=1620.05n

.meas tran vdout1_19ck1610 FIND v(dout1_19) AT=1620.05n

.meas tran vdout1_20ck1610 FIND v(dout1_20) AT=1620.05n

.meas tran vdout1_21ck1610 FIND v(dout1_21) AT=1620.05n

.meas tran vdout1_22ck1610 FIND v(dout1_22) AT=1620.05n

.meas tran vdout1_23ck1610 FIND v(dout1_23) AT=1620.05n

.meas tran vdout1_24ck1610 FIND v(dout1_24) AT=1620.05n

.meas tran vdout1_25ck1610 FIND v(dout1_25) AT=1620.05n

.meas tran vdout1_26ck1610 FIND v(dout1_26) AT=1620.05n

.meas tran vdout1_27ck1610 FIND v(dout1_27) AT=1620.05n

.meas tran vdout1_28ck1610 FIND v(dout1_28) AT=1620.05n

.meas tran vdout1_29ck1610 FIND v(dout1_29) AT=1620.05n

.meas tran vdout1_30ck1610 FIND v(dout1_30) AT=1620.05n

.meas tran vdout1_31ck1610 FIND v(dout1_31) AT=1620.05n

.meas tran vdout1_32ck1610 FIND v(dout1_32) AT=1620.05n

.meas tran vdout1_33ck1610 FIND v(dout1_33) AT=1620.05n

.meas tran vdout1_34ck1610 FIND v(dout1_34) AT=1620.05n

.meas tran vdout1_35ck1610 FIND v(dout1_35) AT=1620.05n

.meas tran vdout1_36ck1610 FIND v(dout1_36) AT=1620.05n

.meas tran vdout1_37ck1610 FIND v(dout1_37) AT=1620.05n

.meas tran vdout1_38ck1610 FIND v(dout1_38) AT=1620.05n

.meas tran vdout1_39ck1610 FIND v(dout1_39) AT=1620.05n

.meas tran vdout1_40ck1610 FIND v(dout1_40) AT=1620.05n

.meas tran vdout1_41ck1610 FIND v(dout1_41) AT=1620.05n

.meas tran vdout1_42ck1610 FIND v(dout1_42) AT=1620.05n

.meas tran vdout1_43ck1610 FIND v(dout1_43) AT=1620.05n

.meas tran vdout1_44ck1610 FIND v(dout1_44) AT=1620.05n

.meas tran vdout1_45ck1610 FIND v(dout1_45) AT=1620.05n

.meas tran vdout1_46ck1610 FIND v(dout1_46) AT=1620.05n

.meas tran vdout1_47ck1610 FIND v(dout1_47) AT=1620.05n

.meas tran vdout1_48ck1610 FIND v(dout1_48) AT=1620.05n

.meas tran vdout1_49ck1610 FIND v(dout1_49) AT=1620.05n

.meas tran vdout1_50ck1610 FIND v(dout1_50) AT=1620.05n

.meas tran vdout1_51ck1610 FIND v(dout1_51) AT=1620.05n

.meas tran vdout1_52ck1610 FIND v(dout1_52) AT=1620.05n

.meas tran vdout1_53ck1610 FIND v(dout1_53) AT=1620.05n

.meas tran vdout1_54ck1610 FIND v(dout1_54) AT=1620.05n

.meas tran vdout1_55ck1610 FIND v(dout1_55) AT=1620.05n

.meas tran vdout1_56ck1610 FIND v(dout1_56) AT=1620.05n

.meas tran vdout1_57ck1610 FIND v(dout1_57) AT=1620.05n

.meas tran vdout1_58ck1610 FIND v(dout1_58) AT=1620.05n

.meas tran vdout1_59ck1610 FIND v(dout1_59) AT=1620.05n

.meas tran vdout1_60ck1610 FIND v(dout1_60) AT=1620.05n

.meas tran vdout1_61ck1610 FIND v(dout1_61) AT=1620.05n

.meas tran vdout1_62ck1610 FIND v(dout1_62) AT=1620.05n

.meas tran vdout1_63ck1610 FIND v(dout1_63) AT=1620.05n

.meas tran vdout0_0ck1630 FIND v(dout0_0) AT=1640.05n

.meas tran vdout0_1ck1630 FIND v(dout0_1) AT=1640.05n

.meas tran vdout0_2ck1630 FIND v(dout0_2) AT=1640.05n

.meas tran vdout0_3ck1630 FIND v(dout0_3) AT=1640.05n

.meas tran vdout0_4ck1630 FIND v(dout0_4) AT=1640.05n

.meas tran vdout0_5ck1630 FIND v(dout0_5) AT=1640.05n

.meas tran vdout0_6ck1630 FIND v(dout0_6) AT=1640.05n

.meas tran vdout0_7ck1630 FIND v(dout0_7) AT=1640.05n

.meas tran vdout0_8ck1630 FIND v(dout0_8) AT=1640.05n

.meas tran vdout0_9ck1630 FIND v(dout0_9) AT=1640.05n

.meas tran vdout0_10ck1630 FIND v(dout0_10) AT=1640.05n

.meas tran vdout0_11ck1630 FIND v(dout0_11) AT=1640.05n

.meas tran vdout0_12ck1630 FIND v(dout0_12) AT=1640.05n

.meas tran vdout0_13ck1630 FIND v(dout0_13) AT=1640.05n

.meas tran vdout0_14ck1630 FIND v(dout0_14) AT=1640.05n

.meas tran vdout0_15ck1630 FIND v(dout0_15) AT=1640.05n

.meas tran vdout0_16ck1630 FIND v(dout0_16) AT=1640.05n

.meas tran vdout0_17ck1630 FIND v(dout0_17) AT=1640.05n

.meas tran vdout0_18ck1630 FIND v(dout0_18) AT=1640.05n

.meas tran vdout0_19ck1630 FIND v(dout0_19) AT=1640.05n

.meas tran vdout0_20ck1630 FIND v(dout0_20) AT=1640.05n

.meas tran vdout0_21ck1630 FIND v(dout0_21) AT=1640.05n

.meas tran vdout0_22ck1630 FIND v(dout0_22) AT=1640.05n

.meas tran vdout0_23ck1630 FIND v(dout0_23) AT=1640.05n

.meas tran vdout0_24ck1630 FIND v(dout0_24) AT=1640.05n

.meas tran vdout0_25ck1630 FIND v(dout0_25) AT=1640.05n

.meas tran vdout0_26ck1630 FIND v(dout0_26) AT=1640.05n

.meas tran vdout0_27ck1630 FIND v(dout0_27) AT=1640.05n

.meas tran vdout0_28ck1630 FIND v(dout0_28) AT=1640.05n

.meas tran vdout0_29ck1630 FIND v(dout0_29) AT=1640.05n

.meas tran vdout0_30ck1630 FIND v(dout0_30) AT=1640.05n

.meas tran vdout0_31ck1630 FIND v(dout0_31) AT=1640.05n

.meas tran vdout0_32ck1630 FIND v(dout0_32) AT=1640.05n

.meas tran vdout0_33ck1630 FIND v(dout0_33) AT=1640.05n

.meas tran vdout0_34ck1630 FIND v(dout0_34) AT=1640.05n

.meas tran vdout0_35ck1630 FIND v(dout0_35) AT=1640.05n

.meas tran vdout0_36ck1630 FIND v(dout0_36) AT=1640.05n

.meas tran vdout0_37ck1630 FIND v(dout0_37) AT=1640.05n

.meas tran vdout0_38ck1630 FIND v(dout0_38) AT=1640.05n

.meas tran vdout0_39ck1630 FIND v(dout0_39) AT=1640.05n

.meas tran vdout0_40ck1630 FIND v(dout0_40) AT=1640.05n

.meas tran vdout0_41ck1630 FIND v(dout0_41) AT=1640.05n

.meas tran vdout0_42ck1630 FIND v(dout0_42) AT=1640.05n

.meas tran vdout0_43ck1630 FIND v(dout0_43) AT=1640.05n

.meas tran vdout0_44ck1630 FIND v(dout0_44) AT=1640.05n

.meas tran vdout0_45ck1630 FIND v(dout0_45) AT=1640.05n

.meas tran vdout0_46ck1630 FIND v(dout0_46) AT=1640.05n

.meas tran vdout0_47ck1630 FIND v(dout0_47) AT=1640.05n

.meas tran vdout0_48ck1630 FIND v(dout0_48) AT=1640.05n

.meas tran vdout0_49ck1630 FIND v(dout0_49) AT=1640.05n

.meas tran vdout0_50ck1630 FIND v(dout0_50) AT=1640.05n

.meas tran vdout0_51ck1630 FIND v(dout0_51) AT=1640.05n

.meas tran vdout0_52ck1630 FIND v(dout0_52) AT=1640.05n

.meas tran vdout0_53ck1630 FIND v(dout0_53) AT=1640.05n

.meas tran vdout0_54ck1630 FIND v(dout0_54) AT=1640.05n

.meas tran vdout0_55ck1630 FIND v(dout0_55) AT=1640.05n

.meas tran vdout0_56ck1630 FIND v(dout0_56) AT=1640.05n

.meas tran vdout0_57ck1630 FIND v(dout0_57) AT=1640.05n

.meas tran vdout0_58ck1630 FIND v(dout0_58) AT=1640.05n

.meas tran vdout0_59ck1630 FIND v(dout0_59) AT=1640.05n

.meas tran vdout0_60ck1630 FIND v(dout0_60) AT=1640.05n

.meas tran vdout0_61ck1630 FIND v(dout0_61) AT=1640.05n

.meas tran vdout0_62ck1630 FIND v(dout0_62) AT=1640.05n

.meas tran vdout0_63ck1630 FIND v(dout0_63) AT=1640.05n

.meas tran vdout1_0ck1630 FIND v(dout1_0) AT=1640.05n

.meas tran vdout1_1ck1630 FIND v(dout1_1) AT=1640.05n

.meas tran vdout1_2ck1630 FIND v(dout1_2) AT=1640.05n

.meas tran vdout1_3ck1630 FIND v(dout1_3) AT=1640.05n

.meas tran vdout1_4ck1630 FIND v(dout1_4) AT=1640.05n

.meas tran vdout1_5ck1630 FIND v(dout1_5) AT=1640.05n

.meas tran vdout1_6ck1630 FIND v(dout1_6) AT=1640.05n

.meas tran vdout1_7ck1630 FIND v(dout1_7) AT=1640.05n

.meas tran vdout1_8ck1630 FIND v(dout1_8) AT=1640.05n

.meas tran vdout1_9ck1630 FIND v(dout1_9) AT=1640.05n

.meas tran vdout1_10ck1630 FIND v(dout1_10) AT=1640.05n

.meas tran vdout1_11ck1630 FIND v(dout1_11) AT=1640.05n

.meas tran vdout1_12ck1630 FIND v(dout1_12) AT=1640.05n

.meas tran vdout1_13ck1630 FIND v(dout1_13) AT=1640.05n

.meas tran vdout1_14ck1630 FIND v(dout1_14) AT=1640.05n

.meas tran vdout1_15ck1630 FIND v(dout1_15) AT=1640.05n

.meas tran vdout1_16ck1630 FIND v(dout1_16) AT=1640.05n

.meas tran vdout1_17ck1630 FIND v(dout1_17) AT=1640.05n

.meas tran vdout1_18ck1630 FIND v(dout1_18) AT=1640.05n

.meas tran vdout1_19ck1630 FIND v(dout1_19) AT=1640.05n

.meas tran vdout1_20ck1630 FIND v(dout1_20) AT=1640.05n

.meas tran vdout1_21ck1630 FIND v(dout1_21) AT=1640.05n

.meas tran vdout1_22ck1630 FIND v(dout1_22) AT=1640.05n

.meas tran vdout1_23ck1630 FIND v(dout1_23) AT=1640.05n

.meas tran vdout1_24ck1630 FIND v(dout1_24) AT=1640.05n

.meas tran vdout1_25ck1630 FIND v(dout1_25) AT=1640.05n

.meas tran vdout1_26ck1630 FIND v(dout1_26) AT=1640.05n

.meas tran vdout1_27ck1630 FIND v(dout1_27) AT=1640.05n

.meas tran vdout1_28ck1630 FIND v(dout1_28) AT=1640.05n

.meas tran vdout1_29ck1630 FIND v(dout1_29) AT=1640.05n

.meas tran vdout1_30ck1630 FIND v(dout1_30) AT=1640.05n

.meas tran vdout1_31ck1630 FIND v(dout1_31) AT=1640.05n

.meas tran vdout1_32ck1630 FIND v(dout1_32) AT=1640.05n

.meas tran vdout1_33ck1630 FIND v(dout1_33) AT=1640.05n

.meas tran vdout1_34ck1630 FIND v(dout1_34) AT=1640.05n

.meas tran vdout1_35ck1630 FIND v(dout1_35) AT=1640.05n

.meas tran vdout1_36ck1630 FIND v(dout1_36) AT=1640.05n

.meas tran vdout1_37ck1630 FIND v(dout1_37) AT=1640.05n

.meas tran vdout1_38ck1630 FIND v(dout1_38) AT=1640.05n

.meas tran vdout1_39ck1630 FIND v(dout1_39) AT=1640.05n

.meas tran vdout1_40ck1630 FIND v(dout1_40) AT=1640.05n

.meas tran vdout1_41ck1630 FIND v(dout1_41) AT=1640.05n

.meas tran vdout1_42ck1630 FIND v(dout1_42) AT=1640.05n

.meas tran vdout1_43ck1630 FIND v(dout1_43) AT=1640.05n

.meas tran vdout1_44ck1630 FIND v(dout1_44) AT=1640.05n

.meas tran vdout1_45ck1630 FIND v(dout1_45) AT=1640.05n

.meas tran vdout1_46ck1630 FIND v(dout1_46) AT=1640.05n

.meas tran vdout1_47ck1630 FIND v(dout1_47) AT=1640.05n

.meas tran vdout1_48ck1630 FIND v(dout1_48) AT=1640.05n

.meas tran vdout1_49ck1630 FIND v(dout1_49) AT=1640.05n

.meas tran vdout1_50ck1630 FIND v(dout1_50) AT=1640.05n

.meas tran vdout1_51ck1630 FIND v(dout1_51) AT=1640.05n

.meas tran vdout1_52ck1630 FIND v(dout1_52) AT=1640.05n

.meas tran vdout1_53ck1630 FIND v(dout1_53) AT=1640.05n

.meas tran vdout1_54ck1630 FIND v(dout1_54) AT=1640.05n

.meas tran vdout1_55ck1630 FIND v(dout1_55) AT=1640.05n

.meas tran vdout1_56ck1630 FIND v(dout1_56) AT=1640.05n

.meas tran vdout1_57ck1630 FIND v(dout1_57) AT=1640.05n

.meas tran vdout1_58ck1630 FIND v(dout1_58) AT=1640.05n

.meas tran vdout1_59ck1630 FIND v(dout1_59) AT=1640.05n

.meas tran vdout1_60ck1630 FIND v(dout1_60) AT=1640.05n

.meas tran vdout1_61ck1630 FIND v(dout1_61) AT=1640.05n

.meas tran vdout1_62ck1630 FIND v(dout1_62) AT=1640.05n

.meas tran vdout1_63ck1630 FIND v(dout1_63) AT=1640.05n

.meas tran vdout1_0ck1640 FIND v(dout1_0) AT=1650.05n

.meas tran vdout1_1ck1640 FIND v(dout1_1) AT=1650.05n

.meas tran vdout1_2ck1640 FIND v(dout1_2) AT=1650.05n

.meas tran vdout1_3ck1640 FIND v(dout1_3) AT=1650.05n

.meas tran vdout1_4ck1640 FIND v(dout1_4) AT=1650.05n

.meas tran vdout1_5ck1640 FIND v(dout1_5) AT=1650.05n

.meas tran vdout1_6ck1640 FIND v(dout1_6) AT=1650.05n

.meas tran vdout1_7ck1640 FIND v(dout1_7) AT=1650.05n

.meas tran vdout1_8ck1640 FIND v(dout1_8) AT=1650.05n

.meas tran vdout1_9ck1640 FIND v(dout1_9) AT=1650.05n

.meas tran vdout1_10ck1640 FIND v(dout1_10) AT=1650.05n

.meas tran vdout1_11ck1640 FIND v(dout1_11) AT=1650.05n

.meas tran vdout1_12ck1640 FIND v(dout1_12) AT=1650.05n

.meas tran vdout1_13ck1640 FIND v(dout1_13) AT=1650.05n

.meas tran vdout1_14ck1640 FIND v(dout1_14) AT=1650.05n

.meas tran vdout1_15ck1640 FIND v(dout1_15) AT=1650.05n

.meas tran vdout1_16ck1640 FIND v(dout1_16) AT=1650.05n

.meas tran vdout1_17ck1640 FIND v(dout1_17) AT=1650.05n

.meas tran vdout1_18ck1640 FIND v(dout1_18) AT=1650.05n

.meas tran vdout1_19ck1640 FIND v(dout1_19) AT=1650.05n

.meas tran vdout1_20ck1640 FIND v(dout1_20) AT=1650.05n

.meas tran vdout1_21ck1640 FIND v(dout1_21) AT=1650.05n

.meas tran vdout1_22ck1640 FIND v(dout1_22) AT=1650.05n

.meas tran vdout1_23ck1640 FIND v(dout1_23) AT=1650.05n

.meas tran vdout1_24ck1640 FIND v(dout1_24) AT=1650.05n

.meas tran vdout1_25ck1640 FIND v(dout1_25) AT=1650.05n

.meas tran vdout1_26ck1640 FIND v(dout1_26) AT=1650.05n

.meas tran vdout1_27ck1640 FIND v(dout1_27) AT=1650.05n

.meas tran vdout1_28ck1640 FIND v(dout1_28) AT=1650.05n

.meas tran vdout1_29ck1640 FIND v(dout1_29) AT=1650.05n

.meas tran vdout1_30ck1640 FIND v(dout1_30) AT=1650.05n

.meas tran vdout1_31ck1640 FIND v(dout1_31) AT=1650.05n

.meas tran vdout1_32ck1640 FIND v(dout1_32) AT=1650.05n

.meas tran vdout1_33ck1640 FIND v(dout1_33) AT=1650.05n

.meas tran vdout1_34ck1640 FIND v(dout1_34) AT=1650.05n

.meas tran vdout1_35ck1640 FIND v(dout1_35) AT=1650.05n

.meas tran vdout1_36ck1640 FIND v(dout1_36) AT=1650.05n

.meas tran vdout1_37ck1640 FIND v(dout1_37) AT=1650.05n

.meas tran vdout1_38ck1640 FIND v(dout1_38) AT=1650.05n

.meas tran vdout1_39ck1640 FIND v(dout1_39) AT=1650.05n

.meas tran vdout1_40ck1640 FIND v(dout1_40) AT=1650.05n

.meas tran vdout1_41ck1640 FIND v(dout1_41) AT=1650.05n

.meas tran vdout1_42ck1640 FIND v(dout1_42) AT=1650.05n

.meas tran vdout1_43ck1640 FIND v(dout1_43) AT=1650.05n

.meas tran vdout1_44ck1640 FIND v(dout1_44) AT=1650.05n

.meas tran vdout1_45ck1640 FIND v(dout1_45) AT=1650.05n

.meas tran vdout1_46ck1640 FIND v(dout1_46) AT=1650.05n

.meas tran vdout1_47ck1640 FIND v(dout1_47) AT=1650.05n

.meas tran vdout1_48ck1640 FIND v(dout1_48) AT=1650.05n

.meas tran vdout1_49ck1640 FIND v(dout1_49) AT=1650.05n

.meas tran vdout1_50ck1640 FIND v(dout1_50) AT=1650.05n

.meas tran vdout1_51ck1640 FIND v(dout1_51) AT=1650.05n

.meas tran vdout1_52ck1640 FIND v(dout1_52) AT=1650.05n

.meas tran vdout1_53ck1640 FIND v(dout1_53) AT=1650.05n

.meas tran vdout1_54ck1640 FIND v(dout1_54) AT=1650.05n

.meas tran vdout1_55ck1640 FIND v(dout1_55) AT=1650.05n

.meas tran vdout1_56ck1640 FIND v(dout1_56) AT=1650.05n

.meas tran vdout1_57ck1640 FIND v(dout1_57) AT=1650.05n

.meas tran vdout1_58ck1640 FIND v(dout1_58) AT=1650.05n

.meas tran vdout1_59ck1640 FIND v(dout1_59) AT=1650.05n

.meas tran vdout1_60ck1640 FIND v(dout1_60) AT=1650.05n

.meas tran vdout1_61ck1640 FIND v(dout1_61) AT=1650.05n

.meas tran vdout1_62ck1640 FIND v(dout1_62) AT=1650.05n

.meas tran vdout1_63ck1640 FIND v(dout1_63) AT=1650.05n

.meas tran vdout1_0ck1650 FIND v(dout1_0) AT=1660.05n

.meas tran vdout1_1ck1650 FIND v(dout1_1) AT=1660.05n

.meas tran vdout1_2ck1650 FIND v(dout1_2) AT=1660.05n

.meas tran vdout1_3ck1650 FIND v(dout1_3) AT=1660.05n

.meas tran vdout1_4ck1650 FIND v(dout1_4) AT=1660.05n

.meas tran vdout1_5ck1650 FIND v(dout1_5) AT=1660.05n

.meas tran vdout1_6ck1650 FIND v(dout1_6) AT=1660.05n

.meas tran vdout1_7ck1650 FIND v(dout1_7) AT=1660.05n

.meas tran vdout1_8ck1650 FIND v(dout1_8) AT=1660.05n

.meas tran vdout1_9ck1650 FIND v(dout1_9) AT=1660.05n

.meas tran vdout1_10ck1650 FIND v(dout1_10) AT=1660.05n

.meas tran vdout1_11ck1650 FIND v(dout1_11) AT=1660.05n

.meas tran vdout1_12ck1650 FIND v(dout1_12) AT=1660.05n

.meas tran vdout1_13ck1650 FIND v(dout1_13) AT=1660.05n

.meas tran vdout1_14ck1650 FIND v(dout1_14) AT=1660.05n

.meas tran vdout1_15ck1650 FIND v(dout1_15) AT=1660.05n

.meas tran vdout1_16ck1650 FIND v(dout1_16) AT=1660.05n

.meas tran vdout1_17ck1650 FIND v(dout1_17) AT=1660.05n

.meas tran vdout1_18ck1650 FIND v(dout1_18) AT=1660.05n

.meas tran vdout1_19ck1650 FIND v(dout1_19) AT=1660.05n

.meas tran vdout1_20ck1650 FIND v(dout1_20) AT=1660.05n

.meas tran vdout1_21ck1650 FIND v(dout1_21) AT=1660.05n

.meas tran vdout1_22ck1650 FIND v(dout1_22) AT=1660.05n

.meas tran vdout1_23ck1650 FIND v(dout1_23) AT=1660.05n

.meas tran vdout1_24ck1650 FIND v(dout1_24) AT=1660.05n

.meas tran vdout1_25ck1650 FIND v(dout1_25) AT=1660.05n

.meas tran vdout1_26ck1650 FIND v(dout1_26) AT=1660.05n

.meas tran vdout1_27ck1650 FIND v(dout1_27) AT=1660.05n

.meas tran vdout1_28ck1650 FIND v(dout1_28) AT=1660.05n

.meas tran vdout1_29ck1650 FIND v(dout1_29) AT=1660.05n

.meas tran vdout1_30ck1650 FIND v(dout1_30) AT=1660.05n

.meas tran vdout1_31ck1650 FIND v(dout1_31) AT=1660.05n

.meas tran vdout1_32ck1650 FIND v(dout1_32) AT=1660.05n

.meas tran vdout1_33ck1650 FIND v(dout1_33) AT=1660.05n

.meas tran vdout1_34ck1650 FIND v(dout1_34) AT=1660.05n

.meas tran vdout1_35ck1650 FIND v(dout1_35) AT=1660.05n

.meas tran vdout1_36ck1650 FIND v(dout1_36) AT=1660.05n

.meas tran vdout1_37ck1650 FIND v(dout1_37) AT=1660.05n

.meas tran vdout1_38ck1650 FIND v(dout1_38) AT=1660.05n

.meas tran vdout1_39ck1650 FIND v(dout1_39) AT=1660.05n

.meas tran vdout1_40ck1650 FIND v(dout1_40) AT=1660.05n

.meas tran vdout1_41ck1650 FIND v(dout1_41) AT=1660.05n

.meas tran vdout1_42ck1650 FIND v(dout1_42) AT=1660.05n

.meas tran vdout1_43ck1650 FIND v(dout1_43) AT=1660.05n

.meas tran vdout1_44ck1650 FIND v(dout1_44) AT=1660.05n

.meas tran vdout1_45ck1650 FIND v(dout1_45) AT=1660.05n

.meas tran vdout1_46ck1650 FIND v(dout1_46) AT=1660.05n

.meas tran vdout1_47ck1650 FIND v(dout1_47) AT=1660.05n

.meas tran vdout1_48ck1650 FIND v(dout1_48) AT=1660.05n

.meas tran vdout1_49ck1650 FIND v(dout1_49) AT=1660.05n

.meas tran vdout1_50ck1650 FIND v(dout1_50) AT=1660.05n

.meas tran vdout1_51ck1650 FIND v(dout1_51) AT=1660.05n

.meas tran vdout1_52ck1650 FIND v(dout1_52) AT=1660.05n

.meas tran vdout1_53ck1650 FIND v(dout1_53) AT=1660.05n

.meas tran vdout1_54ck1650 FIND v(dout1_54) AT=1660.05n

.meas tran vdout1_55ck1650 FIND v(dout1_55) AT=1660.05n

.meas tran vdout1_56ck1650 FIND v(dout1_56) AT=1660.05n

.meas tran vdout1_57ck1650 FIND v(dout1_57) AT=1660.05n

.meas tran vdout1_58ck1650 FIND v(dout1_58) AT=1660.05n

.meas tran vdout1_59ck1650 FIND v(dout1_59) AT=1660.05n

.meas tran vdout1_60ck1650 FIND v(dout1_60) AT=1660.05n

.meas tran vdout1_61ck1650 FIND v(dout1_61) AT=1660.05n

.meas tran vdout1_62ck1650 FIND v(dout1_62) AT=1660.05n

.meas tran vdout1_63ck1650 FIND v(dout1_63) AT=1660.05n

.meas tran vdout0_0ck1660 FIND v(dout0_0) AT=1670.05n

.meas tran vdout0_1ck1660 FIND v(dout0_1) AT=1670.05n

.meas tran vdout0_2ck1660 FIND v(dout0_2) AT=1670.05n

.meas tran vdout0_3ck1660 FIND v(dout0_3) AT=1670.05n

.meas tran vdout0_4ck1660 FIND v(dout0_4) AT=1670.05n

.meas tran vdout0_5ck1660 FIND v(dout0_5) AT=1670.05n

.meas tran vdout0_6ck1660 FIND v(dout0_6) AT=1670.05n

.meas tran vdout0_7ck1660 FIND v(dout0_7) AT=1670.05n

.meas tran vdout0_8ck1660 FIND v(dout0_8) AT=1670.05n

.meas tran vdout0_9ck1660 FIND v(dout0_9) AT=1670.05n

.meas tran vdout0_10ck1660 FIND v(dout0_10) AT=1670.05n

.meas tran vdout0_11ck1660 FIND v(dout0_11) AT=1670.05n

.meas tran vdout0_12ck1660 FIND v(dout0_12) AT=1670.05n

.meas tran vdout0_13ck1660 FIND v(dout0_13) AT=1670.05n

.meas tran vdout0_14ck1660 FIND v(dout0_14) AT=1670.05n

.meas tran vdout0_15ck1660 FIND v(dout0_15) AT=1670.05n

.meas tran vdout0_16ck1660 FIND v(dout0_16) AT=1670.05n

.meas tran vdout0_17ck1660 FIND v(dout0_17) AT=1670.05n

.meas tran vdout0_18ck1660 FIND v(dout0_18) AT=1670.05n

.meas tran vdout0_19ck1660 FIND v(dout0_19) AT=1670.05n

.meas tran vdout0_20ck1660 FIND v(dout0_20) AT=1670.05n

.meas tran vdout0_21ck1660 FIND v(dout0_21) AT=1670.05n

.meas tran vdout0_22ck1660 FIND v(dout0_22) AT=1670.05n

.meas tran vdout0_23ck1660 FIND v(dout0_23) AT=1670.05n

.meas tran vdout0_24ck1660 FIND v(dout0_24) AT=1670.05n

.meas tran vdout0_25ck1660 FIND v(dout0_25) AT=1670.05n

.meas tran vdout0_26ck1660 FIND v(dout0_26) AT=1670.05n

.meas tran vdout0_27ck1660 FIND v(dout0_27) AT=1670.05n

.meas tran vdout0_28ck1660 FIND v(dout0_28) AT=1670.05n

.meas tran vdout0_29ck1660 FIND v(dout0_29) AT=1670.05n

.meas tran vdout0_30ck1660 FIND v(dout0_30) AT=1670.05n

.meas tran vdout0_31ck1660 FIND v(dout0_31) AT=1670.05n

.meas tran vdout0_32ck1660 FIND v(dout0_32) AT=1670.05n

.meas tran vdout0_33ck1660 FIND v(dout0_33) AT=1670.05n

.meas tran vdout0_34ck1660 FIND v(dout0_34) AT=1670.05n

.meas tran vdout0_35ck1660 FIND v(dout0_35) AT=1670.05n

.meas tran vdout0_36ck1660 FIND v(dout0_36) AT=1670.05n

.meas tran vdout0_37ck1660 FIND v(dout0_37) AT=1670.05n

.meas tran vdout0_38ck1660 FIND v(dout0_38) AT=1670.05n

.meas tran vdout0_39ck1660 FIND v(dout0_39) AT=1670.05n

.meas tran vdout0_40ck1660 FIND v(dout0_40) AT=1670.05n

.meas tran vdout0_41ck1660 FIND v(dout0_41) AT=1670.05n

.meas tran vdout0_42ck1660 FIND v(dout0_42) AT=1670.05n

.meas tran vdout0_43ck1660 FIND v(dout0_43) AT=1670.05n

.meas tran vdout0_44ck1660 FIND v(dout0_44) AT=1670.05n

.meas tran vdout0_45ck1660 FIND v(dout0_45) AT=1670.05n

.meas tran vdout0_46ck1660 FIND v(dout0_46) AT=1670.05n

.meas tran vdout0_47ck1660 FIND v(dout0_47) AT=1670.05n

.meas tran vdout0_48ck1660 FIND v(dout0_48) AT=1670.05n

.meas tran vdout0_49ck1660 FIND v(dout0_49) AT=1670.05n

.meas tran vdout0_50ck1660 FIND v(dout0_50) AT=1670.05n

.meas tran vdout0_51ck1660 FIND v(dout0_51) AT=1670.05n

.meas tran vdout0_52ck1660 FIND v(dout0_52) AT=1670.05n

.meas tran vdout0_53ck1660 FIND v(dout0_53) AT=1670.05n

.meas tran vdout0_54ck1660 FIND v(dout0_54) AT=1670.05n

.meas tran vdout0_55ck1660 FIND v(dout0_55) AT=1670.05n

.meas tran vdout0_56ck1660 FIND v(dout0_56) AT=1670.05n

.meas tran vdout0_57ck1660 FIND v(dout0_57) AT=1670.05n

.meas tran vdout0_58ck1660 FIND v(dout0_58) AT=1670.05n

.meas tran vdout0_59ck1660 FIND v(dout0_59) AT=1670.05n

.meas tran vdout0_60ck1660 FIND v(dout0_60) AT=1670.05n

.meas tran vdout0_61ck1660 FIND v(dout0_61) AT=1670.05n

.meas tran vdout0_62ck1660 FIND v(dout0_62) AT=1670.05n

.meas tran vdout0_63ck1660 FIND v(dout0_63) AT=1670.05n

.meas tran vdout1_0ck1660 FIND v(dout1_0) AT=1670.05n

.meas tran vdout1_1ck1660 FIND v(dout1_1) AT=1670.05n

.meas tran vdout1_2ck1660 FIND v(dout1_2) AT=1670.05n

.meas tran vdout1_3ck1660 FIND v(dout1_3) AT=1670.05n

.meas tran vdout1_4ck1660 FIND v(dout1_4) AT=1670.05n

.meas tran vdout1_5ck1660 FIND v(dout1_5) AT=1670.05n

.meas tran vdout1_6ck1660 FIND v(dout1_6) AT=1670.05n

.meas tran vdout1_7ck1660 FIND v(dout1_7) AT=1670.05n

.meas tran vdout1_8ck1660 FIND v(dout1_8) AT=1670.05n

.meas tran vdout1_9ck1660 FIND v(dout1_9) AT=1670.05n

.meas tran vdout1_10ck1660 FIND v(dout1_10) AT=1670.05n

.meas tran vdout1_11ck1660 FIND v(dout1_11) AT=1670.05n

.meas tran vdout1_12ck1660 FIND v(dout1_12) AT=1670.05n

.meas tran vdout1_13ck1660 FIND v(dout1_13) AT=1670.05n

.meas tran vdout1_14ck1660 FIND v(dout1_14) AT=1670.05n

.meas tran vdout1_15ck1660 FIND v(dout1_15) AT=1670.05n

.meas tran vdout1_16ck1660 FIND v(dout1_16) AT=1670.05n

.meas tran vdout1_17ck1660 FIND v(dout1_17) AT=1670.05n

.meas tran vdout1_18ck1660 FIND v(dout1_18) AT=1670.05n

.meas tran vdout1_19ck1660 FIND v(dout1_19) AT=1670.05n

.meas tran vdout1_20ck1660 FIND v(dout1_20) AT=1670.05n

.meas tran vdout1_21ck1660 FIND v(dout1_21) AT=1670.05n

.meas tran vdout1_22ck1660 FIND v(dout1_22) AT=1670.05n

.meas tran vdout1_23ck1660 FIND v(dout1_23) AT=1670.05n

.meas tran vdout1_24ck1660 FIND v(dout1_24) AT=1670.05n

.meas tran vdout1_25ck1660 FIND v(dout1_25) AT=1670.05n

.meas tran vdout1_26ck1660 FIND v(dout1_26) AT=1670.05n

.meas tran vdout1_27ck1660 FIND v(dout1_27) AT=1670.05n

.meas tran vdout1_28ck1660 FIND v(dout1_28) AT=1670.05n

.meas tran vdout1_29ck1660 FIND v(dout1_29) AT=1670.05n

.meas tran vdout1_30ck1660 FIND v(dout1_30) AT=1670.05n

.meas tran vdout1_31ck1660 FIND v(dout1_31) AT=1670.05n

.meas tran vdout1_32ck1660 FIND v(dout1_32) AT=1670.05n

.meas tran vdout1_33ck1660 FIND v(dout1_33) AT=1670.05n

.meas tran vdout1_34ck1660 FIND v(dout1_34) AT=1670.05n

.meas tran vdout1_35ck1660 FIND v(dout1_35) AT=1670.05n

.meas tran vdout1_36ck1660 FIND v(dout1_36) AT=1670.05n

.meas tran vdout1_37ck1660 FIND v(dout1_37) AT=1670.05n

.meas tran vdout1_38ck1660 FIND v(dout1_38) AT=1670.05n

.meas tran vdout1_39ck1660 FIND v(dout1_39) AT=1670.05n

.meas tran vdout1_40ck1660 FIND v(dout1_40) AT=1670.05n

.meas tran vdout1_41ck1660 FIND v(dout1_41) AT=1670.05n

.meas tran vdout1_42ck1660 FIND v(dout1_42) AT=1670.05n

.meas tran vdout1_43ck1660 FIND v(dout1_43) AT=1670.05n

.meas tran vdout1_44ck1660 FIND v(dout1_44) AT=1670.05n

.meas tran vdout1_45ck1660 FIND v(dout1_45) AT=1670.05n

.meas tran vdout1_46ck1660 FIND v(dout1_46) AT=1670.05n

.meas tran vdout1_47ck1660 FIND v(dout1_47) AT=1670.05n

.meas tran vdout1_48ck1660 FIND v(dout1_48) AT=1670.05n

.meas tran vdout1_49ck1660 FIND v(dout1_49) AT=1670.05n

.meas tran vdout1_50ck1660 FIND v(dout1_50) AT=1670.05n

.meas tran vdout1_51ck1660 FIND v(dout1_51) AT=1670.05n

.meas tran vdout1_52ck1660 FIND v(dout1_52) AT=1670.05n

.meas tran vdout1_53ck1660 FIND v(dout1_53) AT=1670.05n

.meas tran vdout1_54ck1660 FIND v(dout1_54) AT=1670.05n

.meas tran vdout1_55ck1660 FIND v(dout1_55) AT=1670.05n

.meas tran vdout1_56ck1660 FIND v(dout1_56) AT=1670.05n

.meas tran vdout1_57ck1660 FIND v(dout1_57) AT=1670.05n

.meas tran vdout1_58ck1660 FIND v(dout1_58) AT=1670.05n

.meas tran vdout1_59ck1660 FIND v(dout1_59) AT=1670.05n

.meas tran vdout1_60ck1660 FIND v(dout1_60) AT=1670.05n

.meas tran vdout1_61ck1660 FIND v(dout1_61) AT=1670.05n

.meas tran vdout1_62ck1660 FIND v(dout1_62) AT=1670.05n

.meas tran vdout1_63ck1660 FIND v(dout1_63) AT=1670.05n

.meas tran vdout0_0ck1670 FIND v(dout0_0) AT=1680.05n

.meas tran vdout0_1ck1670 FIND v(dout0_1) AT=1680.05n

.meas tran vdout0_2ck1670 FIND v(dout0_2) AT=1680.05n

.meas tran vdout0_3ck1670 FIND v(dout0_3) AT=1680.05n

.meas tran vdout0_4ck1670 FIND v(dout0_4) AT=1680.05n

.meas tran vdout0_5ck1670 FIND v(dout0_5) AT=1680.05n

.meas tran vdout0_6ck1670 FIND v(dout0_6) AT=1680.05n

.meas tran vdout0_7ck1670 FIND v(dout0_7) AT=1680.05n

.meas tran vdout0_8ck1670 FIND v(dout0_8) AT=1680.05n

.meas tran vdout0_9ck1670 FIND v(dout0_9) AT=1680.05n

.meas tran vdout0_10ck1670 FIND v(dout0_10) AT=1680.05n

.meas tran vdout0_11ck1670 FIND v(dout0_11) AT=1680.05n

.meas tran vdout0_12ck1670 FIND v(dout0_12) AT=1680.05n

.meas tran vdout0_13ck1670 FIND v(dout0_13) AT=1680.05n

.meas tran vdout0_14ck1670 FIND v(dout0_14) AT=1680.05n

.meas tran vdout0_15ck1670 FIND v(dout0_15) AT=1680.05n

.meas tran vdout0_16ck1670 FIND v(dout0_16) AT=1680.05n

.meas tran vdout0_17ck1670 FIND v(dout0_17) AT=1680.05n

.meas tran vdout0_18ck1670 FIND v(dout0_18) AT=1680.05n

.meas tran vdout0_19ck1670 FIND v(dout0_19) AT=1680.05n

.meas tran vdout0_20ck1670 FIND v(dout0_20) AT=1680.05n

.meas tran vdout0_21ck1670 FIND v(dout0_21) AT=1680.05n

.meas tran vdout0_22ck1670 FIND v(dout0_22) AT=1680.05n

.meas tran vdout0_23ck1670 FIND v(dout0_23) AT=1680.05n

.meas tran vdout0_24ck1670 FIND v(dout0_24) AT=1680.05n

.meas tran vdout0_25ck1670 FIND v(dout0_25) AT=1680.05n

.meas tran vdout0_26ck1670 FIND v(dout0_26) AT=1680.05n

.meas tran vdout0_27ck1670 FIND v(dout0_27) AT=1680.05n

.meas tran vdout0_28ck1670 FIND v(dout0_28) AT=1680.05n

.meas tran vdout0_29ck1670 FIND v(dout0_29) AT=1680.05n

.meas tran vdout0_30ck1670 FIND v(dout0_30) AT=1680.05n

.meas tran vdout0_31ck1670 FIND v(dout0_31) AT=1680.05n

.meas tran vdout0_32ck1670 FIND v(dout0_32) AT=1680.05n

.meas tran vdout0_33ck1670 FIND v(dout0_33) AT=1680.05n

.meas tran vdout0_34ck1670 FIND v(dout0_34) AT=1680.05n

.meas tran vdout0_35ck1670 FIND v(dout0_35) AT=1680.05n

.meas tran vdout0_36ck1670 FIND v(dout0_36) AT=1680.05n

.meas tran vdout0_37ck1670 FIND v(dout0_37) AT=1680.05n

.meas tran vdout0_38ck1670 FIND v(dout0_38) AT=1680.05n

.meas tran vdout0_39ck1670 FIND v(dout0_39) AT=1680.05n

.meas tran vdout0_40ck1670 FIND v(dout0_40) AT=1680.05n

.meas tran vdout0_41ck1670 FIND v(dout0_41) AT=1680.05n

.meas tran vdout0_42ck1670 FIND v(dout0_42) AT=1680.05n

.meas tran vdout0_43ck1670 FIND v(dout0_43) AT=1680.05n

.meas tran vdout0_44ck1670 FIND v(dout0_44) AT=1680.05n

.meas tran vdout0_45ck1670 FIND v(dout0_45) AT=1680.05n

.meas tran vdout0_46ck1670 FIND v(dout0_46) AT=1680.05n

.meas tran vdout0_47ck1670 FIND v(dout0_47) AT=1680.05n

.meas tran vdout0_48ck1670 FIND v(dout0_48) AT=1680.05n

.meas tran vdout0_49ck1670 FIND v(dout0_49) AT=1680.05n

.meas tran vdout0_50ck1670 FIND v(dout0_50) AT=1680.05n

.meas tran vdout0_51ck1670 FIND v(dout0_51) AT=1680.05n

.meas tran vdout0_52ck1670 FIND v(dout0_52) AT=1680.05n

.meas tran vdout0_53ck1670 FIND v(dout0_53) AT=1680.05n

.meas tran vdout0_54ck1670 FIND v(dout0_54) AT=1680.05n

.meas tran vdout0_55ck1670 FIND v(dout0_55) AT=1680.05n

.meas tran vdout0_56ck1670 FIND v(dout0_56) AT=1680.05n

.meas tran vdout0_57ck1670 FIND v(dout0_57) AT=1680.05n

.meas tran vdout0_58ck1670 FIND v(dout0_58) AT=1680.05n

.meas tran vdout0_59ck1670 FIND v(dout0_59) AT=1680.05n

.meas tran vdout0_60ck1670 FIND v(dout0_60) AT=1680.05n

.meas tran vdout0_61ck1670 FIND v(dout0_61) AT=1680.05n

.meas tran vdout0_62ck1670 FIND v(dout0_62) AT=1680.05n

.meas tran vdout0_63ck1670 FIND v(dout0_63) AT=1680.05n

.meas tran vdout1_0ck1670 FIND v(dout1_0) AT=1680.05n

.meas tran vdout1_1ck1670 FIND v(dout1_1) AT=1680.05n

.meas tran vdout1_2ck1670 FIND v(dout1_2) AT=1680.05n

.meas tran vdout1_3ck1670 FIND v(dout1_3) AT=1680.05n

.meas tran vdout1_4ck1670 FIND v(dout1_4) AT=1680.05n

.meas tran vdout1_5ck1670 FIND v(dout1_5) AT=1680.05n

.meas tran vdout1_6ck1670 FIND v(dout1_6) AT=1680.05n

.meas tran vdout1_7ck1670 FIND v(dout1_7) AT=1680.05n

.meas tran vdout1_8ck1670 FIND v(dout1_8) AT=1680.05n

.meas tran vdout1_9ck1670 FIND v(dout1_9) AT=1680.05n

.meas tran vdout1_10ck1670 FIND v(dout1_10) AT=1680.05n

.meas tran vdout1_11ck1670 FIND v(dout1_11) AT=1680.05n

.meas tran vdout1_12ck1670 FIND v(dout1_12) AT=1680.05n

.meas tran vdout1_13ck1670 FIND v(dout1_13) AT=1680.05n

.meas tran vdout1_14ck1670 FIND v(dout1_14) AT=1680.05n

.meas tran vdout1_15ck1670 FIND v(dout1_15) AT=1680.05n

.meas tran vdout1_16ck1670 FIND v(dout1_16) AT=1680.05n

.meas tran vdout1_17ck1670 FIND v(dout1_17) AT=1680.05n

.meas tran vdout1_18ck1670 FIND v(dout1_18) AT=1680.05n

.meas tran vdout1_19ck1670 FIND v(dout1_19) AT=1680.05n

.meas tran vdout1_20ck1670 FIND v(dout1_20) AT=1680.05n

.meas tran vdout1_21ck1670 FIND v(dout1_21) AT=1680.05n

.meas tran vdout1_22ck1670 FIND v(dout1_22) AT=1680.05n

.meas tran vdout1_23ck1670 FIND v(dout1_23) AT=1680.05n

.meas tran vdout1_24ck1670 FIND v(dout1_24) AT=1680.05n

.meas tran vdout1_25ck1670 FIND v(dout1_25) AT=1680.05n

.meas tran vdout1_26ck1670 FIND v(dout1_26) AT=1680.05n

.meas tran vdout1_27ck1670 FIND v(dout1_27) AT=1680.05n

.meas tran vdout1_28ck1670 FIND v(dout1_28) AT=1680.05n

.meas tran vdout1_29ck1670 FIND v(dout1_29) AT=1680.05n

.meas tran vdout1_30ck1670 FIND v(dout1_30) AT=1680.05n

.meas tran vdout1_31ck1670 FIND v(dout1_31) AT=1680.05n

.meas tran vdout1_32ck1670 FIND v(dout1_32) AT=1680.05n

.meas tran vdout1_33ck1670 FIND v(dout1_33) AT=1680.05n

.meas tran vdout1_34ck1670 FIND v(dout1_34) AT=1680.05n

.meas tran vdout1_35ck1670 FIND v(dout1_35) AT=1680.05n

.meas tran vdout1_36ck1670 FIND v(dout1_36) AT=1680.05n

.meas tran vdout1_37ck1670 FIND v(dout1_37) AT=1680.05n

.meas tran vdout1_38ck1670 FIND v(dout1_38) AT=1680.05n

.meas tran vdout1_39ck1670 FIND v(dout1_39) AT=1680.05n

.meas tran vdout1_40ck1670 FIND v(dout1_40) AT=1680.05n

.meas tran vdout1_41ck1670 FIND v(dout1_41) AT=1680.05n

.meas tran vdout1_42ck1670 FIND v(dout1_42) AT=1680.05n

.meas tran vdout1_43ck1670 FIND v(dout1_43) AT=1680.05n

.meas tran vdout1_44ck1670 FIND v(dout1_44) AT=1680.05n

.meas tran vdout1_45ck1670 FIND v(dout1_45) AT=1680.05n

.meas tran vdout1_46ck1670 FIND v(dout1_46) AT=1680.05n

.meas tran vdout1_47ck1670 FIND v(dout1_47) AT=1680.05n

.meas tran vdout1_48ck1670 FIND v(dout1_48) AT=1680.05n

.meas tran vdout1_49ck1670 FIND v(dout1_49) AT=1680.05n

.meas tran vdout1_50ck1670 FIND v(dout1_50) AT=1680.05n

.meas tran vdout1_51ck1670 FIND v(dout1_51) AT=1680.05n

.meas tran vdout1_52ck1670 FIND v(dout1_52) AT=1680.05n

.meas tran vdout1_53ck1670 FIND v(dout1_53) AT=1680.05n

.meas tran vdout1_54ck1670 FIND v(dout1_54) AT=1680.05n

.meas tran vdout1_55ck1670 FIND v(dout1_55) AT=1680.05n

.meas tran vdout1_56ck1670 FIND v(dout1_56) AT=1680.05n

.meas tran vdout1_57ck1670 FIND v(dout1_57) AT=1680.05n

.meas tran vdout1_58ck1670 FIND v(dout1_58) AT=1680.05n

.meas tran vdout1_59ck1670 FIND v(dout1_59) AT=1680.05n

.meas tran vdout1_60ck1670 FIND v(dout1_60) AT=1680.05n

.meas tran vdout1_61ck1670 FIND v(dout1_61) AT=1680.05n

.meas tran vdout1_62ck1670 FIND v(dout1_62) AT=1680.05n

.meas tran vdout1_63ck1670 FIND v(dout1_63) AT=1680.05n

.meas tran vdout1_0ck1680 FIND v(dout1_0) AT=1690.05n

.meas tran vdout1_1ck1680 FIND v(dout1_1) AT=1690.05n

.meas tran vdout1_2ck1680 FIND v(dout1_2) AT=1690.05n

.meas tran vdout1_3ck1680 FIND v(dout1_3) AT=1690.05n

.meas tran vdout1_4ck1680 FIND v(dout1_4) AT=1690.05n

.meas tran vdout1_5ck1680 FIND v(dout1_5) AT=1690.05n

.meas tran vdout1_6ck1680 FIND v(dout1_6) AT=1690.05n

.meas tran vdout1_7ck1680 FIND v(dout1_7) AT=1690.05n

.meas tran vdout1_8ck1680 FIND v(dout1_8) AT=1690.05n

.meas tran vdout1_9ck1680 FIND v(dout1_9) AT=1690.05n

.meas tran vdout1_10ck1680 FIND v(dout1_10) AT=1690.05n

.meas tran vdout1_11ck1680 FIND v(dout1_11) AT=1690.05n

.meas tran vdout1_12ck1680 FIND v(dout1_12) AT=1690.05n

.meas tran vdout1_13ck1680 FIND v(dout1_13) AT=1690.05n

.meas tran vdout1_14ck1680 FIND v(dout1_14) AT=1690.05n

.meas tran vdout1_15ck1680 FIND v(dout1_15) AT=1690.05n

.meas tran vdout1_16ck1680 FIND v(dout1_16) AT=1690.05n

.meas tran vdout1_17ck1680 FIND v(dout1_17) AT=1690.05n

.meas tran vdout1_18ck1680 FIND v(dout1_18) AT=1690.05n

.meas tran vdout1_19ck1680 FIND v(dout1_19) AT=1690.05n

.meas tran vdout1_20ck1680 FIND v(dout1_20) AT=1690.05n

.meas tran vdout1_21ck1680 FIND v(dout1_21) AT=1690.05n

.meas tran vdout1_22ck1680 FIND v(dout1_22) AT=1690.05n

.meas tran vdout1_23ck1680 FIND v(dout1_23) AT=1690.05n

.meas tran vdout1_24ck1680 FIND v(dout1_24) AT=1690.05n

.meas tran vdout1_25ck1680 FIND v(dout1_25) AT=1690.05n

.meas tran vdout1_26ck1680 FIND v(dout1_26) AT=1690.05n

.meas tran vdout1_27ck1680 FIND v(dout1_27) AT=1690.05n

.meas tran vdout1_28ck1680 FIND v(dout1_28) AT=1690.05n

.meas tran vdout1_29ck1680 FIND v(dout1_29) AT=1690.05n

.meas tran vdout1_30ck1680 FIND v(dout1_30) AT=1690.05n

.meas tran vdout1_31ck1680 FIND v(dout1_31) AT=1690.05n

.meas tran vdout1_32ck1680 FIND v(dout1_32) AT=1690.05n

.meas tran vdout1_33ck1680 FIND v(dout1_33) AT=1690.05n

.meas tran vdout1_34ck1680 FIND v(dout1_34) AT=1690.05n

.meas tran vdout1_35ck1680 FIND v(dout1_35) AT=1690.05n

.meas tran vdout1_36ck1680 FIND v(dout1_36) AT=1690.05n

.meas tran vdout1_37ck1680 FIND v(dout1_37) AT=1690.05n

.meas tran vdout1_38ck1680 FIND v(dout1_38) AT=1690.05n

.meas tran vdout1_39ck1680 FIND v(dout1_39) AT=1690.05n

.meas tran vdout1_40ck1680 FIND v(dout1_40) AT=1690.05n

.meas tran vdout1_41ck1680 FIND v(dout1_41) AT=1690.05n

.meas tran vdout1_42ck1680 FIND v(dout1_42) AT=1690.05n

.meas tran vdout1_43ck1680 FIND v(dout1_43) AT=1690.05n

.meas tran vdout1_44ck1680 FIND v(dout1_44) AT=1690.05n

.meas tran vdout1_45ck1680 FIND v(dout1_45) AT=1690.05n

.meas tran vdout1_46ck1680 FIND v(dout1_46) AT=1690.05n

.meas tran vdout1_47ck1680 FIND v(dout1_47) AT=1690.05n

.meas tran vdout1_48ck1680 FIND v(dout1_48) AT=1690.05n

.meas tran vdout1_49ck1680 FIND v(dout1_49) AT=1690.05n

.meas tran vdout1_50ck1680 FIND v(dout1_50) AT=1690.05n

.meas tran vdout1_51ck1680 FIND v(dout1_51) AT=1690.05n

.meas tran vdout1_52ck1680 FIND v(dout1_52) AT=1690.05n

.meas tran vdout1_53ck1680 FIND v(dout1_53) AT=1690.05n

.meas tran vdout1_54ck1680 FIND v(dout1_54) AT=1690.05n

.meas tran vdout1_55ck1680 FIND v(dout1_55) AT=1690.05n

.meas tran vdout1_56ck1680 FIND v(dout1_56) AT=1690.05n

.meas tran vdout1_57ck1680 FIND v(dout1_57) AT=1690.05n

.meas tran vdout1_58ck1680 FIND v(dout1_58) AT=1690.05n

.meas tran vdout1_59ck1680 FIND v(dout1_59) AT=1690.05n

.meas tran vdout1_60ck1680 FIND v(dout1_60) AT=1690.05n

.meas tran vdout1_61ck1680 FIND v(dout1_61) AT=1690.05n

.meas tran vdout1_62ck1680 FIND v(dout1_62) AT=1690.05n

.meas tran vdout1_63ck1680 FIND v(dout1_63) AT=1690.05n

.meas tran vdout0_0ck1690 FIND v(dout0_0) AT=1700.05n

.meas tran vdout0_1ck1690 FIND v(dout0_1) AT=1700.05n

.meas tran vdout0_2ck1690 FIND v(dout0_2) AT=1700.05n

.meas tran vdout0_3ck1690 FIND v(dout0_3) AT=1700.05n

.meas tran vdout0_4ck1690 FIND v(dout0_4) AT=1700.05n

.meas tran vdout0_5ck1690 FIND v(dout0_5) AT=1700.05n

.meas tran vdout0_6ck1690 FIND v(dout0_6) AT=1700.05n

.meas tran vdout0_7ck1690 FIND v(dout0_7) AT=1700.05n

.meas tran vdout0_8ck1690 FIND v(dout0_8) AT=1700.05n

.meas tran vdout0_9ck1690 FIND v(dout0_9) AT=1700.05n

.meas tran vdout0_10ck1690 FIND v(dout0_10) AT=1700.05n

.meas tran vdout0_11ck1690 FIND v(dout0_11) AT=1700.05n

.meas tran vdout0_12ck1690 FIND v(dout0_12) AT=1700.05n

.meas tran vdout0_13ck1690 FIND v(dout0_13) AT=1700.05n

.meas tran vdout0_14ck1690 FIND v(dout0_14) AT=1700.05n

.meas tran vdout0_15ck1690 FIND v(dout0_15) AT=1700.05n

.meas tran vdout0_16ck1690 FIND v(dout0_16) AT=1700.05n

.meas tran vdout0_17ck1690 FIND v(dout0_17) AT=1700.05n

.meas tran vdout0_18ck1690 FIND v(dout0_18) AT=1700.05n

.meas tran vdout0_19ck1690 FIND v(dout0_19) AT=1700.05n

.meas tran vdout0_20ck1690 FIND v(dout0_20) AT=1700.05n

.meas tran vdout0_21ck1690 FIND v(dout0_21) AT=1700.05n

.meas tran vdout0_22ck1690 FIND v(dout0_22) AT=1700.05n

.meas tran vdout0_23ck1690 FIND v(dout0_23) AT=1700.05n

.meas tran vdout0_24ck1690 FIND v(dout0_24) AT=1700.05n

.meas tran vdout0_25ck1690 FIND v(dout0_25) AT=1700.05n

.meas tran vdout0_26ck1690 FIND v(dout0_26) AT=1700.05n

.meas tran vdout0_27ck1690 FIND v(dout0_27) AT=1700.05n

.meas tran vdout0_28ck1690 FIND v(dout0_28) AT=1700.05n

.meas tran vdout0_29ck1690 FIND v(dout0_29) AT=1700.05n

.meas tran vdout0_30ck1690 FIND v(dout0_30) AT=1700.05n

.meas tran vdout0_31ck1690 FIND v(dout0_31) AT=1700.05n

.meas tran vdout0_32ck1690 FIND v(dout0_32) AT=1700.05n

.meas tran vdout0_33ck1690 FIND v(dout0_33) AT=1700.05n

.meas tran vdout0_34ck1690 FIND v(dout0_34) AT=1700.05n

.meas tran vdout0_35ck1690 FIND v(dout0_35) AT=1700.05n

.meas tran vdout0_36ck1690 FIND v(dout0_36) AT=1700.05n

.meas tran vdout0_37ck1690 FIND v(dout0_37) AT=1700.05n

.meas tran vdout0_38ck1690 FIND v(dout0_38) AT=1700.05n

.meas tran vdout0_39ck1690 FIND v(dout0_39) AT=1700.05n

.meas tran vdout0_40ck1690 FIND v(dout0_40) AT=1700.05n

.meas tran vdout0_41ck1690 FIND v(dout0_41) AT=1700.05n

.meas tran vdout0_42ck1690 FIND v(dout0_42) AT=1700.05n

.meas tran vdout0_43ck1690 FIND v(dout0_43) AT=1700.05n

.meas tran vdout0_44ck1690 FIND v(dout0_44) AT=1700.05n

.meas tran vdout0_45ck1690 FIND v(dout0_45) AT=1700.05n

.meas tran vdout0_46ck1690 FIND v(dout0_46) AT=1700.05n

.meas tran vdout0_47ck1690 FIND v(dout0_47) AT=1700.05n

.meas tran vdout0_48ck1690 FIND v(dout0_48) AT=1700.05n

.meas tran vdout0_49ck1690 FIND v(dout0_49) AT=1700.05n

.meas tran vdout0_50ck1690 FIND v(dout0_50) AT=1700.05n

.meas tran vdout0_51ck1690 FIND v(dout0_51) AT=1700.05n

.meas tran vdout0_52ck1690 FIND v(dout0_52) AT=1700.05n

.meas tran vdout0_53ck1690 FIND v(dout0_53) AT=1700.05n

.meas tran vdout0_54ck1690 FIND v(dout0_54) AT=1700.05n

.meas tran vdout0_55ck1690 FIND v(dout0_55) AT=1700.05n

.meas tran vdout0_56ck1690 FIND v(dout0_56) AT=1700.05n

.meas tran vdout0_57ck1690 FIND v(dout0_57) AT=1700.05n

.meas tran vdout0_58ck1690 FIND v(dout0_58) AT=1700.05n

.meas tran vdout0_59ck1690 FIND v(dout0_59) AT=1700.05n

.meas tran vdout0_60ck1690 FIND v(dout0_60) AT=1700.05n

.meas tran vdout0_61ck1690 FIND v(dout0_61) AT=1700.05n

.meas tran vdout0_62ck1690 FIND v(dout0_62) AT=1700.05n

.meas tran vdout0_63ck1690 FIND v(dout0_63) AT=1700.05n

.meas tran vdout1_0ck1690 FIND v(dout1_0) AT=1700.05n

.meas tran vdout1_1ck1690 FIND v(dout1_1) AT=1700.05n

.meas tran vdout1_2ck1690 FIND v(dout1_2) AT=1700.05n

.meas tran vdout1_3ck1690 FIND v(dout1_3) AT=1700.05n

.meas tran vdout1_4ck1690 FIND v(dout1_4) AT=1700.05n

.meas tran vdout1_5ck1690 FIND v(dout1_5) AT=1700.05n

.meas tran vdout1_6ck1690 FIND v(dout1_6) AT=1700.05n

.meas tran vdout1_7ck1690 FIND v(dout1_7) AT=1700.05n

.meas tran vdout1_8ck1690 FIND v(dout1_8) AT=1700.05n

.meas tran vdout1_9ck1690 FIND v(dout1_9) AT=1700.05n

.meas tran vdout1_10ck1690 FIND v(dout1_10) AT=1700.05n

.meas tran vdout1_11ck1690 FIND v(dout1_11) AT=1700.05n

.meas tran vdout1_12ck1690 FIND v(dout1_12) AT=1700.05n

.meas tran vdout1_13ck1690 FIND v(dout1_13) AT=1700.05n

.meas tran vdout1_14ck1690 FIND v(dout1_14) AT=1700.05n

.meas tran vdout1_15ck1690 FIND v(dout1_15) AT=1700.05n

.meas tran vdout1_16ck1690 FIND v(dout1_16) AT=1700.05n

.meas tran vdout1_17ck1690 FIND v(dout1_17) AT=1700.05n

.meas tran vdout1_18ck1690 FIND v(dout1_18) AT=1700.05n

.meas tran vdout1_19ck1690 FIND v(dout1_19) AT=1700.05n

.meas tran vdout1_20ck1690 FIND v(dout1_20) AT=1700.05n

.meas tran vdout1_21ck1690 FIND v(dout1_21) AT=1700.05n

.meas tran vdout1_22ck1690 FIND v(dout1_22) AT=1700.05n

.meas tran vdout1_23ck1690 FIND v(dout1_23) AT=1700.05n

.meas tran vdout1_24ck1690 FIND v(dout1_24) AT=1700.05n

.meas tran vdout1_25ck1690 FIND v(dout1_25) AT=1700.05n

.meas tran vdout1_26ck1690 FIND v(dout1_26) AT=1700.05n

.meas tran vdout1_27ck1690 FIND v(dout1_27) AT=1700.05n

.meas tran vdout1_28ck1690 FIND v(dout1_28) AT=1700.05n

.meas tran vdout1_29ck1690 FIND v(dout1_29) AT=1700.05n

.meas tran vdout1_30ck1690 FIND v(dout1_30) AT=1700.05n

.meas tran vdout1_31ck1690 FIND v(dout1_31) AT=1700.05n

.meas tran vdout1_32ck1690 FIND v(dout1_32) AT=1700.05n

.meas tran vdout1_33ck1690 FIND v(dout1_33) AT=1700.05n

.meas tran vdout1_34ck1690 FIND v(dout1_34) AT=1700.05n

.meas tran vdout1_35ck1690 FIND v(dout1_35) AT=1700.05n

.meas tran vdout1_36ck1690 FIND v(dout1_36) AT=1700.05n

.meas tran vdout1_37ck1690 FIND v(dout1_37) AT=1700.05n

.meas tran vdout1_38ck1690 FIND v(dout1_38) AT=1700.05n

.meas tran vdout1_39ck1690 FIND v(dout1_39) AT=1700.05n

.meas tran vdout1_40ck1690 FIND v(dout1_40) AT=1700.05n

.meas tran vdout1_41ck1690 FIND v(dout1_41) AT=1700.05n

.meas tran vdout1_42ck1690 FIND v(dout1_42) AT=1700.05n

.meas tran vdout1_43ck1690 FIND v(dout1_43) AT=1700.05n

.meas tran vdout1_44ck1690 FIND v(dout1_44) AT=1700.05n

.meas tran vdout1_45ck1690 FIND v(dout1_45) AT=1700.05n

.meas tran vdout1_46ck1690 FIND v(dout1_46) AT=1700.05n

.meas tran vdout1_47ck1690 FIND v(dout1_47) AT=1700.05n

.meas tran vdout1_48ck1690 FIND v(dout1_48) AT=1700.05n

.meas tran vdout1_49ck1690 FIND v(dout1_49) AT=1700.05n

.meas tran vdout1_50ck1690 FIND v(dout1_50) AT=1700.05n

.meas tran vdout1_51ck1690 FIND v(dout1_51) AT=1700.05n

.meas tran vdout1_52ck1690 FIND v(dout1_52) AT=1700.05n

.meas tran vdout1_53ck1690 FIND v(dout1_53) AT=1700.05n

.meas tran vdout1_54ck1690 FIND v(dout1_54) AT=1700.05n

.meas tran vdout1_55ck1690 FIND v(dout1_55) AT=1700.05n

.meas tran vdout1_56ck1690 FIND v(dout1_56) AT=1700.05n

.meas tran vdout1_57ck1690 FIND v(dout1_57) AT=1700.05n

.meas tran vdout1_58ck1690 FIND v(dout1_58) AT=1700.05n

.meas tran vdout1_59ck1690 FIND v(dout1_59) AT=1700.05n

.meas tran vdout1_60ck1690 FIND v(dout1_60) AT=1700.05n

.meas tran vdout1_61ck1690 FIND v(dout1_61) AT=1700.05n

.meas tran vdout1_62ck1690 FIND v(dout1_62) AT=1700.05n

.meas tran vdout1_63ck1690 FIND v(dout1_63) AT=1700.05n

.meas tran vdout1_0ck1710 FIND v(dout1_0) AT=1720.05n

.meas tran vdout1_1ck1710 FIND v(dout1_1) AT=1720.05n

.meas tran vdout1_2ck1710 FIND v(dout1_2) AT=1720.05n

.meas tran vdout1_3ck1710 FIND v(dout1_3) AT=1720.05n

.meas tran vdout1_4ck1710 FIND v(dout1_4) AT=1720.05n

.meas tran vdout1_5ck1710 FIND v(dout1_5) AT=1720.05n

.meas tran vdout1_6ck1710 FIND v(dout1_6) AT=1720.05n

.meas tran vdout1_7ck1710 FIND v(dout1_7) AT=1720.05n

.meas tran vdout1_8ck1710 FIND v(dout1_8) AT=1720.05n

.meas tran vdout1_9ck1710 FIND v(dout1_9) AT=1720.05n

.meas tran vdout1_10ck1710 FIND v(dout1_10) AT=1720.05n

.meas tran vdout1_11ck1710 FIND v(dout1_11) AT=1720.05n

.meas tran vdout1_12ck1710 FIND v(dout1_12) AT=1720.05n

.meas tran vdout1_13ck1710 FIND v(dout1_13) AT=1720.05n

.meas tran vdout1_14ck1710 FIND v(dout1_14) AT=1720.05n

.meas tran vdout1_15ck1710 FIND v(dout1_15) AT=1720.05n

.meas tran vdout1_16ck1710 FIND v(dout1_16) AT=1720.05n

.meas tran vdout1_17ck1710 FIND v(dout1_17) AT=1720.05n

.meas tran vdout1_18ck1710 FIND v(dout1_18) AT=1720.05n

.meas tran vdout1_19ck1710 FIND v(dout1_19) AT=1720.05n

.meas tran vdout1_20ck1710 FIND v(dout1_20) AT=1720.05n

.meas tran vdout1_21ck1710 FIND v(dout1_21) AT=1720.05n

.meas tran vdout1_22ck1710 FIND v(dout1_22) AT=1720.05n

.meas tran vdout1_23ck1710 FIND v(dout1_23) AT=1720.05n

.meas tran vdout1_24ck1710 FIND v(dout1_24) AT=1720.05n

.meas tran vdout1_25ck1710 FIND v(dout1_25) AT=1720.05n

.meas tran vdout1_26ck1710 FIND v(dout1_26) AT=1720.05n

.meas tran vdout1_27ck1710 FIND v(dout1_27) AT=1720.05n

.meas tran vdout1_28ck1710 FIND v(dout1_28) AT=1720.05n

.meas tran vdout1_29ck1710 FIND v(dout1_29) AT=1720.05n

.meas tran vdout1_30ck1710 FIND v(dout1_30) AT=1720.05n

.meas tran vdout1_31ck1710 FIND v(dout1_31) AT=1720.05n

.meas tran vdout1_32ck1710 FIND v(dout1_32) AT=1720.05n

.meas tran vdout1_33ck1710 FIND v(dout1_33) AT=1720.05n

.meas tran vdout1_34ck1710 FIND v(dout1_34) AT=1720.05n

.meas tran vdout1_35ck1710 FIND v(dout1_35) AT=1720.05n

.meas tran vdout1_36ck1710 FIND v(dout1_36) AT=1720.05n

.meas tran vdout1_37ck1710 FIND v(dout1_37) AT=1720.05n

.meas tran vdout1_38ck1710 FIND v(dout1_38) AT=1720.05n

.meas tran vdout1_39ck1710 FIND v(dout1_39) AT=1720.05n

.meas tran vdout1_40ck1710 FIND v(dout1_40) AT=1720.05n

.meas tran vdout1_41ck1710 FIND v(dout1_41) AT=1720.05n

.meas tran vdout1_42ck1710 FIND v(dout1_42) AT=1720.05n

.meas tran vdout1_43ck1710 FIND v(dout1_43) AT=1720.05n

.meas tran vdout1_44ck1710 FIND v(dout1_44) AT=1720.05n

.meas tran vdout1_45ck1710 FIND v(dout1_45) AT=1720.05n

.meas tran vdout1_46ck1710 FIND v(dout1_46) AT=1720.05n

.meas tran vdout1_47ck1710 FIND v(dout1_47) AT=1720.05n

.meas tran vdout1_48ck1710 FIND v(dout1_48) AT=1720.05n

.meas tran vdout1_49ck1710 FIND v(dout1_49) AT=1720.05n

.meas tran vdout1_50ck1710 FIND v(dout1_50) AT=1720.05n

.meas tran vdout1_51ck1710 FIND v(dout1_51) AT=1720.05n

.meas tran vdout1_52ck1710 FIND v(dout1_52) AT=1720.05n

.meas tran vdout1_53ck1710 FIND v(dout1_53) AT=1720.05n

.meas tran vdout1_54ck1710 FIND v(dout1_54) AT=1720.05n

.meas tran vdout1_55ck1710 FIND v(dout1_55) AT=1720.05n

.meas tran vdout1_56ck1710 FIND v(dout1_56) AT=1720.05n

.meas tran vdout1_57ck1710 FIND v(dout1_57) AT=1720.05n

.meas tran vdout1_58ck1710 FIND v(dout1_58) AT=1720.05n

.meas tran vdout1_59ck1710 FIND v(dout1_59) AT=1720.05n

.meas tran vdout1_60ck1710 FIND v(dout1_60) AT=1720.05n

.meas tran vdout1_61ck1710 FIND v(dout1_61) AT=1720.05n

.meas tran vdout1_62ck1710 FIND v(dout1_62) AT=1720.05n

.meas tran vdout1_63ck1710 FIND v(dout1_63) AT=1720.05n

.meas tran vdout0_0ck1720 FIND v(dout0_0) AT=1730.05n

.meas tran vdout0_1ck1720 FIND v(dout0_1) AT=1730.05n

.meas tran vdout0_2ck1720 FIND v(dout0_2) AT=1730.05n

.meas tran vdout0_3ck1720 FIND v(dout0_3) AT=1730.05n

.meas tran vdout0_4ck1720 FIND v(dout0_4) AT=1730.05n

.meas tran vdout0_5ck1720 FIND v(dout0_5) AT=1730.05n

.meas tran vdout0_6ck1720 FIND v(dout0_6) AT=1730.05n

.meas tran vdout0_7ck1720 FIND v(dout0_7) AT=1730.05n

.meas tran vdout0_8ck1720 FIND v(dout0_8) AT=1730.05n

.meas tran vdout0_9ck1720 FIND v(dout0_9) AT=1730.05n

.meas tran vdout0_10ck1720 FIND v(dout0_10) AT=1730.05n

.meas tran vdout0_11ck1720 FIND v(dout0_11) AT=1730.05n

.meas tran vdout0_12ck1720 FIND v(dout0_12) AT=1730.05n

.meas tran vdout0_13ck1720 FIND v(dout0_13) AT=1730.05n

.meas tran vdout0_14ck1720 FIND v(dout0_14) AT=1730.05n

.meas tran vdout0_15ck1720 FIND v(dout0_15) AT=1730.05n

.meas tran vdout0_16ck1720 FIND v(dout0_16) AT=1730.05n

.meas tran vdout0_17ck1720 FIND v(dout0_17) AT=1730.05n

.meas tran vdout0_18ck1720 FIND v(dout0_18) AT=1730.05n

.meas tran vdout0_19ck1720 FIND v(dout0_19) AT=1730.05n

.meas tran vdout0_20ck1720 FIND v(dout0_20) AT=1730.05n

.meas tran vdout0_21ck1720 FIND v(dout0_21) AT=1730.05n

.meas tran vdout0_22ck1720 FIND v(dout0_22) AT=1730.05n

.meas tran vdout0_23ck1720 FIND v(dout0_23) AT=1730.05n

.meas tran vdout0_24ck1720 FIND v(dout0_24) AT=1730.05n

.meas tran vdout0_25ck1720 FIND v(dout0_25) AT=1730.05n

.meas tran vdout0_26ck1720 FIND v(dout0_26) AT=1730.05n

.meas tran vdout0_27ck1720 FIND v(dout0_27) AT=1730.05n

.meas tran vdout0_28ck1720 FIND v(dout0_28) AT=1730.05n

.meas tran vdout0_29ck1720 FIND v(dout0_29) AT=1730.05n

.meas tran vdout0_30ck1720 FIND v(dout0_30) AT=1730.05n

.meas tran vdout0_31ck1720 FIND v(dout0_31) AT=1730.05n

.meas tran vdout0_32ck1720 FIND v(dout0_32) AT=1730.05n

.meas tran vdout0_33ck1720 FIND v(dout0_33) AT=1730.05n

.meas tran vdout0_34ck1720 FIND v(dout0_34) AT=1730.05n

.meas tran vdout0_35ck1720 FIND v(dout0_35) AT=1730.05n

.meas tran vdout0_36ck1720 FIND v(dout0_36) AT=1730.05n

.meas tran vdout0_37ck1720 FIND v(dout0_37) AT=1730.05n

.meas tran vdout0_38ck1720 FIND v(dout0_38) AT=1730.05n

.meas tran vdout0_39ck1720 FIND v(dout0_39) AT=1730.05n

.meas tran vdout0_40ck1720 FIND v(dout0_40) AT=1730.05n

.meas tran vdout0_41ck1720 FIND v(dout0_41) AT=1730.05n

.meas tran vdout0_42ck1720 FIND v(dout0_42) AT=1730.05n

.meas tran vdout0_43ck1720 FIND v(dout0_43) AT=1730.05n

.meas tran vdout0_44ck1720 FIND v(dout0_44) AT=1730.05n

.meas tran vdout0_45ck1720 FIND v(dout0_45) AT=1730.05n

.meas tran vdout0_46ck1720 FIND v(dout0_46) AT=1730.05n

.meas tran vdout0_47ck1720 FIND v(dout0_47) AT=1730.05n

.meas tran vdout0_48ck1720 FIND v(dout0_48) AT=1730.05n

.meas tran vdout0_49ck1720 FIND v(dout0_49) AT=1730.05n

.meas tran vdout0_50ck1720 FIND v(dout0_50) AT=1730.05n

.meas tran vdout0_51ck1720 FIND v(dout0_51) AT=1730.05n

.meas tran vdout0_52ck1720 FIND v(dout0_52) AT=1730.05n

.meas tran vdout0_53ck1720 FIND v(dout0_53) AT=1730.05n

.meas tran vdout0_54ck1720 FIND v(dout0_54) AT=1730.05n

.meas tran vdout0_55ck1720 FIND v(dout0_55) AT=1730.05n

.meas tran vdout0_56ck1720 FIND v(dout0_56) AT=1730.05n

.meas tran vdout0_57ck1720 FIND v(dout0_57) AT=1730.05n

.meas tran vdout0_58ck1720 FIND v(dout0_58) AT=1730.05n

.meas tran vdout0_59ck1720 FIND v(dout0_59) AT=1730.05n

.meas tran vdout0_60ck1720 FIND v(dout0_60) AT=1730.05n

.meas tran vdout0_61ck1720 FIND v(dout0_61) AT=1730.05n

.meas tran vdout0_62ck1720 FIND v(dout0_62) AT=1730.05n

.meas tran vdout0_63ck1720 FIND v(dout0_63) AT=1730.05n

.meas tran vdout1_0ck1720 FIND v(dout1_0) AT=1730.05n

.meas tran vdout1_1ck1720 FIND v(dout1_1) AT=1730.05n

.meas tran vdout1_2ck1720 FIND v(dout1_2) AT=1730.05n

.meas tran vdout1_3ck1720 FIND v(dout1_3) AT=1730.05n

.meas tran vdout1_4ck1720 FIND v(dout1_4) AT=1730.05n

.meas tran vdout1_5ck1720 FIND v(dout1_5) AT=1730.05n

.meas tran vdout1_6ck1720 FIND v(dout1_6) AT=1730.05n

.meas tran vdout1_7ck1720 FIND v(dout1_7) AT=1730.05n

.meas tran vdout1_8ck1720 FIND v(dout1_8) AT=1730.05n

.meas tran vdout1_9ck1720 FIND v(dout1_9) AT=1730.05n

.meas tran vdout1_10ck1720 FIND v(dout1_10) AT=1730.05n

.meas tran vdout1_11ck1720 FIND v(dout1_11) AT=1730.05n

.meas tran vdout1_12ck1720 FIND v(dout1_12) AT=1730.05n

.meas tran vdout1_13ck1720 FIND v(dout1_13) AT=1730.05n

.meas tran vdout1_14ck1720 FIND v(dout1_14) AT=1730.05n

.meas tran vdout1_15ck1720 FIND v(dout1_15) AT=1730.05n

.meas tran vdout1_16ck1720 FIND v(dout1_16) AT=1730.05n

.meas tran vdout1_17ck1720 FIND v(dout1_17) AT=1730.05n

.meas tran vdout1_18ck1720 FIND v(dout1_18) AT=1730.05n

.meas tran vdout1_19ck1720 FIND v(dout1_19) AT=1730.05n

.meas tran vdout1_20ck1720 FIND v(dout1_20) AT=1730.05n

.meas tran vdout1_21ck1720 FIND v(dout1_21) AT=1730.05n

.meas tran vdout1_22ck1720 FIND v(dout1_22) AT=1730.05n

.meas tran vdout1_23ck1720 FIND v(dout1_23) AT=1730.05n

.meas tran vdout1_24ck1720 FIND v(dout1_24) AT=1730.05n

.meas tran vdout1_25ck1720 FIND v(dout1_25) AT=1730.05n

.meas tran vdout1_26ck1720 FIND v(dout1_26) AT=1730.05n

.meas tran vdout1_27ck1720 FIND v(dout1_27) AT=1730.05n

.meas tran vdout1_28ck1720 FIND v(dout1_28) AT=1730.05n

.meas tran vdout1_29ck1720 FIND v(dout1_29) AT=1730.05n

.meas tran vdout1_30ck1720 FIND v(dout1_30) AT=1730.05n

.meas tran vdout1_31ck1720 FIND v(dout1_31) AT=1730.05n

.meas tran vdout1_32ck1720 FIND v(dout1_32) AT=1730.05n

.meas tran vdout1_33ck1720 FIND v(dout1_33) AT=1730.05n

.meas tran vdout1_34ck1720 FIND v(dout1_34) AT=1730.05n

.meas tran vdout1_35ck1720 FIND v(dout1_35) AT=1730.05n

.meas tran vdout1_36ck1720 FIND v(dout1_36) AT=1730.05n

.meas tran vdout1_37ck1720 FIND v(dout1_37) AT=1730.05n

.meas tran vdout1_38ck1720 FIND v(dout1_38) AT=1730.05n

.meas tran vdout1_39ck1720 FIND v(dout1_39) AT=1730.05n

.meas tran vdout1_40ck1720 FIND v(dout1_40) AT=1730.05n

.meas tran vdout1_41ck1720 FIND v(dout1_41) AT=1730.05n

.meas tran vdout1_42ck1720 FIND v(dout1_42) AT=1730.05n

.meas tran vdout1_43ck1720 FIND v(dout1_43) AT=1730.05n

.meas tran vdout1_44ck1720 FIND v(dout1_44) AT=1730.05n

.meas tran vdout1_45ck1720 FIND v(dout1_45) AT=1730.05n

.meas tran vdout1_46ck1720 FIND v(dout1_46) AT=1730.05n

.meas tran vdout1_47ck1720 FIND v(dout1_47) AT=1730.05n

.meas tran vdout1_48ck1720 FIND v(dout1_48) AT=1730.05n

.meas tran vdout1_49ck1720 FIND v(dout1_49) AT=1730.05n

.meas tran vdout1_50ck1720 FIND v(dout1_50) AT=1730.05n

.meas tran vdout1_51ck1720 FIND v(dout1_51) AT=1730.05n

.meas tran vdout1_52ck1720 FIND v(dout1_52) AT=1730.05n

.meas tran vdout1_53ck1720 FIND v(dout1_53) AT=1730.05n

.meas tran vdout1_54ck1720 FIND v(dout1_54) AT=1730.05n

.meas tran vdout1_55ck1720 FIND v(dout1_55) AT=1730.05n

.meas tran vdout1_56ck1720 FIND v(dout1_56) AT=1730.05n

.meas tran vdout1_57ck1720 FIND v(dout1_57) AT=1730.05n

.meas tran vdout1_58ck1720 FIND v(dout1_58) AT=1730.05n

.meas tran vdout1_59ck1720 FIND v(dout1_59) AT=1730.05n

.meas tran vdout1_60ck1720 FIND v(dout1_60) AT=1730.05n

.meas tran vdout1_61ck1720 FIND v(dout1_61) AT=1730.05n

.meas tran vdout1_62ck1720 FIND v(dout1_62) AT=1730.05n

.meas tran vdout1_63ck1720 FIND v(dout1_63) AT=1730.05n

.meas tran vdout1_0ck1740 FIND v(dout1_0) AT=1750.05n

.meas tran vdout1_1ck1740 FIND v(dout1_1) AT=1750.05n

.meas tran vdout1_2ck1740 FIND v(dout1_2) AT=1750.05n

.meas tran vdout1_3ck1740 FIND v(dout1_3) AT=1750.05n

.meas tran vdout1_4ck1740 FIND v(dout1_4) AT=1750.05n

.meas tran vdout1_5ck1740 FIND v(dout1_5) AT=1750.05n

.meas tran vdout1_6ck1740 FIND v(dout1_6) AT=1750.05n

.meas tran vdout1_7ck1740 FIND v(dout1_7) AT=1750.05n

.meas tran vdout1_8ck1740 FIND v(dout1_8) AT=1750.05n

.meas tran vdout1_9ck1740 FIND v(dout1_9) AT=1750.05n

.meas tran vdout1_10ck1740 FIND v(dout1_10) AT=1750.05n

.meas tran vdout1_11ck1740 FIND v(dout1_11) AT=1750.05n

.meas tran vdout1_12ck1740 FIND v(dout1_12) AT=1750.05n

.meas tran vdout1_13ck1740 FIND v(dout1_13) AT=1750.05n

.meas tran vdout1_14ck1740 FIND v(dout1_14) AT=1750.05n

.meas tran vdout1_15ck1740 FIND v(dout1_15) AT=1750.05n

.meas tran vdout1_16ck1740 FIND v(dout1_16) AT=1750.05n

.meas tran vdout1_17ck1740 FIND v(dout1_17) AT=1750.05n

.meas tran vdout1_18ck1740 FIND v(dout1_18) AT=1750.05n

.meas tran vdout1_19ck1740 FIND v(dout1_19) AT=1750.05n

.meas tran vdout1_20ck1740 FIND v(dout1_20) AT=1750.05n

.meas tran vdout1_21ck1740 FIND v(dout1_21) AT=1750.05n

.meas tran vdout1_22ck1740 FIND v(dout1_22) AT=1750.05n

.meas tran vdout1_23ck1740 FIND v(dout1_23) AT=1750.05n

.meas tran vdout1_24ck1740 FIND v(dout1_24) AT=1750.05n

.meas tran vdout1_25ck1740 FIND v(dout1_25) AT=1750.05n

.meas tran vdout1_26ck1740 FIND v(dout1_26) AT=1750.05n

.meas tran vdout1_27ck1740 FIND v(dout1_27) AT=1750.05n

.meas tran vdout1_28ck1740 FIND v(dout1_28) AT=1750.05n

.meas tran vdout1_29ck1740 FIND v(dout1_29) AT=1750.05n

.meas tran vdout1_30ck1740 FIND v(dout1_30) AT=1750.05n

.meas tran vdout1_31ck1740 FIND v(dout1_31) AT=1750.05n

.meas tran vdout1_32ck1740 FIND v(dout1_32) AT=1750.05n

.meas tran vdout1_33ck1740 FIND v(dout1_33) AT=1750.05n

.meas tran vdout1_34ck1740 FIND v(dout1_34) AT=1750.05n

.meas tran vdout1_35ck1740 FIND v(dout1_35) AT=1750.05n

.meas tran vdout1_36ck1740 FIND v(dout1_36) AT=1750.05n

.meas tran vdout1_37ck1740 FIND v(dout1_37) AT=1750.05n

.meas tran vdout1_38ck1740 FIND v(dout1_38) AT=1750.05n

.meas tran vdout1_39ck1740 FIND v(dout1_39) AT=1750.05n

.meas tran vdout1_40ck1740 FIND v(dout1_40) AT=1750.05n

.meas tran vdout1_41ck1740 FIND v(dout1_41) AT=1750.05n

.meas tran vdout1_42ck1740 FIND v(dout1_42) AT=1750.05n

.meas tran vdout1_43ck1740 FIND v(dout1_43) AT=1750.05n

.meas tran vdout1_44ck1740 FIND v(dout1_44) AT=1750.05n

.meas tran vdout1_45ck1740 FIND v(dout1_45) AT=1750.05n

.meas tran vdout1_46ck1740 FIND v(dout1_46) AT=1750.05n

.meas tran vdout1_47ck1740 FIND v(dout1_47) AT=1750.05n

.meas tran vdout1_48ck1740 FIND v(dout1_48) AT=1750.05n

.meas tran vdout1_49ck1740 FIND v(dout1_49) AT=1750.05n

.meas tran vdout1_50ck1740 FIND v(dout1_50) AT=1750.05n

.meas tran vdout1_51ck1740 FIND v(dout1_51) AT=1750.05n

.meas tran vdout1_52ck1740 FIND v(dout1_52) AT=1750.05n

.meas tran vdout1_53ck1740 FIND v(dout1_53) AT=1750.05n

.meas tran vdout1_54ck1740 FIND v(dout1_54) AT=1750.05n

.meas tran vdout1_55ck1740 FIND v(dout1_55) AT=1750.05n

.meas tran vdout1_56ck1740 FIND v(dout1_56) AT=1750.05n

.meas tran vdout1_57ck1740 FIND v(dout1_57) AT=1750.05n

.meas tran vdout1_58ck1740 FIND v(dout1_58) AT=1750.05n

.meas tran vdout1_59ck1740 FIND v(dout1_59) AT=1750.05n

.meas tran vdout1_60ck1740 FIND v(dout1_60) AT=1750.05n

.meas tran vdout1_61ck1740 FIND v(dout1_61) AT=1750.05n

.meas tran vdout1_62ck1740 FIND v(dout1_62) AT=1750.05n

.meas tran vdout1_63ck1740 FIND v(dout1_63) AT=1750.05n

.meas tran vdout0_0ck1750 FIND v(dout0_0) AT=1760.05n

.meas tran vdout0_1ck1750 FIND v(dout0_1) AT=1760.05n

.meas tran vdout0_2ck1750 FIND v(dout0_2) AT=1760.05n

.meas tran vdout0_3ck1750 FIND v(dout0_3) AT=1760.05n

.meas tran vdout0_4ck1750 FIND v(dout0_4) AT=1760.05n

.meas tran vdout0_5ck1750 FIND v(dout0_5) AT=1760.05n

.meas tran vdout0_6ck1750 FIND v(dout0_6) AT=1760.05n

.meas tran vdout0_7ck1750 FIND v(dout0_7) AT=1760.05n

.meas tran vdout0_8ck1750 FIND v(dout0_8) AT=1760.05n

.meas tran vdout0_9ck1750 FIND v(dout0_9) AT=1760.05n

.meas tran vdout0_10ck1750 FIND v(dout0_10) AT=1760.05n

.meas tran vdout0_11ck1750 FIND v(dout0_11) AT=1760.05n

.meas tran vdout0_12ck1750 FIND v(dout0_12) AT=1760.05n

.meas tran vdout0_13ck1750 FIND v(dout0_13) AT=1760.05n

.meas tran vdout0_14ck1750 FIND v(dout0_14) AT=1760.05n

.meas tran vdout0_15ck1750 FIND v(dout0_15) AT=1760.05n

.meas tran vdout0_16ck1750 FIND v(dout0_16) AT=1760.05n

.meas tran vdout0_17ck1750 FIND v(dout0_17) AT=1760.05n

.meas tran vdout0_18ck1750 FIND v(dout0_18) AT=1760.05n

.meas tran vdout0_19ck1750 FIND v(dout0_19) AT=1760.05n

.meas tran vdout0_20ck1750 FIND v(dout0_20) AT=1760.05n

.meas tran vdout0_21ck1750 FIND v(dout0_21) AT=1760.05n

.meas tran vdout0_22ck1750 FIND v(dout0_22) AT=1760.05n

.meas tran vdout0_23ck1750 FIND v(dout0_23) AT=1760.05n

.meas tran vdout0_24ck1750 FIND v(dout0_24) AT=1760.05n

.meas tran vdout0_25ck1750 FIND v(dout0_25) AT=1760.05n

.meas tran vdout0_26ck1750 FIND v(dout0_26) AT=1760.05n

.meas tran vdout0_27ck1750 FIND v(dout0_27) AT=1760.05n

.meas tran vdout0_28ck1750 FIND v(dout0_28) AT=1760.05n

.meas tran vdout0_29ck1750 FIND v(dout0_29) AT=1760.05n

.meas tran vdout0_30ck1750 FIND v(dout0_30) AT=1760.05n

.meas tran vdout0_31ck1750 FIND v(dout0_31) AT=1760.05n

.meas tran vdout0_32ck1750 FIND v(dout0_32) AT=1760.05n

.meas tran vdout0_33ck1750 FIND v(dout0_33) AT=1760.05n

.meas tran vdout0_34ck1750 FIND v(dout0_34) AT=1760.05n

.meas tran vdout0_35ck1750 FIND v(dout0_35) AT=1760.05n

.meas tran vdout0_36ck1750 FIND v(dout0_36) AT=1760.05n

.meas tran vdout0_37ck1750 FIND v(dout0_37) AT=1760.05n

.meas tran vdout0_38ck1750 FIND v(dout0_38) AT=1760.05n

.meas tran vdout0_39ck1750 FIND v(dout0_39) AT=1760.05n

.meas tran vdout0_40ck1750 FIND v(dout0_40) AT=1760.05n

.meas tran vdout0_41ck1750 FIND v(dout0_41) AT=1760.05n

.meas tran vdout0_42ck1750 FIND v(dout0_42) AT=1760.05n

.meas tran vdout0_43ck1750 FIND v(dout0_43) AT=1760.05n

.meas tran vdout0_44ck1750 FIND v(dout0_44) AT=1760.05n

.meas tran vdout0_45ck1750 FIND v(dout0_45) AT=1760.05n

.meas tran vdout0_46ck1750 FIND v(dout0_46) AT=1760.05n

.meas tran vdout0_47ck1750 FIND v(dout0_47) AT=1760.05n

.meas tran vdout0_48ck1750 FIND v(dout0_48) AT=1760.05n

.meas tran vdout0_49ck1750 FIND v(dout0_49) AT=1760.05n

.meas tran vdout0_50ck1750 FIND v(dout0_50) AT=1760.05n

.meas tran vdout0_51ck1750 FIND v(dout0_51) AT=1760.05n

.meas tran vdout0_52ck1750 FIND v(dout0_52) AT=1760.05n

.meas tran vdout0_53ck1750 FIND v(dout0_53) AT=1760.05n

.meas tran vdout0_54ck1750 FIND v(dout0_54) AT=1760.05n

.meas tran vdout0_55ck1750 FIND v(dout0_55) AT=1760.05n

.meas tran vdout0_56ck1750 FIND v(dout0_56) AT=1760.05n

.meas tran vdout0_57ck1750 FIND v(dout0_57) AT=1760.05n

.meas tran vdout0_58ck1750 FIND v(dout0_58) AT=1760.05n

.meas tran vdout0_59ck1750 FIND v(dout0_59) AT=1760.05n

.meas tran vdout0_60ck1750 FIND v(dout0_60) AT=1760.05n

.meas tran vdout0_61ck1750 FIND v(dout0_61) AT=1760.05n

.meas tran vdout0_62ck1750 FIND v(dout0_62) AT=1760.05n

.meas tran vdout0_63ck1750 FIND v(dout0_63) AT=1760.05n

.meas tran vdout0_0ck1760 FIND v(dout0_0) AT=1770.05n

.meas tran vdout0_1ck1760 FIND v(dout0_1) AT=1770.05n

.meas tran vdout0_2ck1760 FIND v(dout0_2) AT=1770.05n

.meas tran vdout0_3ck1760 FIND v(dout0_3) AT=1770.05n

.meas tran vdout0_4ck1760 FIND v(dout0_4) AT=1770.05n

.meas tran vdout0_5ck1760 FIND v(dout0_5) AT=1770.05n

.meas tran vdout0_6ck1760 FIND v(dout0_6) AT=1770.05n

.meas tran vdout0_7ck1760 FIND v(dout0_7) AT=1770.05n

.meas tran vdout0_8ck1760 FIND v(dout0_8) AT=1770.05n

.meas tran vdout0_9ck1760 FIND v(dout0_9) AT=1770.05n

.meas tran vdout0_10ck1760 FIND v(dout0_10) AT=1770.05n

.meas tran vdout0_11ck1760 FIND v(dout0_11) AT=1770.05n

.meas tran vdout0_12ck1760 FIND v(dout0_12) AT=1770.05n

.meas tran vdout0_13ck1760 FIND v(dout0_13) AT=1770.05n

.meas tran vdout0_14ck1760 FIND v(dout0_14) AT=1770.05n

.meas tran vdout0_15ck1760 FIND v(dout0_15) AT=1770.05n

.meas tran vdout0_16ck1760 FIND v(dout0_16) AT=1770.05n

.meas tran vdout0_17ck1760 FIND v(dout0_17) AT=1770.05n

.meas tran vdout0_18ck1760 FIND v(dout0_18) AT=1770.05n

.meas tran vdout0_19ck1760 FIND v(dout0_19) AT=1770.05n

.meas tran vdout0_20ck1760 FIND v(dout0_20) AT=1770.05n

.meas tran vdout0_21ck1760 FIND v(dout0_21) AT=1770.05n

.meas tran vdout0_22ck1760 FIND v(dout0_22) AT=1770.05n

.meas tran vdout0_23ck1760 FIND v(dout0_23) AT=1770.05n

.meas tran vdout0_24ck1760 FIND v(dout0_24) AT=1770.05n

.meas tran vdout0_25ck1760 FIND v(dout0_25) AT=1770.05n

.meas tran vdout0_26ck1760 FIND v(dout0_26) AT=1770.05n

.meas tran vdout0_27ck1760 FIND v(dout0_27) AT=1770.05n

.meas tran vdout0_28ck1760 FIND v(dout0_28) AT=1770.05n

.meas tran vdout0_29ck1760 FIND v(dout0_29) AT=1770.05n

.meas tran vdout0_30ck1760 FIND v(dout0_30) AT=1770.05n

.meas tran vdout0_31ck1760 FIND v(dout0_31) AT=1770.05n

.meas tran vdout0_32ck1760 FIND v(dout0_32) AT=1770.05n

.meas tran vdout0_33ck1760 FIND v(dout0_33) AT=1770.05n

.meas tran vdout0_34ck1760 FIND v(dout0_34) AT=1770.05n

.meas tran vdout0_35ck1760 FIND v(dout0_35) AT=1770.05n

.meas tran vdout0_36ck1760 FIND v(dout0_36) AT=1770.05n

.meas tran vdout0_37ck1760 FIND v(dout0_37) AT=1770.05n

.meas tran vdout0_38ck1760 FIND v(dout0_38) AT=1770.05n

.meas tran vdout0_39ck1760 FIND v(dout0_39) AT=1770.05n

.meas tran vdout0_40ck1760 FIND v(dout0_40) AT=1770.05n

.meas tran vdout0_41ck1760 FIND v(dout0_41) AT=1770.05n

.meas tran vdout0_42ck1760 FIND v(dout0_42) AT=1770.05n

.meas tran vdout0_43ck1760 FIND v(dout0_43) AT=1770.05n

.meas tran vdout0_44ck1760 FIND v(dout0_44) AT=1770.05n

.meas tran vdout0_45ck1760 FIND v(dout0_45) AT=1770.05n

.meas tran vdout0_46ck1760 FIND v(dout0_46) AT=1770.05n

.meas tran vdout0_47ck1760 FIND v(dout0_47) AT=1770.05n

.meas tran vdout0_48ck1760 FIND v(dout0_48) AT=1770.05n

.meas tran vdout0_49ck1760 FIND v(dout0_49) AT=1770.05n

.meas tran vdout0_50ck1760 FIND v(dout0_50) AT=1770.05n

.meas tran vdout0_51ck1760 FIND v(dout0_51) AT=1770.05n

.meas tran vdout0_52ck1760 FIND v(dout0_52) AT=1770.05n

.meas tran vdout0_53ck1760 FIND v(dout0_53) AT=1770.05n

.meas tran vdout0_54ck1760 FIND v(dout0_54) AT=1770.05n

.meas tran vdout0_55ck1760 FIND v(dout0_55) AT=1770.05n

.meas tran vdout0_56ck1760 FIND v(dout0_56) AT=1770.05n

.meas tran vdout0_57ck1760 FIND v(dout0_57) AT=1770.05n

.meas tran vdout0_58ck1760 FIND v(dout0_58) AT=1770.05n

.meas tran vdout0_59ck1760 FIND v(dout0_59) AT=1770.05n

.meas tran vdout0_60ck1760 FIND v(dout0_60) AT=1770.05n

.meas tran vdout0_61ck1760 FIND v(dout0_61) AT=1770.05n

.meas tran vdout0_62ck1760 FIND v(dout0_62) AT=1770.05n

.meas tran vdout0_63ck1760 FIND v(dout0_63) AT=1770.05n

.meas tran vdout0_0ck1770 FIND v(dout0_0) AT=1780.05n

.meas tran vdout0_1ck1770 FIND v(dout0_1) AT=1780.05n

.meas tran vdout0_2ck1770 FIND v(dout0_2) AT=1780.05n

.meas tran vdout0_3ck1770 FIND v(dout0_3) AT=1780.05n

.meas tran vdout0_4ck1770 FIND v(dout0_4) AT=1780.05n

.meas tran vdout0_5ck1770 FIND v(dout0_5) AT=1780.05n

.meas tran vdout0_6ck1770 FIND v(dout0_6) AT=1780.05n

.meas tran vdout0_7ck1770 FIND v(dout0_7) AT=1780.05n

.meas tran vdout0_8ck1770 FIND v(dout0_8) AT=1780.05n

.meas tran vdout0_9ck1770 FIND v(dout0_9) AT=1780.05n

.meas tran vdout0_10ck1770 FIND v(dout0_10) AT=1780.05n

.meas tran vdout0_11ck1770 FIND v(dout0_11) AT=1780.05n

.meas tran vdout0_12ck1770 FIND v(dout0_12) AT=1780.05n

.meas tran vdout0_13ck1770 FIND v(dout0_13) AT=1780.05n

.meas tran vdout0_14ck1770 FIND v(dout0_14) AT=1780.05n

.meas tran vdout0_15ck1770 FIND v(dout0_15) AT=1780.05n

.meas tran vdout0_16ck1770 FIND v(dout0_16) AT=1780.05n

.meas tran vdout0_17ck1770 FIND v(dout0_17) AT=1780.05n

.meas tran vdout0_18ck1770 FIND v(dout0_18) AT=1780.05n

.meas tran vdout0_19ck1770 FIND v(dout0_19) AT=1780.05n

.meas tran vdout0_20ck1770 FIND v(dout0_20) AT=1780.05n

.meas tran vdout0_21ck1770 FIND v(dout0_21) AT=1780.05n

.meas tran vdout0_22ck1770 FIND v(dout0_22) AT=1780.05n

.meas tran vdout0_23ck1770 FIND v(dout0_23) AT=1780.05n

.meas tran vdout0_24ck1770 FIND v(dout0_24) AT=1780.05n

.meas tran vdout0_25ck1770 FIND v(dout0_25) AT=1780.05n

.meas tran vdout0_26ck1770 FIND v(dout0_26) AT=1780.05n

.meas tran vdout0_27ck1770 FIND v(dout0_27) AT=1780.05n

.meas tran vdout0_28ck1770 FIND v(dout0_28) AT=1780.05n

.meas tran vdout0_29ck1770 FIND v(dout0_29) AT=1780.05n

.meas tran vdout0_30ck1770 FIND v(dout0_30) AT=1780.05n

.meas tran vdout0_31ck1770 FIND v(dout0_31) AT=1780.05n

.meas tran vdout0_32ck1770 FIND v(dout0_32) AT=1780.05n

.meas tran vdout0_33ck1770 FIND v(dout0_33) AT=1780.05n

.meas tran vdout0_34ck1770 FIND v(dout0_34) AT=1780.05n

.meas tran vdout0_35ck1770 FIND v(dout0_35) AT=1780.05n

.meas tran vdout0_36ck1770 FIND v(dout0_36) AT=1780.05n

.meas tran vdout0_37ck1770 FIND v(dout0_37) AT=1780.05n

.meas tran vdout0_38ck1770 FIND v(dout0_38) AT=1780.05n

.meas tran vdout0_39ck1770 FIND v(dout0_39) AT=1780.05n

.meas tran vdout0_40ck1770 FIND v(dout0_40) AT=1780.05n

.meas tran vdout0_41ck1770 FIND v(dout0_41) AT=1780.05n

.meas tran vdout0_42ck1770 FIND v(dout0_42) AT=1780.05n

.meas tran vdout0_43ck1770 FIND v(dout0_43) AT=1780.05n

.meas tran vdout0_44ck1770 FIND v(dout0_44) AT=1780.05n

.meas tran vdout0_45ck1770 FIND v(dout0_45) AT=1780.05n

.meas tran vdout0_46ck1770 FIND v(dout0_46) AT=1780.05n

.meas tran vdout0_47ck1770 FIND v(dout0_47) AT=1780.05n

.meas tran vdout0_48ck1770 FIND v(dout0_48) AT=1780.05n

.meas tran vdout0_49ck1770 FIND v(dout0_49) AT=1780.05n

.meas tran vdout0_50ck1770 FIND v(dout0_50) AT=1780.05n

.meas tran vdout0_51ck1770 FIND v(dout0_51) AT=1780.05n

.meas tran vdout0_52ck1770 FIND v(dout0_52) AT=1780.05n

.meas tran vdout0_53ck1770 FIND v(dout0_53) AT=1780.05n

.meas tran vdout0_54ck1770 FIND v(dout0_54) AT=1780.05n

.meas tran vdout0_55ck1770 FIND v(dout0_55) AT=1780.05n

.meas tran vdout0_56ck1770 FIND v(dout0_56) AT=1780.05n

.meas tran vdout0_57ck1770 FIND v(dout0_57) AT=1780.05n

.meas tran vdout0_58ck1770 FIND v(dout0_58) AT=1780.05n

.meas tran vdout0_59ck1770 FIND v(dout0_59) AT=1780.05n

.meas tran vdout0_60ck1770 FIND v(dout0_60) AT=1780.05n

.meas tran vdout0_61ck1770 FIND v(dout0_61) AT=1780.05n

.meas tran vdout0_62ck1770 FIND v(dout0_62) AT=1780.05n

.meas tran vdout0_63ck1770 FIND v(dout0_63) AT=1780.05n

.meas tran vdout0_0ck1780 FIND v(dout0_0) AT=1790.05n

.meas tran vdout0_1ck1780 FIND v(dout0_1) AT=1790.05n

.meas tran vdout0_2ck1780 FIND v(dout0_2) AT=1790.05n

.meas tran vdout0_3ck1780 FIND v(dout0_3) AT=1790.05n

.meas tran vdout0_4ck1780 FIND v(dout0_4) AT=1790.05n

.meas tran vdout0_5ck1780 FIND v(dout0_5) AT=1790.05n

.meas tran vdout0_6ck1780 FIND v(dout0_6) AT=1790.05n

.meas tran vdout0_7ck1780 FIND v(dout0_7) AT=1790.05n

.meas tran vdout0_8ck1780 FIND v(dout0_8) AT=1790.05n

.meas tran vdout0_9ck1780 FIND v(dout0_9) AT=1790.05n

.meas tran vdout0_10ck1780 FIND v(dout0_10) AT=1790.05n

.meas tran vdout0_11ck1780 FIND v(dout0_11) AT=1790.05n

.meas tran vdout0_12ck1780 FIND v(dout0_12) AT=1790.05n

.meas tran vdout0_13ck1780 FIND v(dout0_13) AT=1790.05n

.meas tran vdout0_14ck1780 FIND v(dout0_14) AT=1790.05n

.meas tran vdout0_15ck1780 FIND v(dout0_15) AT=1790.05n

.meas tran vdout0_16ck1780 FIND v(dout0_16) AT=1790.05n

.meas tran vdout0_17ck1780 FIND v(dout0_17) AT=1790.05n

.meas tran vdout0_18ck1780 FIND v(dout0_18) AT=1790.05n

.meas tran vdout0_19ck1780 FIND v(dout0_19) AT=1790.05n

.meas tran vdout0_20ck1780 FIND v(dout0_20) AT=1790.05n

.meas tran vdout0_21ck1780 FIND v(dout0_21) AT=1790.05n

.meas tran vdout0_22ck1780 FIND v(dout0_22) AT=1790.05n

.meas tran vdout0_23ck1780 FIND v(dout0_23) AT=1790.05n

.meas tran vdout0_24ck1780 FIND v(dout0_24) AT=1790.05n

.meas tran vdout0_25ck1780 FIND v(dout0_25) AT=1790.05n

.meas tran vdout0_26ck1780 FIND v(dout0_26) AT=1790.05n

.meas tran vdout0_27ck1780 FIND v(dout0_27) AT=1790.05n

.meas tran vdout0_28ck1780 FIND v(dout0_28) AT=1790.05n

.meas tran vdout0_29ck1780 FIND v(dout0_29) AT=1790.05n

.meas tran vdout0_30ck1780 FIND v(dout0_30) AT=1790.05n

.meas tran vdout0_31ck1780 FIND v(dout0_31) AT=1790.05n

.meas tran vdout0_32ck1780 FIND v(dout0_32) AT=1790.05n

.meas tran vdout0_33ck1780 FIND v(dout0_33) AT=1790.05n

.meas tran vdout0_34ck1780 FIND v(dout0_34) AT=1790.05n

.meas tran vdout0_35ck1780 FIND v(dout0_35) AT=1790.05n

.meas tran vdout0_36ck1780 FIND v(dout0_36) AT=1790.05n

.meas tran vdout0_37ck1780 FIND v(dout0_37) AT=1790.05n

.meas tran vdout0_38ck1780 FIND v(dout0_38) AT=1790.05n

.meas tran vdout0_39ck1780 FIND v(dout0_39) AT=1790.05n

.meas tran vdout0_40ck1780 FIND v(dout0_40) AT=1790.05n

.meas tran vdout0_41ck1780 FIND v(dout0_41) AT=1790.05n

.meas tran vdout0_42ck1780 FIND v(dout0_42) AT=1790.05n

.meas tran vdout0_43ck1780 FIND v(dout0_43) AT=1790.05n

.meas tran vdout0_44ck1780 FIND v(dout0_44) AT=1790.05n

.meas tran vdout0_45ck1780 FIND v(dout0_45) AT=1790.05n

.meas tran vdout0_46ck1780 FIND v(dout0_46) AT=1790.05n

.meas tran vdout0_47ck1780 FIND v(dout0_47) AT=1790.05n

.meas tran vdout0_48ck1780 FIND v(dout0_48) AT=1790.05n

.meas tran vdout0_49ck1780 FIND v(dout0_49) AT=1790.05n

.meas tran vdout0_50ck1780 FIND v(dout0_50) AT=1790.05n

.meas tran vdout0_51ck1780 FIND v(dout0_51) AT=1790.05n

.meas tran vdout0_52ck1780 FIND v(dout0_52) AT=1790.05n

.meas tran vdout0_53ck1780 FIND v(dout0_53) AT=1790.05n

.meas tran vdout0_54ck1780 FIND v(dout0_54) AT=1790.05n

.meas tran vdout0_55ck1780 FIND v(dout0_55) AT=1790.05n

.meas tran vdout0_56ck1780 FIND v(dout0_56) AT=1790.05n

.meas tran vdout0_57ck1780 FIND v(dout0_57) AT=1790.05n

.meas tran vdout0_58ck1780 FIND v(dout0_58) AT=1790.05n

.meas tran vdout0_59ck1780 FIND v(dout0_59) AT=1790.05n

.meas tran vdout0_60ck1780 FIND v(dout0_60) AT=1790.05n

.meas tran vdout0_61ck1780 FIND v(dout0_61) AT=1790.05n

.meas tran vdout0_62ck1780 FIND v(dout0_62) AT=1790.05n

.meas tran vdout0_63ck1780 FIND v(dout0_63) AT=1790.05n

.meas tran vdout0_0ck1790 FIND v(dout0_0) AT=1800.05n

.meas tran vdout0_1ck1790 FIND v(dout0_1) AT=1800.05n

.meas tran vdout0_2ck1790 FIND v(dout0_2) AT=1800.05n

.meas tran vdout0_3ck1790 FIND v(dout0_3) AT=1800.05n

.meas tran vdout0_4ck1790 FIND v(dout0_4) AT=1800.05n

.meas tran vdout0_5ck1790 FIND v(dout0_5) AT=1800.05n

.meas tran vdout0_6ck1790 FIND v(dout0_6) AT=1800.05n

.meas tran vdout0_7ck1790 FIND v(dout0_7) AT=1800.05n

.meas tran vdout0_8ck1790 FIND v(dout0_8) AT=1800.05n

.meas tran vdout0_9ck1790 FIND v(dout0_9) AT=1800.05n

.meas tran vdout0_10ck1790 FIND v(dout0_10) AT=1800.05n

.meas tran vdout0_11ck1790 FIND v(dout0_11) AT=1800.05n

.meas tran vdout0_12ck1790 FIND v(dout0_12) AT=1800.05n

.meas tran vdout0_13ck1790 FIND v(dout0_13) AT=1800.05n

.meas tran vdout0_14ck1790 FIND v(dout0_14) AT=1800.05n

.meas tran vdout0_15ck1790 FIND v(dout0_15) AT=1800.05n

.meas tran vdout0_16ck1790 FIND v(dout0_16) AT=1800.05n

.meas tran vdout0_17ck1790 FIND v(dout0_17) AT=1800.05n

.meas tran vdout0_18ck1790 FIND v(dout0_18) AT=1800.05n

.meas tran vdout0_19ck1790 FIND v(dout0_19) AT=1800.05n

.meas tran vdout0_20ck1790 FIND v(dout0_20) AT=1800.05n

.meas tran vdout0_21ck1790 FIND v(dout0_21) AT=1800.05n

.meas tran vdout0_22ck1790 FIND v(dout0_22) AT=1800.05n

.meas tran vdout0_23ck1790 FIND v(dout0_23) AT=1800.05n

.meas tran vdout0_24ck1790 FIND v(dout0_24) AT=1800.05n

.meas tran vdout0_25ck1790 FIND v(dout0_25) AT=1800.05n

.meas tran vdout0_26ck1790 FIND v(dout0_26) AT=1800.05n

.meas tran vdout0_27ck1790 FIND v(dout0_27) AT=1800.05n

.meas tran vdout0_28ck1790 FIND v(dout0_28) AT=1800.05n

.meas tran vdout0_29ck1790 FIND v(dout0_29) AT=1800.05n

.meas tran vdout0_30ck1790 FIND v(dout0_30) AT=1800.05n

.meas tran vdout0_31ck1790 FIND v(dout0_31) AT=1800.05n

.meas tran vdout0_32ck1790 FIND v(dout0_32) AT=1800.05n

.meas tran vdout0_33ck1790 FIND v(dout0_33) AT=1800.05n

.meas tran vdout0_34ck1790 FIND v(dout0_34) AT=1800.05n

.meas tran vdout0_35ck1790 FIND v(dout0_35) AT=1800.05n

.meas tran vdout0_36ck1790 FIND v(dout0_36) AT=1800.05n

.meas tran vdout0_37ck1790 FIND v(dout0_37) AT=1800.05n

.meas tran vdout0_38ck1790 FIND v(dout0_38) AT=1800.05n

.meas tran vdout0_39ck1790 FIND v(dout0_39) AT=1800.05n

.meas tran vdout0_40ck1790 FIND v(dout0_40) AT=1800.05n

.meas tran vdout0_41ck1790 FIND v(dout0_41) AT=1800.05n

.meas tran vdout0_42ck1790 FIND v(dout0_42) AT=1800.05n

.meas tran vdout0_43ck1790 FIND v(dout0_43) AT=1800.05n

.meas tran vdout0_44ck1790 FIND v(dout0_44) AT=1800.05n

.meas tran vdout0_45ck1790 FIND v(dout0_45) AT=1800.05n

.meas tran vdout0_46ck1790 FIND v(dout0_46) AT=1800.05n

.meas tran vdout0_47ck1790 FIND v(dout0_47) AT=1800.05n

.meas tran vdout0_48ck1790 FIND v(dout0_48) AT=1800.05n

.meas tran vdout0_49ck1790 FIND v(dout0_49) AT=1800.05n

.meas tran vdout0_50ck1790 FIND v(dout0_50) AT=1800.05n

.meas tran vdout0_51ck1790 FIND v(dout0_51) AT=1800.05n

.meas tran vdout0_52ck1790 FIND v(dout0_52) AT=1800.05n

.meas tran vdout0_53ck1790 FIND v(dout0_53) AT=1800.05n

.meas tran vdout0_54ck1790 FIND v(dout0_54) AT=1800.05n

.meas tran vdout0_55ck1790 FIND v(dout0_55) AT=1800.05n

.meas tran vdout0_56ck1790 FIND v(dout0_56) AT=1800.05n

.meas tran vdout0_57ck1790 FIND v(dout0_57) AT=1800.05n

.meas tran vdout0_58ck1790 FIND v(dout0_58) AT=1800.05n

.meas tran vdout0_59ck1790 FIND v(dout0_59) AT=1800.05n

.meas tran vdout0_60ck1790 FIND v(dout0_60) AT=1800.05n

.meas tran vdout0_61ck1790 FIND v(dout0_61) AT=1800.05n

.meas tran vdout0_62ck1790 FIND v(dout0_62) AT=1800.05n

.meas tran vdout0_63ck1790 FIND v(dout0_63) AT=1800.05n

.meas tran vdout1_0ck1800 FIND v(dout1_0) AT=1810.05n

.meas tran vdout1_1ck1800 FIND v(dout1_1) AT=1810.05n

.meas tran vdout1_2ck1800 FIND v(dout1_2) AT=1810.05n

.meas tran vdout1_3ck1800 FIND v(dout1_3) AT=1810.05n

.meas tran vdout1_4ck1800 FIND v(dout1_4) AT=1810.05n

.meas tran vdout1_5ck1800 FIND v(dout1_5) AT=1810.05n

.meas tran vdout1_6ck1800 FIND v(dout1_6) AT=1810.05n

.meas tran vdout1_7ck1800 FIND v(dout1_7) AT=1810.05n

.meas tran vdout1_8ck1800 FIND v(dout1_8) AT=1810.05n

.meas tran vdout1_9ck1800 FIND v(dout1_9) AT=1810.05n

.meas tran vdout1_10ck1800 FIND v(dout1_10) AT=1810.05n

.meas tran vdout1_11ck1800 FIND v(dout1_11) AT=1810.05n

.meas tran vdout1_12ck1800 FIND v(dout1_12) AT=1810.05n

.meas tran vdout1_13ck1800 FIND v(dout1_13) AT=1810.05n

.meas tran vdout1_14ck1800 FIND v(dout1_14) AT=1810.05n

.meas tran vdout1_15ck1800 FIND v(dout1_15) AT=1810.05n

.meas tran vdout1_16ck1800 FIND v(dout1_16) AT=1810.05n

.meas tran vdout1_17ck1800 FIND v(dout1_17) AT=1810.05n

.meas tran vdout1_18ck1800 FIND v(dout1_18) AT=1810.05n

.meas tran vdout1_19ck1800 FIND v(dout1_19) AT=1810.05n

.meas tran vdout1_20ck1800 FIND v(dout1_20) AT=1810.05n

.meas tran vdout1_21ck1800 FIND v(dout1_21) AT=1810.05n

.meas tran vdout1_22ck1800 FIND v(dout1_22) AT=1810.05n

.meas tran vdout1_23ck1800 FIND v(dout1_23) AT=1810.05n

.meas tran vdout1_24ck1800 FIND v(dout1_24) AT=1810.05n

.meas tran vdout1_25ck1800 FIND v(dout1_25) AT=1810.05n

.meas tran vdout1_26ck1800 FIND v(dout1_26) AT=1810.05n

.meas tran vdout1_27ck1800 FIND v(dout1_27) AT=1810.05n

.meas tran vdout1_28ck1800 FIND v(dout1_28) AT=1810.05n

.meas tran vdout1_29ck1800 FIND v(dout1_29) AT=1810.05n

.meas tran vdout1_30ck1800 FIND v(dout1_30) AT=1810.05n

.meas tran vdout1_31ck1800 FIND v(dout1_31) AT=1810.05n

.meas tran vdout1_32ck1800 FIND v(dout1_32) AT=1810.05n

.meas tran vdout1_33ck1800 FIND v(dout1_33) AT=1810.05n

.meas tran vdout1_34ck1800 FIND v(dout1_34) AT=1810.05n

.meas tran vdout1_35ck1800 FIND v(dout1_35) AT=1810.05n

.meas tran vdout1_36ck1800 FIND v(dout1_36) AT=1810.05n

.meas tran vdout1_37ck1800 FIND v(dout1_37) AT=1810.05n

.meas tran vdout1_38ck1800 FIND v(dout1_38) AT=1810.05n

.meas tran vdout1_39ck1800 FIND v(dout1_39) AT=1810.05n

.meas tran vdout1_40ck1800 FIND v(dout1_40) AT=1810.05n

.meas tran vdout1_41ck1800 FIND v(dout1_41) AT=1810.05n

.meas tran vdout1_42ck1800 FIND v(dout1_42) AT=1810.05n

.meas tran vdout1_43ck1800 FIND v(dout1_43) AT=1810.05n

.meas tran vdout1_44ck1800 FIND v(dout1_44) AT=1810.05n

.meas tran vdout1_45ck1800 FIND v(dout1_45) AT=1810.05n

.meas tran vdout1_46ck1800 FIND v(dout1_46) AT=1810.05n

.meas tran vdout1_47ck1800 FIND v(dout1_47) AT=1810.05n

.meas tran vdout1_48ck1800 FIND v(dout1_48) AT=1810.05n

.meas tran vdout1_49ck1800 FIND v(dout1_49) AT=1810.05n

.meas tran vdout1_50ck1800 FIND v(dout1_50) AT=1810.05n

.meas tran vdout1_51ck1800 FIND v(dout1_51) AT=1810.05n

.meas tran vdout1_52ck1800 FIND v(dout1_52) AT=1810.05n

.meas tran vdout1_53ck1800 FIND v(dout1_53) AT=1810.05n

.meas tran vdout1_54ck1800 FIND v(dout1_54) AT=1810.05n

.meas tran vdout1_55ck1800 FIND v(dout1_55) AT=1810.05n

.meas tran vdout1_56ck1800 FIND v(dout1_56) AT=1810.05n

.meas tran vdout1_57ck1800 FIND v(dout1_57) AT=1810.05n

.meas tran vdout1_58ck1800 FIND v(dout1_58) AT=1810.05n

.meas tran vdout1_59ck1800 FIND v(dout1_59) AT=1810.05n

.meas tran vdout1_60ck1800 FIND v(dout1_60) AT=1810.05n

.meas tran vdout1_61ck1800 FIND v(dout1_61) AT=1810.05n

.meas tran vdout1_62ck1800 FIND v(dout1_62) AT=1810.05n

.meas tran vdout1_63ck1800 FIND v(dout1_63) AT=1810.05n

.meas tran vdout0_0ck1820 FIND v(dout0_0) AT=1830.05n

.meas tran vdout0_1ck1820 FIND v(dout0_1) AT=1830.05n

.meas tran vdout0_2ck1820 FIND v(dout0_2) AT=1830.05n

.meas tran vdout0_3ck1820 FIND v(dout0_3) AT=1830.05n

.meas tran vdout0_4ck1820 FIND v(dout0_4) AT=1830.05n

.meas tran vdout0_5ck1820 FIND v(dout0_5) AT=1830.05n

.meas tran vdout0_6ck1820 FIND v(dout0_6) AT=1830.05n

.meas tran vdout0_7ck1820 FIND v(dout0_7) AT=1830.05n

.meas tran vdout0_8ck1820 FIND v(dout0_8) AT=1830.05n

.meas tran vdout0_9ck1820 FIND v(dout0_9) AT=1830.05n

.meas tran vdout0_10ck1820 FIND v(dout0_10) AT=1830.05n

.meas tran vdout0_11ck1820 FIND v(dout0_11) AT=1830.05n

.meas tran vdout0_12ck1820 FIND v(dout0_12) AT=1830.05n

.meas tran vdout0_13ck1820 FIND v(dout0_13) AT=1830.05n

.meas tran vdout0_14ck1820 FIND v(dout0_14) AT=1830.05n

.meas tran vdout0_15ck1820 FIND v(dout0_15) AT=1830.05n

.meas tran vdout0_16ck1820 FIND v(dout0_16) AT=1830.05n

.meas tran vdout0_17ck1820 FIND v(dout0_17) AT=1830.05n

.meas tran vdout0_18ck1820 FIND v(dout0_18) AT=1830.05n

.meas tran vdout0_19ck1820 FIND v(dout0_19) AT=1830.05n

.meas tran vdout0_20ck1820 FIND v(dout0_20) AT=1830.05n

.meas tran vdout0_21ck1820 FIND v(dout0_21) AT=1830.05n

.meas tran vdout0_22ck1820 FIND v(dout0_22) AT=1830.05n

.meas tran vdout0_23ck1820 FIND v(dout0_23) AT=1830.05n

.meas tran vdout0_24ck1820 FIND v(dout0_24) AT=1830.05n

.meas tran vdout0_25ck1820 FIND v(dout0_25) AT=1830.05n

.meas tran vdout0_26ck1820 FIND v(dout0_26) AT=1830.05n

.meas tran vdout0_27ck1820 FIND v(dout0_27) AT=1830.05n

.meas tran vdout0_28ck1820 FIND v(dout0_28) AT=1830.05n

.meas tran vdout0_29ck1820 FIND v(dout0_29) AT=1830.05n

.meas tran vdout0_30ck1820 FIND v(dout0_30) AT=1830.05n

.meas tran vdout0_31ck1820 FIND v(dout0_31) AT=1830.05n

.meas tran vdout0_32ck1820 FIND v(dout0_32) AT=1830.05n

.meas tran vdout0_33ck1820 FIND v(dout0_33) AT=1830.05n

.meas tran vdout0_34ck1820 FIND v(dout0_34) AT=1830.05n

.meas tran vdout0_35ck1820 FIND v(dout0_35) AT=1830.05n

.meas tran vdout0_36ck1820 FIND v(dout0_36) AT=1830.05n

.meas tran vdout0_37ck1820 FIND v(dout0_37) AT=1830.05n

.meas tran vdout0_38ck1820 FIND v(dout0_38) AT=1830.05n

.meas tran vdout0_39ck1820 FIND v(dout0_39) AT=1830.05n

.meas tran vdout0_40ck1820 FIND v(dout0_40) AT=1830.05n

.meas tran vdout0_41ck1820 FIND v(dout0_41) AT=1830.05n

.meas tran vdout0_42ck1820 FIND v(dout0_42) AT=1830.05n

.meas tran vdout0_43ck1820 FIND v(dout0_43) AT=1830.05n

.meas tran vdout0_44ck1820 FIND v(dout0_44) AT=1830.05n

.meas tran vdout0_45ck1820 FIND v(dout0_45) AT=1830.05n

.meas tran vdout0_46ck1820 FIND v(dout0_46) AT=1830.05n

.meas tran vdout0_47ck1820 FIND v(dout0_47) AT=1830.05n

.meas tran vdout0_48ck1820 FIND v(dout0_48) AT=1830.05n

.meas tran vdout0_49ck1820 FIND v(dout0_49) AT=1830.05n

.meas tran vdout0_50ck1820 FIND v(dout0_50) AT=1830.05n

.meas tran vdout0_51ck1820 FIND v(dout0_51) AT=1830.05n

.meas tran vdout0_52ck1820 FIND v(dout0_52) AT=1830.05n

.meas tran vdout0_53ck1820 FIND v(dout0_53) AT=1830.05n

.meas tran vdout0_54ck1820 FIND v(dout0_54) AT=1830.05n

.meas tran vdout0_55ck1820 FIND v(dout0_55) AT=1830.05n

.meas tran vdout0_56ck1820 FIND v(dout0_56) AT=1830.05n

.meas tran vdout0_57ck1820 FIND v(dout0_57) AT=1830.05n

.meas tran vdout0_58ck1820 FIND v(dout0_58) AT=1830.05n

.meas tran vdout0_59ck1820 FIND v(dout0_59) AT=1830.05n

.meas tran vdout0_60ck1820 FIND v(dout0_60) AT=1830.05n

.meas tran vdout0_61ck1820 FIND v(dout0_61) AT=1830.05n

.meas tran vdout0_62ck1820 FIND v(dout0_62) AT=1830.05n

.meas tran vdout0_63ck1820 FIND v(dout0_63) AT=1830.05n

.meas tran vdout1_0ck1840 FIND v(dout1_0) AT=1850.05n

.meas tran vdout1_1ck1840 FIND v(dout1_1) AT=1850.05n

.meas tran vdout1_2ck1840 FIND v(dout1_2) AT=1850.05n

.meas tran vdout1_3ck1840 FIND v(dout1_3) AT=1850.05n

.meas tran vdout1_4ck1840 FIND v(dout1_4) AT=1850.05n

.meas tran vdout1_5ck1840 FIND v(dout1_5) AT=1850.05n

.meas tran vdout1_6ck1840 FIND v(dout1_6) AT=1850.05n

.meas tran vdout1_7ck1840 FIND v(dout1_7) AT=1850.05n

.meas tran vdout1_8ck1840 FIND v(dout1_8) AT=1850.05n

.meas tran vdout1_9ck1840 FIND v(dout1_9) AT=1850.05n

.meas tran vdout1_10ck1840 FIND v(dout1_10) AT=1850.05n

.meas tran vdout1_11ck1840 FIND v(dout1_11) AT=1850.05n

.meas tran vdout1_12ck1840 FIND v(dout1_12) AT=1850.05n

.meas tran vdout1_13ck1840 FIND v(dout1_13) AT=1850.05n

.meas tran vdout1_14ck1840 FIND v(dout1_14) AT=1850.05n

.meas tran vdout1_15ck1840 FIND v(dout1_15) AT=1850.05n

.meas tran vdout1_16ck1840 FIND v(dout1_16) AT=1850.05n

.meas tran vdout1_17ck1840 FIND v(dout1_17) AT=1850.05n

.meas tran vdout1_18ck1840 FIND v(dout1_18) AT=1850.05n

.meas tran vdout1_19ck1840 FIND v(dout1_19) AT=1850.05n

.meas tran vdout1_20ck1840 FIND v(dout1_20) AT=1850.05n

.meas tran vdout1_21ck1840 FIND v(dout1_21) AT=1850.05n

.meas tran vdout1_22ck1840 FIND v(dout1_22) AT=1850.05n

.meas tran vdout1_23ck1840 FIND v(dout1_23) AT=1850.05n

.meas tran vdout1_24ck1840 FIND v(dout1_24) AT=1850.05n

.meas tran vdout1_25ck1840 FIND v(dout1_25) AT=1850.05n

.meas tran vdout1_26ck1840 FIND v(dout1_26) AT=1850.05n

.meas tran vdout1_27ck1840 FIND v(dout1_27) AT=1850.05n

.meas tran vdout1_28ck1840 FIND v(dout1_28) AT=1850.05n

.meas tran vdout1_29ck1840 FIND v(dout1_29) AT=1850.05n

.meas tran vdout1_30ck1840 FIND v(dout1_30) AT=1850.05n

.meas tran vdout1_31ck1840 FIND v(dout1_31) AT=1850.05n

.meas tran vdout1_32ck1840 FIND v(dout1_32) AT=1850.05n

.meas tran vdout1_33ck1840 FIND v(dout1_33) AT=1850.05n

.meas tran vdout1_34ck1840 FIND v(dout1_34) AT=1850.05n

.meas tran vdout1_35ck1840 FIND v(dout1_35) AT=1850.05n

.meas tran vdout1_36ck1840 FIND v(dout1_36) AT=1850.05n

.meas tran vdout1_37ck1840 FIND v(dout1_37) AT=1850.05n

.meas tran vdout1_38ck1840 FIND v(dout1_38) AT=1850.05n

.meas tran vdout1_39ck1840 FIND v(dout1_39) AT=1850.05n

.meas tran vdout1_40ck1840 FIND v(dout1_40) AT=1850.05n

.meas tran vdout1_41ck1840 FIND v(dout1_41) AT=1850.05n

.meas tran vdout1_42ck1840 FIND v(dout1_42) AT=1850.05n

.meas tran vdout1_43ck1840 FIND v(dout1_43) AT=1850.05n

.meas tran vdout1_44ck1840 FIND v(dout1_44) AT=1850.05n

.meas tran vdout1_45ck1840 FIND v(dout1_45) AT=1850.05n

.meas tran vdout1_46ck1840 FIND v(dout1_46) AT=1850.05n

.meas tran vdout1_47ck1840 FIND v(dout1_47) AT=1850.05n

.meas tran vdout1_48ck1840 FIND v(dout1_48) AT=1850.05n

.meas tran vdout1_49ck1840 FIND v(dout1_49) AT=1850.05n

.meas tran vdout1_50ck1840 FIND v(dout1_50) AT=1850.05n

.meas tran vdout1_51ck1840 FIND v(dout1_51) AT=1850.05n

.meas tran vdout1_52ck1840 FIND v(dout1_52) AT=1850.05n

.meas tran vdout1_53ck1840 FIND v(dout1_53) AT=1850.05n

.meas tran vdout1_54ck1840 FIND v(dout1_54) AT=1850.05n

.meas tran vdout1_55ck1840 FIND v(dout1_55) AT=1850.05n

.meas tran vdout1_56ck1840 FIND v(dout1_56) AT=1850.05n

.meas tran vdout1_57ck1840 FIND v(dout1_57) AT=1850.05n

.meas tran vdout1_58ck1840 FIND v(dout1_58) AT=1850.05n

.meas tran vdout1_59ck1840 FIND v(dout1_59) AT=1850.05n

.meas tran vdout1_60ck1840 FIND v(dout1_60) AT=1850.05n

.meas tran vdout1_61ck1840 FIND v(dout1_61) AT=1850.05n

.meas tran vdout1_62ck1840 FIND v(dout1_62) AT=1850.05n

.meas tran vdout1_63ck1840 FIND v(dout1_63) AT=1850.05n

.meas tran vdout1_0ck1850 FIND v(dout1_0) AT=1860.05n

.meas tran vdout1_1ck1850 FIND v(dout1_1) AT=1860.05n

.meas tran vdout1_2ck1850 FIND v(dout1_2) AT=1860.05n

.meas tran vdout1_3ck1850 FIND v(dout1_3) AT=1860.05n

.meas tran vdout1_4ck1850 FIND v(dout1_4) AT=1860.05n

.meas tran vdout1_5ck1850 FIND v(dout1_5) AT=1860.05n

.meas tran vdout1_6ck1850 FIND v(dout1_6) AT=1860.05n

.meas tran vdout1_7ck1850 FIND v(dout1_7) AT=1860.05n

.meas tran vdout1_8ck1850 FIND v(dout1_8) AT=1860.05n

.meas tran vdout1_9ck1850 FIND v(dout1_9) AT=1860.05n

.meas tran vdout1_10ck1850 FIND v(dout1_10) AT=1860.05n

.meas tran vdout1_11ck1850 FIND v(dout1_11) AT=1860.05n

.meas tran vdout1_12ck1850 FIND v(dout1_12) AT=1860.05n

.meas tran vdout1_13ck1850 FIND v(dout1_13) AT=1860.05n

.meas tran vdout1_14ck1850 FIND v(dout1_14) AT=1860.05n

.meas tran vdout1_15ck1850 FIND v(dout1_15) AT=1860.05n

.meas tran vdout1_16ck1850 FIND v(dout1_16) AT=1860.05n

.meas tran vdout1_17ck1850 FIND v(dout1_17) AT=1860.05n

.meas tran vdout1_18ck1850 FIND v(dout1_18) AT=1860.05n

.meas tran vdout1_19ck1850 FIND v(dout1_19) AT=1860.05n

.meas tran vdout1_20ck1850 FIND v(dout1_20) AT=1860.05n

.meas tran vdout1_21ck1850 FIND v(dout1_21) AT=1860.05n

.meas tran vdout1_22ck1850 FIND v(dout1_22) AT=1860.05n

.meas tran vdout1_23ck1850 FIND v(dout1_23) AT=1860.05n

.meas tran vdout1_24ck1850 FIND v(dout1_24) AT=1860.05n

.meas tran vdout1_25ck1850 FIND v(dout1_25) AT=1860.05n

.meas tran vdout1_26ck1850 FIND v(dout1_26) AT=1860.05n

.meas tran vdout1_27ck1850 FIND v(dout1_27) AT=1860.05n

.meas tran vdout1_28ck1850 FIND v(dout1_28) AT=1860.05n

.meas tran vdout1_29ck1850 FIND v(dout1_29) AT=1860.05n

.meas tran vdout1_30ck1850 FIND v(dout1_30) AT=1860.05n

.meas tran vdout1_31ck1850 FIND v(dout1_31) AT=1860.05n

.meas tran vdout1_32ck1850 FIND v(dout1_32) AT=1860.05n

.meas tran vdout1_33ck1850 FIND v(dout1_33) AT=1860.05n

.meas tran vdout1_34ck1850 FIND v(dout1_34) AT=1860.05n

.meas tran vdout1_35ck1850 FIND v(dout1_35) AT=1860.05n

.meas tran vdout1_36ck1850 FIND v(dout1_36) AT=1860.05n

.meas tran vdout1_37ck1850 FIND v(dout1_37) AT=1860.05n

.meas tran vdout1_38ck1850 FIND v(dout1_38) AT=1860.05n

.meas tran vdout1_39ck1850 FIND v(dout1_39) AT=1860.05n

.meas tran vdout1_40ck1850 FIND v(dout1_40) AT=1860.05n

.meas tran vdout1_41ck1850 FIND v(dout1_41) AT=1860.05n

.meas tran vdout1_42ck1850 FIND v(dout1_42) AT=1860.05n

.meas tran vdout1_43ck1850 FIND v(dout1_43) AT=1860.05n

.meas tran vdout1_44ck1850 FIND v(dout1_44) AT=1860.05n

.meas tran vdout1_45ck1850 FIND v(dout1_45) AT=1860.05n

.meas tran vdout1_46ck1850 FIND v(dout1_46) AT=1860.05n

.meas tran vdout1_47ck1850 FIND v(dout1_47) AT=1860.05n

.meas tran vdout1_48ck1850 FIND v(dout1_48) AT=1860.05n

.meas tran vdout1_49ck1850 FIND v(dout1_49) AT=1860.05n

.meas tran vdout1_50ck1850 FIND v(dout1_50) AT=1860.05n

.meas tran vdout1_51ck1850 FIND v(dout1_51) AT=1860.05n

.meas tran vdout1_52ck1850 FIND v(dout1_52) AT=1860.05n

.meas tran vdout1_53ck1850 FIND v(dout1_53) AT=1860.05n

.meas tran vdout1_54ck1850 FIND v(dout1_54) AT=1860.05n

.meas tran vdout1_55ck1850 FIND v(dout1_55) AT=1860.05n

.meas tran vdout1_56ck1850 FIND v(dout1_56) AT=1860.05n

.meas tran vdout1_57ck1850 FIND v(dout1_57) AT=1860.05n

.meas tran vdout1_58ck1850 FIND v(dout1_58) AT=1860.05n

.meas tran vdout1_59ck1850 FIND v(dout1_59) AT=1860.05n

.meas tran vdout1_60ck1850 FIND v(dout1_60) AT=1860.05n

.meas tran vdout1_61ck1850 FIND v(dout1_61) AT=1860.05n

.meas tran vdout1_62ck1850 FIND v(dout1_62) AT=1860.05n

.meas tran vdout1_63ck1850 FIND v(dout1_63) AT=1860.05n

.meas tran vdout1_0ck1860 FIND v(dout1_0) AT=1870.05n

.meas tran vdout1_1ck1860 FIND v(dout1_1) AT=1870.05n

.meas tran vdout1_2ck1860 FIND v(dout1_2) AT=1870.05n

.meas tran vdout1_3ck1860 FIND v(dout1_3) AT=1870.05n

.meas tran vdout1_4ck1860 FIND v(dout1_4) AT=1870.05n

.meas tran vdout1_5ck1860 FIND v(dout1_5) AT=1870.05n

.meas tran vdout1_6ck1860 FIND v(dout1_6) AT=1870.05n

.meas tran vdout1_7ck1860 FIND v(dout1_7) AT=1870.05n

.meas tran vdout1_8ck1860 FIND v(dout1_8) AT=1870.05n

.meas tran vdout1_9ck1860 FIND v(dout1_9) AT=1870.05n

.meas tran vdout1_10ck1860 FIND v(dout1_10) AT=1870.05n

.meas tran vdout1_11ck1860 FIND v(dout1_11) AT=1870.05n

.meas tran vdout1_12ck1860 FIND v(dout1_12) AT=1870.05n

.meas tran vdout1_13ck1860 FIND v(dout1_13) AT=1870.05n

.meas tran vdout1_14ck1860 FIND v(dout1_14) AT=1870.05n

.meas tran vdout1_15ck1860 FIND v(dout1_15) AT=1870.05n

.meas tran vdout1_16ck1860 FIND v(dout1_16) AT=1870.05n

.meas tran vdout1_17ck1860 FIND v(dout1_17) AT=1870.05n

.meas tran vdout1_18ck1860 FIND v(dout1_18) AT=1870.05n

.meas tran vdout1_19ck1860 FIND v(dout1_19) AT=1870.05n

.meas tran vdout1_20ck1860 FIND v(dout1_20) AT=1870.05n

.meas tran vdout1_21ck1860 FIND v(dout1_21) AT=1870.05n

.meas tran vdout1_22ck1860 FIND v(dout1_22) AT=1870.05n

.meas tran vdout1_23ck1860 FIND v(dout1_23) AT=1870.05n

.meas tran vdout1_24ck1860 FIND v(dout1_24) AT=1870.05n

.meas tran vdout1_25ck1860 FIND v(dout1_25) AT=1870.05n

.meas tran vdout1_26ck1860 FIND v(dout1_26) AT=1870.05n

.meas tran vdout1_27ck1860 FIND v(dout1_27) AT=1870.05n

.meas tran vdout1_28ck1860 FIND v(dout1_28) AT=1870.05n

.meas tran vdout1_29ck1860 FIND v(dout1_29) AT=1870.05n

.meas tran vdout1_30ck1860 FIND v(dout1_30) AT=1870.05n

.meas tran vdout1_31ck1860 FIND v(dout1_31) AT=1870.05n

.meas tran vdout1_32ck1860 FIND v(dout1_32) AT=1870.05n

.meas tran vdout1_33ck1860 FIND v(dout1_33) AT=1870.05n

.meas tran vdout1_34ck1860 FIND v(dout1_34) AT=1870.05n

.meas tran vdout1_35ck1860 FIND v(dout1_35) AT=1870.05n

.meas tran vdout1_36ck1860 FIND v(dout1_36) AT=1870.05n

.meas tran vdout1_37ck1860 FIND v(dout1_37) AT=1870.05n

.meas tran vdout1_38ck1860 FIND v(dout1_38) AT=1870.05n

.meas tran vdout1_39ck1860 FIND v(dout1_39) AT=1870.05n

.meas tran vdout1_40ck1860 FIND v(dout1_40) AT=1870.05n

.meas tran vdout1_41ck1860 FIND v(dout1_41) AT=1870.05n

.meas tran vdout1_42ck1860 FIND v(dout1_42) AT=1870.05n

.meas tran vdout1_43ck1860 FIND v(dout1_43) AT=1870.05n

.meas tran vdout1_44ck1860 FIND v(dout1_44) AT=1870.05n

.meas tran vdout1_45ck1860 FIND v(dout1_45) AT=1870.05n

.meas tran vdout1_46ck1860 FIND v(dout1_46) AT=1870.05n

.meas tran vdout1_47ck1860 FIND v(dout1_47) AT=1870.05n

.meas tran vdout1_48ck1860 FIND v(dout1_48) AT=1870.05n

.meas tran vdout1_49ck1860 FIND v(dout1_49) AT=1870.05n

.meas tran vdout1_50ck1860 FIND v(dout1_50) AT=1870.05n

.meas tran vdout1_51ck1860 FIND v(dout1_51) AT=1870.05n

.meas tran vdout1_52ck1860 FIND v(dout1_52) AT=1870.05n

.meas tran vdout1_53ck1860 FIND v(dout1_53) AT=1870.05n

.meas tran vdout1_54ck1860 FIND v(dout1_54) AT=1870.05n

.meas tran vdout1_55ck1860 FIND v(dout1_55) AT=1870.05n

.meas tran vdout1_56ck1860 FIND v(dout1_56) AT=1870.05n

.meas tran vdout1_57ck1860 FIND v(dout1_57) AT=1870.05n

.meas tran vdout1_58ck1860 FIND v(dout1_58) AT=1870.05n

.meas tran vdout1_59ck1860 FIND v(dout1_59) AT=1870.05n

.meas tran vdout1_60ck1860 FIND v(dout1_60) AT=1870.05n

.meas tran vdout1_61ck1860 FIND v(dout1_61) AT=1870.05n

.meas tran vdout1_62ck1860 FIND v(dout1_62) AT=1870.05n

.meas tran vdout1_63ck1860 FIND v(dout1_63) AT=1870.05n

.meas tran vdout0_0ck1870 FIND v(dout0_0) AT=1880.05n

.meas tran vdout0_1ck1870 FIND v(dout0_1) AT=1880.05n

.meas tran vdout0_2ck1870 FIND v(dout0_2) AT=1880.05n

.meas tran vdout0_3ck1870 FIND v(dout0_3) AT=1880.05n

.meas tran vdout0_4ck1870 FIND v(dout0_4) AT=1880.05n

.meas tran vdout0_5ck1870 FIND v(dout0_5) AT=1880.05n

.meas tran vdout0_6ck1870 FIND v(dout0_6) AT=1880.05n

.meas tran vdout0_7ck1870 FIND v(dout0_7) AT=1880.05n

.meas tran vdout0_8ck1870 FIND v(dout0_8) AT=1880.05n

.meas tran vdout0_9ck1870 FIND v(dout0_9) AT=1880.05n

.meas tran vdout0_10ck1870 FIND v(dout0_10) AT=1880.05n

.meas tran vdout0_11ck1870 FIND v(dout0_11) AT=1880.05n

.meas tran vdout0_12ck1870 FIND v(dout0_12) AT=1880.05n

.meas tran vdout0_13ck1870 FIND v(dout0_13) AT=1880.05n

.meas tran vdout0_14ck1870 FIND v(dout0_14) AT=1880.05n

.meas tran vdout0_15ck1870 FIND v(dout0_15) AT=1880.05n

.meas tran vdout0_16ck1870 FIND v(dout0_16) AT=1880.05n

.meas tran vdout0_17ck1870 FIND v(dout0_17) AT=1880.05n

.meas tran vdout0_18ck1870 FIND v(dout0_18) AT=1880.05n

.meas tran vdout0_19ck1870 FIND v(dout0_19) AT=1880.05n

.meas tran vdout0_20ck1870 FIND v(dout0_20) AT=1880.05n

.meas tran vdout0_21ck1870 FIND v(dout0_21) AT=1880.05n

.meas tran vdout0_22ck1870 FIND v(dout0_22) AT=1880.05n

.meas tran vdout0_23ck1870 FIND v(dout0_23) AT=1880.05n

.meas tran vdout0_24ck1870 FIND v(dout0_24) AT=1880.05n

.meas tran vdout0_25ck1870 FIND v(dout0_25) AT=1880.05n

.meas tran vdout0_26ck1870 FIND v(dout0_26) AT=1880.05n

.meas tran vdout0_27ck1870 FIND v(dout0_27) AT=1880.05n

.meas tran vdout0_28ck1870 FIND v(dout0_28) AT=1880.05n

.meas tran vdout0_29ck1870 FIND v(dout0_29) AT=1880.05n

.meas tran vdout0_30ck1870 FIND v(dout0_30) AT=1880.05n

.meas tran vdout0_31ck1870 FIND v(dout0_31) AT=1880.05n

.meas tran vdout0_32ck1870 FIND v(dout0_32) AT=1880.05n

.meas tran vdout0_33ck1870 FIND v(dout0_33) AT=1880.05n

.meas tran vdout0_34ck1870 FIND v(dout0_34) AT=1880.05n

.meas tran vdout0_35ck1870 FIND v(dout0_35) AT=1880.05n

.meas tran vdout0_36ck1870 FIND v(dout0_36) AT=1880.05n

.meas tran vdout0_37ck1870 FIND v(dout0_37) AT=1880.05n

.meas tran vdout0_38ck1870 FIND v(dout0_38) AT=1880.05n

.meas tran vdout0_39ck1870 FIND v(dout0_39) AT=1880.05n

.meas tran vdout0_40ck1870 FIND v(dout0_40) AT=1880.05n

.meas tran vdout0_41ck1870 FIND v(dout0_41) AT=1880.05n

.meas tran vdout0_42ck1870 FIND v(dout0_42) AT=1880.05n

.meas tran vdout0_43ck1870 FIND v(dout0_43) AT=1880.05n

.meas tran vdout0_44ck1870 FIND v(dout0_44) AT=1880.05n

.meas tran vdout0_45ck1870 FIND v(dout0_45) AT=1880.05n

.meas tran vdout0_46ck1870 FIND v(dout0_46) AT=1880.05n

.meas tran vdout0_47ck1870 FIND v(dout0_47) AT=1880.05n

.meas tran vdout0_48ck1870 FIND v(dout0_48) AT=1880.05n

.meas tran vdout0_49ck1870 FIND v(dout0_49) AT=1880.05n

.meas tran vdout0_50ck1870 FIND v(dout0_50) AT=1880.05n

.meas tran vdout0_51ck1870 FIND v(dout0_51) AT=1880.05n

.meas tran vdout0_52ck1870 FIND v(dout0_52) AT=1880.05n

.meas tran vdout0_53ck1870 FIND v(dout0_53) AT=1880.05n

.meas tran vdout0_54ck1870 FIND v(dout0_54) AT=1880.05n

.meas tran vdout0_55ck1870 FIND v(dout0_55) AT=1880.05n

.meas tran vdout0_56ck1870 FIND v(dout0_56) AT=1880.05n

.meas tran vdout0_57ck1870 FIND v(dout0_57) AT=1880.05n

.meas tran vdout0_58ck1870 FIND v(dout0_58) AT=1880.05n

.meas tran vdout0_59ck1870 FIND v(dout0_59) AT=1880.05n

.meas tran vdout0_60ck1870 FIND v(dout0_60) AT=1880.05n

.meas tran vdout0_61ck1870 FIND v(dout0_61) AT=1880.05n

.meas tran vdout0_62ck1870 FIND v(dout0_62) AT=1880.05n

.meas tran vdout0_63ck1870 FIND v(dout0_63) AT=1880.05n

.meas tran vdout0_0ck1890 FIND v(dout0_0) AT=1900.05n

.meas tran vdout0_1ck1890 FIND v(dout0_1) AT=1900.05n

.meas tran vdout0_2ck1890 FIND v(dout0_2) AT=1900.05n

.meas tran vdout0_3ck1890 FIND v(dout0_3) AT=1900.05n

.meas tran vdout0_4ck1890 FIND v(dout0_4) AT=1900.05n

.meas tran vdout0_5ck1890 FIND v(dout0_5) AT=1900.05n

.meas tran vdout0_6ck1890 FIND v(dout0_6) AT=1900.05n

.meas tran vdout0_7ck1890 FIND v(dout0_7) AT=1900.05n

.meas tran vdout0_8ck1890 FIND v(dout0_8) AT=1900.05n

.meas tran vdout0_9ck1890 FIND v(dout0_9) AT=1900.05n

.meas tran vdout0_10ck1890 FIND v(dout0_10) AT=1900.05n

.meas tran vdout0_11ck1890 FIND v(dout0_11) AT=1900.05n

.meas tran vdout0_12ck1890 FIND v(dout0_12) AT=1900.05n

.meas tran vdout0_13ck1890 FIND v(dout0_13) AT=1900.05n

.meas tran vdout0_14ck1890 FIND v(dout0_14) AT=1900.05n

.meas tran vdout0_15ck1890 FIND v(dout0_15) AT=1900.05n

.meas tran vdout0_16ck1890 FIND v(dout0_16) AT=1900.05n

.meas tran vdout0_17ck1890 FIND v(dout0_17) AT=1900.05n

.meas tran vdout0_18ck1890 FIND v(dout0_18) AT=1900.05n

.meas tran vdout0_19ck1890 FIND v(dout0_19) AT=1900.05n

.meas tran vdout0_20ck1890 FIND v(dout0_20) AT=1900.05n

.meas tran vdout0_21ck1890 FIND v(dout0_21) AT=1900.05n

.meas tran vdout0_22ck1890 FIND v(dout0_22) AT=1900.05n

.meas tran vdout0_23ck1890 FIND v(dout0_23) AT=1900.05n

.meas tran vdout0_24ck1890 FIND v(dout0_24) AT=1900.05n

.meas tran vdout0_25ck1890 FIND v(dout0_25) AT=1900.05n

.meas tran vdout0_26ck1890 FIND v(dout0_26) AT=1900.05n

.meas tran vdout0_27ck1890 FIND v(dout0_27) AT=1900.05n

.meas tran vdout0_28ck1890 FIND v(dout0_28) AT=1900.05n

.meas tran vdout0_29ck1890 FIND v(dout0_29) AT=1900.05n

.meas tran vdout0_30ck1890 FIND v(dout0_30) AT=1900.05n

.meas tran vdout0_31ck1890 FIND v(dout0_31) AT=1900.05n

.meas tran vdout0_32ck1890 FIND v(dout0_32) AT=1900.05n

.meas tran vdout0_33ck1890 FIND v(dout0_33) AT=1900.05n

.meas tran vdout0_34ck1890 FIND v(dout0_34) AT=1900.05n

.meas tran vdout0_35ck1890 FIND v(dout0_35) AT=1900.05n

.meas tran vdout0_36ck1890 FIND v(dout0_36) AT=1900.05n

.meas tran vdout0_37ck1890 FIND v(dout0_37) AT=1900.05n

.meas tran vdout0_38ck1890 FIND v(dout0_38) AT=1900.05n

.meas tran vdout0_39ck1890 FIND v(dout0_39) AT=1900.05n

.meas tran vdout0_40ck1890 FIND v(dout0_40) AT=1900.05n

.meas tran vdout0_41ck1890 FIND v(dout0_41) AT=1900.05n

.meas tran vdout0_42ck1890 FIND v(dout0_42) AT=1900.05n

.meas tran vdout0_43ck1890 FIND v(dout0_43) AT=1900.05n

.meas tran vdout0_44ck1890 FIND v(dout0_44) AT=1900.05n

.meas tran vdout0_45ck1890 FIND v(dout0_45) AT=1900.05n

.meas tran vdout0_46ck1890 FIND v(dout0_46) AT=1900.05n

.meas tran vdout0_47ck1890 FIND v(dout0_47) AT=1900.05n

.meas tran vdout0_48ck1890 FIND v(dout0_48) AT=1900.05n

.meas tran vdout0_49ck1890 FIND v(dout0_49) AT=1900.05n

.meas tran vdout0_50ck1890 FIND v(dout0_50) AT=1900.05n

.meas tran vdout0_51ck1890 FIND v(dout0_51) AT=1900.05n

.meas tran vdout0_52ck1890 FIND v(dout0_52) AT=1900.05n

.meas tran vdout0_53ck1890 FIND v(dout0_53) AT=1900.05n

.meas tran vdout0_54ck1890 FIND v(dout0_54) AT=1900.05n

.meas tran vdout0_55ck1890 FIND v(dout0_55) AT=1900.05n

.meas tran vdout0_56ck1890 FIND v(dout0_56) AT=1900.05n

.meas tran vdout0_57ck1890 FIND v(dout0_57) AT=1900.05n

.meas tran vdout0_58ck1890 FIND v(dout0_58) AT=1900.05n

.meas tran vdout0_59ck1890 FIND v(dout0_59) AT=1900.05n

.meas tran vdout0_60ck1890 FIND v(dout0_60) AT=1900.05n

.meas tran vdout0_61ck1890 FIND v(dout0_61) AT=1900.05n

.meas tran vdout0_62ck1890 FIND v(dout0_62) AT=1900.05n

.meas tran vdout0_63ck1890 FIND v(dout0_63) AT=1900.05n

.meas tran vdout0_0ck1930 FIND v(dout0_0) AT=1940.05n

.meas tran vdout0_1ck1930 FIND v(dout0_1) AT=1940.05n

.meas tran vdout0_2ck1930 FIND v(dout0_2) AT=1940.05n

.meas tran vdout0_3ck1930 FIND v(dout0_3) AT=1940.05n

.meas tran vdout0_4ck1930 FIND v(dout0_4) AT=1940.05n

.meas tran vdout0_5ck1930 FIND v(dout0_5) AT=1940.05n

.meas tran vdout0_6ck1930 FIND v(dout0_6) AT=1940.05n

.meas tran vdout0_7ck1930 FIND v(dout0_7) AT=1940.05n

.meas tran vdout0_8ck1930 FIND v(dout0_8) AT=1940.05n

.meas tran vdout0_9ck1930 FIND v(dout0_9) AT=1940.05n

.meas tran vdout0_10ck1930 FIND v(dout0_10) AT=1940.05n

.meas tran vdout0_11ck1930 FIND v(dout0_11) AT=1940.05n

.meas tran vdout0_12ck1930 FIND v(dout0_12) AT=1940.05n

.meas tran vdout0_13ck1930 FIND v(dout0_13) AT=1940.05n

.meas tran vdout0_14ck1930 FIND v(dout0_14) AT=1940.05n

.meas tran vdout0_15ck1930 FIND v(dout0_15) AT=1940.05n

.meas tran vdout0_16ck1930 FIND v(dout0_16) AT=1940.05n

.meas tran vdout0_17ck1930 FIND v(dout0_17) AT=1940.05n

.meas tran vdout0_18ck1930 FIND v(dout0_18) AT=1940.05n

.meas tran vdout0_19ck1930 FIND v(dout0_19) AT=1940.05n

.meas tran vdout0_20ck1930 FIND v(dout0_20) AT=1940.05n

.meas tran vdout0_21ck1930 FIND v(dout0_21) AT=1940.05n

.meas tran vdout0_22ck1930 FIND v(dout0_22) AT=1940.05n

.meas tran vdout0_23ck1930 FIND v(dout0_23) AT=1940.05n

.meas tran vdout0_24ck1930 FIND v(dout0_24) AT=1940.05n

.meas tran vdout0_25ck1930 FIND v(dout0_25) AT=1940.05n

.meas tran vdout0_26ck1930 FIND v(dout0_26) AT=1940.05n

.meas tran vdout0_27ck1930 FIND v(dout0_27) AT=1940.05n

.meas tran vdout0_28ck1930 FIND v(dout0_28) AT=1940.05n

.meas tran vdout0_29ck1930 FIND v(dout0_29) AT=1940.05n

.meas tran vdout0_30ck1930 FIND v(dout0_30) AT=1940.05n

.meas tran vdout0_31ck1930 FIND v(dout0_31) AT=1940.05n

.meas tran vdout0_32ck1930 FIND v(dout0_32) AT=1940.05n

.meas tran vdout0_33ck1930 FIND v(dout0_33) AT=1940.05n

.meas tran vdout0_34ck1930 FIND v(dout0_34) AT=1940.05n

.meas tran vdout0_35ck1930 FIND v(dout0_35) AT=1940.05n

.meas tran vdout0_36ck1930 FIND v(dout0_36) AT=1940.05n

.meas tran vdout0_37ck1930 FIND v(dout0_37) AT=1940.05n

.meas tran vdout0_38ck1930 FIND v(dout0_38) AT=1940.05n

.meas tran vdout0_39ck1930 FIND v(dout0_39) AT=1940.05n

.meas tran vdout0_40ck1930 FIND v(dout0_40) AT=1940.05n

.meas tran vdout0_41ck1930 FIND v(dout0_41) AT=1940.05n

.meas tran vdout0_42ck1930 FIND v(dout0_42) AT=1940.05n

.meas tran vdout0_43ck1930 FIND v(dout0_43) AT=1940.05n

.meas tran vdout0_44ck1930 FIND v(dout0_44) AT=1940.05n

.meas tran vdout0_45ck1930 FIND v(dout0_45) AT=1940.05n

.meas tran vdout0_46ck1930 FIND v(dout0_46) AT=1940.05n

.meas tran vdout0_47ck1930 FIND v(dout0_47) AT=1940.05n

.meas tran vdout0_48ck1930 FIND v(dout0_48) AT=1940.05n

.meas tran vdout0_49ck1930 FIND v(dout0_49) AT=1940.05n

.meas tran vdout0_50ck1930 FIND v(dout0_50) AT=1940.05n

.meas tran vdout0_51ck1930 FIND v(dout0_51) AT=1940.05n

.meas tran vdout0_52ck1930 FIND v(dout0_52) AT=1940.05n

.meas tran vdout0_53ck1930 FIND v(dout0_53) AT=1940.05n

.meas tran vdout0_54ck1930 FIND v(dout0_54) AT=1940.05n

.meas tran vdout0_55ck1930 FIND v(dout0_55) AT=1940.05n

.meas tran vdout0_56ck1930 FIND v(dout0_56) AT=1940.05n

.meas tran vdout0_57ck1930 FIND v(dout0_57) AT=1940.05n

.meas tran vdout0_58ck1930 FIND v(dout0_58) AT=1940.05n

.meas tran vdout0_59ck1930 FIND v(dout0_59) AT=1940.05n

.meas tran vdout0_60ck1930 FIND v(dout0_60) AT=1940.05n

.meas tran vdout0_61ck1930 FIND v(dout0_61) AT=1940.05n

.meas tran vdout0_62ck1930 FIND v(dout0_62) AT=1940.05n

.meas tran vdout0_63ck1930 FIND v(dout0_63) AT=1940.05n

.meas tran vdout1_0ck1930 FIND v(dout1_0) AT=1940.05n

.meas tran vdout1_1ck1930 FIND v(dout1_1) AT=1940.05n

.meas tran vdout1_2ck1930 FIND v(dout1_2) AT=1940.05n

.meas tran vdout1_3ck1930 FIND v(dout1_3) AT=1940.05n

.meas tran vdout1_4ck1930 FIND v(dout1_4) AT=1940.05n

.meas tran vdout1_5ck1930 FIND v(dout1_5) AT=1940.05n

.meas tran vdout1_6ck1930 FIND v(dout1_6) AT=1940.05n

.meas tran vdout1_7ck1930 FIND v(dout1_7) AT=1940.05n

.meas tran vdout1_8ck1930 FIND v(dout1_8) AT=1940.05n

.meas tran vdout1_9ck1930 FIND v(dout1_9) AT=1940.05n

.meas tran vdout1_10ck1930 FIND v(dout1_10) AT=1940.05n

.meas tran vdout1_11ck1930 FIND v(dout1_11) AT=1940.05n

.meas tran vdout1_12ck1930 FIND v(dout1_12) AT=1940.05n

.meas tran vdout1_13ck1930 FIND v(dout1_13) AT=1940.05n

.meas tran vdout1_14ck1930 FIND v(dout1_14) AT=1940.05n

.meas tran vdout1_15ck1930 FIND v(dout1_15) AT=1940.05n

.meas tran vdout1_16ck1930 FIND v(dout1_16) AT=1940.05n

.meas tran vdout1_17ck1930 FIND v(dout1_17) AT=1940.05n

.meas tran vdout1_18ck1930 FIND v(dout1_18) AT=1940.05n

.meas tran vdout1_19ck1930 FIND v(dout1_19) AT=1940.05n

.meas tran vdout1_20ck1930 FIND v(dout1_20) AT=1940.05n

.meas tran vdout1_21ck1930 FIND v(dout1_21) AT=1940.05n

.meas tran vdout1_22ck1930 FIND v(dout1_22) AT=1940.05n

.meas tran vdout1_23ck1930 FIND v(dout1_23) AT=1940.05n

.meas tran vdout1_24ck1930 FIND v(dout1_24) AT=1940.05n

.meas tran vdout1_25ck1930 FIND v(dout1_25) AT=1940.05n

.meas tran vdout1_26ck1930 FIND v(dout1_26) AT=1940.05n

.meas tran vdout1_27ck1930 FIND v(dout1_27) AT=1940.05n

.meas tran vdout1_28ck1930 FIND v(dout1_28) AT=1940.05n

.meas tran vdout1_29ck1930 FIND v(dout1_29) AT=1940.05n

.meas tran vdout1_30ck1930 FIND v(dout1_30) AT=1940.05n

.meas tran vdout1_31ck1930 FIND v(dout1_31) AT=1940.05n

.meas tran vdout1_32ck1930 FIND v(dout1_32) AT=1940.05n

.meas tran vdout1_33ck1930 FIND v(dout1_33) AT=1940.05n

.meas tran vdout1_34ck1930 FIND v(dout1_34) AT=1940.05n

.meas tran vdout1_35ck1930 FIND v(dout1_35) AT=1940.05n

.meas tran vdout1_36ck1930 FIND v(dout1_36) AT=1940.05n

.meas tran vdout1_37ck1930 FIND v(dout1_37) AT=1940.05n

.meas tran vdout1_38ck1930 FIND v(dout1_38) AT=1940.05n

.meas tran vdout1_39ck1930 FIND v(dout1_39) AT=1940.05n

.meas tran vdout1_40ck1930 FIND v(dout1_40) AT=1940.05n

.meas tran vdout1_41ck1930 FIND v(dout1_41) AT=1940.05n

.meas tran vdout1_42ck1930 FIND v(dout1_42) AT=1940.05n

.meas tran vdout1_43ck1930 FIND v(dout1_43) AT=1940.05n

.meas tran vdout1_44ck1930 FIND v(dout1_44) AT=1940.05n

.meas tran vdout1_45ck1930 FIND v(dout1_45) AT=1940.05n

.meas tran vdout1_46ck1930 FIND v(dout1_46) AT=1940.05n

.meas tran vdout1_47ck1930 FIND v(dout1_47) AT=1940.05n

.meas tran vdout1_48ck1930 FIND v(dout1_48) AT=1940.05n

.meas tran vdout1_49ck1930 FIND v(dout1_49) AT=1940.05n

.meas tran vdout1_50ck1930 FIND v(dout1_50) AT=1940.05n

.meas tran vdout1_51ck1930 FIND v(dout1_51) AT=1940.05n

.meas tran vdout1_52ck1930 FIND v(dout1_52) AT=1940.05n

.meas tran vdout1_53ck1930 FIND v(dout1_53) AT=1940.05n

.meas tran vdout1_54ck1930 FIND v(dout1_54) AT=1940.05n

.meas tran vdout1_55ck1930 FIND v(dout1_55) AT=1940.05n

.meas tran vdout1_56ck1930 FIND v(dout1_56) AT=1940.05n

.meas tran vdout1_57ck1930 FIND v(dout1_57) AT=1940.05n

.meas tran vdout1_58ck1930 FIND v(dout1_58) AT=1940.05n

.meas tran vdout1_59ck1930 FIND v(dout1_59) AT=1940.05n

.meas tran vdout1_60ck1930 FIND v(dout1_60) AT=1940.05n

.meas tran vdout1_61ck1930 FIND v(dout1_61) AT=1940.05n

.meas tran vdout1_62ck1930 FIND v(dout1_62) AT=1940.05n

.meas tran vdout1_63ck1930 FIND v(dout1_63) AT=1940.05n

.meas tran vdout1_0ck1950 FIND v(dout1_0) AT=1960.05n

.meas tran vdout1_1ck1950 FIND v(dout1_1) AT=1960.05n

.meas tran vdout1_2ck1950 FIND v(dout1_2) AT=1960.05n

.meas tran vdout1_3ck1950 FIND v(dout1_3) AT=1960.05n

.meas tran vdout1_4ck1950 FIND v(dout1_4) AT=1960.05n

.meas tran vdout1_5ck1950 FIND v(dout1_5) AT=1960.05n

.meas tran vdout1_6ck1950 FIND v(dout1_6) AT=1960.05n

.meas tran vdout1_7ck1950 FIND v(dout1_7) AT=1960.05n

.meas tran vdout1_8ck1950 FIND v(dout1_8) AT=1960.05n

.meas tran vdout1_9ck1950 FIND v(dout1_9) AT=1960.05n

.meas tran vdout1_10ck1950 FIND v(dout1_10) AT=1960.05n

.meas tran vdout1_11ck1950 FIND v(dout1_11) AT=1960.05n

.meas tran vdout1_12ck1950 FIND v(dout1_12) AT=1960.05n

.meas tran vdout1_13ck1950 FIND v(dout1_13) AT=1960.05n

.meas tran vdout1_14ck1950 FIND v(dout1_14) AT=1960.05n

.meas tran vdout1_15ck1950 FIND v(dout1_15) AT=1960.05n

.meas tran vdout1_16ck1950 FIND v(dout1_16) AT=1960.05n

.meas tran vdout1_17ck1950 FIND v(dout1_17) AT=1960.05n

.meas tran vdout1_18ck1950 FIND v(dout1_18) AT=1960.05n

.meas tran vdout1_19ck1950 FIND v(dout1_19) AT=1960.05n

.meas tran vdout1_20ck1950 FIND v(dout1_20) AT=1960.05n

.meas tran vdout1_21ck1950 FIND v(dout1_21) AT=1960.05n

.meas tran vdout1_22ck1950 FIND v(dout1_22) AT=1960.05n

.meas tran vdout1_23ck1950 FIND v(dout1_23) AT=1960.05n

.meas tran vdout1_24ck1950 FIND v(dout1_24) AT=1960.05n

.meas tran vdout1_25ck1950 FIND v(dout1_25) AT=1960.05n

.meas tran vdout1_26ck1950 FIND v(dout1_26) AT=1960.05n

.meas tran vdout1_27ck1950 FIND v(dout1_27) AT=1960.05n

.meas tran vdout1_28ck1950 FIND v(dout1_28) AT=1960.05n

.meas tran vdout1_29ck1950 FIND v(dout1_29) AT=1960.05n

.meas tran vdout1_30ck1950 FIND v(dout1_30) AT=1960.05n

.meas tran vdout1_31ck1950 FIND v(dout1_31) AT=1960.05n

.meas tran vdout1_32ck1950 FIND v(dout1_32) AT=1960.05n

.meas tran vdout1_33ck1950 FIND v(dout1_33) AT=1960.05n

.meas tran vdout1_34ck1950 FIND v(dout1_34) AT=1960.05n

.meas tran vdout1_35ck1950 FIND v(dout1_35) AT=1960.05n

.meas tran vdout1_36ck1950 FIND v(dout1_36) AT=1960.05n

.meas tran vdout1_37ck1950 FIND v(dout1_37) AT=1960.05n

.meas tran vdout1_38ck1950 FIND v(dout1_38) AT=1960.05n

.meas tran vdout1_39ck1950 FIND v(dout1_39) AT=1960.05n

.meas tran vdout1_40ck1950 FIND v(dout1_40) AT=1960.05n

.meas tran vdout1_41ck1950 FIND v(dout1_41) AT=1960.05n

.meas tran vdout1_42ck1950 FIND v(dout1_42) AT=1960.05n

.meas tran vdout1_43ck1950 FIND v(dout1_43) AT=1960.05n

.meas tran vdout1_44ck1950 FIND v(dout1_44) AT=1960.05n

.meas tran vdout1_45ck1950 FIND v(dout1_45) AT=1960.05n

.meas tran vdout1_46ck1950 FIND v(dout1_46) AT=1960.05n

.meas tran vdout1_47ck1950 FIND v(dout1_47) AT=1960.05n

.meas tran vdout1_48ck1950 FIND v(dout1_48) AT=1960.05n

.meas tran vdout1_49ck1950 FIND v(dout1_49) AT=1960.05n

.meas tran vdout1_50ck1950 FIND v(dout1_50) AT=1960.05n

.meas tran vdout1_51ck1950 FIND v(dout1_51) AT=1960.05n

.meas tran vdout1_52ck1950 FIND v(dout1_52) AT=1960.05n

.meas tran vdout1_53ck1950 FIND v(dout1_53) AT=1960.05n

.meas tran vdout1_54ck1950 FIND v(dout1_54) AT=1960.05n

.meas tran vdout1_55ck1950 FIND v(dout1_55) AT=1960.05n

.meas tran vdout1_56ck1950 FIND v(dout1_56) AT=1960.05n

.meas tran vdout1_57ck1950 FIND v(dout1_57) AT=1960.05n

.meas tran vdout1_58ck1950 FIND v(dout1_58) AT=1960.05n

.meas tran vdout1_59ck1950 FIND v(dout1_59) AT=1960.05n

.meas tran vdout1_60ck1950 FIND v(dout1_60) AT=1960.05n

.meas tran vdout1_61ck1950 FIND v(dout1_61) AT=1960.05n

.meas tran vdout1_62ck1950 FIND v(dout1_62) AT=1960.05n

.meas tran vdout1_63ck1950 FIND v(dout1_63) AT=1960.05n

.meas tran vdout0_0ck1960 FIND v(dout0_0) AT=1970.05n

.meas tran vdout0_1ck1960 FIND v(dout0_1) AT=1970.05n

.meas tran vdout0_2ck1960 FIND v(dout0_2) AT=1970.05n

.meas tran vdout0_3ck1960 FIND v(dout0_3) AT=1970.05n

.meas tran vdout0_4ck1960 FIND v(dout0_4) AT=1970.05n

.meas tran vdout0_5ck1960 FIND v(dout0_5) AT=1970.05n

.meas tran vdout0_6ck1960 FIND v(dout0_6) AT=1970.05n

.meas tran vdout0_7ck1960 FIND v(dout0_7) AT=1970.05n

.meas tran vdout0_8ck1960 FIND v(dout0_8) AT=1970.05n

.meas tran vdout0_9ck1960 FIND v(dout0_9) AT=1970.05n

.meas tran vdout0_10ck1960 FIND v(dout0_10) AT=1970.05n

.meas tran vdout0_11ck1960 FIND v(dout0_11) AT=1970.05n

.meas tran vdout0_12ck1960 FIND v(dout0_12) AT=1970.05n

.meas tran vdout0_13ck1960 FIND v(dout0_13) AT=1970.05n

.meas tran vdout0_14ck1960 FIND v(dout0_14) AT=1970.05n

.meas tran vdout0_15ck1960 FIND v(dout0_15) AT=1970.05n

.meas tran vdout0_16ck1960 FIND v(dout0_16) AT=1970.05n

.meas tran vdout0_17ck1960 FIND v(dout0_17) AT=1970.05n

.meas tran vdout0_18ck1960 FIND v(dout0_18) AT=1970.05n

.meas tran vdout0_19ck1960 FIND v(dout0_19) AT=1970.05n

.meas tran vdout0_20ck1960 FIND v(dout0_20) AT=1970.05n

.meas tran vdout0_21ck1960 FIND v(dout0_21) AT=1970.05n

.meas tran vdout0_22ck1960 FIND v(dout0_22) AT=1970.05n

.meas tran vdout0_23ck1960 FIND v(dout0_23) AT=1970.05n

.meas tran vdout0_24ck1960 FIND v(dout0_24) AT=1970.05n

.meas tran vdout0_25ck1960 FIND v(dout0_25) AT=1970.05n

.meas tran vdout0_26ck1960 FIND v(dout0_26) AT=1970.05n

.meas tran vdout0_27ck1960 FIND v(dout0_27) AT=1970.05n

.meas tran vdout0_28ck1960 FIND v(dout0_28) AT=1970.05n

.meas tran vdout0_29ck1960 FIND v(dout0_29) AT=1970.05n

.meas tran vdout0_30ck1960 FIND v(dout0_30) AT=1970.05n

.meas tran vdout0_31ck1960 FIND v(dout0_31) AT=1970.05n

.meas tran vdout0_32ck1960 FIND v(dout0_32) AT=1970.05n

.meas tran vdout0_33ck1960 FIND v(dout0_33) AT=1970.05n

.meas tran vdout0_34ck1960 FIND v(dout0_34) AT=1970.05n

.meas tran vdout0_35ck1960 FIND v(dout0_35) AT=1970.05n

.meas tran vdout0_36ck1960 FIND v(dout0_36) AT=1970.05n

.meas tran vdout0_37ck1960 FIND v(dout0_37) AT=1970.05n

.meas tran vdout0_38ck1960 FIND v(dout0_38) AT=1970.05n

.meas tran vdout0_39ck1960 FIND v(dout0_39) AT=1970.05n

.meas tran vdout0_40ck1960 FIND v(dout0_40) AT=1970.05n

.meas tran vdout0_41ck1960 FIND v(dout0_41) AT=1970.05n

.meas tran vdout0_42ck1960 FIND v(dout0_42) AT=1970.05n

.meas tran vdout0_43ck1960 FIND v(dout0_43) AT=1970.05n

.meas tran vdout0_44ck1960 FIND v(dout0_44) AT=1970.05n

.meas tran vdout0_45ck1960 FIND v(dout0_45) AT=1970.05n

.meas tran vdout0_46ck1960 FIND v(dout0_46) AT=1970.05n

.meas tran vdout0_47ck1960 FIND v(dout0_47) AT=1970.05n

.meas tran vdout0_48ck1960 FIND v(dout0_48) AT=1970.05n

.meas tran vdout0_49ck1960 FIND v(dout0_49) AT=1970.05n

.meas tran vdout0_50ck1960 FIND v(dout0_50) AT=1970.05n

.meas tran vdout0_51ck1960 FIND v(dout0_51) AT=1970.05n

.meas tran vdout0_52ck1960 FIND v(dout0_52) AT=1970.05n

.meas tran vdout0_53ck1960 FIND v(dout0_53) AT=1970.05n

.meas tran vdout0_54ck1960 FIND v(dout0_54) AT=1970.05n

.meas tran vdout0_55ck1960 FIND v(dout0_55) AT=1970.05n

.meas tran vdout0_56ck1960 FIND v(dout0_56) AT=1970.05n

.meas tran vdout0_57ck1960 FIND v(dout0_57) AT=1970.05n

.meas tran vdout0_58ck1960 FIND v(dout0_58) AT=1970.05n

.meas tran vdout0_59ck1960 FIND v(dout0_59) AT=1970.05n

.meas tran vdout0_60ck1960 FIND v(dout0_60) AT=1970.05n

.meas tran vdout0_61ck1960 FIND v(dout0_61) AT=1970.05n

.meas tran vdout0_62ck1960 FIND v(dout0_62) AT=1970.05n

.meas tran vdout0_63ck1960 FIND v(dout0_63) AT=1970.05n

.meas tran vdout1_0ck1970 FIND v(dout1_0) AT=1980.05n

.meas tran vdout1_1ck1970 FIND v(dout1_1) AT=1980.05n

.meas tran vdout1_2ck1970 FIND v(dout1_2) AT=1980.05n

.meas tran vdout1_3ck1970 FIND v(dout1_3) AT=1980.05n

.meas tran vdout1_4ck1970 FIND v(dout1_4) AT=1980.05n

.meas tran vdout1_5ck1970 FIND v(dout1_5) AT=1980.05n

.meas tran vdout1_6ck1970 FIND v(dout1_6) AT=1980.05n

.meas tran vdout1_7ck1970 FIND v(dout1_7) AT=1980.05n

.meas tran vdout1_8ck1970 FIND v(dout1_8) AT=1980.05n

.meas tran vdout1_9ck1970 FIND v(dout1_9) AT=1980.05n

.meas tran vdout1_10ck1970 FIND v(dout1_10) AT=1980.05n

.meas tran vdout1_11ck1970 FIND v(dout1_11) AT=1980.05n

.meas tran vdout1_12ck1970 FIND v(dout1_12) AT=1980.05n

.meas tran vdout1_13ck1970 FIND v(dout1_13) AT=1980.05n

.meas tran vdout1_14ck1970 FIND v(dout1_14) AT=1980.05n

.meas tran vdout1_15ck1970 FIND v(dout1_15) AT=1980.05n

.meas tran vdout1_16ck1970 FIND v(dout1_16) AT=1980.05n

.meas tran vdout1_17ck1970 FIND v(dout1_17) AT=1980.05n

.meas tran vdout1_18ck1970 FIND v(dout1_18) AT=1980.05n

.meas tran vdout1_19ck1970 FIND v(dout1_19) AT=1980.05n

.meas tran vdout1_20ck1970 FIND v(dout1_20) AT=1980.05n

.meas tran vdout1_21ck1970 FIND v(dout1_21) AT=1980.05n

.meas tran vdout1_22ck1970 FIND v(dout1_22) AT=1980.05n

.meas tran vdout1_23ck1970 FIND v(dout1_23) AT=1980.05n

.meas tran vdout1_24ck1970 FIND v(dout1_24) AT=1980.05n

.meas tran vdout1_25ck1970 FIND v(dout1_25) AT=1980.05n

.meas tran vdout1_26ck1970 FIND v(dout1_26) AT=1980.05n

.meas tran vdout1_27ck1970 FIND v(dout1_27) AT=1980.05n

.meas tran vdout1_28ck1970 FIND v(dout1_28) AT=1980.05n

.meas tran vdout1_29ck1970 FIND v(dout1_29) AT=1980.05n

.meas tran vdout1_30ck1970 FIND v(dout1_30) AT=1980.05n

.meas tran vdout1_31ck1970 FIND v(dout1_31) AT=1980.05n

.meas tran vdout1_32ck1970 FIND v(dout1_32) AT=1980.05n

.meas tran vdout1_33ck1970 FIND v(dout1_33) AT=1980.05n

.meas tran vdout1_34ck1970 FIND v(dout1_34) AT=1980.05n

.meas tran vdout1_35ck1970 FIND v(dout1_35) AT=1980.05n

.meas tran vdout1_36ck1970 FIND v(dout1_36) AT=1980.05n

.meas tran vdout1_37ck1970 FIND v(dout1_37) AT=1980.05n

.meas tran vdout1_38ck1970 FIND v(dout1_38) AT=1980.05n

.meas tran vdout1_39ck1970 FIND v(dout1_39) AT=1980.05n

.meas tran vdout1_40ck1970 FIND v(dout1_40) AT=1980.05n

.meas tran vdout1_41ck1970 FIND v(dout1_41) AT=1980.05n

.meas tran vdout1_42ck1970 FIND v(dout1_42) AT=1980.05n

.meas tran vdout1_43ck1970 FIND v(dout1_43) AT=1980.05n

.meas tran vdout1_44ck1970 FIND v(dout1_44) AT=1980.05n

.meas tran vdout1_45ck1970 FIND v(dout1_45) AT=1980.05n

.meas tran vdout1_46ck1970 FIND v(dout1_46) AT=1980.05n

.meas tran vdout1_47ck1970 FIND v(dout1_47) AT=1980.05n

.meas tran vdout1_48ck1970 FIND v(dout1_48) AT=1980.05n

.meas tran vdout1_49ck1970 FIND v(dout1_49) AT=1980.05n

.meas tran vdout1_50ck1970 FIND v(dout1_50) AT=1980.05n

.meas tran vdout1_51ck1970 FIND v(dout1_51) AT=1980.05n

.meas tran vdout1_52ck1970 FIND v(dout1_52) AT=1980.05n

.meas tran vdout1_53ck1970 FIND v(dout1_53) AT=1980.05n

.meas tran vdout1_54ck1970 FIND v(dout1_54) AT=1980.05n

.meas tran vdout1_55ck1970 FIND v(dout1_55) AT=1980.05n

.meas tran vdout1_56ck1970 FIND v(dout1_56) AT=1980.05n

.meas tran vdout1_57ck1970 FIND v(dout1_57) AT=1980.05n

.meas tran vdout1_58ck1970 FIND v(dout1_58) AT=1980.05n

.meas tran vdout1_59ck1970 FIND v(dout1_59) AT=1980.05n

.meas tran vdout1_60ck1970 FIND v(dout1_60) AT=1980.05n

.meas tran vdout1_61ck1970 FIND v(dout1_61) AT=1980.05n

.meas tran vdout1_62ck1970 FIND v(dout1_62) AT=1980.05n

.meas tran vdout1_63ck1970 FIND v(dout1_63) AT=1980.05n

.meas tran vdout0_0ck1990 FIND v(dout0_0) AT=2000.05n

.meas tran vdout0_1ck1990 FIND v(dout0_1) AT=2000.05n

.meas tran vdout0_2ck1990 FIND v(dout0_2) AT=2000.05n

.meas tran vdout0_3ck1990 FIND v(dout0_3) AT=2000.05n

.meas tran vdout0_4ck1990 FIND v(dout0_4) AT=2000.05n

.meas tran vdout0_5ck1990 FIND v(dout0_5) AT=2000.05n

.meas tran vdout0_6ck1990 FIND v(dout0_6) AT=2000.05n

.meas tran vdout0_7ck1990 FIND v(dout0_7) AT=2000.05n

.meas tran vdout0_8ck1990 FIND v(dout0_8) AT=2000.05n

.meas tran vdout0_9ck1990 FIND v(dout0_9) AT=2000.05n

.meas tran vdout0_10ck1990 FIND v(dout0_10) AT=2000.05n

.meas tran vdout0_11ck1990 FIND v(dout0_11) AT=2000.05n

.meas tran vdout0_12ck1990 FIND v(dout0_12) AT=2000.05n

.meas tran vdout0_13ck1990 FIND v(dout0_13) AT=2000.05n

.meas tran vdout0_14ck1990 FIND v(dout0_14) AT=2000.05n

.meas tran vdout0_15ck1990 FIND v(dout0_15) AT=2000.05n

.meas tran vdout0_16ck1990 FIND v(dout0_16) AT=2000.05n

.meas tran vdout0_17ck1990 FIND v(dout0_17) AT=2000.05n

.meas tran vdout0_18ck1990 FIND v(dout0_18) AT=2000.05n

.meas tran vdout0_19ck1990 FIND v(dout0_19) AT=2000.05n

.meas tran vdout0_20ck1990 FIND v(dout0_20) AT=2000.05n

.meas tran vdout0_21ck1990 FIND v(dout0_21) AT=2000.05n

.meas tran vdout0_22ck1990 FIND v(dout0_22) AT=2000.05n

.meas tran vdout0_23ck1990 FIND v(dout0_23) AT=2000.05n

.meas tran vdout0_24ck1990 FIND v(dout0_24) AT=2000.05n

.meas tran vdout0_25ck1990 FIND v(dout0_25) AT=2000.05n

.meas tran vdout0_26ck1990 FIND v(dout0_26) AT=2000.05n

.meas tran vdout0_27ck1990 FIND v(dout0_27) AT=2000.05n

.meas tran vdout0_28ck1990 FIND v(dout0_28) AT=2000.05n

.meas tran vdout0_29ck1990 FIND v(dout0_29) AT=2000.05n

.meas tran vdout0_30ck1990 FIND v(dout0_30) AT=2000.05n

.meas tran vdout0_31ck1990 FIND v(dout0_31) AT=2000.05n

.meas tran vdout0_32ck1990 FIND v(dout0_32) AT=2000.05n

.meas tran vdout0_33ck1990 FIND v(dout0_33) AT=2000.05n

.meas tran vdout0_34ck1990 FIND v(dout0_34) AT=2000.05n

.meas tran vdout0_35ck1990 FIND v(dout0_35) AT=2000.05n

.meas tran vdout0_36ck1990 FIND v(dout0_36) AT=2000.05n

.meas tran vdout0_37ck1990 FIND v(dout0_37) AT=2000.05n

.meas tran vdout0_38ck1990 FIND v(dout0_38) AT=2000.05n

.meas tran vdout0_39ck1990 FIND v(dout0_39) AT=2000.05n

.meas tran vdout0_40ck1990 FIND v(dout0_40) AT=2000.05n

.meas tran vdout0_41ck1990 FIND v(dout0_41) AT=2000.05n

.meas tran vdout0_42ck1990 FIND v(dout0_42) AT=2000.05n

.meas tran vdout0_43ck1990 FIND v(dout0_43) AT=2000.05n

.meas tran vdout0_44ck1990 FIND v(dout0_44) AT=2000.05n

.meas tran vdout0_45ck1990 FIND v(dout0_45) AT=2000.05n

.meas tran vdout0_46ck1990 FIND v(dout0_46) AT=2000.05n

.meas tran vdout0_47ck1990 FIND v(dout0_47) AT=2000.05n

.meas tran vdout0_48ck1990 FIND v(dout0_48) AT=2000.05n

.meas tran vdout0_49ck1990 FIND v(dout0_49) AT=2000.05n

.meas tran vdout0_50ck1990 FIND v(dout0_50) AT=2000.05n

.meas tran vdout0_51ck1990 FIND v(dout0_51) AT=2000.05n

.meas tran vdout0_52ck1990 FIND v(dout0_52) AT=2000.05n

.meas tran vdout0_53ck1990 FIND v(dout0_53) AT=2000.05n

.meas tran vdout0_54ck1990 FIND v(dout0_54) AT=2000.05n

.meas tran vdout0_55ck1990 FIND v(dout0_55) AT=2000.05n

.meas tran vdout0_56ck1990 FIND v(dout0_56) AT=2000.05n

.meas tran vdout0_57ck1990 FIND v(dout0_57) AT=2000.05n

.meas tran vdout0_58ck1990 FIND v(dout0_58) AT=2000.05n

.meas tran vdout0_59ck1990 FIND v(dout0_59) AT=2000.05n

.meas tran vdout0_60ck1990 FIND v(dout0_60) AT=2000.05n

.meas tran vdout0_61ck1990 FIND v(dout0_61) AT=2000.05n

.meas tran vdout0_62ck1990 FIND v(dout0_62) AT=2000.05n

.meas tran vdout0_63ck1990 FIND v(dout0_63) AT=2000.05n

.meas tran vdout1_0ck1990 FIND v(dout1_0) AT=2000.05n

.meas tran vdout1_1ck1990 FIND v(dout1_1) AT=2000.05n

.meas tran vdout1_2ck1990 FIND v(dout1_2) AT=2000.05n

.meas tran vdout1_3ck1990 FIND v(dout1_3) AT=2000.05n

.meas tran vdout1_4ck1990 FIND v(dout1_4) AT=2000.05n

.meas tran vdout1_5ck1990 FIND v(dout1_5) AT=2000.05n

.meas tran vdout1_6ck1990 FIND v(dout1_6) AT=2000.05n

.meas tran vdout1_7ck1990 FIND v(dout1_7) AT=2000.05n

.meas tran vdout1_8ck1990 FIND v(dout1_8) AT=2000.05n

.meas tran vdout1_9ck1990 FIND v(dout1_9) AT=2000.05n

.meas tran vdout1_10ck1990 FIND v(dout1_10) AT=2000.05n

.meas tran vdout1_11ck1990 FIND v(dout1_11) AT=2000.05n

.meas tran vdout1_12ck1990 FIND v(dout1_12) AT=2000.05n

.meas tran vdout1_13ck1990 FIND v(dout1_13) AT=2000.05n

.meas tran vdout1_14ck1990 FIND v(dout1_14) AT=2000.05n

.meas tran vdout1_15ck1990 FIND v(dout1_15) AT=2000.05n

.meas tran vdout1_16ck1990 FIND v(dout1_16) AT=2000.05n

.meas tran vdout1_17ck1990 FIND v(dout1_17) AT=2000.05n

.meas tran vdout1_18ck1990 FIND v(dout1_18) AT=2000.05n

.meas tran vdout1_19ck1990 FIND v(dout1_19) AT=2000.05n

.meas tran vdout1_20ck1990 FIND v(dout1_20) AT=2000.05n

.meas tran vdout1_21ck1990 FIND v(dout1_21) AT=2000.05n

.meas tran vdout1_22ck1990 FIND v(dout1_22) AT=2000.05n

.meas tran vdout1_23ck1990 FIND v(dout1_23) AT=2000.05n

.meas tran vdout1_24ck1990 FIND v(dout1_24) AT=2000.05n

.meas tran vdout1_25ck1990 FIND v(dout1_25) AT=2000.05n

.meas tran vdout1_26ck1990 FIND v(dout1_26) AT=2000.05n

.meas tran vdout1_27ck1990 FIND v(dout1_27) AT=2000.05n

.meas tran vdout1_28ck1990 FIND v(dout1_28) AT=2000.05n

.meas tran vdout1_29ck1990 FIND v(dout1_29) AT=2000.05n

.meas tran vdout1_30ck1990 FIND v(dout1_30) AT=2000.05n

.meas tran vdout1_31ck1990 FIND v(dout1_31) AT=2000.05n

.meas tran vdout1_32ck1990 FIND v(dout1_32) AT=2000.05n

.meas tran vdout1_33ck1990 FIND v(dout1_33) AT=2000.05n

.meas tran vdout1_34ck1990 FIND v(dout1_34) AT=2000.05n

.meas tran vdout1_35ck1990 FIND v(dout1_35) AT=2000.05n

.meas tran vdout1_36ck1990 FIND v(dout1_36) AT=2000.05n

.meas tran vdout1_37ck1990 FIND v(dout1_37) AT=2000.05n

.meas tran vdout1_38ck1990 FIND v(dout1_38) AT=2000.05n

.meas tran vdout1_39ck1990 FIND v(dout1_39) AT=2000.05n

.meas tran vdout1_40ck1990 FIND v(dout1_40) AT=2000.05n

.meas tran vdout1_41ck1990 FIND v(dout1_41) AT=2000.05n

.meas tran vdout1_42ck1990 FIND v(dout1_42) AT=2000.05n

.meas tran vdout1_43ck1990 FIND v(dout1_43) AT=2000.05n

.meas tran vdout1_44ck1990 FIND v(dout1_44) AT=2000.05n

.meas tran vdout1_45ck1990 FIND v(dout1_45) AT=2000.05n

.meas tran vdout1_46ck1990 FIND v(dout1_46) AT=2000.05n

.meas tran vdout1_47ck1990 FIND v(dout1_47) AT=2000.05n

.meas tran vdout1_48ck1990 FIND v(dout1_48) AT=2000.05n

.meas tran vdout1_49ck1990 FIND v(dout1_49) AT=2000.05n

.meas tran vdout1_50ck1990 FIND v(dout1_50) AT=2000.05n

.meas tran vdout1_51ck1990 FIND v(dout1_51) AT=2000.05n

.meas tran vdout1_52ck1990 FIND v(dout1_52) AT=2000.05n

.meas tran vdout1_53ck1990 FIND v(dout1_53) AT=2000.05n

.meas tran vdout1_54ck1990 FIND v(dout1_54) AT=2000.05n

.meas tran vdout1_55ck1990 FIND v(dout1_55) AT=2000.05n

.meas tran vdout1_56ck1990 FIND v(dout1_56) AT=2000.05n

.meas tran vdout1_57ck1990 FIND v(dout1_57) AT=2000.05n

.meas tran vdout1_58ck1990 FIND v(dout1_58) AT=2000.05n

.meas tran vdout1_59ck1990 FIND v(dout1_59) AT=2000.05n

.meas tran vdout1_60ck1990 FIND v(dout1_60) AT=2000.05n

.meas tran vdout1_61ck1990 FIND v(dout1_61) AT=2000.05n

.meas tran vdout1_62ck1990 FIND v(dout1_62) AT=2000.05n

.meas tran vdout1_63ck1990 FIND v(dout1_63) AT=2000.05n

.meas tran vdout1_0ck2000 FIND v(dout1_0) AT=2010.05n

.meas tran vdout1_1ck2000 FIND v(dout1_1) AT=2010.05n

.meas tran vdout1_2ck2000 FIND v(dout1_2) AT=2010.05n

.meas tran vdout1_3ck2000 FIND v(dout1_3) AT=2010.05n

.meas tran vdout1_4ck2000 FIND v(dout1_4) AT=2010.05n

.meas tran vdout1_5ck2000 FIND v(dout1_5) AT=2010.05n

.meas tran vdout1_6ck2000 FIND v(dout1_6) AT=2010.05n

.meas tran vdout1_7ck2000 FIND v(dout1_7) AT=2010.05n

.meas tran vdout1_8ck2000 FIND v(dout1_8) AT=2010.05n

.meas tran vdout1_9ck2000 FIND v(dout1_9) AT=2010.05n

.meas tran vdout1_10ck2000 FIND v(dout1_10) AT=2010.05n

.meas tran vdout1_11ck2000 FIND v(dout1_11) AT=2010.05n

.meas tran vdout1_12ck2000 FIND v(dout1_12) AT=2010.05n

.meas tran vdout1_13ck2000 FIND v(dout1_13) AT=2010.05n

.meas tran vdout1_14ck2000 FIND v(dout1_14) AT=2010.05n

.meas tran vdout1_15ck2000 FIND v(dout1_15) AT=2010.05n

.meas tran vdout1_16ck2000 FIND v(dout1_16) AT=2010.05n

.meas tran vdout1_17ck2000 FIND v(dout1_17) AT=2010.05n

.meas tran vdout1_18ck2000 FIND v(dout1_18) AT=2010.05n

.meas tran vdout1_19ck2000 FIND v(dout1_19) AT=2010.05n

.meas tran vdout1_20ck2000 FIND v(dout1_20) AT=2010.05n

.meas tran vdout1_21ck2000 FIND v(dout1_21) AT=2010.05n

.meas tran vdout1_22ck2000 FIND v(dout1_22) AT=2010.05n

.meas tran vdout1_23ck2000 FIND v(dout1_23) AT=2010.05n

.meas tran vdout1_24ck2000 FIND v(dout1_24) AT=2010.05n

.meas tran vdout1_25ck2000 FIND v(dout1_25) AT=2010.05n

.meas tran vdout1_26ck2000 FIND v(dout1_26) AT=2010.05n

.meas tran vdout1_27ck2000 FIND v(dout1_27) AT=2010.05n

.meas tran vdout1_28ck2000 FIND v(dout1_28) AT=2010.05n

.meas tran vdout1_29ck2000 FIND v(dout1_29) AT=2010.05n

.meas tran vdout1_30ck2000 FIND v(dout1_30) AT=2010.05n

.meas tran vdout1_31ck2000 FIND v(dout1_31) AT=2010.05n

.meas tran vdout1_32ck2000 FIND v(dout1_32) AT=2010.05n

.meas tran vdout1_33ck2000 FIND v(dout1_33) AT=2010.05n

.meas tran vdout1_34ck2000 FIND v(dout1_34) AT=2010.05n

.meas tran vdout1_35ck2000 FIND v(dout1_35) AT=2010.05n

.meas tran vdout1_36ck2000 FIND v(dout1_36) AT=2010.05n

.meas tran vdout1_37ck2000 FIND v(dout1_37) AT=2010.05n

.meas tran vdout1_38ck2000 FIND v(dout1_38) AT=2010.05n

.meas tran vdout1_39ck2000 FIND v(dout1_39) AT=2010.05n

.meas tran vdout1_40ck2000 FIND v(dout1_40) AT=2010.05n

.meas tran vdout1_41ck2000 FIND v(dout1_41) AT=2010.05n

.meas tran vdout1_42ck2000 FIND v(dout1_42) AT=2010.05n

.meas tran vdout1_43ck2000 FIND v(dout1_43) AT=2010.05n

.meas tran vdout1_44ck2000 FIND v(dout1_44) AT=2010.05n

.meas tran vdout1_45ck2000 FIND v(dout1_45) AT=2010.05n

.meas tran vdout1_46ck2000 FIND v(dout1_46) AT=2010.05n

.meas tran vdout1_47ck2000 FIND v(dout1_47) AT=2010.05n

.meas tran vdout1_48ck2000 FIND v(dout1_48) AT=2010.05n

.meas tran vdout1_49ck2000 FIND v(dout1_49) AT=2010.05n

.meas tran vdout1_50ck2000 FIND v(dout1_50) AT=2010.05n

.meas tran vdout1_51ck2000 FIND v(dout1_51) AT=2010.05n

.meas tran vdout1_52ck2000 FIND v(dout1_52) AT=2010.05n

.meas tran vdout1_53ck2000 FIND v(dout1_53) AT=2010.05n

.meas tran vdout1_54ck2000 FIND v(dout1_54) AT=2010.05n

.meas tran vdout1_55ck2000 FIND v(dout1_55) AT=2010.05n

.meas tran vdout1_56ck2000 FIND v(dout1_56) AT=2010.05n

.meas tran vdout1_57ck2000 FIND v(dout1_57) AT=2010.05n

.meas tran vdout1_58ck2000 FIND v(dout1_58) AT=2010.05n

.meas tran vdout1_59ck2000 FIND v(dout1_59) AT=2010.05n

.meas tran vdout1_60ck2000 FIND v(dout1_60) AT=2010.05n

.meas tran vdout1_61ck2000 FIND v(dout1_61) AT=2010.05n

.meas tran vdout1_62ck2000 FIND v(dout1_62) AT=2010.05n

.meas tran vdout1_63ck2000 FIND v(dout1_63) AT=2010.05n

.meas tran vdout1_0ck2010 FIND v(dout1_0) AT=2020.05n

.meas tran vdout1_1ck2010 FIND v(dout1_1) AT=2020.05n

.meas tran vdout1_2ck2010 FIND v(dout1_2) AT=2020.05n

.meas tran vdout1_3ck2010 FIND v(dout1_3) AT=2020.05n

.meas tran vdout1_4ck2010 FIND v(dout1_4) AT=2020.05n

.meas tran vdout1_5ck2010 FIND v(dout1_5) AT=2020.05n

.meas tran vdout1_6ck2010 FIND v(dout1_6) AT=2020.05n

.meas tran vdout1_7ck2010 FIND v(dout1_7) AT=2020.05n

.meas tran vdout1_8ck2010 FIND v(dout1_8) AT=2020.05n

.meas tran vdout1_9ck2010 FIND v(dout1_9) AT=2020.05n

.meas tran vdout1_10ck2010 FIND v(dout1_10) AT=2020.05n

.meas tran vdout1_11ck2010 FIND v(dout1_11) AT=2020.05n

.meas tran vdout1_12ck2010 FIND v(dout1_12) AT=2020.05n

.meas tran vdout1_13ck2010 FIND v(dout1_13) AT=2020.05n

.meas tran vdout1_14ck2010 FIND v(dout1_14) AT=2020.05n

.meas tran vdout1_15ck2010 FIND v(dout1_15) AT=2020.05n

.meas tran vdout1_16ck2010 FIND v(dout1_16) AT=2020.05n

.meas tran vdout1_17ck2010 FIND v(dout1_17) AT=2020.05n

.meas tran vdout1_18ck2010 FIND v(dout1_18) AT=2020.05n

.meas tran vdout1_19ck2010 FIND v(dout1_19) AT=2020.05n

.meas tran vdout1_20ck2010 FIND v(dout1_20) AT=2020.05n

.meas tran vdout1_21ck2010 FIND v(dout1_21) AT=2020.05n

.meas tran vdout1_22ck2010 FIND v(dout1_22) AT=2020.05n

.meas tran vdout1_23ck2010 FIND v(dout1_23) AT=2020.05n

.meas tran vdout1_24ck2010 FIND v(dout1_24) AT=2020.05n

.meas tran vdout1_25ck2010 FIND v(dout1_25) AT=2020.05n

.meas tran vdout1_26ck2010 FIND v(dout1_26) AT=2020.05n

.meas tran vdout1_27ck2010 FIND v(dout1_27) AT=2020.05n

.meas tran vdout1_28ck2010 FIND v(dout1_28) AT=2020.05n

.meas tran vdout1_29ck2010 FIND v(dout1_29) AT=2020.05n

.meas tran vdout1_30ck2010 FIND v(dout1_30) AT=2020.05n

.meas tran vdout1_31ck2010 FIND v(dout1_31) AT=2020.05n

.meas tran vdout1_32ck2010 FIND v(dout1_32) AT=2020.05n

.meas tran vdout1_33ck2010 FIND v(dout1_33) AT=2020.05n

.meas tran vdout1_34ck2010 FIND v(dout1_34) AT=2020.05n

.meas tran vdout1_35ck2010 FIND v(dout1_35) AT=2020.05n

.meas tran vdout1_36ck2010 FIND v(dout1_36) AT=2020.05n

.meas tran vdout1_37ck2010 FIND v(dout1_37) AT=2020.05n

.meas tran vdout1_38ck2010 FIND v(dout1_38) AT=2020.05n

.meas tran vdout1_39ck2010 FIND v(dout1_39) AT=2020.05n

.meas tran vdout1_40ck2010 FIND v(dout1_40) AT=2020.05n

.meas tran vdout1_41ck2010 FIND v(dout1_41) AT=2020.05n

.meas tran vdout1_42ck2010 FIND v(dout1_42) AT=2020.05n

.meas tran vdout1_43ck2010 FIND v(dout1_43) AT=2020.05n

.meas tran vdout1_44ck2010 FIND v(dout1_44) AT=2020.05n

.meas tran vdout1_45ck2010 FIND v(dout1_45) AT=2020.05n

.meas tran vdout1_46ck2010 FIND v(dout1_46) AT=2020.05n

.meas tran vdout1_47ck2010 FIND v(dout1_47) AT=2020.05n

.meas tran vdout1_48ck2010 FIND v(dout1_48) AT=2020.05n

.meas tran vdout1_49ck2010 FIND v(dout1_49) AT=2020.05n

.meas tran vdout1_50ck2010 FIND v(dout1_50) AT=2020.05n

.meas tran vdout1_51ck2010 FIND v(dout1_51) AT=2020.05n

.meas tran vdout1_52ck2010 FIND v(dout1_52) AT=2020.05n

.meas tran vdout1_53ck2010 FIND v(dout1_53) AT=2020.05n

.meas tran vdout1_54ck2010 FIND v(dout1_54) AT=2020.05n

.meas tran vdout1_55ck2010 FIND v(dout1_55) AT=2020.05n

.meas tran vdout1_56ck2010 FIND v(dout1_56) AT=2020.05n

.meas tran vdout1_57ck2010 FIND v(dout1_57) AT=2020.05n

.meas tran vdout1_58ck2010 FIND v(dout1_58) AT=2020.05n

.meas tran vdout1_59ck2010 FIND v(dout1_59) AT=2020.05n

.meas tran vdout1_60ck2010 FIND v(dout1_60) AT=2020.05n

.meas tran vdout1_61ck2010 FIND v(dout1_61) AT=2020.05n

.meas tran vdout1_62ck2010 FIND v(dout1_62) AT=2020.05n

.meas tran vdout1_63ck2010 FIND v(dout1_63) AT=2020.05n

.meas tran vdout0_0ck2020 FIND v(dout0_0) AT=2030.05n

.meas tran vdout0_1ck2020 FIND v(dout0_1) AT=2030.05n

.meas tran vdout0_2ck2020 FIND v(dout0_2) AT=2030.05n

.meas tran vdout0_3ck2020 FIND v(dout0_3) AT=2030.05n

.meas tran vdout0_4ck2020 FIND v(dout0_4) AT=2030.05n

.meas tran vdout0_5ck2020 FIND v(dout0_5) AT=2030.05n

.meas tran vdout0_6ck2020 FIND v(dout0_6) AT=2030.05n

.meas tran vdout0_7ck2020 FIND v(dout0_7) AT=2030.05n

.meas tran vdout0_8ck2020 FIND v(dout0_8) AT=2030.05n

.meas tran vdout0_9ck2020 FIND v(dout0_9) AT=2030.05n

.meas tran vdout0_10ck2020 FIND v(dout0_10) AT=2030.05n

.meas tran vdout0_11ck2020 FIND v(dout0_11) AT=2030.05n

.meas tran vdout0_12ck2020 FIND v(dout0_12) AT=2030.05n

.meas tran vdout0_13ck2020 FIND v(dout0_13) AT=2030.05n

.meas tran vdout0_14ck2020 FIND v(dout0_14) AT=2030.05n

.meas tran vdout0_15ck2020 FIND v(dout0_15) AT=2030.05n

.meas tran vdout0_16ck2020 FIND v(dout0_16) AT=2030.05n

.meas tran vdout0_17ck2020 FIND v(dout0_17) AT=2030.05n

.meas tran vdout0_18ck2020 FIND v(dout0_18) AT=2030.05n

.meas tran vdout0_19ck2020 FIND v(dout0_19) AT=2030.05n

.meas tran vdout0_20ck2020 FIND v(dout0_20) AT=2030.05n

.meas tran vdout0_21ck2020 FIND v(dout0_21) AT=2030.05n

.meas tran vdout0_22ck2020 FIND v(dout0_22) AT=2030.05n

.meas tran vdout0_23ck2020 FIND v(dout0_23) AT=2030.05n

.meas tran vdout0_24ck2020 FIND v(dout0_24) AT=2030.05n

.meas tran vdout0_25ck2020 FIND v(dout0_25) AT=2030.05n

.meas tran vdout0_26ck2020 FIND v(dout0_26) AT=2030.05n

.meas tran vdout0_27ck2020 FIND v(dout0_27) AT=2030.05n

.meas tran vdout0_28ck2020 FIND v(dout0_28) AT=2030.05n

.meas tran vdout0_29ck2020 FIND v(dout0_29) AT=2030.05n

.meas tran vdout0_30ck2020 FIND v(dout0_30) AT=2030.05n

.meas tran vdout0_31ck2020 FIND v(dout0_31) AT=2030.05n

.meas tran vdout0_32ck2020 FIND v(dout0_32) AT=2030.05n

.meas tran vdout0_33ck2020 FIND v(dout0_33) AT=2030.05n

.meas tran vdout0_34ck2020 FIND v(dout0_34) AT=2030.05n

.meas tran vdout0_35ck2020 FIND v(dout0_35) AT=2030.05n

.meas tran vdout0_36ck2020 FIND v(dout0_36) AT=2030.05n

.meas tran vdout0_37ck2020 FIND v(dout0_37) AT=2030.05n

.meas tran vdout0_38ck2020 FIND v(dout0_38) AT=2030.05n

.meas tran vdout0_39ck2020 FIND v(dout0_39) AT=2030.05n

.meas tran vdout0_40ck2020 FIND v(dout0_40) AT=2030.05n

.meas tran vdout0_41ck2020 FIND v(dout0_41) AT=2030.05n

.meas tran vdout0_42ck2020 FIND v(dout0_42) AT=2030.05n

.meas tran vdout0_43ck2020 FIND v(dout0_43) AT=2030.05n

.meas tran vdout0_44ck2020 FIND v(dout0_44) AT=2030.05n

.meas tran vdout0_45ck2020 FIND v(dout0_45) AT=2030.05n

.meas tran vdout0_46ck2020 FIND v(dout0_46) AT=2030.05n

.meas tran vdout0_47ck2020 FIND v(dout0_47) AT=2030.05n

.meas tran vdout0_48ck2020 FIND v(dout0_48) AT=2030.05n

.meas tran vdout0_49ck2020 FIND v(dout0_49) AT=2030.05n

.meas tran vdout0_50ck2020 FIND v(dout0_50) AT=2030.05n

.meas tran vdout0_51ck2020 FIND v(dout0_51) AT=2030.05n

.meas tran vdout0_52ck2020 FIND v(dout0_52) AT=2030.05n

.meas tran vdout0_53ck2020 FIND v(dout0_53) AT=2030.05n

.meas tran vdout0_54ck2020 FIND v(dout0_54) AT=2030.05n

.meas tran vdout0_55ck2020 FIND v(dout0_55) AT=2030.05n

.meas tran vdout0_56ck2020 FIND v(dout0_56) AT=2030.05n

.meas tran vdout0_57ck2020 FIND v(dout0_57) AT=2030.05n

.meas tran vdout0_58ck2020 FIND v(dout0_58) AT=2030.05n

.meas tran vdout0_59ck2020 FIND v(dout0_59) AT=2030.05n

.meas tran vdout0_60ck2020 FIND v(dout0_60) AT=2030.05n

.meas tran vdout0_61ck2020 FIND v(dout0_61) AT=2030.05n

.meas tran vdout0_62ck2020 FIND v(dout0_62) AT=2030.05n

.meas tran vdout0_63ck2020 FIND v(dout0_63) AT=2030.05n

.meas tran vdout1_0ck2020 FIND v(dout1_0) AT=2030.05n

.meas tran vdout1_1ck2020 FIND v(dout1_1) AT=2030.05n

.meas tran vdout1_2ck2020 FIND v(dout1_2) AT=2030.05n

.meas tran vdout1_3ck2020 FIND v(dout1_3) AT=2030.05n

.meas tran vdout1_4ck2020 FIND v(dout1_4) AT=2030.05n

.meas tran vdout1_5ck2020 FIND v(dout1_5) AT=2030.05n

.meas tran vdout1_6ck2020 FIND v(dout1_6) AT=2030.05n

.meas tran vdout1_7ck2020 FIND v(dout1_7) AT=2030.05n

.meas tran vdout1_8ck2020 FIND v(dout1_8) AT=2030.05n

.meas tran vdout1_9ck2020 FIND v(dout1_9) AT=2030.05n

.meas tran vdout1_10ck2020 FIND v(dout1_10) AT=2030.05n

.meas tran vdout1_11ck2020 FIND v(dout1_11) AT=2030.05n

.meas tran vdout1_12ck2020 FIND v(dout1_12) AT=2030.05n

.meas tran vdout1_13ck2020 FIND v(dout1_13) AT=2030.05n

.meas tran vdout1_14ck2020 FIND v(dout1_14) AT=2030.05n

.meas tran vdout1_15ck2020 FIND v(dout1_15) AT=2030.05n

.meas tran vdout1_16ck2020 FIND v(dout1_16) AT=2030.05n

.meas tran vdout1_17ck2020 FIND v(dout1_17) AT=2030.05n

.meas tran vdout1_18ck2020 FIND v(dout1_18) AT=2030.05n

.meas tran vdout1_19ck2020 FIND v(dout1_19) AT=2030.05n

.meas tran vdout1_20ck2020 FIND v(dout1_20) AT=2030.05n

.meas tran vdout1_21ck2020 FIND v(dout1_21) AT=2030.05n

.meas tran vdout1_22ck2020 FIND v(dout1_22) AT=2030.05n

.meas tran vdout1_23ck2020 FIND v(dout1_23) AT=2030.05n

.meas tran vdout1_24ck2020 FIND v(dout1_24) AT=2030.05n

.meas tran vdout1_25ck2020 FIND v(dout1_25) AT=2030.05n

.meas tran vdout1_26ck2020 FIND v(dout1_26) AT=2030.05n

.meas tran vdout1_27ck2020 FIND v(dout1_27) AT=2030.05n

.meas tran vdout1_28ck2020 FIND v(dout1_28) AT=2030.05n

.meas tran vdout1_29ck2020 FIND v(dout1_29) AT=2030.05n

.meas tran vdout1_30ck2020 FIND v(dout1_30) AT=2030.05n

.meas tran vdout1_31ck2020 FIND v(dout1_31) AT=2030.05n

.meas tran vdout1_32ck2020 FIND v(dout1_32) AT=2030.05n

.meas tran vdout1_33ck2020 FIND v(dout1_33) AT=2030.05n

.meas tran vdout1_34ck2020 FIND v(dout1_34) AT=2030.05n

.meas tran vdout1_35ck2020 FIND v(dout1_35) AT=2030.05n

.meas tran vdout1_36ck2020 FIND v(dout1_36) AT=2030.05n

.meas tran vdout1_37ck2020 FIND v(dout1_37) AT=2030.05n

.meas tran vdout1_38ck2020 FIND v(dout1_38) AT=2030.05n

.meas tran vdout1_39ck2020 FIND v(dout1_39) AT=2030.05n

.meas tran vdout1_40ck2020 FIND v(dout1_40) AT=2030.05n

.meas tran vdout1_41ck2020 FIND v(dout1_41) AT=2030.05n

.meas tran vdout1_42ck2020 FIND v(dout1_42) AT=2030.05n

.meas tran vdout1_43ck2020 FIND v(dout1_43) AT=2030.05n

.meas tran vdout1_44ck2020 FIND v(dout1_44) AT=2030.05n

.meas tran vdout1_45ck2020 FIND v(dout1_45) AT=2030.05n

.meas tran vdout1_46ck2020 FIND v(dout1_46) AT=2030.05n

.meas tran vdout1_47ck2020 FIND v(dout1_47) AT=2030.05n

.meas tran vdout1_48ck2020 FIND v(dout1_48) AT=2030.05n

.meas tran vdout1_49ck2020 FIND v(dout1_49) AT=2030.05n

.meas tran vdout1_50ck2020 FIND v(dout1_50) AT=2030.05n

.meas tran vdout1_51ck2020 FIND v(dout1_51) AT=2030.05n

.meas tran vdout1_52ck2020 FIND v(dout1_52) AT=2030.05n

.meas tran vdout1_53ck2020 FIND v(dout1_53) AT=2030.05n

.meas tran vdout1_54ck2020 FIND v(dout1_54) AT=2030.05n

.meas tran vdout1_55ck2020 FIND v(dout1_55) AT=2030.05n

.meas tran vdout1_56ck2020 FIND v(dout1_56) AT=2030.05n

.meas tran vdout1_57ck2020 FIND v(dout1_57) AT=2030.05n

.meas tran vdout1_58ck2020 FIND v(dout1_58) AT=2030.05n

.meas tran vdout1_59ck2020 FIND v(dout1_59) AT=2030.05n

.meas tran vdout1_60ck2020 FIND v(dout1_60) AT=2030.05n

.meas tran vdout1_61ck2020 FIND v(dout1_61) AT=2030.05n

.meas tran vdout1_62ck2020 FIND v(dout1_62) AT=2030.05n

.meas tran vdout1_63ck2020 FIND v(dout1_63) AT=2030.05n

.meas tran vdout0_0ck2030 FIND v(dout0_0) AT=2040.05n

.meas tran vdout0_1ck2030 FIND v(dout0_1) AT=2040.05n

.meas tran vdout0_2ck2030 FIND v(dout0_2) AT=2040.05n

.meas tran vdout0_3ck2030 FIND v(dout0_3) AT=2040.05n

.meas tran vdout0_4ck2030 FIND v(dout0_4) AT=2040.05n

.meas tran vdout0_5ck2030 FIND v(dout0_5) AT=2040.05n

.meas tran vdout0_6ck2030 FIND v(dout0_6) AT=2040.05n

.meas tran vdout0_7ck2030 FIND v(dout0_7) AT=2040.05n

.meas tran vdout0_8ck2030 FIND v(dout0_8) AT=2040.05n

.meas tran vdout0_9ck2030 FIND v(dout0_9) AT=2040.05n

.meas tran vdout0_10ck2030 FIND v(dout0_10) AT=2040.05n

.meas tran vdout0_11ck2030 FIND v(dout0_11) AT=2040.05n

.meas tran vdout0_12ck2030 FIND v(dout0_12) AT=2040.05n

.meas tran vdout0_13ck2030 FIND v(dout0_13) AT=2040.05n

.meas tran vdout0_14ck2030 FIND v(dout0_14) AT=2040.05n

.meas tran vdout0_15ck2030 FIND v(dout0_15) AT=2040.05n

.meas tran vdout0_16ck2030 FIND v(dout0_16) AT=2040.05n

.meas tran vdout0_17ck2030 FIND v(dout0_17) AT=2040.05n

.meas tran vdout0_18ck2030 FIND v(dout0_18) AT=2040.05n

.meas tran vdout0_19ck2030 FIND v(dout0_19) AT=2040.05n

.meas tran vdout0_20ck2030 FIND v(dout0_20) AT=2040.05n

.meas tran vdout0_21ck2030 FIND v(dout0_21) AT=2040.05n

.meas tran vdout0_22ck2030 FIND v(dout0_22) AT=2040.05n

.meas tran vdout0_23ck2030 FIND v(dout0_23) AT=2040.05n

.meas tran vdout0_24ck2030 FIND v(dout0_24) AT=2040.05n

.meas tran vdout0_25ck2030 FIND v(dout0_25) AT=2040.05n

.meas tran vdout0_26ck2030 FIND v(dout0_26) AT=2040.05n

.meas tran vdout0_27ck2030 FIND v(dout0_27) AT=2040.05n

.meas tran vdout0_28ck2030 FIND v(dout0_28) AT=2040.05n

.meas tran vdout0_29ck2030 FIND v(dout0_29) AT=2040.05n

.meas tran vdout0_30ck2030 FIND v(dout0_30) AT=2040.05n

.meas tran vdout0_31ck2030 FIND v(dout0_31) AT=2040.05n

.meas tran vdout0_32ck2030 FIND v(dout0_32) AT=2040.05n

.meas tran vdout0_33ck2030 FIND v(dout0_33) AT=2040.05n

.meas tran vdout0_34ck2030 FIND v(dout0_34) AT=2040.05n

.meas tran vdout0_35ck2030 FIND v(dout0_35) AT=2040.05n

.meas tran vdout0_36ck2030 FIND v(dout0_36) AT=2040.05n

.meas tran vdout0_37ck2030 FIND v(dout0_37) AT=2040.05n

.meas tran vdout0_38ck2030 FIND v(dout0_38) AT=2040.05n

.meas tran vdout0_39ck2030 FIND v(dout0_39) AT=2040.05n

.meas tran vdout0_40ck2030 FIND v(dout0_40) AT=2040.05n

.meas tran vdout0_41ck2030 FIND v(dout0_41) AT=2040.05n

.meas tran vdout0_42ck2030 FIND v(dout0_42) AT=2040.05n

.meas tran vdout0_43ck2030 FIND v(dout0_43) AT=2040.05n

.meas tran vdout0_44ck2030 FIND v(dout0_44) AT=2040.05n

.meas tran vdout0_45ck2030 FIND v(dout0_45) AT=2040.05n

.meas tran vdout0_46ck2030 FIND v(dout0_46) AT=2040.05n

.meas tran vdout0_47ck2030 FIND v(dout0_47) AT=2040.05n

.meas tran vdout0_48ck2030 FIND v(dout0_48) AT=2040.05n

.meas tran vdout0_49ck2030 FIND v(dout0_49) AT=2040.05n

.meas tran vdout0_50ck2030 FIND v(dout0_50) AT=2040.05n

.meas tran vdout0_51ck2030 FIND v(dout0_51) AT=2040.05n

.meas tran vdout0_52ck2030 FIND v(dout0_52) AT=2040.05n

.meas tran vdout0_53ck2030 FIND v(dout0_53) AT=2040.05n

.meas tran vdout0_54ck2030 FIND v(dout0_54) AT=2040.05n

.meas tran vdout0_55ck2030 FIND v(dout0_55) AT=2040.05n

.meas tran vdout0_56ck2030 FIND v(dout0_56) AT=2040.05n

.meas tran vdout0_57ck2030 FIND v(dout0_57) AT=2040.05n

.meas tran vdout0_58ck2030 FIND v(dout0_58) AT=2040.05n

.meas tran vdout0_59ck2030 FIND v(dout0_59) AT=2040.05n

.meas tran vdout0_60ck2030 FIND v(dout0_60) AT=2040.05n

.meas tran vdout0_61ck2030 FIND v(dout0_61) AT=2040.05n

.meas tran vdout0_62ck2030 FIND v(dout0_62) AT=2040.05n

.meas tran vdout0_63ck2030 FIND v(dout0_63) AT=2040.05n

.meas tran vdout1_0ck2030 FIND v(dout1_0) AT=2040.05n

.meas tran vdout1_1ck2030 FIND v(dout1_1) AT=2040.05n

.meas tran vdout1_2ck2030 FIND v(dout1_2) AT=2040.05n

.meas tran vdout1_3ck2030 FIND v(dout1_3) AT=2040.05n

.meas tran vdout1_4ck2030 FIND v(dout1_4) AT=2040.05n

.meas tran vdout1_5ck2030 FIND v(dout1_5) AT=2040.05n

.meas tran vdout1_6ck2030 FIND v(dout1_6) AT=2040.05n

.meas tran vdout1_7ck2030 FIND v(dout1_7) AT=2040.05n

.meas tran vdout1_8ck2030 FIND v(dout1_8) AT=2040.05n

.meas tran vdout1_9ck2030 FIND v(dout1_9) AT=2040.05n

.meas tran vdout1_10ck2030 FIND v(dout1_10) AT=2040.05n

.meas tran vdout1_11ck2030 FIND v(dout1_11) AT=2040.05n

.meas tran vdout1_12ck2030 FIND v(dout1_12) AT=2040.05n

.meas tran vdout1_13ck2030 FIND v(dout1_13) AT=2040.05n

.meas tran vdout1_14ck2030 FIND v(dout1_14) AT=2040.05n

.meas tran vdout1_15ck2030 FIND v(dout1_15) AT=2040.05n

.meas tran vdout1_16ck2030 FIND v(dout1_16) AT=2040.05n

.meas tran vdout1_17ck2030 FIND v(dout1_17) AT=2040.05n

.meas tran vdout1_18ck2030 FIND v(dout1_18) AT=2040.05n

.meas tran vdout1_19ck2030 FIND v(dout1_19) AT=2040.05n

.meas tran vdout1_20ck2030 FIND v(dout1_20) AT=2040.05n

.meas tran vdout1_21ck2030 FIND v(dout1_21) AT=2040.05n

.meas tran vdout1_22ck2030 FIND v(dout1_22) AT=2040.05n

.meas tran vdout1_23ck2030 FIND v(dout1_23) AT=2040.05n

.meas tran vdout1_24ck2030 FIND v(dout1_24) AT=2040.05n

.meas tran vdout1_25ck2030 FIND v(dout1_25) AT=2040.05n

.meas tran vdout1_26ck2030 FIND v(dout1_26) AT=2040.05n

.meas tran vdout1_27ck2030 FIND v(dout1_27) AT=2040.05n

.meas tran vdout1_28ck2030 FIND v(dout1_28) AT=2040.05n

.meas tran vdout1_29ck2030 FIND v(dout1_29) AT=2040.05n

.meas tran vdout1_30ck2030 FIND v(dout1_30) AT=2040.05n

.meas tran vdout1_31ck2030 FIND v(dout1_31) AT=2040.05n

.meas tran vdout1_32ck2030 FIND v(dout1_32) AT=2040.05n

.meas tran vdout1_33ck2030 FIND v(dout1_33) AT=2040.05n

.meas tran vdout1_34ck2030 FIND v(dout1_34) AT=2040.05n

.meas tran vdout1_35ck2030 FIND v(dout1_35) AT=2040.05n

.meas tran vdout1_36ck2030 FIND v(dout1_36) AT=2040.05n

.meas tran vdout1_37ck2030 FIND v(dout1_37) AT=2040.05n

.meas tran vdout1_38ck2030 FIND v(dout1_38) AT=2040.05n

.meas tran vdout1_39ck2030 FIND v(dout1_39) AT=2040.05n

.meas tran vdout1_40ck2030 FIND v(dout1_40) AT=2040.05n

.meas tran vdout1_41ck2030 FIND v(dout1_41) AT=2040.05n

.meas tran vdout1_42ck2030 FIND v(dout1_42) AT=2040.05n

.meas tran vdout1_43ck2030 FIND v(dout1_43) AT=2040.05n

.meas tran vdout1_44ck2030 FIND v(dout1_44) AT=2040.05n

.meas tran vdout1_45ck2030 FIND v(dout1_45) AT=2040.05n

.meas tran vdout1_46ck2030 FIND v(dout1_46) AT=2040.05n

.meas tran vdout1_47ck2030 FIND v(dout1_47) AT=2040.05n

.meas tran vdout1_48ck2030 FIND v(dout1_48) AT=2040.05n

.meas tran vdout1_49ck2030 FIND v(dout1_49) AT=2040.05n

.meas tran vdout1_50ck2030 FIND v(dout1_50) AT=2040.05n

.meas tran vdout1_51ck2030 FIND v(dout1_51) AT=2040.05n

.meas tran vdout1_52ck2030 FIND v(dout1_52) AT=2040.05n

.meas tran vdout1_53ck2030 FIND v(dout1_53) AT=2040.05n

.meas tran vdout1_54ck2030 FIND v(dout1_54) AT=2040.05n

.meas tran vdout1_55ck2030 FIND v(dout1_55) AT=2040.05n

.meas tran vdout1_56ck2030 FIND v(dout1_56) AT=2040.05n

.meas tran vdout1_57ck2030 FIND v(dout1_57) AT=2040.05n

.meas tran vdout1_58ck2030 FIND v(dout1_58) AT=2040.05n

.meas tran vdout1_59ck2030 FIND v(dout1_59) AT=2040.05n

.meas tran vdout1_60ck2030 FIND v(dout1_60) AT=2040.05n

.meas tran vdout1_61ck2030 FIND v(dout1_61) AT=2040.05n

.meas tran vdout1_62ck2030 FIND v(dout1_62) AT=2040.05n

.meas tran vdout1_63ck2030 FIND v(dout1_63) AT=2040.05n

.meas tran vdout0_0ck2040 FIND v(dout0_0) AT=2050.05n

.meas tran vdout0_1ck2040 FIND v(dout0_1) AT=2050.05n

.meas tran vdout0_2ck2040 FIND v(dout0_2) AT=2050.05n

.meas tran vdout0_3ck2040 FIND v(dout0_3) AT=2050.05n

.meas tran vdout0_4ck2040 FIND v(dout0_4) AT=2050.05n

.meas tran vdout0_5ck2040 FIND v(dout0_5) AT=2050.05n

.meas tran vdout0_6ck2040 FIND v(dout0_6) AT=2050.05n

.meas tran vdout0_7ck2040 FIND v(dout0_7) AT=2050.05n

.meas tran vdout0_8ck2040 FIND v(dout0_8) AT=2050.05n

.meas tran vdout0_9ck2040 FIND v(dout0_9) AT=2050.05n

.meas tran vdout0_10ck2040 FIND v(dout0_10) AT=2050.05n

.meas tran vdout0_11ck2040 FIND v(dout0_11) AT=2050.05n

.meas tran vdout0_12ck2040 FIND v(dout0_12) AT=2050.05n

.meas tran vdout0_13ck2040 FIND v(dout0_13) AT=2050.05n

.meas tran vdout0_14ck2040 FIND v(dout0_14) AT=2050.05n

.meas tran vdout0_15ck2040 FIND v(dout0_15) AT=2050.05n

.meas tran vdout0_16ck2040 FIND v(dout0_16) AT=2050.05n

.meas tran vdout0_17ck2040 FIND v(dout0_17) AT=2050.05n

.meas tran vdout0_18ck2040 FIND v(dout0_18) AT=2050.05n

.meas tran vdout0_19ck2040 FIND v(dout0_19) AT=2050.05n

.meas tran vdout0_20ck2040 FIND v(dout0_20) AT=2050.05n

.meas tran vdout0_21ck2040 FIND v(dout0_21) AT=2050.05n

.meas tran vdout0_22ck2040 FIND v(dout0_22) AT=2050.05n

.meas tran vdout0_23ck2040 FIND v(dout0_23) AT=2050.05n

.meas tran vdout0_24ck2040 FIND v(dout0_24) AT=2050.05n

.meas tran vdout0_25ck2040 FIND v(dout0_25) AT=2050.05n

.meas tran vdout0_26ck2040 FIND v(dout0_26) AT=2050.05n

.meas tran vdout0_27ck2040 FIND v(dout0_27) AT=2050.05n

.meas tran vdout0_28ck2040 FIND v(dout0_28) AT=2050.05n

.meas tran vdout0_29ck2040 FIND v(dout0_29) AT=2050.05n

.meas tran vdout0_30ck2040 FIND v(dout0_30) AT=2050.05n

.meas tran vdout0_31ck2040 FIND v(dout0_31) AT=2050.05n

.meas tran vdout0_32ck2040 FIND v(dout0_32) AT=2050.05n

.meas tran vdout0_33ck2040 FIND v(dout0_33) AT=2050.05n

.meas tran vdout0_34ck2040 FIND v(dout0_34) AT=2050.05n

.meas tran vdout0_35ck2040 FIND v(dout0_35) AT=2050.05n

.meas tran vdout0_36ck2040 FIND v(dout0_36) AT=2050.05n

.meas tran vdout0_37ck2040 FIND v(dout0_37) AT=2050.05n

.meas tran vdout0_38ck2040 FIND v(dout0_38) AT=2050.05n

.meas tran vdout0_39ck2040 FIND v(dout0_39) AT=2050.05n

.meas tran vdout0_40ck2040 FIND v(dout0_40) AT=2050.05n

.meas tran vdout0_41ck2040 FIND v(dout0_41) AT=2050.05n

.meas tran vdout0_42ck2040 FIND v(dout0_42) AT=2050.05n

.meas tran vdout0_43ck2040 FIND v(dout0_43) AT=2050.05n

.meas tran vdout0_44ck2040 FIND v(dout0_44) AT=2050.05n

.meas tran vdout0_45ck2040 FIND v(dout0_45) AT=2050.05n

.meas tran vdout0_46ck2040 FIND v(dout0_46) AT=2050.05n

.meas tran vdout0_47ck2040 FIND v(dout0_47) AT=2050.05n

.meas tran vdout0_48ck2040 FIND v(dout0_48) AT=2050.05n

.meas tran vdout0_49ck2040 FIND v(dout0_49) AT=2050.05n

.meas tran vdout0_50ck2040 FIND v(dout0_50) AT=2050.05n

.meas tran vdout0_51ck2040 FIND v(dout0_51) AT=2050.05n

.meas tran vdout0_52ck2040 FIND v(dout0_52) AT=2050.05n

.meas tran vdout0_53ck2040 FIND v(dout0_53) AT=2050.05n

.meas tran vdout0_54ck2040 FIND v(dout0_54) AT=2050.05n

.meas tran vdout0_55ck2040 FIND v(dout0_55) AT=2050.05n

.meas tran vdout0_56ck2040 FIND v(dout0_56) AT=2050.05n

.meas tran vdout0_57ck2040 FIND v(dout0_57) AT=2050.05n

.meas tran vdout0_58ck2040 FIND v(dout0_58) AT=2050.05n

.meas tran vdout0_59ck2040 FIND v(dout0_59) AT=2050.05n

.meas tran vdout0_60ck2040 FIND v(dout0_60) AT=2050.05n

.meas tran vdout0_61ck2040 FIND v(dout0_61) AT=2050.05n

.meas tran vdout0_62ck2040 FIND v(dout0_62) AT=2050.05n

.meas tran vdout0_63ck2040 FIND v(dout0_63) AT=2050.05n

.meas tran vdout1_0ck2040 FIND v(dout1_0) AT=2050.05n

.meas tran vdout1_1ck2040 FIND v(dout1_1) AT=2050.05n

.meas tran vdout1_2ck2040 FIND v(dout1_2) AT=2050.05n

.meas tran vdout1_3ck2040 FIND v(dout1_3) AT=2050.05n

.meas tran vdout1_4ck2040 FIND v(dout1_4) AT=2050.05n

.meas tran vdout1_5ck2040 FIND v(dout1_5) AT=2050.05n

.meas tran vdout1_6ck2040 FIND v(dout1_6) AT=2050.05n

.meas tran vdout1_7ck2040 FIND v(dout1_7) AT=2050.05n

.meas tran vdout1_8ck2040 FIND v(dout1_8) AT=2050.05n

.meas tran vdout1_9ck2040 FIND v(dout1_9) AT=2050.05n

.meas tran vdout1_10ck2040 FIND v(dout1_10) AT=2050.05n

.meas tran vdout1_11ck2040 FIND v(dout1_11) AT=2050.05n

.meas tran vdout1_12ck2040 FIND v(dout1_12) AT=2050.05n

.meas tran vdout1_13ck2040 FIND v(dout1_13) AT=2050.05n

.meas tran vdout1_14ck2040 FIND v(dout1_14) AT=2050.05n

.meas tran vdout1_15ck2040 FIND v(dout1_15) AT=2050.05n

.meas tran vdout1_16ck2040 FIND v(dout1_16) AT=2050.05n

.meas tran vdout1_17ck2040 FIND v(dout1_17) AT=2050.05n

.meas tran vdout1_18ck2040 FIND v(dout1_18) AT=2050.05n

.meas tran vdout1_19ck2040 FIND v(dout1_19) AT=2050.05n

.meas tran vdout1_20ck2040 FIND v(dout1_20) AT=2050.05n

.meas tran vdout1_21ck2040 FIND v(dout1_21) AT=2050.05n

.meas tran vdout1_22ck2040 FIND v(dout1_22) AT=2050.05n

.meas tran vdout1_23ck2040 FIND v(dout1_23) AT=2050.05n

.meas tran vdout1_24ck2040 FIND v(dout1_24) AT=2050.05n

.meas tran vdout1_25ck2040 FIND v(dout1_25) AT=2050.05n

.meas tran vdout1_26ck2040 FIND v(dout1_26) AT=2050.05n

.meas tran vdout1_27ck2040 FIND v(dout1_27) AT=2050.05n

.meas tran vdout1_28ck2040 FIND v(dout1_28) AT=2050.05n

.meas tran vdout1_29ck2040 FIND v(dout1_29) AT=2050.05n

.meas tran vdout1_30ck2040 FIND v(dout1_30) AT=2050.05n

.meas tran vdout1_31ck2040 FIND v(dout1_31) AT=2050.05n

.meas tran vdout1_32ck2040 FIND v(dout1_32) AT=2050.05n

.meas tran vdout1_33ck2040 FIND v(dout1_33) AT=2050.05n

.meas tran vdout1_34ck2040 FIND v(dout1_34) AT=2050.05n

.meas tran vdout1_35ck2040 FIND v(dout1_35) AT=2050.05n

.meas tran vdout1_36ck2040 FIND v(dout1_36) AT=2050.05n

.meas tran vdout1_37ck2040 FIND v(dout1_37) AT=2050.05n

.meas tran vdout1_38ck2040 FIND v(dout1_38) AT=2050.05n

.meas tran vdout1_39ck2040 FIND v(dout1_39) AT=2050.05n

.meas tran vdout1_40ck2040 FIND v(dout1_40) AT=2050.05n

.meas tran vdout1_41ck2040 FIND v(dout1_41) AT=2050.05n

.meas tran vdout1_42ck2040 FIND v(dout1_42) AT=2050.05n

.meas tran vdout1_43ck2040 FIND v(dout1_43) AT=2050.05n

.meas tran vdout1_44ck2040 FIND v(dout1_44) AT=2050.05n

.meas tran vdout1_45ck2040 FIND v(dout1_45) AT=2050.05n

.meas tran vdout1_46ck2040 FIND v(dout1_46) AT=2050.05n

.meas tran vdout1_47ck2040 FIND v(dout1_47) AT=2050.05n

.meas tran vdout1_48ck2040 FIND v(dout1_48) AT=2050.05n

.meas tran vdout1_49ck2040 FIND v(dout1_49) AT=2050.05n

.meas tran vdout1_50ck2040 FIND v(dout1_50) AT=2050.05n

.meas tran vdout1_51ck2040 FIND v(dout1_51) AT=2050.05n

.meas tran vdout1_52ck2040 FIND v(dout1_52) AT=2050.05n

.meas tran vdout1_53ck2040 FIND v(dout1_53) AT=2050.05n

.meas tran vdout1_54ck2040 FIND v(dout1_54) AT=2050.05n

.meas tran vdout1_55ck2040 FIND v(dout1_55) AT=2050.05n

.meas tran vdout1_56ck2040 FIND v(dout1_56) AT=2050.05n

.meas tran vdout1_57ck2040 FIND v(dout1_57) AT=2050.05n

.meas tran vdout1_58ck2040 FIND v(dout1_58) AT=2050.05n

.meas tran vdout1_59ck2040 FIND v(dout1_59) AT=2050.05n

.meas tran vdout1_60ck2040 FIND v(dout1_60) AT=2050.05n

.meas tran vdout1_61ck2040 FIND v(dout1_61) AT=2050.05n

.meas tran vdout1_62ck2040 FIND v(dout1_62) AT=2050.05n

.meas tran vdout1_63ck2040 FIND v(dout1_63) AT=2050.05n
