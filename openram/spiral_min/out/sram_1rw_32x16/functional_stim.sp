* Functional test stimulus file for 10ns period

* TT process corner
.lib "/home/lukas/Projects/pdks/sky130A/libs.tech/ngspice/sky130.lib.spice" tt
.include "/tmp/openram_lukas_104284_temp/sram.sp"

* Global Power Supplies
Vvdd vdd 0 1.8

*Nodes gnd and 0 are the same global ground node in ngspice/hspice/xa. Otherwise, this source may be needed.
*Vgnd gnd 0 0.0

* Instantiation of the SRAM
Xsram_1rw_32x16 din0_0 din0_1 din0_2 din0_3 din0_4 din0_5 din0_6 din0_7 din0_8 din0_9 din0_10 din0_11 din0_12 din0_13 din0_14 din0_15 din0_16 din0_17 din0_18 din0_19 din0_20 din0_21 din0_22 din0_23 din0_24 din0_25 din0_26 din0_27 din0_28 din0_29 din0_30 din0_31 din0_32 a0_0 a0_1 a0_2 a0_3 a0_4 CSB0 WEB0 clk0 SPARE_WEN0_0 dout0_0 dout0_1 dout0_2 dout0_3 dout0_4 dout0_5 dout0_6 dout0_7 dout0_8 dout0_9 dout0_10 dout0_11 dout0_12 dout0_13 dout0_14 dout0_15 dout0_16 dout0_17 dout0_18 dout0_19 dout0_20 dout0_21 dout0_22 dout0_23 dout0_24 dout0_25 dout0_26 dout0_27 dout0_28 dout0_29 dout0_30 dout0_31 dout0_32 vdd gnd sram_1rw_32x16

* SRAM output loads
CD00 dout0_0  0 27.56f
CD01 dout0_1  0 27.56f
CD02 dout0_2  0 27.56f
CD03 dout0_3  0 27.56f
CD04 dout0_4  0 27.56f
CD05 dout0_5  0 27.56f
CD06 dout0_6  0 27.56f
CD07 dout0_7  0 27.56f
CD08 dout0_8  0 27.56f
CD09 dout0_9  0 27.56f
CD010 dout0_10  0 27.56f
CD011 dout0_11  0 27.56f
CD012 dout0_12  0 27.56f
CD013 dout0_13  0 27.56f
CD014 dout0_14  0 27.56f
CD015 dout0_15  0 27.56f
CD016 dout0_16  0 27.56f
CD017 dout0_17  0 27.56f
CD018 dout0_18  0 27.56f
CD019 dout0_19  0 27.56f
CD020 dout0_20  0 27.56f
CD021 dout0_21  0 27.56f
CD022 dout0_22  0 27.56f
CD023 dout0_23  0 27.56f
CD024 dout0_24  0 27.56f
CD025 dout0_25  0 27.56f
CD026 dout0_26  0 27.56f
CD027 dout0_27  0 27.56f
CD028 dout0_28  0 27.56f
CD029 dout0_29  0 27.56f
CD030 dout0_30  0 27.56f
CD031 dout0_31  0 27.56f
CD032 dout0_32  0 27.56f

* Important signals for debug
* bl:	xsram:xbank0:bl_0_0
* br:	xsram:xbank0:br_0_0
* s_en:	xsram:s_en
* q:	xsram:xbank0:xbitcell_array:xbitcell_array:xbit_r0_c0.Q
* qbar:	xsram:xbank0:xbitcell_array:xbitcell_array:xbit_r0_c0.Q_bar

* Sequence of operations
*	Idle during cycle 0 (0ns - 10ns)
*	Writing 0+10011010101100000110011001000001  to  address 01111 (from port 0) during cycle 1 (10ns - 20ns)
*	Writing 0+00111010000111100100100110000110  to  address 01111 (from port 0) during cycle 2 (20ns - 30ns)
*	Writing 0+00000111011001011101110100001101  to  address 01111 (from port 0) during cycle 3 (30ns - 40ns)
*	Reading 0+00000111011001011101110100001101 from address 01111 (from port 0) during cycle 4 (40ns - 50ns)
*	Reading 0+00000111011001011101110100001101 from address 01111 (from port 0) during cycle 5 (50ns - 60ns)
*	Writing 0+00011100101110111000000100111111  to  address 00000 (from port 0) during cycle 6 (60ns - 70ns)
*	Reading 0+00000111011001011101110100001101 from address 01111 (from port 0) during cycle 7 (70ns - 80ns)
*	Writing 0+01011101010100101111111100101000  to  address 00000 (from port 0) during cycle 8 (80ns - 90ns)
*	Reading 0+00000111011001011101110100001101 from address 01111 (from port 0) during cycle 9 (90ns - 100ns)
*	Writing 0+00111010100001111011011100001010  to  address 00000 (from port 0) during cycle 11 (110ns - 120ns)
*	Writing 0+01000110100010111011101000011001  to  address 01111 (from port 0) during cycle 12 (120ns - 130ns)
*	Reading 0+00111010100001111011011100001010 from address 00000 (from port 0) during cycle 13 (130ns - 140ns)
*	Reading 0+00111010100001111011011100001010 from address 00000 (from port 0) during cycle 14 (140ns - 150ns)
*	Reading 0+01000110100010111011101000011001 from address 01111 (from port 0) during cycle 15 (150ns - 160ns)
*	Reading 0+00111010100001111011011100001010 from address 00000 (from port 0) during cycle 16 (160ns - 170ns)
*	Reading 0+01000110100010111011101000011001 from address 01111 (from port 0) during cycle 17 (170ns - 180ns)
*	Reading 0+01000110100010111011101000011001 from address 01111 (from port 0) during cycle 18 (180ns - 190ns)
*	Reading 0+00111010100001111011011100001010 from address 00000 (from port 0) during cycle 22 (220ns - 230ns)
*	Reading 0+00111010100001111011011100001010 from address 00000 (from port 0) during cycle 23 (230ns - 240ns)
*	Reading 0+01000110100010111011101000011001 from address 01111 (from port 0) during cycle 24 (240ns - 250ns)
*	Reading 0+00111010100001111011011100001010 from address 00000 (from port 0) during cycle 25 (250ns - 260ns)
*	Writing 0+01101001011001010011011110010100  to  address 00000 (from port 0) during cycle 26 (260ns - 270ns)
*	Reading 0+01101001011001010011011110010100 from address 00000 (from port 0) during cycle 27 (270ns - 280ns)
*	Writing 0+11111100111101010001010101001100  to  address 00000 (from port 0) during cycle 28 (280ns - 290ns)
*	Reading 0+01000110100010111011101000011001 from address 01111 (from port 0) during cycle 29 (290ns - 300ns)
*	Reading 0+11111100111101010001010101001100 from address 00000 (from port 0) during cycle 31 (310ns - 320ns)
*	Reading 0+01000110100010111011101000011001 from address 01111 (from port 0) during cycle 32 (320ns - 330ns)
*	Reading 0+11111100111101010001010101001100 from address 00000 (from port 0) during cycle 34 (340ns - 350ns)
*	Reading 0+01000110100010111011101000011001 from address 01111 (from port 0) during cycle 35 (350ns - 360ns)
*	Reading 0+11111100111101010001010101001100 from address 00000 (from port 0) during cycle 36 (360ns - 370ns)
*	Reading 0+01000110100010111011101000011001 from address 01111 (from port 0) during cycle 37 (370ns - 380ns)
*	Reading 0+01000110100010111011101000011001 from address 01111 (from port 0) during cycle 38 (380ns - 390ns)
*	Writing 0+10010110100001011110011110010100  to  address 00000 (from port 0) during cycle 40 (400ns - 410ns)
*	Reading 0+01000110100010111011101000011001 from address 01111 (from port 0) during cycle 41 (410ns - 420ns)
*	Reading 0+01000110100010111011101000011001 from address 01111 (from port 0) during cycle 43 (430ns - 440ns)
*	Reading 0+01000110100010111011101000011001 from address 01111 (from port 0) during cycle 44 (440ns - 450ns)
*	Writing 0+01001000110001101010010111111001  to  address 01111 (from port 0) during cycle 45 (450ns - 460ns)
*	Writing 0+01001111100010101100001100000100  to  address 01111 (from port 0) during cycle 46 (460ns - 470ns)
*	Writing 0+10100101100010000110010010101010  to  address 01111 (from port 0) during cycle 47 (470ns - 480ns)
*	Reading 0+10100101100010000110010010101010 from address 01111 (from port 0) during cycle 48 (480ns - 490ns)
*	Reading 0+10010110100001011110011110010100 from address 00000 (from port 0) during cycle 49 (490ns - 500ns)
*	Reading 0+10100101100010000110010010101010 from address 01111 (from port 0) during cycle 51 (510ns - 520ns)
*	Reading 0+10010110100001011110011110010100 from address 00000 (from port 0) during cycle 52 (520ns - 530ns)
*	Reading 0+10100101100010000110010010101010 from address 01111 (from port 0) during cycle 53 (530ns - 540ns)
*	Writing 0+01110101011111100010011100010100  to  address 00000 (from port 0) during cycle 54 (540ns - 550ns)
*	Reading 0+01110101011111100010011100010100 from address 00000 (from port 0) during cycle 55 (550ns - 560ns)
*	Reading 0+10100101100010000110010010101010 from address 01111 (from port 0) during cycle 58 (580ns - 590ns)
*	Writing 0+10111110000000000101100101010010  to  address 00000 (from port 0) during cycle 59 (590ns - 600ns)
*	Writing 0+10000101111110100011100101101101  to  address 00000 (from port 0) during cycle 60 (600ns - 610ns)
*	Reading 0+10100101100010000110010010101010 from address 01111 (from port 0) during cycle 61 (610ns - 620ns)
*	Writing 0+01000011001101010010100100111111  to  address 00000 (from port 0) during cycle 63 (630ns - 640ns)
*	Reading 0+01000011001101010010100100111111 from address 00000 (from port 0) during cycle 65 (650ns - 660ns)
*	Writing 0+00011100111010001011001101110000  to  address 00000 (from port 0) during cycle 66 (660ns - 670ns)
*	Reading 0+10100101100010000110010010101010 from address 01111 (from port 0) during cycle 68 (680ns - 690ns)
*	Writing 0+00101101101110111111001011011100  to  address 01111 (from port 0) during cycle 69 (690ns - 700ns)
*	Writing 0+01111000001110101010001010111000  to  address 01111 (from port 0) during cycle 70 (700ns - 710ns)
*	Reading 0+01111000001110101010001010111000 from address 01111 (from port 0) during cycle 71 (710ns - 720ns)
*	Reading 0+00011100111010001011001101110000 from address 00000 (from port 0) during cycle 72 (720ns - 730ns)
*	Reading 0+00011100111010001011001101110000 from address 00000 (from port 0) during cycle 73 (730ns - 740ns)
*	Reading 0+00011100111010001011001101110000 from address 00000 (from port 0) during cycle 76 (760ns - 770ns)
*	Writing 0+10011110010001000000111111000000  to  address 01111 (from port 0) during cycle 77 (770ns - 780ns)
*	Writing 0+11110100100010110111110101000001  to  address 01111 (from port 0) during cycle 78 (780ns - 790ns)
*	Reading 0+00011100111010001011001101110000 from address 00000 (from port 0) during cycle 79 (790ns - 800ns)
*	Reading 0+00011100111010001011001101110000 from address 00000 (from port 0) during cycle 80 (800ns - 810ns)
*	Reading 0+00011100111010001011001101110000 from address 00000 (from port 0) during cycle 81 (810ns - 820ns)
*	Writing 0+00001100001001101111110110111101  to  address 00000 (from port 0) during cycle 83 (830ns - 840ns)
*	Reading 0+00001100001001101111110110111101 from address 00000 (from port 0) during cycle 84 (840ns - 850ns)
*	Reading 0+00001100001001101111110110111101 from address 00000 (from port 0) during cycle 86 (860ns - 870ns)
*	Reading 0+00001100001001101111110110111101 from address 00000 (from port 0) during cycle 87 (870ns - 880ns)
*	Writing 0+11100101110001100011110000001001  to  address 00000 (from port 0) during cycle 88 (880ns - 890ns)
*	Writing 0+10001000000101110001010001101010  to  address 01111 (from port 0) during cycle 89 (890ns - 900ns)
*	Writing 0+10000110001000000110000000000111  to  address 01111 (from port 0) during cycle 90 (900ns - 910ns)
*	Reading 0+11100101110001100011110000001001 from address 00000 (from port 0) during cycle 92 (920ns - 930ns)
*	Reading 0+11100101110001100011110000001001 from address 00000 (from port 0) during cycle 93 (930ns - 940ns)
*	Writing 0+10011110010100101101001001101100  to  address 01111 (from port 0) during cycle 94 (940ns - 950ns)
*	Reading 0+10011110010100101101001001101100 from address 01111 (from port 0) during cycle 95 (950ns - 960ns)
*	Reading 0+10011110010100101101001001101100 from address 01111 (from port 0) during cycle 96 (960ns - 970ns)
*	Reading 0+10011110010100101101001001101100 from address 01111 (from port 0) during cycle 98 (980ns - 990ns)
*	Reading 0+10011110010100101101001001101100 from address 01111 (from port 0) during cycle 99 (990ns - 1000ns)
*	Writing 0+11000100011111011000111101011111  to  address 00000 (from port 0) during cycle 100 (1000ns - 1010ns)
*	Reading 0+11000100011111011000111101011111 from address 00000 (from port 0) during cycle 101 (1010ns - 1020ns)
*	Writing 0+11001101110001010111011100011110  to  address 00000 (from port 0) during cycle 102 (1020ns - 1030ns)
*	Reading 0+11001101110001010111011100011110 from address 00000 (from port 0) during cycle 104 (1040ns - 1050ns)
*	Reading 0+10011110010100101101001001101100 from address 01111 (from port 0) during cycle 105 (1050ns - 1060ns)
*	Reading 0+11001101110001010111011100011110 from address 00000 (from port 0) during cycle 106 (1060ns - 1070ns)
*	Writing 0+00011111010100001111111011111001  to  address 00000 (from port 0) during cycle 108 (1080ns - 1090ns)
*	Writing 0+10001001100110101001111000100100  to  address 01111 (from port 0) during cycle 109 (1090ns - 1100ns)
*	Reading 0+00011111010100001111111011111001 from address 00000 (from port 0) during cycle 110 (1100ns - 1110ns)
*	Writing 0+01011111001110011000101000011010  to  address 00000 (from port 0) during cycle 114 (1140ns - 1150ns)
*	Reading 0+01011111001110011000101000011010 from address 00000 (from port 0) during cycle 115 (1150ns - 1160ns)
*	Reading 0+01011111001110011000101000011010 from address 00000 (from port 0) during cycle 116 (1160ns - 1170ns)
*	Reading 0+01011111001110011000101000011010 from address 00000 (from port 0) during cycle 118 (1180ns - 1190ns)
*	Reading 0+10001001100110101001111000100100 from address 01111 (from port 0) during cycle 119 (1190ns - 1200ns)
*	Reading 0+01011111001110011000101000011010 from address 00000 (from port 0) during cycle 120 (1200ns - 1210ns)
*	Reading 0+10001001100110101001111000100100 from address 01111 (from port 0) during cycle 122 (1220ns - 1230ns)
*	Reading 0+10001001100110101001111000100100 from address 01111 (from port 0) during cycle 125 (1250ns - 1260ns)
*	Writing 0+01001001100011101001001110110010  to  address 01111 (from port 0) during cycle 126 (1260ns - 1270ns)
*	Reading 0+01001001100011101001001110110010 from address 01111 (from port 0) during cycle 127 (1270ns - 1280ns)
*	Writing 0+00110111101001001000110011101010  to  address 00000 (from port 0) during cycle 130 (1300ns - 1310ns)
*	Writing 0+11000101001000111111010100011100  to  address 01111 (from port 0) during cycle 131 (1310ns - 1320ns)
*	Reading 0+11000101001000111111010100011100 from address 01111 (from port 0) during cycle 132 (1320ns - 1330ns)
*	Reading 0+00110111101001001000110011101010 from address 00000 (from port 0) during cycle 133 (1330ns - 1340ns)
*	Reading 0+11000101001000111111010100011100 from address 01111 (from port 0) during cycle 135 (1350ns - 1360ns)
*	Writing 0+00010101010110011110011011010101  to  address 01111 (from port 0) during cycle 136 (1360ns - 1370ns)
*	Reading 0+00110111101001001000110011101010 from address 00000 (from port 0) during cycle 138 (1380ns - 1390ns)
*	Reading 0+00010101010110011110011011010101 from address 01111 (from port 0) during cycle 139 (1390ns - 1400ns)
*	Writing 0+00101100101001111011011000000001  to  address 00000 (from port 0) during cycle 141 (1410ns - 1420ns)
*	Reading 0+00101100101001111011011000000001 from address 00000 (from port 0) during cycle 142 (1420ns - 1430ns)
*	Writing 0+11101100001000100000100010100111  to  address 01111 (from port 0) during cycle 143 (1430ns - 1440ns)
*	Writing 0+11110010111110010111000110100010  to  address 01111 (from port 0) during cycle 144 (1440ns - 1450ns)
*	Reading 0+11110010111110010111000110100010 from address 01111 (from port 0) during cycle 145 (1450ns - 1460ns)
*	Writing 0+01101110010000111101010111000010  to  address 00000 (from port 0) during cycle 146 (1460ns - 1470ns)
*	Writing 0+11100100101100110000001110101101  to  address 01111 (from port 0) during cycle 147 (1470ns - 1480ns)
*	Writing 0+11111010000000001101110111011110  to  address 00000 (from port 0) during cycle 149 (1490ns - 1500ns)
*	Reading 0+11100100101100110000001110101101 from address 01111 (from port 0) during cycle 150 (1500ns - 1510ns)
*	Reading 0+11111010000000001101110111011110 from address 00000 (from port 0) during cycle 151 (1510ns - 1520ns)
*	Reading 0+11100100101100110000001110101101 from address 01111 (from port 0) during cycle 153 (1530ns - 1540ns)
*	Reading 0+11100100101100110000001110101101 from address 01111 (from port 0) during cycle 154 (1540ns - 1550ns)
*	Writing 0+01001110010100000101001011111111  to  address 00000 (from port 0) during cycle 155 (1550ns - 1560ns)
*	Reading 0+01001110010100000101001011111111 from address 00000 (from port 0) during cycle 156 (1560ns - 1570ns)
*	Reading 0+01001110010100000101001011111111 from address 00000 (from port 0) during cycle 157 (1570ns - 1580ns)
*	Writing 0+00110011111010100101011100111010  to  address 00000 (from port 0) during cycle 158 (1580ns - 1590ns)
*	Writing 0+10111111110100000111110110001010  to  address 01111 (from port 0) during cycle 159 (1590ns - 1600ns)
*	Reading 0+10111111110100000111110110001010 from address 01111 (from port 0) during cycle 160 (1600ns - 1610ns)
*	Reading 0+00110011111010100101011100111010 from address 00000 (from port 0) during cycle 161 (1610ns - 1620ns)
*	Writing 0+10000011101001110001110110111110  to  address 01111 (from port 0) during cycle 163 (1630ns - 1640ns)
*	Reading 0+00110011111010100101011100111010 from address 00000 (from port 0) during cycle 165 (1650ns - 1660ns)
*	Reading 0+00110011111010100101011100111010 from address 00000 (from port 0) during cycle 167 (1670ns - 1680ns)
*	Writing 0+10100001011001010011010000001111  to  address 01111 (from port 0) during cycle 170 (1700ns - 1710ns)
*	Writing 0+10011101010001111011110111111001  to  address 01111 (from port 0) during cycle 171 (1710ns - 1720ns)
*	Writing 0+11010010000101111000111110111001  to  address 00000 (from port 0) during cycle 173 (1730ns - 1740ns)
*	Reading 0+10011101010001111011110111111001 from address 01111 (from port 0) during cycle 174 (1740ns - 1750ns)
*	Reading 0+10011101010001111011110111111001 from address 01111 (from port 0) during cycle 175 (1750ns - 1760ns)
*	Reading 0+11010010000101111000111110111001 from address 00000 (from port 0) during cycle 176 (1760ns - 1770ns)
*	Reading 0+10011101010001111011110111111001 from address 01111 (from port 0) during cycle 177 (1770ns - 1780ns)
*	Reading 0+11010010000101111000111110111001 from address 00000 (from port 0) during cycle 179 (1790ns - 1800ns)
*	Writing 0+11100100101111111010100101110011  to  address 00000 (from port 0) during cycle 180 (1800ns - 1810ns)
*	Reading 0+10011101010001111011110111111001 from address 01111 (from port 0) during cycle 181 (1810ns - 1820ns)
*	Reading 0+10011101010001111011110111111001 from address 01111 (from port 0) during cycle 182 (1820ns - 1830ns)
*	Reading 0+10011101010001111011110111111001 from address 01111 (from port 0) during cycle 183 (1830ns - 1840ns)
*	Writing 0+00001001011010110111011000011011  to  address 00000 (from port 0) during cycle 184 (1840ns - 1850ns)
*	Reading 0+00001001011010110111011000011011 from address 00000 (from port 0) during cycle 185 (1850ns - 1860ns)
*	Writing 0+11001111101010001110010011110110  to  address 01111 (from port 0) during cycle 186 (1860ns - 1870ns)
*	Reading 0+11001111101010001110010011110110 from address 01111 (from port 0) during cycle 187 (1870ns - 1880ns)
*	Reading 0+00001001011010110111011000011011 from address 00000 (from port 0) during cycle 188 (1880ns - 1890ns)
*	Writing 0+10111001010010010011000001000010  to  address 01111 (from port 0) during cycle 191 (1910ns - 1920ns)
*	Reading 0+10111001010010010011000001000010 from address 01111 (from port 0) during cycle 192 (1920ns - 1930ns)
*	Reading 0+00001001011010110111011000011011 from address 00000 (from port 0) during cycle 193 (1930ns - 1940ns)
*	Reading 0+10111001010010010011000001000010 from address 01111 (from port 0) during cycle 194 (1940ns - 1950ns)
*	Reading 0+10111001010010010011000001000010 from address 01111 (from port 0) during cycle 195 (1950ns - 1960ns)
*	Writing 0+10001010110000111010101110011000  to  address 00000 (from port 0) during cycle 196 (1960ns - 1970ns)
*	Reading 0+10111001010010010011000001000010 from address 01111 (from port 0) during cycle 198 (1980ns - 1990ns)
*	Reading 0+10001010110000111010101110011000 from address 00000 (from port 0) during cycle 201 (2010ns - 2020ns)
*	Writing 0+11010010010110000111001000000010  to  address 00000 (from port 0) during cycle 203 (2030ns - 2040ns)
*	Writing 0+11011011111100001011100000011010  to  address 01111 (from port 0) during cycle 204 (2040ns - 2050ns)
*	Idle during cycle 205 (2050ns - 2060ns)

* Generation of data and address signals
* (time, data): [(0, 0), (10, 1), (20, 0), (30, 1), (40, 1), (50, 1), (60, 1), (70, 1), (80, 0), (90, 0), (100, 0), (110, 0), (120, 1), (130, 1), (140, 1), (150, 1), (160, 1), (170, 1), (180, 1), (190, 1), (200, 1), (210, 1), (220, 1), (230, 1), (240, 1), (250, 1), (260, 0), (270, 0), (280, 0), (290, 0), (300, 0), (310, 0), (320, 0), (330, 0), (340, 0), (350, 0), (360, 0), (370, 0), (380, 0), (390, 0), (400, 0), (410, 0), (420, 0), (430, 0), (440, 0), (450, 1), (460, 0), (470, 0), (480, 0), (490, 0), (500, 0), (510, 0), (520, 0), (530, 0), (540, 0), (550, 0), (560, 0), (570, 0), (580, 0), (590, 0), (600, 1), (610, 1), (620, 1), (630, 1), (640, 1), (650, 1), (660, 0), (670, 0), (680, 0), (690, 0), (700, 0), (710, 0), (720, 0), (730, 0), (740, 0), (750, 0), (760, 0), (770, 0), (780, 1), (790, 1), (800, 1), (810, 1), (820, 1), (830, 1), (840, 1), (850, 1), (860, 1), (870, 1), (880, 1), (890, 0), (900, 1), (910, 1), (920, 1), (930, 1), (940, 0), (950, 0), (960, 0), (970, 0), (980, 0), (990, 0), (1000, 1), (1010, 1), (1020, 0), (1030, 0), (1040, 0), (1050, 0), (1060, 0), (1070, 0), (1080, 1), (1090, 0), (1100, 0), (1110, 0), (1120, 0), (1130, 0), (1140, 0), (1150, 0), (1160, 0), (1170, 0), (1180, 0), (1190, 0), (1200, 0), (1210, 0), (1220, 0), (1230, 0), (1240, 0), (1250, 0), (1260, 0), (1270, 0), (1280, 0), (1290, 0), (1300, 0), (1310, 0), (1320, 0), (1330, 0), (1340, 0), (1350, 0), (1360, 1), (1370, 1), (1380, 1), (1390, 1), (1400, 1), (1410, 1), (1420, 1), (1430, 1), (1440, 0), (1450, 0), (1460, 0), (1470, 1), (1480, 1), (1490, 0), (1500, 0), (1510, 0), (1520, 0), (1530, 0), (1540, 0), (1550, 1), (1560, 1), (1570, 1), (1580, 0), (1590, 0), (1600, 0), (1610, 0), (1620, 0), (1630, 0), (1640, 0), (1650, 0), (1660, 0), (1670, 0), (1680, 0), (1690, 0), (1700, 1), (1710, 1), (1720, 1), (1730, 1), (1740, 1), (1750, 1), (1760, 1), (1770, 1), (1780, 1), (1790, 1), (1800, 1), (1810, 1), (1820, 1), (1830, 1), (1840, 1), (1850, 1), (1860, 0), (1870, 0), (1880, 0), (1890, 0), (1900, 0), (1910, 0), (1920, 0), (1930, 0), (1940, 0), (1950, 0), (1960, 0), (1970, 0), (1980, 0), (1990, 0), (2000, 0), (2010, 0), (2020, 0), (2030, 0), (2040, 0), (2050, 0)]
Vdin0_0  din0_0  0 PWL (0n 0.0v 9.495n 0.0v 9.505n 1.8v 19.495n 1.8v 19.505n 0.0v 29.495n 0.0v 29.505n 1.8v 39.495n 1.8v 39.505n 1.8v 49.495n 1.8v 49.505n 1.8v 59.495n 1.8v 59.505n 1.8v 69.495n 1.8v 69.505n 1.8v 79.495n 1.8v 79.505n 0.0v 89.495n 0.0v 89.505n 0.0v 99.495n 0.0v 99.505n 0.0v 109.495n 0.0v 109.505n 0.0v 119.495n 0.0v 119.505n 1.8v 129.495n 1.8v 129.505n 1.8v 139.495n 1.8v 139.505n 1.8v 149.495n 1.8v 149.505n 1.8v 159.495n 1.8v 159.505n 1.8v 169.495n 1.8v 169.505n 1.8v 179.495n 1.8v 179.505n 1.8v 189.495n 1.8v 189.505n 1.8v 199.495n 1.8v 199.505n 1.8v 209.495n 1.8v 209.505n 1.8v 219.495n 1.8v 219.505n 1.8v 229.495n 1.8v 229.505n 1.8v 239.495n 1.8v 239.505n 1.8v 249.495n 1.8v 249.505n 1.8v 259.495n 1.8v 259.505n 0.0v 269.495n 0.0v 269.505n 0.0v 279.495n 0.0v 279.505n 0.0v 289.495n 0.0v 289.505n 0.0v 299.495n 0.0v 299.505n 0.0v 309.495n 0.0v 309.505n 0.0v 319.495n 0.0v 319.505n 0.0v 329.495n 0.0v 329.505n 0.0v 339.495n 0.0v 339.505n 0.0v 349.495n 0.0v 349.505n 0.0v 359.495n 0.0v 359.505n 0.0v 369.495n 0.0v 369.505n 0.0v 379.495n 0.0v 379.505n 0.0v 389.495n 0.0v 389.505n 0.0v 399.495n 0.0v 399.505n 0.0v 409.495n 0.0v 409.505n 0.0v 419.495n 0.0v 419.505n 0.0v 429.495n 0.0v 429.505n 0.0v 439.495n 0.0v 439.505n 0.0v 449.495n 0.0v 449.505n 1.8v 459.495n 1.8v 459.505n 0.0v 469.495n 0.0v 469.505n 0.0v 479.495n 0.0v 479.505n 0.0v 489.495n 0.0v 489.505n 0.0v 499.495n 0.0v 499.505n 0.0v 509.495n 0.0v 509.505n 0.0v 519.495n 0.0v 519.505n 0.0v 529.495n 0.0v 529.505n 0.0v 539.495n 0.0v 539.505n 0.0v 549.495n 0.0v 549.505n 0.0v 559.495n 0.0v 559.505n 0.0v 569.495n 0.0v 569.505n 0.0v 579.495n 0.0v 579.505n 0.0v 589.495n 0.0v 589.505n 0.0v 599.495n 0.0v 599.505n 1.8v 609.495n 1.8v 609.505n 1.8v 619.495n 1.8v 619.505n 1.8v 629.495n 1.8v 629.505n 1.8v 639.495n 1.8v 639.505n 1.8v 649.495n 1.8v 649.505n 1.8v 659.495n 1.8v 659.505n 0.0v 669.495n 0.0v 669.505n 0.0v 679.495n 0.0v 679.505n 0.0v 689.495n 0.0v 689.505n 0.0v 699.495n 0.0v 699.505n 0.0v 709.495n 0.0v 709.505n 0.0v 719.495n 0.0v 719.505n 0.0v 729.495n 0.0v 729.505n 0.0v 739.495n 0.0v 739.505n 0.0v 749.495n 0.0v 749.505n 0.0v 759.495n 0.0v 759.505n 0.0v 769.495n 0.0v 769.505n 0.0v 779.495n 0.0v 779.505n 1.8v 789.495n 1.8v 789.505n 1.8v 799.495n 1.8v 799.505n 1.8v 809.495n 1.8v 809.505n 1.8v 819.495n 1.8v 819.505n 1.8v 829.495n 1.8v 829.505n 1.8v 839.495n 1.8v 839.505n 1.8v 849.495n 1.8v 849.505n 1.8v 859.495n 1.8v 859.505n 1.8v 869.495n 1.8v 869.505n 1.8v 879.495n 1.8v 879.505n 1.8v 889.495n 1.8v 889.505n 0.0v 899.495n 0.0v 899.505n 1.8v 909.495n 1.8v 909.505n 1.8v 919.495n 1.8v 919.505n 1.8v 929.495n 1.8v 929.505n 1.8v 939.495n 1.8v 939.505n 0.0v 949.495n 0.0v 949.505n 0.0v 959.495n 0.0v 959.505n 0.0v 969.495n 0.0v 969.505n 0.0v 979.495n 0.0v 979.505n 0.0v 989.495n 0.0v 989.505n 0.0v 999.495n 0.0v 999.505n 1.8v 1009.495n 1.8v 1009.505n 1.8v 1019.495n 1.8v 1019.505n 0.0v 1029.495n 0.0v 1029.505n 0.0v 1039.495n 0.0v 1039.505n 0.0v 1049.495n 0.0v 1049.505n 0.0v 1059.495n 0.0v 1059.505n 0.0v 1069.495n 0.0v 1069.505n 0.0v 1079.495n 0.0v 1079.505n 1.8v 1089.495n 1.8v 1089.505n 0.0v 1099.495n 0.0v 1099.505n 0.0v 1109.495n 0.0v 1109.505n 0.0v 1119.495n 0.0v 1119.505n 0.0v 1129.495n 0.0v 1129.505n 0.0v 1139.495n 0.0v 1139.505n 0.0v 1149.495n 0.0v 1149.505n 0.0v 1159.495n 0.0v 1159.505n 0.0v 1169.495n 0.0v 1169.505n 0.0v 1179.495n 0.0v 1179.505n 0.0v 1189.495n 0.0v 1189.505n 0.0v 1199.495n 0.0v 1199.505n 0.0v 1209.495n 0.0v 1209.505n 0.0v 1219.495n 0.0v 1219.505n 0.0v 1229.495n 0.0v 1229.505n 0.0v 1239.495n 0.0v 1239.505n 0.0v 1249.495n 0.0v 1249.505n 0.0v 1259.495n 0.0v 1259.505n 0.0v 1269.495n 0.0v 1269.505n 0.0v 1279.495n 0.0v 1279.505n 0.0v 1289.495n 0.0v 1289.505n 0.0v 1299.495n 0.0v 1299.505n 0.0v 1309.495n 0.0v 1309.505n 0.0v 1319.495n 0.0v 1319.505n 0.0v 1329.495n 0.0v 1329.505n 0.0v 1339.495n 0.0v 1339.505n 0.0v 1349.495n 0.0v 1349.505n 0.0v 1359.495n 0.0v 1359.505n 1.8v 1369.495n 1.8v 1369.505n 1.8v 1379.495n 1.8v 1379.505n 1.8v 1389.495n 1.8v 1389.505n 1.8v 1399.495n 1.8v 1399.505n 1.8v 1409.495n 1.8v 1409.505n 1.8v 1419.495n 1.8v 1419.505n 1.8v 1429.495n 1.8v 1429.505n 1.8v 1439.495n 1.8v 1439.505n 0.0v 1449.495n 0.0v 1449.505n 0.0v 1459.495n 0.0v 1459.505n 0.0v 1469.495n 0.0v 1469.505n 1.8v 1479.495n 1.8v 1479.505n 1.8v 1489.495n 1.8v 1489.505n 0.0v 1499.495n 0.0v 1499.505n 0.0v 1509.495n 0.0v 1509.505n 0.0v 1519.495n 0.0v 1519.505n 0.0v 1529.495n 0.0v 1529.505n 0.0v 1539.495n 0.0v 1539.505n 0.0v 1549.495n 0.0v 1549.505n 1.8v 1559.495n 1.8v 1559.505n 1.8v 1569.495n 1.8v 1569.505n 1.8v 1579.495n 1.8v 1579.505n 0.0v 1589.495n 0.0v 1589.505n 0.0v 1599.495n 0.0v 1599.505n 0.0v 1609.495n 0.0v 1609.505n 0.0v 1619.495n 0.0v 1619.505n 0.0v 1629.495n 0.0v 1629.505n 0.0v 1639.495n 0.0v 1639.505n 0.0v 1649.495n 0.0v 1649.505n 0.0v 1659.495n 0.0v 1659.505n 0.0v 1669.495n 0.0v 1669.505n 0.0v 1679.495n 0.0v 1679.505n 0.0v 1689.495n 0.0v 1689.505n 0.0v 1699.495n 0.0v 1699.505n 1.8v 1709.495n 1.8v 1709.505n 1.8v 1719.495n 1.8v 1719.505n 1.8v 1729.495n 1.8v 1729.505n 1.8v 1739.495n 1.8v 1739.505n 1.8v 1749.495n 1.8v 1749.505n 1.8v 1759.495n 1.8v 1759.505n 1.8v 1769.495n 1.8v 1769.505n 1.8v 1779.495n 1.8v 1779.505n 1.8v 1789.495n 1.8v 1789.505n 1.8v 1799.495n 1.8v 1799.505n 1.8v 1809.495n 1.8v 1809.505n 1.8v 1819.495n 1.8v 1819.505n 1.8v 1829.495n 1.8v 1829.505n 1.8v 1839.495n 1.8v 1839.505n 1.8v 1849.495n 1.8v 1849.505n 1.8v 1859.495n 1.8v 1859.505n 0.0v 1869.495n 0.0v 1869.505n 0.0v 1879.495n 0.0v 1879.505n 0.0v 1889.495n 0.0v 1889.505n 0.0v 1899.495n 0.0v 1899.505n 0.0v 1909.495n 0.0v 1909.505n 0.0v 1919.495n 0.0v 1919.505n 0.0v 1929.495n 0.0v 1929.505n 0.0v 1939.495n 0.0v 1939.505n 0.0v 1949.495n 0.0v 1949.505n 0.0v 1959.495n 0.0v 1959.505n 0.0v 1969.495n 0.0v 1969.505n 0.0v 1979.495n 0.0v 1979.505n 0.0v 1989.495n 0.0v 1989.505n 0.0v 1999.495n 0.0v 1999.505n 0.0v 2009.495n 0.0v 2009.505n 0.0v 2019.495n 0.0v 2019.505n 0.0v 2029.495n 0.0v 2029.505n 0.0v 2039.495n 0.0v 2039.505n 0.0v 2049.495n 0.0v 2049.505n 0.0v )
* (time, data): [(0, 0), (10, 0), (20, 1), (30, 0), (40, 0), (50, 0), (60, 1), (70, 1), (80, 0), (90, 0), (100, 0), (110, 1), (120, 0), (130, 0), (140, 0), (150, 0), (160, 0), (170, 0), (180, 0), (190, 0), (200, 0), (210, 0), (220, 0), (230, 0), (240, 0), (250, 0), (260, 0), (270, 0), (280, 0), (290, 0), (300, 0), (310, 0), (320, 0), (330, 0), (340, 0), (350, 0), (360, 0), (370, 0), (380, 0), (390, 0), (400, 0), (410, 0), (420, 0), (430, 0), (440, 0), (450, 0), (460, 0), (470, 1), (480, 1), (490, 1), (500, 1), (510, 1), (520, 1), (530, 1), (540, 0), (550, 0), (560, 0), (570, 0), (580, 0), (590, 1), (600, 0), (610, 0), (620, 0), (630, 1), (640, 1), (650, 1), (660, 0), (670, 0), (680, 0), (690, 0), (700, 0), (710, 0), (720, 0), (730, 0), (740, 0), (750, 0), (760, 0), (770, 0), (780, 0), (790, 0), (800, 0), (810, 0), (820, 0), (830, 0), (840, 0), (850, 0), (860, 0), (870, 0), (880, 0), (890, 1), (900, 1), (910, 1), (920, 1), (930, 1), (940, 0), (950, 0), (960, 0), (970, 0), (980, 0), (990, 0), (1000, 1), (1010, 1), (1020, 1), (1030, 1), (1040, 1), (1050, 1), (1060, 1), (1070, 1), (1080, 0), (1090, 0), (1100, 0), (1110, 0), (1120, 0), (1130, 0), (1140, 1), (1150, 1), (1160, 1), (1170, 1), (1180, 1), (1190, 1), (1200, 1), (1210, 1), (1220, 1), (1230, 1), (1240, 1), (1250, 1), (1260, 1), (1270, 1), (1280, 1), (1290, 1), (1300, 1), (1310, 0), (1320, 0), (1330, 0), (1340, 0), (1350, 0), (1360, 0), (1370, 0), (1380, 0), (1390, 0), (1400, 0), (1410, 0), (1420, 0), (1430, 1), (1440, 1), (1450, 1), (1460, 1), (1470, 0), (1480, 0), (1490, 1), (1500, 1), (1510, 1), (1520, 1), (1530, 1), (1540, 1), (1550, 1), (1560, 1), (1570, 1), (1580, 1), (1590, 1), (1600, 1), (1610, 1), (1620, 1), (1630, 1), (1640, 1), (1650, 1), (1660, 1), (1670, 1), (1680, 1), (1690, 1), (1700, 1), (1710, 0), (1720, 0), (1730, 0), (1740, 0), (1750, 0), (1760, 0), (1770, 0), (1780, 0), (1790, 0), (1800, 1), (1810, 1), (1820, 1), (1830, 1), (1840, 1), (1850, 1), (1860, 1), (1870, 1), (1880, 1), (1890, 1), (1900, 1), (1910, 1), (1920, 1), (1930, 1), (1940, 1), (1950, 1), (1960, 0), (1970, 0), (1980, 0), (1990, 0), (2000, 0), (2010, 0), (2020, 0), (2030, 1), (2040, 1), (2050, 1)]
Vdin0_1  din0_1  0 PWL (0n 0.0v 9.495n 0.0v 9.505n 0.0v 19.495n 0.0v 19.505n 1.8v 29.495n 1.8v 29.505n 0.0v 39.495n 0.0v 39.505n 0.0v 49.495n 0.0v 49.505n 0.0v 59.495n 0.0v 59.505n 1.8v 69.495n 1.8v 69.505n 1.8v 79.495n 1.8v 79.505n 0.0v 89.495n 0.0v 89.505n 0.0v 99.495n 0.0v 99.505n 0.0v 109.495n 0.0v 109.505n 1.8v 119.495n 1.8v 119.505n 0.0v 129.495n 0.0v 129.505n 0.0v 139.495n 0.0v 139.505n 0.0v 149.495n 0.0v 149.505n 0.0v 159.495n 0.0v 159.505n 0.0v 169.495n 0.0v 169.505n 0.0v 179.495n 0.0v 179.505n 0.0v 189.495n 0.0v 189.505n 0.0v 199.495n 0.0v 199.505n 0.0v 209.495n 0.0v 209.505n 0.0v 219.495n 0.0v 219.505n 0.0v 229.495n 0.0v 229.505n 0.0v 239.495n 0.0v 239.505n 0.0v 249.495n 0.0v 249.505n 0.0v 259.495n 0.0v 259.505n 0.0v 269.495n 0.0v 269.505n 0.0v 279.495n 0.0v 279.505n 0.0v 289.495n 0.0v 289.505n 0.0v 299.495n 0.0v 299.505n 0.0v 309.495n 0.0v 309.505n 0.0v 319.495n 0.0v 319.505n 0.0v 329.495n 0.0v 329.505n 0.0v 339.495n 0.0v 339.505n 0.0v 349.495n 0.0v 349.505n 0.0v 359.495n 0.0v 359.505n 0.0v 369.495n 0.0v 369.505n 0.0v 379.495n 0.0v 379.505n 0.0v 389.495n 0.0v 389.505n 0.0v 399.495n 0.0v 399.505n 0.0v 409.495n 0.0v 409.505n 0.0v 419.495n 0.0v 419.505n 0.0v 429.495n 0.0v 429.505n 0.0v 439.495n 0.0v 439.505n 0.0v 449.495n 0.0v 449.505n 0.0v 459.495n 0.0v 459.505n 0.0v 469.495n 0.0v 469.505n 1.8v 479.495n 1.8v 479.505n 1.8v 489.495n 1.8v 489.505n 1.8v 499.495n 1.8v 499.505n 1.8v 509.495n 1.8v 509.505n 1.8v 519.495n 1.8v 519.505n 1.8v 529.495n 1.8v 529.505n 1.8v 539.495n 1.8v 539.505n 0.0v 549.495n 0.0v 549.505n 0.0v 559.495n 0.0v 559.505n 0.0v 569.495n 0.0v 569.505n 0.0v 579.495n 0.0v 579.505n 0.0v 589.495n 0.0v 589.505n 1.8v 599.495n 1.8v 599.505n 0.0v 609.495n 0.0v 609.505n 0.0v 619.495n 0.0v 619.505n 0.0v 629.495n 0.0v 629.505n 1.8v 639.495n 1.8v 639.505n 1.8v 649.495n 1.8v 649.505n 1.8v 659.495n 1.8v 659.505n 0.0v 669.495n 0.0v 669.505n 0.0v 679.495n 0.0v 679.505n 0.0v 689.495n 0.0v 689.505n 0.0v 699.495n 0.0v 699.505n 0.0v 709.495n 0.0v 709.505n 0.0v 719.495n 0.0v 719.505n 0.0v 729.495n 0.0v 729.505n 0.0v 739.495n 0.0v 739.505n 0.0v 749.495n 0.0v 749.505n 0.0v 759.495n 0.0v 759.505n 0.0v 769.495n 0.0v 769.505n 0.0v 779.495n 0.0v 779.505n 0.0v 789.495n 0.0v 789.505n 0.0v 799.495n 0.0v 799.505n 0.0v 809.495n 0.0v 809.505n 0.0v 819.495n 0.0v 819.505n 0.0v 829.495n 0.0v 829.505n 0.0v 839.495n 0.0v 839.505n 0.0v 849.495n 0.0v 849.505n 0.0v 859.495n 0.0v 859.505n 0.0v 869.495n 0.0v 869.505n 0.0v 879.495n 0.0v 879.505n 0.0v 889.495n 0.0v 889.505n 1.8v 899.495n 1.8v 899.505n 1.8v 909.495n 1.8v 909.505n 1.8v 919.495n 1.8v 919.505n 1.8v 929.495n 1.8v 929.505n 1.8v 939.495n 1.8v 939.505n 0.0v 949.495n 0.0v 949.505n 0.0v 959.495n 0.0v 959.505n 0.0v 969.495n 0.0v 969.505n 0.0v 979.495n 0.0v 979.505n 0.0v 989.495n 0.0v 989.505n 0.0v 999.495n 0.0v 999.505n 1.8v 1009.495n 1.8v 1009.505n 1.8v 1019.495n 1.8v 1019.505n 1.8v 1029.495n 1.8v 1029.505n 1.8v 1039.495n 1.8v 1039.505n 1.8v 1049.495n 1.8v 1049.505n 1.8v 1059.495n 1.8v 1059.505n 1.8v 1069.495n 1.8v 1069.505n 1.8v 1079.495n 1.8v 1079.505n 0.0v 1089.495n 0.0v 1089.505n 0.0v 1099.495n 0.0v 1099.505n 0.0v 1109.495n 0.0v 1109.505n 0.0v 1119.495n 0.0v 1119.505n 0.0v 1129.495n 0.0v 1129.505n 0.0v 1139.495n 0.0v 1139.505n 1.8v 1149.495n 1.8v 1149.505n 1.8v 1159.495n 1.8v 1159.505n 1.8v 1169.495n 1.8v 1169.505n 1.8v 1179.495n 1.8v 1179.505n 1.8v 1189.495n 1.8v 1189.505n 1.8v 1199.495n 1.8v 1199.505n 1.8v 1209.495n 1.8v 1209.505n 1.8v 1219.495n 1.8v 1219.505n 1.8v 1229.495n 1.8v 1229.505n 1.8v 1239.495n 1.8v 1239.505n 1.8v 1249.495n 1.8v 1249.505n 1.8v 1259.495n 1.8v 1259.505n 1.8v 1269.495n 1.8v 1269.505n 1.8v 1279.495n 1.8v 1279.505n 1.8v 1289.495n 1.8v 1289.505n 1.8v 1299.495n 1.8v 1299.505n 1.8v 1309.495n 1.8v 1309.505n 0.0v 1319.495n 0.0v 1319.505n 0.0v 1329.495n 0.0v 1329.505n 0.0v 1339.495n 0.0v 1339.505n 0.0v 1349.495n 0.0v 1349.505n 0.0v 1359.495n 0.0v 1359.505n 0.0v 1369.495n 0.0v 1369.505n 0.0v 1379.495n 0.0v 1379.505n 0.0v 1389.495n 0.0v 1389.505n 0.0v 1399.495n 0.0v 1399.505n 0.0v 1409.495n 0.0v 1409.505n 0.0v 1419.495n 0.0v 1419.505n 0.0v 1429.495n 0.0v 1429.505n 1.8v 1439.495n 1.8v 1439.505n 1.8v 1449.495n 1.8v 1449.505n 1.8v 1459.495n 1.8v 1459.505n 1.8v 1469.495n 1.8v 1469.505n 0.0v 1479.495n 0.0v 1479.505n 0.0v 1489.495n 0.0v 1489.505n 1.8v 1499.495n 1.8v 1499.505n 1.8v 1509.495n 1.8v 1509.505n 1.8v 1519.495n 1.8v 1519.505n 1.8v 1529.495n 1.8v 1529.505n 1.8v 1539.495n 1.8v 1539.505n 1.8v 1549.495n 1.8v 1549.505n 1.8v 1559.495n 1.8v 1559.505n 1.8v 1569.495n 1.8v 1569.505n 1.8v 1579.495n 1.8v 1579.505n 1.8v 1589.495n 1.8v 1589.505n 1.8v 1599.495n 1.8v 1599.505n 1.8v 1609.495n 1.8v 1609.505n 1.8v 1619.495n 1.8v 1619.505n 1.8v 1629.495n 1.8v 1629.505n 1.8v 1639.495n 1.8v 1639.505n 1.8v 1649.495n 1.8v 1649.505n 1.8v 1659.495n 1.8v 1659.505n 1.8v 1669.495n 1.8v 1669.505n 1.8v 1679.495n 1.8v 1679.505n 1.8v 1689.495n 1.8v 1689.505n 1.8v 1699.495n 1.8v 1699.505n 1.8v 1709.495n 1.8v 1709.505n 0.0v 1719.495n 0.0v 1719.505n 0.0v 1729.495n 0.0v 1729.505n 0.0v 1739.495n 0.0v 1739.505n 0.0v 1749.495n 0.0v 1749.505n 0.0v 1759.495n 0.0v 1759.505n 0.0v 1769.495n 0.0v 1769.505n 0.0v 1779.495n 0.0v 1779.505n 0.0v 1789.495n 0.0v 1789.505n 0.0v 1799.495n 0.0v 1799.505n 1.8v 1809.495n 1.8v 1809.505n 1.8v 1819.495n 1.8v 1819.505n 1.8v 1829.495n 1.8v 1829.505n 1.8v 1839.495n 1.8v 1839.505n 1.8v 1849.495n 1.8v 1849.505n 1.8v 1859.495n 1.8v 1859.505n 1.8v 1869.495n 1.8v 1869.505n 1.8v 1879.495n 1.8v 1879.505n 1.8v 1889.495n 1.8v 1889.505n 1.8v 1899.495n 1.8v 1899.505n 1.8v 1909.495n 1.8v 1909.505n 1.8v 1919.495n 1.8v 1919.505n 1.8v 1929.495n 1.8v 1929.505n 1.8v 1939.495n 1.8v 1939.505n 1.8v 1949.495n 1.8v 1949.505n 1.8v 1959.495n 1.8v 1959.505n 0.0v 1969.495n 0.0v 1969.505n 0.0v 1979.495n 0.0v 1979.505n 0.0v 1989.495n 0.0v 1989.505n 0.0v 1999.495n 0.0v 1999.505n 0.0v 2009.495n 0.0v 2009.505n 0.0v 2019.495n 0.0v 2019.505n 0.0v 2029.495n 0.0v 2029.505n 1.8v 2039.495n 1.8v 2039.505n 1.8v 2049.495n 1.8v 2049.505n 1.8v )
* (time, data): [(0, 0), (10, 0), (20, 1), (30, 1), (40, 1), (50, 1), (60, 1), (70, 1), (80, 0), (90, 0), (100, 0), (110, 0), (120, 0), (130, 0), (140, 0), (150, 0), (160, 0), (170, 0), (180, 0), (190, 0), (200, 0), (210, 0), (220, 0), (230, 0), (240, 0), (250, 0), (260, 1), (270, 1), (280, 1), (290, 1), (300, 1), (310, 1), (320, 1), (330, 1), (340, 1), (350, 1), (360, 1), (370, 1), (380, 1), (390, 1), (400, 1), (410, 1), (420, 1), (430, 1), (440, 1), (450, 0), (460, 1), (470, 0), (480, 0), (490, 0), (500, 0), (510, 0), (520, 0), (530, 0), (540, 1), (550, 1), (560, 1), (570, 1), (580, 1), (590, 0), (600, 1), (610, 1), (620, 1), (630, 1), (640, 1), (650, 1), (660, 0), (670, 0), (680, 0), (690, 1), (700, 0), (710, 0), (720, 0), (730, 0), (740, 0), (750, 0), (760, 0), (770, 0), (780, 0), (790, 0), (800, 0), (810, 0), (820, 0), (830, 1), (840, 1), (850, 1), (860, 1), (870, 1), (880, 0), (890, 0), (900, 1), (910, 1), (920, 1), (930, 1), (940, 1), (950, 1), (960, 1), (970, 1), (980, 1), (990, 1), (1000, 1), (1010, 1), (1020, 1), (1030, 1), (1040, 1), (1050, 1), (1060, 1), (1070, 1), (1080, 0), (1090, 1), (1100, 1), (1110, 1), (1120, 1), (1130, 1), (1140, 0), (1150, 0), (1160, 0), (1170, 0), (1180, 0), (1190, 0), (1200, 0), (1210, 0), (1220, 0), (1230, 0), (1240, 0), (1250, 0), (1260, 0), (1270, 0), (1280, 0), (1290, 0), (1300, 0), (1310, 1), (1320, 1), (1330, 1), (1340, 1), (1350, 1), (1360, 1), (1370, 1), (1380, 1), (1390, 1), (1400, 1), (1410, 0), (1420, 0), (1430, 1), (1440, 0), (1450, 0), (1460, 0), (1470, 1), (1480, 1), (1490, 1), (1500, 1), (1510, 1), (1520, 1), (1530, 1), (1540, 1), (1550, 1), (1560, 1), (1570, 1), (1580, 0), (1590, 0), (1600, 0), (1610, 0), (1620, 0), (1630, 1), (1640, 1), (1650, 1), (1660, 1), (1670, 1), (1680, 1), (1690, 1), (1700, 1), (1710, 0), (1720, 0), (1730, 0), (1740, 0), (1750, 0), (1760, 0), (1770, 0), (1780, 0), (1790, 0), (1800, 0), (1810, 0), (1820, 0), (1830, 0), (1840, 0), (1850, 0), (1860, 1), (1870, 1), (1880, 1), (1890, 1), (1900, 1), (1910, 0), (1920, 0), (1930, 0), (1940, 0), (1950, 0), (1960, 0), (1970, 0), (1980, 0), (1990, 0), (2000, 0), (2010, 0), (2020, 0), (2030, 0), (2040, 0), (2050, 0)]
Vdin0_2  din0_2  0 PWL (0n 0.0v 9.495n 0.0v 9.505n 0.0v 19.495n 0.0v 19.505n 1.8v 29.495n 1.8v 29.505n 1.8v 39.495n 1.8v 39.505n 1.8v 49.495n 1.8v 49.505n 1.8v 59.495n 1.8v 59.505n 1.8v 69.495n 1.8v 69.505n 1.8v 79.495n 1.8v 79.505n 0.0v 89.495n 0.0v 89.505n 0.0v 99.495n 0.0v 99.505n 0.0v 109.495n 0.0v 109.505n 0.0v 119.495n 0.0v 119.505n 0.0v 129.495n 0.0v 129.505n 0.0v 139.495n 0.0v 139.505n 0.0v 149.495n 0.0v 149.505n 0.0v 159.495n 0.0v 159.505n 0.0v 169.495n 0.0v 169.505n 0.0v 179.495n 0.0v 179.505n 0.0v 189.495n 0.0v 189.505n 0.0v 199.495n 0.0v 199.505n 0.0v 209.495n 0.0v 209.505n 0.0v 219.495n 0.0v 219.505n 0.0v 229.495n 0.0v 229.505n 0.0v 239.495n 0.0v 239.505n 0.0v 249.495n 0.0v 249.505n 0.0v 259.495n 0.0v 259.505n 1.8v 269.495n 1.8v 269.505n 1.8v 279.495n 1.8v 279.505n 1.8v 289.495n 1.8v 289.505n 1.8v 299.495n 1.8v 299.505n 1.8v 309.495n 1.8v 309.505n 1.8v 319.495n 1.8v 319.505n 1.8v 329.495n 1.8v 329.505n 1.8v 339.495n 1.8v 339.505n 1.8v 349.495n 1.8v 349.505n 1.8v 359.495n 1.8v 359.505n 1.8v 369.495n 1.8v 369.505n 1.8v 379.495n 1.8v 379.505n 1.8v 389.495n 1.8v 389.505n 1.8v 399.495n 1.8v 399.505n 1.8v 409.495n 1.8v 409.505n 1.8v 419.495n 1.8v 419.505n 1.8v 429.495n 1.8v 429.505n 1.8v 439.495n 1.8v 439.505n 1.8v 449.495n 1.8v 449.505n 0.0v 459.495n 0.0v 459.505n 1.8v 469.495n 1.8v 469.505n 0.0v 479.495n 0.0v 479.505n 0.0v 489.495n 0.0v 489.505n 0.0v 499.495n 0.0v 499.505n 0.0v 509.495n 0.0v 509.505n 0.0v 519.495n 0.0v 519.505n 0.0v 529.495n 0.0v 529.505n 0.0v 539.495n 0.0v 539.505n 1.8v 549.495n 1.8v 549.505n 1.8v 559.495n 1.8v 559.505n 1.8v 569.495n 1.8v 569.505n 1.8v 579.495n 1.8v 579.505n 1.8v 589.495n 1.8v 589.505n 0.0v 599.495n 0.0v 599.505n 1.8v 609.495n 1.8v 609.505n 1.8v 619.495n 1.8v 619.505n 1.8v 629.495n 1.8v 629.505n 1.8v 639.495n 1.8v 639.505n 1.8v 649.495n 1.8v 649.505n 1.8v 659.495n 1.8v 659.505n 0.0v 669.495n 0.0v 669.505n 0.0v 679.495n 0.0v 679.505n 0.0v 689.495n 0.0v 689.505n 1.8v 699.495n 1.8v 699.505n 0.0v 709.495n 0.0v 709.505n 0.0v 719.495n 0.0v 719.505n 0.0v 729.495n 0.0v 729.505n 0.0v 739.495n 0.0v 739.505n 0.0v 749.495n 0.0v 749.505n 0.0v 759.495n 0.0v 759.505n 0.0v 769.495n 0.0v 769.505n 0.0v 779.495n 0.0v 779.505n 0.0v 789.495n 0.0v 789.505n 0.0v 799.495n 0.0v 799.505n 0.0v 809.495n 0.0v 809.505n 0.0v 819.495n 0.0v 819.505n 0.0v 829.495n 0.0v 829.505n 1.8v 839.495n 1.8v 839.505n 1.8v 849.495n 1.8v 849.505n 1.8v 859.495n 1.8v 859.505n 1.8v 869.495n 1.8v 869.505n 1.8v 879.495n 1.8v 879.505n 0.0v 889.495n 0.0v 889.505n 0.0v 899.495n 0.0v 899.505n 1.8v 909.495n 1.8v 909.505n 1.8v 919.495n 1.8v 919.505n 1.8v 929.495n 1.8v 929.505n 1.8v 939.495n 1.8v 939.505n 1.8v 949.495n 1.8v 949.505n 1.8v 959.495n 1.8v 959.505n 1.8v 969.495n 1.8v 969.505n 1.8v 979.495n 1.8v 979.505n 1.8v 989.495n 1.8v 989.505n 1.8v 999.495n 1.8v 999.505n 1.8v 1009.495n 1.8v 1009.505n 1.8v 1019.495n 1.8v 1019.505n 1.8v 1029.495n 1.8v 1029.505n 1.8v 1039.495n 1.8v 1039.505n 1.8v 1049.495n 1.8v 1049.505n 1.8v 1059.495n 1.8v 1059.505n 1.8v 1069.495n 1.8v 1069.505n 1.8v 1079.495n 1.8v 1079.505n 0.0v 1089.495n 0.0v 1089.505n 1.8v 1099.495n 1.8v 1099.505n 1.8v 1109.495n 1.8v 1109.505n 1.8v 1119.495n 1.8v 1119.505n 1.8v 1129.495n 1.8v 1129.505n 1.8v 1139.495n 1.8v 1139.505n 0.0v 1149.495n 0.0v 1149.505n 0.0v 1159.495n 0.0v 1159.505n 0.0v 1169.495n 0.0v 1169.505n 0.0v 1179.495n 0.0v 1179.505n 0.0v 1189.495n 0.0v 1189.505n 0.0v 1199.495n 0.0v 1199.505n 0.0v 1209.495n 0.0v 1209.505n 0.0v 1219.495n 0.0v 1219.505n 0.0v 1229.495n 0.0v 1229.505n 0.0v 1239.495n 0.0v 1239.505n 0.0v 1249.495n 0.0v 1249.505n 0.0v 1259.495n 0.0v 1259.505n 0.0v 1269.495n 0.0v 1269.505n 0.0v 1279.495n 0.0v 1279.505n 0.0v 1289.495n 0.0v 1289.505n 0.0v 1299.495n 0.0v 1299.505n 0.0v 1309.495n 0.0v 1309.505n 1.8v 1319.495n 1.8v 1319.505n 1.8v 1329.495n 1.8v 1329.505n 1.8v 1339.495n 1.8v 1339.505n 1.8v 1349.495n 1.8v 1349.505n 1.8v 1359.495n 1.8v 1359.505n 1.8v 1369.495n 1.8v 1369.505n 1.8v 1379.495n 1.8v 1379.505n 1.8v 1389.495n 1.8v 1389.505n 1.8v 1399.495n 1.8v 1399.505n 1.8v 1409.495n 1.8v 1409.505n 0.0v 1419.495n 0.0v 1419.505n 0.0v 1429.495n 0.0v 1429.505n 1.8v 1439.495n 1.8v 1439.505n 0.0v 1449.495n 0.0v 1449.505n 0.0v 1459.495n 0.0v 1459.505n 0.0v 1469.495n 0.0v 1469.505n 1.8v 1479.495n 1.8v 1479.505n 1.8v 1489.495n 1.8v 1489.505n 1.8v 1499.495n 1.8v 1499.505n 1.8v 1509.495n 1.8v 1509.505n 1.8v 1519.495n 1.8v 1519.505n 1.8v 1529.495n 1.8v 1529.505n 1.8v 1539.495n 1.8v 1539.505n 1.8v 1549.495n 1.8v 1549.505n 1.8v 1559.495n 1.8v 1559.505n 1.8v 1569.495n 1.8v 1569.505n 1.8v 1579.495n 1.8v 1579.505n 0.0v 1589.495n 0.0v 1589.505n 0.0v 1599.495n 0.0v 1599.505n 0.0v 1609.495n 0.0v 1609.505n 0.0v 1619.495n 0.0v 1619.505n 0.0v 1629.495n 0.0v 1629.505n 1.8v 1639.495n 1.8v 1639.505n 1.8v 1649.495n 1.8v 1649.505n 1.8v 1659.495n 1.8v 1659.505n 1.8v 1669.495n 1.8v 1669.505n 1.8v 1679.495n 1.8v 1679.505n 1.8v 1689.495n 1.8v 1689.505n 1.8v 1699.495n 1.8v 1699.505n 1.8v 1709.495n 1.8v 1709.505n 0.0v 1719.495n 0.0v 1719.505n 0.0v 1729.495n 0.0v 1729.505n 0.0v 1739.495n 0.0v 1739.505n 0.0v 1749.495n 0.0v 1749.505n 0.0v 1759.495n 0.0v 1759.505n 0.0v 1769.495n 0.0v 1769.505n 0.0v 1779.495n 0.0v 1779.505n 0.0v 1789.495n 0.0v 1789.505n 0.0v 1799.495n 0.0v 1799.505n 0.0v 1809.495n 0.0v 1809.505n 0.0v 1819.495n 0.0v 1819.505n 0.0v 1829.495n 0.0v 1829.505n 0.0v 1839.495n 0.0v 1839.505n 0.0v 1849.495n 0.0v 1849.505n 0.0v 1859.495n 0.0v 1859.505n 1.8v 1869.495n 1.8v 1869.505n 1.8v 1879.495n 1.8v 1879.505n 1.8v 1889.495n 1.8v 1889.505n 1.8v 1899.495n 1.8v 1899.505n 1.8v 1909.495n 1.8v 1909.505n 0.0v 1919.495n 0.0v 1919.505n 0.0v 1929.495n 0.0v 1929.505n 0.0v 1939.495n 0.0v 1939.505n 0.0v 1949.495n 0.0v 1949.505n 0.0v 1959.495n 0.0v 1959.505n 0.0v 1969.495n 0.0v 1969.505n 0.0v 1979.495n 0.0v 1979.505n 0.0v 1989.495n 0.0v 1989.505n 0.0v 1999.495n 0.0v 1999.505n 0.0v 2009.495n 0.0v 2009.505n 0.0v 2019.495n 0.0v 2019.505n 0.0v 2029.495n 0.0v 2029.505n 0.0v 2039.495n 0.0v 2039.505n 0.0v 2049.495n 0.0v 2049.505n 0.0v )
* (time, data): [(0, 0), (10, 0), (20, 0), (30, 1), (40, 1), (50, 1), (60, 1), (70, 1), (80, 1), (90, 1), (100, 1), (110, 1), (120, 1), (130, 1), (140, 1), (150, 1), (160, 1), (170, 1), (180, 1), (190, 1), (200, 1), (210, 1), (220, 1), (230, 1), (240, 1), (250, 1), (260, 0), (270, 0), (280, 1), (290, 1), (300, 1), (310, 1), (320, 1), (330, 1), (340, 1), (350, 1), (360, 1), (370, 1), (380, 1), (390, 1), (400, 0), (410, 0), (420, 0), (430, 0), (440, 0), (450, 1), (460, 0), (470, 1), (480, 1), (490, 1), (500, 1), (510, 1), (520, 1), (530, 1), (540, 0), (550, 0), (560, 0), (570, 0), (580, 0), (590, 0), (600, 1), (610, 1), (620, 1), (630, 1), (640, 1), (650, 1), (660, 0), (670, 0), (680, 0), (690, 1), (700, 1), (710, 1), (720, 1), (730, 1), (740, 1), (750, 1), (760, 1), (770, 0), (780, 0), (790, 0), (800, 0), (810, 0), (820, 0), (830, 1), (840, 1), (850, 1), (860, 1), (870, 1), (880, 1), (890, 1), (900, 0), (910, 0), (920, 0), (930, 0), (940, 1), (950, 1), (960, 1), (970, 1), (980, 1), (990, 1), (1000, 1), (1010, 1), (1020, 1), (1030, 1), (1040, 1), (1050, 1), (1060, 1), (1070, 1), (1080, 1), (1090, 0), (1100, 0), (1110, 0), (1120, 0), (1130, 0), (1140, 1), (1150, 1), (1160, 1), (1170, 1), (1180, 1), (1190, 1), (1200, 1), (1210, 1), (1220, 1), (1230, 1), (1240, 1), (1250, 1), (1260, 0), (1270, 0), (1280, 0), (1290, 0), (1300, 1), (1310, 1), (1320, 1), (1330, 1), (1340, 1), (1350, 1), (1360, 0), (1370, 0), (1380, 0), (1390, 0), (1400, 0), (1410, 0), (1420, 0), (1430, 0), (1440, 0), (1450, 0), (1460, 0), (1470, 1), (1480, 1), (1490, 1), (1500, 1), (1510, 1), (1520, 1), (1530, 1), (1540, 1), (1550, 1), (1560, 1), (1570, 1), (1580, 1), (1590, 1), (1600, 1), (1610, 1), (1620, 1), (1630, 1), (1640, 1), (1650, 1), (1660, 1), (1670, 1), (1680, 1), (1690, 1), (1700, 1), (1710, 1), (1720, 1), (1730, 1), (1740, 1), (1750, 1), (1760, 1), (1770, 1), (1780, 1), (1790, 1), (1800, 0), (1810, 0), (1820, 0), (1830, 0), (1840, 1), (1850, 1), (1860, 0), (1870, 0), (1880, 0), (1890, 0), (1900, 0), (1910, 0), (1920, 0), (1930, 0), (1940, 0), (1950, 0), (1960, 1), (1970, 1), (1980, 1), (1990, 1), (2000, 1), (2010, 1), (2020, 1), (2030, 0), (2040, 1), (2050, 1)]
Vdin0_3  din0_3  0 PWL (0n 0.0v 9.495n 0.0v 9.505n 0.0v 19.495n 0.0v 19.505n 0.0v 29.495n 0.0v 29.505n 1.8v 39.495n 1.8v 39.505n 1.8v 49.495n 1.8v 49.505n 1.8v 59.495n 1.8v 59.505n 1.8v 69.495n 1.8v 69.505n 1.8v 79.495n 1.8v 79.505n 1.8v 89.495n 1.8v 89.505n 1.8v 99.495n 1.8v 99.505n 1.8v 109.495n 1.8v 109.505n 1.8v 119.495n 1.8v 119.505n 1.8v 129.495n 1.8v 129.505n 1.8v 139.495n 1.8v 139.505n 1.8v 149.495n 1.8v 149.505n 1.8v 159.495n 1.8v 159.505n 1.8v 169.495n 1.8v 169.505n 1.8v 179.495n 1.8v 179.505n 1.8v 189.495n 1.8v 189.505n 1.8v 199.495n 1.8v 199.505n 1.8v 209.495n 1.8v 209.505n 1.8v 219.495n 1.8v 219.505n 1.8v 229.495n 1.8v 229.505n 1.8v 239.495n 1.8v 239.505n 1.8v 249.495n 1.8v 249.505n 1.8v 259.495n 1.8v 259.505n 0.0v 269.495n 0.0v 269.505n 0.0v 279.495n 0.0v 279.505n 1.8v 289.495n 1.8v 289.505n 1.8v 299.495n 1.8v 299.505n 1.8v 309.495n 1.8v 309.505n 1.8v 319.495n 1.8v 319.505n 1.8v 329.495n 1.8v 329.505n 1.8v 339.495n 1.8v 339.505n 1.8v 349.495n 1.8v 349.505n 1.8v 359.495n 1.8v 359.505n 1.8v 369.495n 1.8v 369.505n 1.8v 379.495n 1.8v 379.505n 1.8v 389.495n 1.8v 389.505n 1.8v 399.495n 1.8v 399.505n 0.0v 409.495n 0.0v 409.505n 0.0v 419.495n 0.0v 419.505n 0.0v 429.495n 0.0v 429.505n 0.0v 439.495n 0.0v 439.505n 0.0v 449.495n 0.0v 449.505n 1.8v 459.495n 1.8v 459.505n 0.0v 469.495n 0.0v 469.505n 1.8v 479.495n 1.8v 479.505n 1.8v 489.495n 1.8v 489.505n 1.8v 499.495n 1.8v 499.505n 1.8v 509.495n 1.8v 509.505n 1.8v 519.495n 1.8v 519.505n 1.8v 529.495n 1.8v 529.505n 1.8v 539.495n 1.8v 539.505n 0.0v 549.495n 0.0v 549.505n 0.0v 559.495n 0.0v 559.505n 0.0v 569.495n 0.0v 569.505n 0.0v 579.495n 0.0v 579.505n 0.0v 589.495n 0.0v 589.505n 0.0v 599.495n 0.0v 599.505n 1.8v 609.495n 1.8v 609.505n 1.8v 619.495n 1.8v 619.505n 1.8v 629.495n 1.8v 629.505n 1.8v 639.495n 1.8v 639.505n 1.8v 649.495n 1.8v 649.505n 1.8v 659.495n 1.8v 659.505n 0.0v 669.495n 0.0v 669.505n 0.0v 679.495n 0.0v 679.505n 0.0v 689.495n 0.0v 689.505n 1.8v 699.495n 1.8v 699.505n 1.8v 709.495n 1.8v 709.505n 1.8v 719.495n 1.8v 719.505n 1.8v 729.495n 1.8v 729.505n 1.8v 739.495n 1.8v 739.505n 1.8v 749.495n 1.8v 749.505n 1.8v 759.495n 1.8v 759.505n 1.8v 769.495n 1.8v 769.505n 0.0v 779.495n 0.0v 779.505n 0.0v 789.495n 0.0v 789.505n 0.0v 799.495n 0.0v 799.505n 0.0v 809.495n 0.0v 809.505n 0.0v 819.495n 0.0v 819.505n 0.0v 829.495n 0.0v 829.505n 1.8v 839.495n 1.8v 839.505n 1.8v 849.495n 1.8v 849.505n 1.8v 859.495n 1.8v 859.505n 1.8v 869.495n 1.8v 869.505n 1.8v 879.495n 1.8v 879.505n 1.8v 889.495n 1.8v 889.505n 1.8v 899.495n 1.8v 899.505n 0.0v 909.495n 0.0v 909.505n 0.0v 919.495n 0.0v 919.505n 0.0v 929.495n 0.0v 929.505n 0.0v 939.495n 0.0v 939.505n 1.8v 949.495n 1.8v 949.505n 1.8v 959.495n 1.8v 959.505n 1.8v 969.495n 1.8v 969.505n 1.8v 979.495n 1.8v 979.505n 1.8v 989.495n 1.8v 989.505n 1.8v 999.495n 1.8v 999.505n 1.8v 1009.495n 1.8v 1009.505n 1.8v 1019.495n 1.8v 1019.505n 1.8v 1029.495n 1.8v 1029.505n 1.8v 1039.495n 1.8v 1039.505n 1.8v 1049.495n 1.8v 1049.505n 1.8v 1059.495n 1.8v 1059.505n 1.8v 1069.495n 1.8v 1069.505n 1.8v 1079.495n 1.8v 1079.505n 1.8v 1089.495n 1.8v 1089.505n 0.0v 1099.495n 0.0v 1099.505n 0.0v 1109.495n 0.0v 1109.505n 0.0v 1119.495n 0.0v 1119.505n 0.0v 1129.495n 0.0v 1129.505n 0.0v 1139.495n 0.0v 1139.505n 1.8v 1149.495n 1.8v 1149.505n 1.8v 1159.495n 1.8v 1159.505n 1.8v 1169.495n 1.8v 1169.505n 1.8v 1179.495n 1.8v 1179.505n 1.8v 1189.495n 1.8v 1189.505n 1.8v 1199.495n 1.8v 1199.505n 1.8v 1209.495n 1.8v 1209.505n 1.8v 1219.495n 1.8v 1219.505n 1.8v 1229.495n 1.8v 1229.505n 1.8v 1239.495n 1.8v 1239.505n 1.8v 1249.495n 1.8v 1249.505n 1.8v 1259.495n 1.8v 1259.505n 0.0v 1269.495n 0.0v 1269.505n 0.0v 1279.495n 0.0v 1279.505n 0.0v 1289.495n 0.0v 1289.505n 0.0v 1299.495n 0.0v 1299.505n 1.8v 1309.495n 1.8v 1309.505n 1.8v 1319.495n 1.8v 1319.505n 1.8v 1329.495n 1.8v 1329.505n 1.8v 1339.495n 1.8v 1339.505n 1.8v 1349.495n 1.8v 1349.505n 1.8v 1359.495n 1.8v 1359.505n 0.0v 1369.495n 0.0v 1369.505n 0.0v 1379.495n 0.0v 1379.505n 0.0v 1389.495n 0.0v 1389.505n 0.0v 1399.495n 0.0v 1399.505n 0.0v 1409.495n 0.0v 1409.505n 0.0v 1419.495n 0.0v 1419.505n 0.0v 1429.495n 0.0v 1429.505n 0.0v 1439.495n 0.0v 1439.505n 0.0v 1449.495n 0.0v 1449.505n 0.0v 1459.495n 0.0v 1459.505n 0.0v 1469.495n 0.0v 1469.505n 1.8v 1479.495n 1.8v 1479.505n 1.8v 1489.495n 1.8v 1489.505n 1.8v 1499.495n 1.8v 1499.505n 1.8v 1509.495n 1.8v 1509.505n 1.8v 1519.495n 1.8v 1519.505n 1.8v 1529.495n 1.8v 1529.505n 1.8v 1539.495n 1.8v 1539.505n 1.8v 1549.495n 1.8v 1549.505n 1.8v 1559.495n 1.8v 1559.505n 1.8v 1569.495n 1.8v 1569.505n 1.8v 1579.495n 1.8v 1579.505n 1.8v 1589.495n 1.8v 1589.505n 1.8v 1599.495n 1.8v 1599.505n 1.8v 1609.495n 1.8v 1609.505n 1.8v 1619.495n 1.8v 1619.505n 1.8v 1629.495n 1.8v 1629.505n 1.8v 1639.495n 1.8v 1639.505n 1.8v 1649.495n 1.8v 1649.505n 1.8v 1659.495n 1.8v 1659.505n 1.8v 1669.495n 1.8v 1669.505n 1.8v 1679.495n 1.8v 1679.505n 1.8v 1689.495n 1.8v 1689.505n 1.8v 1699.495n 1.8v 1699.505n 1.8v 1709.495n 1.8v 1709.505n 1.8v 1719.495n 1.8v 1719.505n 1.8v 1729.495n 1.8v 1729.505n 1.8v 1739.495n 1.8v 1739.505n 1.8v 1749.495n 1.8v 1749.505n 1.8v 1759.495n 1.8v 1759.505n 1.8v 1769.495n 1.8v 1769.505n 1.8v 1779.495n 1.8v 1779.505n 1.8v 1789.495n 1.8v 1789.505n 1.8v 1799.495n 1.8v 1799.505n 0.0v 1809.495n 0.0v 1809.505n 0.0v 1819.495n 0.0v 1819.505n 0.0v 1829.495n 0.0v 1829.505n 0.0v 1839.495n 0.0v 1839.505n 1.8v 1849.495n 1.8v 1849.505n 1.8v 1859.495n 1.8v 1859.505n 0.0v 1869.495n 0.0v 1869.505n 0.0v 1879.495n 0.0v 1879.505n 0.0v 1889.495n 0.0v 1889.505n 0.0v 1899.495n 0.0v 1899.505n 0.0v 1909.495n 0.0v 1909.505n 0.0v 1919.495n 0.0v 1919.505n 0.0v 1929.495n 0.0v 1929.505n 0.0v 1939.495n 0.0v 1939.505n 0.0v 1949.495n 0.0v 1949.505n 0.0v 1959.495n 0.0v 1959.505n 1.8v 1969.495n 1.8v 1969.505n 1.8v 1979.495n 1.8v 1979.505n 1.8v 1989.495n 1.8v 1989.505n 1.8v 1999.495n 1.8v 1999.505n 1.8v 2009.495n 1.8v 2009.505n 1.8v 2019.495n 1.8v 2019.505n 1.8v 2029.495n 1.8v 2029.505n 0.0v 2039.495n 0.0v 2039.505n 1.8v 2049.495n 1.8v 2049.505n 1.8v )
* (time, data): [(0, 0), (10, 0), (20, 0), (30, 0), (40, 0), (50, 0), (60, 1), (70, 1), (80, 0), (90, 0), (100, 0), (110, 0), (120, 1), (130, 1), (140, 1), (150, 1), (160, 1), (170, 1), (180, 1), (190, 1), (200, 1), (210, 1), (220, 1), (230, 1), (240, 1), (250, 1), (260, 1), (270, 1), (280, 0), (290, 0), (300, 0), (310, 0), (320, 0), (330, 0), (340, 0), (350, 0), (360, 0), (370, 0), (380, 0), (390, 0), (400, 1), (410, 1), (420, 1), (430, 1), (440, 1), (450, 1), (460, 0), (470, 0), (480, 0), (490, 0), (500, 0), (510, 0), (520, 0), (530, 0), (540, 1), (550, 1), (560, 1), (570, 1), (580, 1), (590, 1), (600, 0), (610, 0), (620, 0), (630, 1), (640, 1), (650, 1), (660, 1), (670, 1), (680, 1), (690, 1), (700, 1), (710, 1), (720, 1), (730, 1), (740, 1), (750, 1), (760, 1), (770, 0), (780, 0), (790, 0), (800, 0), (810, 0), (820, 0), (830, 1), (840, 1), (850, 1), (860, 1), (870, 1), (880, 0), (890, 0), (900, 0), (910, 0), (920, 0), (930, 0), (940, 0), (950, 0), (960, 0), (970, 0), (980, 0), (990, 0), (1000, 1), (1010, 1), (1020, 1), (1030, 1), (1040, 1), (1050, 1), (1060, 1), (1070, 1), (1080, 1), (1090, 0), (1100, 0), (1110, 0), (1120, 0), (1130, 0), (1140, 1), (1150, 1), (1160, 1), (1170, 1), (1180, 1), (1190, 1), (1200, 1), (1210, 1), (1220, 1), (1230, 1), (1240, 1), (1250, 1), (1260, 1), (1270, 1), (1280, 1), (1290, 1), (1300, 0), (1310, 1), (1320, 1), (1330, 1), (1340, 1), (1350, 1), (1360, 1), (1370, 1), (1380, 1), (1390, 1), (1400, 1), (1410, 0), (1420, 0), (1430, 0), (1440, 0), (1450, 0), (1460, 0), (1470, 0), (1480, 0), (1490, 1), (1500, 1), (1510, 1), (1520, 1), (1530, 1), (1540, 1), (1550, 1), (1560, 1), (1570, 1), (1580, 1), (1590, 0), (1600, 0), (1610, 0), (1620, 0), (1630, 1), (1640, 1), (1650, 1), (1660, 1), (1670, 1), (1680, 1), (1690, 1), (1700, 0), (1710, 1), (1720, 1), (1730, 1), (1740, 1), (1750, 1), (1760, 1), (1770, 1), (1780, 1), (1790, 1), (1800, 1), (1810, 1), (1820, 1), (1830, 1), (1840, 1), (1850, 1), (1860, 1), (1870, 1), (1880, 1), (1890, 1), (1900, 1), (1910, 0), (1920, 0), (1930, 0), (1940, 0), (1950, 0), (1960, 1), (1970, 1), (1980, 1), (1990, 1), (2000, 1), (2010, 1), (2020, 1), (2030, 0), (2040, 1), (2050, 1)]
Vdin0_4  din0_4  0 PWL (0n 0.0v 9.495n 0.0v 9.505n 0.0v 19.495n 0.0v 19.505n 0.0v 29.495n 0.0v 29.505n 0.0v 39.495n 0.0v 39.505n 0.0v 49.495n 0.0v 49.505n 0.0v 59.495n 0.0v 59.505n 1.8v 69.495n 1.8v 69.505n 1.8v 79.495n 1.8v 79.505n 0.0v 89.495n 0.0v 89.505n 0.0v 99.495n 0.0v 99.505n 0.0v 109.495n 0.0v 109.505n 0.0v 119.495n 0.0v 119.505n 1.8v 129.495n 1.8v 129.505n 1.8v 139.495n 1.8v 139.505n 1.8v 149.495n 1.8v 149.505n 1.8v 159.495n 1.8v 159.505n 1.8v 169.495n 1.8v 169.505n 1.8v 179.495n 1.8v 179.505n 1.8v 189.495n 1.8v 189.505n 1.8v 199.495n 1.8v 199.505n 1.8v 209.495n 1.8v 209.505n 1.8v 219.495n 1.8v 219.505n 1.8v 229.495n 1.8v 229.505n 1.8v 239.495n 1.8v 239.505n 1.8v 249.495n 1.8v 249.505n 1.8v 259.495n 1.8v 259.505n 1.8v 269.495n 1.8v 269.505n 1.8v 279.495n 1.8v 279.505n 0.0v 289.495n 0.0v 289.505n 0.0v 299.495n 0.0v 299.505n 0.0v 309.495n 0.0v 309.505n 0.0v 319.495n 0.0v 319.505n 0.0v 329.495n 0.0v 329.505n 0.0v 339.495n 0.0v 339.505n 0.0v 349.495n 0.0v 349.505n 0.0v 359.495n 0.0v 359.505n 0.0v 369.495n 0.0v 369.505n 0.0v 379.495n 0.0v 379.505n 0.0v 389.495n 0.0v 389.505n 0.0v 399.495n 0.0v 399.505n 1.8v 409.495n 1.8v 409.505n 1.8v 419.495n 1.8v 419.505n 1.8v 429.495n 1.8v 429.505n 1.8v 439.495n 1.8v 439.505n 1.8v 449.495n 1.8v 449.505n 1.8v 459.495n 1.8v 459.505n 0.0v 469.495n 0.0v 469.505n 0.0v 479.495n 0.0v 479.505n 0.0v 489.495n 0.0v 489.505n 0.0v 499.495n 0.0v 499.505n 0.0v 509.495n 0.0v 509.505n 0.0v 519.495n 0.0v 519.505n 0.0v 529.495n 0.0v 529.505n 0.0v 539.495n 0.0v 539.505n 1.8v 549.495n 1.8v 549.505n 1.8v 559.495n 1.8v 559.505n 1.8v 569.495n 1.8v 569.505n 1.8v 579.495n 1.8v 579.505n 1.8v 589.495n 1.8v 589.505n 1.8v 599.495n 1.8v 599.505n 0.0v 609.495n 0.0v 609.505n 0.0v 619.495n 0.0v 619.505n 0.0v 629.495n 0.0v 629.505n 1.8v 639.495n 1.8v 639.505n 1.8v 649.495n 1.8v 649.505n 1.8v 659.495n 1.8v 659.505n 1.8v 669.495n 1.8v 669.505n 1.8v 679.495n 1.8v 679.505n 1.8v 689.495n 1.8v 689.505n 1.8v 699.495n 1.8v 699.505n 1.8v 709.495n 1.8v 709.505n 1.8v 719.495n 1.8v 719.505n 1.8v 729.495n 1.8v 729.505n 1.8v 739.495n 1.8v 739.505n 1.8v 749.495n 1.8v 749.505n 1.8v 759.495n 1.8v 759.505n 1.8v 769.495n 1.8v 769.505n 0.0v 779.495n 0.0v 779.505n 0.0v 789.495n 0.0v 789.505n 0.0v 799.495n 0.0v 799.505n 0.0v 809.495n 0.0v 809.505n 0.0v 819.495n 0.0v 819.505n 0.0v 829.495n 0.0v 829.505n 1.8v 839.495n 1.8v 839.505n 1.8v 849.495n 1.8v 849.505n 1.8v 859.495n 1.8v 859.505n 1.8v 869.495n 1.8v 869.505n 1.8v 879.495n 1.8v 879.505n 0.0v 889.495n 0.0v 889.505n 0.0v 899.495n 0.0v 899.505n 0.0v 909.495n 0.0v 909.505n 0.0v 919.495n 0.0v 919.505n 0.0v 929.495n 0.0v 929.505n 0.0v 939.495n 0.0v 939.505n 0.0v 949.495n 0.0v 949.505n 0.0v 959.495n 0.0v 959.505n 0.0v 969.495n 0.0v 969.505n 0.0v 979.495n 0.0v 979.505n 0.0v 989.495n 0.0v 989.505n 0.0v 999.495n 0.0v 999.505n 1.8v 1009.495n 1.8v 1009.505n 1.8v 1019.495n 1.8v 1019.505n 1.8v 1029.495n 1.8v 1029.505n 1.8v 1039.495n 1.8v 1039.505n 1.8v 1049.495n 1.8v 1049.505n 1.8v 1059.495n 1.8v 1059.505n 1.8v 1069.495n 1.8v 1069.505n 1.8v 1079.495n 1.8v 1079.505n 1.8v 1089.495n 1.8v 1089.505n 0.0v 1099.495n 0.0v 1099.505n 0.0v 1109.495n 0.0v 1109.505n 0.0v 1119.495n 0.0v 1119.505n 0.0v 1129.495n 0.0v 1129.505n 0.0v 1139.495n 0.0v 1139.505n 1.8v 1149.495n 1.8v 1149.505n 1.8v 1159.495n 1.8v 1159.505n 1.8v 1169.495n 1.8v 1169.505n 1.8v 1179.495n 1.8v 1179.505n 1.8v 1189.495n 1.8v 1189.505n 1.8v 1199.495n 1.8v 1199.505n 1.8v 1209.495n 1.8v 1209.505n 1.8v 1219.495n 1.8v 1219.505n 1.8v 1229.495n 1.8v 1229.505n 1.8v 1239.495n 1.8v 1239.505n 1.8v 1249.495n 1.8v 1249.505n 1.8v 1259.495n 1.8v 1259.505n 1.8v 1269.495n 1.8v 1269.505n 1.8v 1279.495n 1.8v 1279.505n 1.8v 1289.495n 1.8v 1289.505n 1.8v 1299.495n 1.8v 1299.505n 0.0v 1309.495n 0.0v 1309.505n 1.8v 1319.495n 1.8v 1319.505n 1.8v 1329.495n 1.8v 1329.505n 1.8v 1339.495n 1.8v 1339.505n 1.8v 1349.495n 1.8v 1349.505n 1.8v 1359.495n 1.8v 1359.505n 1.8v 1369.495n 1.8v 1369.505n 1.8v 1379.495n 1.8v 1379.505n 1.8v 1389.495n 1.8v 1389.505n 1.8v 1399.495n 1.8v 1399.505n 1.8v 1409.495n 1.8v 1409.505n 0.0v 1419.495n 0.0v 1419.505n 0.0v 1429.495n 0.0v 1429.505n 0.0v 1439.495n 0.0v 1439.505n 0.0v 1449.495n 0.0v 1449.505n 0.0v 1459.495n 0.0v 1459.505n 0.0v 1469.495n 0.0v 1469.505n 0.0v 1479.495n 0.0v 1479.505n 0.0v 1489.495n 0.0v 1489.505n 1.8v 1499.495n 1.8v 1499.505n 1.8v 1509.495n 1.8v 1509.505n 1.8v 1519.495n 1.8v 1519.505n 1.8v 1529.495n 1.8v 1529.505n 1.8v 1539.495n 1.8v 1539.505n 1.8v 1549.495n 1.8v 1549.505n 1.8v 1559.495n 1.8v 1559.505n 1.8v 1569.495n 1.8v 1569.505n 1.8v 1579.495n 1.8v 1579.505n 1.8v 1589.495n 1.8v 1589.505n 0.0v 1599.495n 0.0v 1599.505n 0.0v 1609.495n 0.0v 1609.505n 0.0v 1619.495n 0.0v 1619.505n 0.0v 1629.495n 0.0v 1629.505n 1.8v 1639.495n 1.8v 1639.505n 1.8v 1649.495n 1.8v 1649.505n 1.8v 1659.495n 1.8v 1659.505n 1.8v 1669.495n 1.8v 1669.505n 1.8v 1679.495n 1.8v 1679.505n 1.8v 1689.495n 1.8v 1689.505n 1.8v 1699.495n 1.8v 1699.505n 0.0v 1709.495n 0.0v 1709.505n 1.8v 1719.495n 1.8v 1719.505n 1.8v 1729.495n 1.8v 1729.505n 1.8v 1739.495n 1.8v 1739.505n 1.8v 1749.495n 1.8v 1749.505n 1.8v 1759.495n 1.8v 1759.505n 1.8v 1769.495n 1.8v 1769.505n 1.8v 1779.495n 1.8v 1779.505n 1.8v 1789.495n 1.8v 1789.505n 1.8v 1799.495n 1.8v 1799.505n 1.8v 1809.495n 1.8v 1809.505n 1.8v 1819.495n 1.8v 1819.505n 1.8v 1829.495n 1.8v 1829.505n 1.8v 1839.495n 1.8v 1839.505n 1.8v 1849.495n 1.8v 1849.505n 1.8v 1859.495n 1.8v 1859.505n 1.8v 1869.495n 1.8v 1869.505n 1.8v 1879.495n 1.8v 1879.505n 1.8v 1889.495n 1.8v 1889.505n 1.8v 1899.495n 1.8v 1899.505n 1.8v 1909.495n 1.8v 1909.505n 0.0v 1919.495n 0.0v 1919.505n 0.0v 1929.495n 0.0v 1929.505n 0.0v 1939.495n 0.0v 1939.505n 0.0v 1949.495n 0.0v 1949.505n 0.0v 1959.495n 0.0v 1959.505n 1.8v 1969.495n 1.8v 1969.505n 1.8v 1979.495n 1.8v 1979.505n 1.8v 1989.495n 1.8v 1989.505n 1.8v 1999.495n 1.8v 1999.505n 1.8v 2009.495n 1.8v 2009.505n 1.8v 2019.495n 1.8v 2019.505n 1.8v 2029.495n 1.8v 2029.505n 0.0v 2039.495n 0.0v 2039.505n 1.8v 2049.495n 1.8v 2049.505n 1.8v )
* (time, data): [(0, 0), (10, 0), (20, 0), (30, 0), (40, 0), (50, 0), (60, 1), (70, 1), (80, 1), (90, 1), (100, 1), (110, 0), (120, 0), (130, 0), (140, 0), (150, 0), (160, 0), (170, 0), (180, 0), (190, 0), (200, 0), (210, 0), (220, 0), (230, 0), (240, 0), (250, 0), (260, 0), (270, 0), (280, 0), (290, 0), (300, 0), (310, 0), (320, 0), (330, 0), (340, 0), (350, 0), (360, 0), (370, 0), (380, 0), (390, 0), (400, 0), (410, 0), (420, 0), (430, 0), (440, 0), (450, 1), (460, 0), (470, 1), (480, 1), (490, 1), (500, 1), (510, 1), (520, 1), (530, 1), (540, 0), (550, 0), (560, 0), (570, 0), (580, 0), (590, 0), (600, 1), (610, 1), (620, 1), (630, 1), (640, 1), (650, 1), (660, 1), (670, 1), (680, 1), (690, 0), (700, 1), (710, 1), (720, 1), (730, 1), (740, 1), (750, 1), (760, 1), (770, 0), (780, 0), (790, 0), (800, 0), (810, 0), (820, 0), (830, 1), (840, 1), (850, 1), (860, 1), (870, 1), (880, 0), (890, 1), (900, 0), (910, 0), (920, 0), (930, 0), (940, 1), (950, 1), (960, 1), (970, 1), (980, 1), (990, 1), (1000, 0), (1010, 0), (1020, 0), (1030, 0), (1040, 0), (1050, 0), (1060, 0), (1070, 0), (1080, 1), (1090, 1), (1100, 1), (1110, 1), (1120, 1), (1130, 1), (1140, 0), (1150, 0), (1160, 0), (1170, 0), (1180, 0), (1190, 0), (1200, 0), (1210, 0), (1220, 0), (1230, 0), (1240, 0), (1250, 0), (1260, 1), (1270, 1), (1280, 1), (1290, 1), (1300, 1), (1310, 0), (1320, 0), (1330, 0), (1340, 0), (1350, 0), (1360, 0), (1370, 0), (1380, 0), (1390, 0), (1400, 0), (1410, 0), (1420, 0), (1430, 1), (1440, 1), (1450, 1), (1460, 0), (1470, 1), (1480, 1), (1490, 0), (1500, 0), (1510, 0), (1520, 0), (1530, 0), (1540, 0), (1550, 1), (1560, 1), (1570, 1), (1580, 1), (1590, 0), (1600, 0), (1610, 0), (1620, 0), (1630, 1), (1640, 1), (1650, 1), (1660, 1), (1670, 1), (1680, 1), (1690, 1), (1700, 0), (1710, 1), (1720, 1), (1730, 1), (1740, 1), (1750, 1), (1760, 1), (1770, 1), (1780, 1), (1790, 1), (1800, 1), (1810, 1), (1820, 1), (1830, 1), (1840, 0), (1850, 0), (1860, 1), (1870, 1), (1880, 1), (1890, 1), (1900, 1), (1910, 0), (1920, 0), (1930, 0), (1940, 0), (1950, 0), (1960, 0), (1970, 0), (1980, 0), (1990, 0), (2000, 0), (2010, 0), (2020, 0), (2030, 0), (2040, 0), (2050, 0)]
Vdin0_5  din0_5  0 PWL (0n 0.0v 9.495n 0.0v 9.505n 0.0v 19.495n 0.0v 19.505n 0.0v 29.495n 0.0v 29.505n 0.0v 39.495n 0.0v 39.505n 0.0v 49.495n 0.0v 49.505n 0.0v 59.495n 0.0v 59.505n 1.8v 69.495n 1.8v 69.505n 1.8v 79.495n 1.8v 79.505n 1.8v 89.495n 1.8v 89.505n 1.8v 99.495n 1.8v 99.505n 1.8v 109.495n 1.8v 109.505n 0.0v 119.495n 0.0v 119.505n 0.0v 129.495n 0.0v 129.505n 0.0v 139.495n 0.0v 139.505n 0.0v 149.495n 0.0v 149.505n 0.0v 159.495n 0.0v 159.505n 0.0v 169.495n 0.0v 169.505n 0.0v 179.495n 0.0v 179.505n 0.0v 189.495n 0.0v 189.505n 0.0v 199.495n 0.0v 199.505n 0.0v 209.495n 0.0v 209.505n 0.0v 219.495n 0.0v 219.505n 0.0v 229.495n 0.0v 229.505n 0.0v 239.495n 0.0v 239.505n 0.0v 249.495n 0.0v 249.505n 0.0v 259.495n 0.0v 259.505n 0.0v 269.495n 0.0v 269.505n 0.0v 279.495n 0.0v 279.505n 0.0v 289.495n 0.0v 289.505n 0.0v 299.495n 0.0v 299.505n 0.0v 309.495n 0.0v 309.505n 0.0v 319.495n 0.0v 319.505n 0.0v 329.495n 0.0v 329.505n 0.0v 339.495n 0.0v 339.505n 0.0v 349.495n 0.0v 349.505n 0.0v 359.495n 0.0v 359.505n 0.0v 369.495n 0.0v 369.505n 0.0v 379.495n 0.0v 379.505n 0.0v 389.495n 0.0v 389.505n 0.0v 399.495n 0.0v 399.505n 0.0v 409.495n 0.0v 409.505n 0.0v 419.495n 0.0v 419.505n 0.0v 429.495n 0.0v 429.505n 0.0v 439.495n 0.0v 439.505n 0.0v 449.495n 0.0v 449.505n 1.8v 459.495n 1.8v 459.505n 0.0v 469.495n 0.0v 469.505n 1.8v 479.495n 1.8v 479.505n 1.8v 489.495n 1.8v 489.505n 1.8v 499.495n 1.8v 499.505n 1.8v 509.495n 1.8v 509.505n 1.8v 519.495n 1.8v 519.505n 1.8v 529.495n 1.8v 529.505n 1.8v 539.495n 1.8v 539.505n 0.0v 549.495n 0.0v 549.505n 0.0v 559.495n 0.0v 559.505n 0.0v 569.495n 0.0v 569.505n 0.0v 579.495n 0.0v 579.505n 0.0v 589.495n 0.0v 589.505n 0.0v 599.495n 0.0v 599.505n 1.8v 609.495n 1.8v 609.505n 1.8v 619.495n 1.8v 619.505n 1.8v 629.495n 1.8v 629.505n 1.8v 639.495n 1.8v 639.505n 1.8v 649.495n 1.8v 649.505n 1.8v 659.495n 1.8v 659.505n 1.8v 669.495n 1.8v 669.505n 1.8v 679.495n 1.8v 679.505n 1.8v 689.495n 1.8v 689.505n 0.0v 699.495n 0.0v 699.505n 1.8v 709.495n 1.8v 709.505n 1.8v 719.495n 1.8v 719.505n 1.8v 729.495n 1.8v 729.505n 1.8v 739.495n 1.8v 739.505n 1.8v 749.495n 1.8v 749.505n 1.8v 759.495n 1.8v 759.505n 1.8v 769.495n 1.8v 769.505n 0.0v 779.495n 0.0v 779.505n 0.0v 789.495n 0.0v 789.505n 0.0v 799.495n 0.0v 799.505n 0.0v 809.495n 0.0v 809.505n 0.0v 819.495n 0.0v 819.505n 0.0v 829.495n 0.0v 829.505n 1.8v 839.495n 1.8v 839.505n 1.8v 849.495n 1.8v 849.505n 1.8v 859.495n 1.8v 859.505n 1.8v 869.495n 1.8v 869.505n 1.8v 879.495n 1.8v 879.505n 0.0v 889.495n 0.0v 889.505n 1.8v 899.495n 1.8v 899.505n 0.0v 909.495n 0.0v 909.505n 0.0v 919.495n 0.0v 919.505n 0.0v 929.495n 0.0v 929.505n 0.0v 939.495n 0.0v 939.505n 1.8v 949.495n 1.8v 949.505n 1.8v 959.495n 1.8v 959.505n 1.8v 969.495n 1.8v 969.505n 1.8v 979.495n 1.8v 979.505n 1.8v 989.495n 1.8v 989.505n 1.8v 999.495n 1.8v 999.505n 0.0v 1009.495n 0.0v 1009.505n 0.0v 1019.495n 0.0v 1019.505n 0.0v 1029.495n 0.0v 1029.505n 0.0v 1039.495n 0.0v 1039.505n 0.0v 1049.495n 0.0v 1049.505n 0.0v 1059.495n 0.0v 1059.505n 0.0v 1069.495n 0.0v 1069.505n 0.0v 1079.495n 0.0v 1079.505n 1.8v 1089.495n 1.8v 1089.505n 1.8v 1099.495n 1.8v 1099.505n 1.8v 1109.495n 1.8v 1109.505n 1.8v 1119.495n 1.8v 1119.505n 1.8v 1129.495n 1.8v 1129.505n 1.8v 1139.495n 1.8v 1139.505n 0.0v 1149.495n 0.0v 1149.505n 0.0v 1159.495n 0.0v 1159.505n 0.0v 1169.495n 0.0v 1169.505n 0.0v 1179.495n 0.0v 1179.505n 0.0v 1189.495n 0.0v 1189.505n 0.0v 1199.495n 0.0v 1199.505n 0.0v 1209.495n 0.0v 1209.505n 0.0v 1219.495n 0.0v 1219.505n 0.0v 1229.495n 0.0v 1229.505n 0.0v 1239.495n 0.0v 1239.505n 0.0v 1249.495n 0.0v 1249.505n 0.0v 1259.495n 0.0v 1259.505n 1.8v 1269.495n 1.8v 1269.505n 1.8v 1279.495n 1.8v 1279.505n 1.8v 1289.495n 1.8v 1289.505n 1.8v 1299.495n 1.8v 1299.505n 1.8v 1309.495n 1.8v 1309.505n 0.0v 1319.495n 0.0v 1319.505n 0.0v 1329.495n 0.0v 1329.505n 0.0v 1339.495n 0.0v 1339.505n 0.0v 1349.495n 0.0v 1349.505n 0.0v 1359.495n 0.0v 1359.505n 0.0v 1369.495n 0.0v 1369.505n 0.0v 1379.495n 0.0v 1379.505n 0.0v 1389.495n 0.0v 1389.505n 0.0v 1399.495n 0.0v 1399.505n 0.0v 1409.495n 0.0v 1409.505n 0.0v 1419.495n 0.0v 1419.505n 0.0v 1429.495n 0.0v 1429.505n 1.8v 1439.495n 1.8v 1439.505n 1.8v 1449.495n 1.8v 1449.505n 1.8v 1459.495n 1.8v 1459.505n 0.0v 1469.495n 0.0v 1469.505n 1.8v 1479.495n 1.8v 1479.505n 1.8v 1489.495n 1.8v 1489.505n 0.0v 1499.495n 0.0v 1499.505n 0.0v 1509.495n 0.0v 1509.505n 0.0v 1519.495n 0.0v 1519.505n 0.0v 1529.495n 0.0v 1529.505n 0.0v 1539.495n 0.0v 1539.505n 0.0v 1549.495n 0.0v 1549.505n 1.8v 1559.495n 1.8v 1559.505n 1.8v 1569.495n 1.8v 1569.505n 1.8v 1579.495n 1.8v 1579.505n 1.8v 1589.495n 1.8v 1589.505n 0.0v 1599.495n 0.0v 1599.505n 0.0v 1609.495n 0.0v 1609.505n 0.0v 1619.495n 0.0v 1619.505n 0.0v 1629.495n 0.0v 1629.505n 1.8v 1639.495n 1.8v 1639.505n 1.8v 1649.495n 1.8v 1649.505n 1.8v 1659.495n 1.8v 1659.505n 1.8v 1669.495n 1.8v 1669.505n 1.8v 1679.495n 1.8v 1679.505n 1.8v 1689.495n 1.8v 1689.505n 1.8v 1699.495n 1.8v 1699.505n 0.0v 1709.495n 0.0v 1709.505n 1.8v 1719.495n 1.8v 1719.505n 1.8v 1729.495n 1.8v 1729.505n 1.8v 1739.495n 1.8v 1739.505n 1.8v 1749.495n 1.8v 1749.505n 1.8v 1759.495n 1.8v 1759.505n 1.8v 1769.495n 1.8v 1769.505n 1.8v 1779.495n 1.8v 1779.505n 1.8v 1789.495n 1.8v 1789.505n 1.8v 1799.495n 1.8v 1799.505n 1.8v 1809.495n 1.8v 1809.505n 1.8v 1819.495n 1.8v 1819.505n 1.8v 1829.495n 1.8v 1829.505n 1.8v 1839.495n 1.8v 1839.505n 0.0v 1849.495n 0.0v 1849.505n 0.0v 1859.495n 0.0v 1859.505n 1.8v 1869.495n 1.8v 1869.505n 1.8v 1879.495n 1.8v 1879.505n 1.8v 1889.495n 1.8v 1889.505n 1.8v 1899.495n 1.8v 1899.505n 1.8v 1909.495n 1.8v 1909.505n 0.0v 1919.495n 0.0v 1919.505n 0.0v 1929.495n 0.0v 1929.505n 0.0v 1939.495n 0.0v 1939.505n 0.0v 1949.495n 0.0v 1949.505n 0.0v 1959.495n 0.0v 1959.505n 0.0v 1969.495n 0.0v 1969.505n 0.0v 1979.495n 0.0v 1979.505n 0.0v 1989.495n 0.0v 1989.505n 0.0v 1999.495n 0.0v 1999.505n 0.0v 2009.495n 0.0v 2009.505n 0.0v 2019.495n 0.0v 2019.505n 0.0v 2029.495n 0.0v 2029.505n 0.0v 2039.495n 0.0v 2039.505n 0.0v 2049.495n 0.0v 2049.505n 0.0v )
* (time, data): [(0, 0), (10, 1), (20, 0), (30, 0), (40, 0), (50, 0), (60, 0), (70, 0), (80, 0), (90, 0), (100, 0), (110, 0), (120, 0), (130, 0), (140, 0), (150, 0), (160, 0), (170, 0), (180, 0), (190, 0), (200, 0), (210, 0), (220, 0), (230, 0), (240, 0), (250, 0), (260, 0), (270, 0), (280, 1), (290, 1), (300, 1), (310, 1), (320, 1), (330, 1), (340, 1), (350, 1), (360, 1), (370, 1), (380, 1), (390, 1), (400, 0), (410, 0), (420, 0), (430, 0), (440, 0), (450, 1), (460, 0), (470, 0), (480, 0), (490, 0), (500, 0), (510, 0), (520, 0), (530, 0), (540, 0), (550, 0), (560, 0), (570, 0), (580, 0), (590, 1), (600, 1), (610, 1), (620, 1), (630, 0), (640, 0), (650, 0), (660, 1), (670, 1), (680, 1), (690, 1), (700, 0), (710, 0), (720, 0), (730, 0), (740, 0), (750, 0), (760, 0), (770, 1), (780, 1), (790, 1), (800, 1), (810, 1), (820, 1), (830, 0), (840, 0), (850, 0), (860, 0), (870, 0), (880, 0), (890, 1), (900, 0), (910, 0), (920, 0), (930, 0), (940, 1), (950, 1), (960, 1), (970, 1), (980, 1), (990, 1), (1000, 1), (1010, 1), (1020, 0), (1030, 0), (1040, 0), (1050, 0), (1060, 0), (1070, 0), (1080, 1), (1090, 0), (1100, 0), (1110, 0), (1120, 0), (1130, 0), (1140, 0), (1150, 0), (1160, 0), (1170, 0), (1180, 0), (1190, 0), (1200, 0), (1210, 0), (1220, 0), (1230, 0), (1240, 0), (1250, 0), (1260, 0), (1270, 0), (1280, 0), (1290, 0), (1300, 1), (1310, 0), (1320, 0), (1330, 0), (1340, 0), (1350, 0), (1360, 1), (1370, 1), (1380, 1), (1390, 1), (1400, 1), (1410, 0), (1420, 0), (1430, 0), (1440, 0), (1450, 0), (1460, 1), (1470, 0), (1480, 0), (1490, 1), (1500, 1), (1510, 1), (1520, 1), (1530, 1), (1540, 1), (1550, 1), (1560, 1), (1570, 1), (1580, 0), (1590, 0), (1600, 0), (1610, 0), (1620, 0), (1630, 0), (1640, 0), (1650, 0), (1660, 0), (1670, 0), (1680, 0), (1690, 0), (1700, 0), (1710, 1), (1720, 1), (1730, 0), (1740, 0), (1750, 0), (1760, 0), (1770, 0), (1780, 0), (1790, 0), (1800, 1), (1810, 1), (1820, 1), (1830, 1), (1840, 0), (1850, 0), (1860, 1), (1870, 1), (1880, 1), (1890, 1), (1900, 1), (1910, 1), (1920, 1), (1930, 1), (1940, 1), (1950, 1), (1960, 0), (1970, 0), (1980, 0), (1990, 0), (2000, 0), (2010, 0), (2020, 0), (2030, 0), (2040, 0), (2050, 0)]
Vdin0_6  din0_6  0 PWL (0n 0.0v 9.495n 0.0v 9.505n 1.8v 19.495n 1.8v 19.505n 0.0v 29.495n 0.0v 29.505n 0.0v 39.495n 0.0v 39.505n 0.0v 49.495n 0.0v 49.505n 0.0v 59.495n 0.0v 59.505n 0.0v 69.495n 0.0v 69.505n 0.0v 79.495n 0.0v 79.505n 0.0v 89.495n 0.0v 89.505n 0.0v 99.495n 0.0v 99.505n 0.0v 109.495n 0.0v 109.505n 0.0v 119.495n 0.0v 119.505n 0.0v 129.495n 0.0v 129.505n 0.0v 139.495n 0.0v 139.505n 0.0v 149.495n 0.0v 149.505n 0.0v 159.495n 0.0v 159.505n 0.0v 169.495n 0.0v 169.505n 0.0v 179.495n 0.0v 179.505n 0.0v 189.495n 0.0v 189.505n 0.0v 199.495n 0.0v 199.505n 0.0v 209.495n 0.0v 209.505n 0.0v 219.495n 0.0v 219.505n 0.0v 229.495n 0.0v 229.505n 0.0v 239.495n 0.0v 239.505n 0.0v 249.495n 0.0v 249.505n 0.0v 259.495n 0.0v 259.505n 0.0v 269.495n 0.0v 269.505n 0.0v 279.495n 0.0v 279.505n 1.8v 289.495n 1.8v 289.505n 1.8v 299.495n 1.8v 299.505n 1.8v 309.495n 1.8v 309.505n 1.8v 319.495n 1.8v 319.505n 1.8v 329.495n 1.8v 329.505n 1.8v 339.495n 1.8v 339.505n 1.8v 349.495n 1.8v 349.505n 1.8v 359.495n 1.8v 359.505n 1.8v 369.495n 1.8v 369.505n 1.8v 379.495n 1.8v 379.505n 1.8v 389.495n 1.8v 389.505n 1.8v 399.495n 1.8v 399.505n 0.0v 409.495n 0.0v 409.505n 0.0v 419.495n 0.0v 419.505n 0.0v 429.495n 0.0v 429.505n 0.0v 439.495n 0.0v 439.505n 0.0v 449.495n 0.0v 449.505n 1.8v 459.495n 1.8v 459.505n 0.0v 469.495n 0.0v 469.505n 0.0v 479.495n 0.0v 479.505n 0.0v 489.495n 0.0v 489.505n 0.0v 499.495n 0.0v 499.505n 0.0v 509.495n 0.0v 509.505n 0.0v 519.495n 0.0v 519.505n 0.0v 529.495n 0.0v 529.505n 0.0v 539.495n 0.0v 539.505n 0.0v 549.495n 0.0v 549.505n 0.0v 559.495n 0.0v 559.505n 0.0v 569.495n 0.0v 569.505n 0.0v 579.495n 0.0v 579.505n 0.0v 589.495n 0.0v 589.505n 1.8v 599.495n 1.8v 599.505n 1.8v 609.495n 1.8v 609.505n 1.8v 619.495n 1.8v 619.505n 1.8v 629.495n 1.8v 629.505n 0.0v 639.495n 0.0v 639.505n 0.0v 649.495n 0.0v 649.505n 0.0v 659.495n 0.0v 659.505n 1.8v 669.495n 1.8v 669.505n 1.8v 679.495n 1.8v 679.505n 1.8v 689.495n 1.8v 689.505n 1.8v 699.495n 1.8v 699.505n 0.0v 709.495n 0.0v 709.505n 0.0v 719.495n 0.0v 719.505n 0.0v 729.495n 0.0v 729.505n 0.0v 739.495n 0.0v 739.505n 0.0v 749.495n 0.0v 749.505n 0.0v 759.495n 0.0v 759.505n 0.0v 769.495n 0.0v 769.505n 1.8v 779.495n 1.8v 779.505n 1.8v 789.495n 1.8v 789.505n 1.8v 799.495n 1.8v 799.505n 1.8v 809.495n 1.8v 809.505n 1.8v 819.495n 1.8v 819.505n 1.8v 829.495n 1.8v 829.505n 0.0v 839.495n 0.0v 839.505n 0.0v 849.495n 0.0v 849.505n 0.0v 859.495n 0.0v 859.505n 0.0v 869.495n 0.0v 869.505n 0.0v 879.495n 0.0v 879.505n 0.0v 889.495n 0.0v 889.505n 1.8v 899.495n 1.8v 899.505n 0.0v 909.495n 0.0v 909.505n 0.0v 919.495n 0.0v 919.505n 0.0v 929.495n 0.0v 929.505n 0.0v 939.495n 0.0v 939.505n 1.8v 949.495n 1.8v 949.505n 1.8v 959.495n 1.8v 959.505n 1.8v 969.495n 1.8v 969.505n 1.8v 979.495n 1.8v 979.505n 1.8v 989.495n 1.8v 989.505n 1.8v 999.495n 1.8v 999.505n 1.8v 1009.495n 1.8v 1009.505n 1.8v 1019.495n 1.8v 1019.505n 0.0v 1029.495n 0.0v 1029.505n 0.0v 1039.495n 0.0v 1039.505n 0.0v 1049.495n 0.0v 1049.505n 0.0v 1059.495n 0.0v 1059.505n 0.0v 1069.495n 0.0v 1069.505n 0.0v 1079.495n 0.0v 1079.505n 1.8v 1089.495n 1.8v 1089.505n 0.0v 1099.495n 0.0v 1099.505n 0.0v 1109.495n 0.0v 1109.505n 0.0v 1119.495n 0.0v 1119.505n 0.0v 1129.495n 0.0v 1129.505n 0.0v 1139.495n 0.0v 1139.505n 0.0v 1149.495n 0.0v 1149.505n 0.0v 1159.495n 0.0v 1159.505n 0.0v 1169.495n 0.0v 1169.505n 0.0v 1179.495n 0.0v 1179.505n 0.0v 1189.495n 0.0v 1189.505n 0.0v 1199.495n 0.0v 1199.505n 0.0v 1209.495n 0.0v 1209.505n 0.0v 1219.495n 0.0v 1219.505n 0.0v 1229.495n 0.0v 1229.505n 0.0v 1239.495n 0.0v 1239.505n 0.0v 1249.495n 0.0v 1249.505n 0.0v 1259.495n 0.0v 1259.505n 0.0v 1269.495n 0.0v 1269.505n 0.0v 1279.495n 0.0v 1279.505n 0.0v 1289.495n 0.0v 1289.505n 0.0v 1299.495n 0.0v 1299.505n 1.8v 1309.495n 1.8v 1309.505n 0.0v 1319.495n 0.0v 1319.505n 0.0v 1329.495n 0.0v 1329.505n 0.0v 1339.495n 0.0v 1339.505n 0.0v 1349.495n 0.0v 1349.505n 0.0v 1359.495n 0.0v 1359.505n 1.8v 1369.495n 1.8v 1369.505n 1.8v 1379.495n 1.8v 1379.505n 1.8v 1389.495n 1.8v 1389.505n 1.8v 1399.495n 1.8v 1399.505n 1.8v 1409.495n 1.8v 1409.505n 0.0v 1419.495n 0.0v 1419.505n 0.0v 1429.495n 0.0v 1429.505n 0.0v 1439.495n 0.0v 1439.505n 0.0v 1449.495n 0.0v 1449.505n 0.0v 1459.495n 0.0v 1459.505n 1.8v 1469.495n 1.8v 1469.505n 0.0v 1479.495n 0.0v 1479.505n 0.0v 1489.495n 0.0v 1489.505n 1.8v 1499.495n 1.8v 1499.505n 1.8v 1509.495n 1.8v 1509.505n 1.8v 1519.495n 1.8v 1519.505n 1.8v 1529.495n 1.8v 1529.505n 1.8v 1539.495n 1.8v 1539.505n 1.8v 1549.495n 1.8v 1549.505n 1.8v 1559.495n 1.8v 1559.505n 1.8v 1569.495n 1.8v 1569.505n 1.8v 1579.495n 1.8v 1579.505n 0.0v 1589.495n 0.0v 1589.505n 0.0v 1599.495n 0.0v 1599.505n 0.0v 1609.495n 0.0v 1609.505n 0.0v 1619.495n 0.0v 1619.505n 0.0v 1629.495n 0.0v 1629.505n 0.0v 1639.495n 0.0v 1639.505n 0.0v 1649.495n 0.0v 1649.505n 0.0v 1659.495n 0.0v 1659.505n 0.0v 1669.495n 0.0v 1669.505n 0.0v 1679.495n 0.0v 1679.505n 0.0v 1689.495n 0.0v 1689.505n 0.0v 1699.495n 0.0v 1699.505n 0.0v 1709.495n 0.0v 1709.505n 1.8v 1719.495n 1.8v 1719.505n 1.8v 1729.495n 1.8v 1729.505n 0.0v 1739.495n 0.0v 1739.505n 0.0v 1749.495n 0.0v 1749.505n 0.0v 1759.495n 0.0v 1759.505n 0.0v 1769.495n 0.0v 1769.505n 0.0v 1779.495n 0.0v 1779.505n 0.0v 1789.495n 0.0v 1789.505n 0.0v 1799.495n 0.0v 1799.505n 1.8v 1809.495n 1.8v 1809.505n 1.8v 1819.495n 1.8v 1819.505n 1.8v 1829.495n 1.8v 1829.505n 1.8v 1839.495n 1.8v 1839.505n 0.0v 1849.495n 0.0v 1849.505n 0.0v 1859.495n 0.0v 1859.505n 1.8v 1869.495n 1.8v 1869.505n 1.8v 1879.495n 1.8v 1879.505n 1.8v 1889.495n 1.8v 1889.505n 1.8v 1899.495n 1.8v 1899.505n 1.8v 1909.495n 1.8v 1909.505n 1.8v 1919.495n 1.8v 1919.505n 1.8v 1929.495n 1.8v 1929.505n 1.8v 1939.495n 1.8v 1939.505n 1.8v 1949.495n 1.8v 1949.505n 1.8v 1959.495n 1.8v 1959.505n 0.0v 1969.495n 0.0v 1969.505n 0.0v 1979.495n 0.0v 1979.505n 0.0v 1989.495n 0.0v 1989.505n 0.0v 1999.495n 0.0v 1999.505n 0.0v 2009.495n 0.0v 2009.505n 0.0v 2019.495n 0.0v 2019.505n 0.0v 2029.495n 0.0v 2029.505n 0.0v 2039.495n 0.0v 2039.505n 0.0v 2049.495n 0.0v 2049.505n 0.0v )
* (time, data): [(0, 0), (10, 0), (20, 1), (30, 0), (40, 0), (50, 0), (60, 0), (70, 0), (80, 0), (90, 0), (100, 0), (110, 0), (120, 0), (130, 0), (140, 0), (150, 0), (160, 0), (170, 0), (180, 0), (190, 0), (200, 0), (210, 0), (220, 0), (230, 0), (240, 0), (250, 0), (260, 1), (270, 1), (280, 0), (290, 0), (300, 0), (310, 0), (320, 0), (330, 0), (340, 0), (350, 0), (360, 0), (370, 0), (380, 0), (390, 0), (400, 1), (410, 1), (420, 1), (430, 1), (440, 1), (450, 1), (460, 0), (470, 1), (480, 1), (490, 1), (500, 1), (510, 1), (520, 1), (530, 1), (540, 0), (550, 0), (560, 0), (570, 0), (580, 0), (590, 0), (600, 0), (610, 0), (620, 0), (630, 0), (640, 0), (650, 0), (660, 0), (670, 0), (680, 0), (690, 1), (700, 1), (710, 1), (720, 1), (730, 1), (740, 1), (750, 1), (760, 1), (770, 1), (780, 0), (790, 0), (800, 0), (810, 0), (820, 0), (830, 1), (840, 1), (850, 1), (860, 1), (870, 1), (880, 0), (890, 0), (900, 0), (910, 0), (920, 0), (930, 0), (940, 0), (950, 0), (960, 0), (970, 0), (980, 0), (990, 0), (1000, 0), (1010, 0), (1020, 0), (1030, 0), (1040, 0), (1050, 0), (1060, 0), (1070, 0), (1080, 1), (1090, 0), (1100, 0), (1110, 0), (1120, 0), (1130, 0), (1140, 0), (1150, 0), (1160, 0), (1170, 0), (1180, 0), (1190, 0), (1200, 0), (1210, 0), (1220, 0), (1230, 0), (1240, 0), (1250, 0), (1260, 1), (1270, 1), (1280, 1), (1290, 1), (1300, 1), (1310, 0), (1320, 0), (1330, 0), (1340, 0), (1350, 0), (1360, 1), (1370, 1), (1380, 1), (1390, 1), (1400, 1), (1410, 0), (1420, 0), (1430, 1), (1440, 1), (1450, 1), (1460, 1), (1470, 1), (1480, 1), (1490, 1), (1500, 1), (1510, 1), (1520, 1), (1530, 1), (1540, 1), (1550, 1), (1560, 1), (1570, 1), (1580, 0), (1590, 1), (1600, 1), (1610, 1), (1620, 1), (1630, 1), (1640, 1), (1650, 1), (1660, 1), (1670, 1), (1680, 1), (1690, 1), (1700, 0), (1710, 1), (1720, 1), (1730, 1), (1740, 1), (1750, 1), (1760, 1), (1770, 1), (1780, 1), (1790, 1), (1800, 0), (1810, 0), (1820, 0), (1830, 0), (1840, 0), (1850, 0), (1860, 1), (1870, 1), (1880, 1), (1890, 1), (1900, 1), (1910, 0), (1920, 0), (1930, 0), (1940, 0), (1950, 0), (1960, 1), (1970, 1), (1980, 1), (1990, 1), (2000, 1), (2010, 1), (2020, 1), (2030, 0), (2040, 0), (2050, 0)]
Vdin0_7  din0_7  0 PWL (0n 0.0v 9.495n 0.0v 9.505n 0.0v 19.495n 0.0v 19.505n 1.8v 29.495n 1.8v 29.505n 0.0v 39.495n 0.0v 39.505n 0.0v 49.495n 0.0v 49.505n 0.0v 59.495n 0.0v 59.505n 0.0v 69.495n 0.0v 69.505n 0.0v 79.495n 0.0v 79.505n 0.0v 89.495n 0.0v 89.505n 0.0v 99.495n 0.0v 99.505n 0.0v 109.495n 0.0v 109.505n 0.0v 119.495n 0.0v 119.505n 0.0v 129.495n 0.0v 129.505n 0.0v 139.495n 0.0v 139.505n 0.0v 149.495n 0.0v 149.505n 0.0v 159.495n 0.0v 159.505n 0.0v 169.495n 0.0v 169.505n 0.0v 179.495n 0.0v 179.505n 0.0v 189.495n 0.0v 189.505n 0.0v 199.495n 0.0v 199.505n 0.0v 209.495n 0.0v 209.505n 0.0v 219.495n 0.0v 219.505n 0.0v 229.495n 0.0v 229.505n 0.0v 239.495n 0.0v 239.505n 0.0v 249.495n 0.0v 249.505n 0.0v 259.495n 0.0v 259.505n 1.8v 269.495n 1.8v 269.505n 1.8v 279.495n 1.8v 279.505n 0.0v 289.495n 0.0v 289.505n 0.0v 299.495n 0.0v 299.505n 0.0v 309.495n 0.0v 309.505n 0.0v 319.495n 0.0v 319.505n 0.0v 329.495n 0.0v 329.505n 0.0v 339.495n 0.0v 339.505n 0.0v 349.495n 0.0v 349.505n 0.0v 359.495n 0.0v 359.505n 0.0v 369.495n 0.0v 369.505n 0.0v 379.495n 0.0v 379.505n 0.0v 389.495n 0.0v 389.505n 0.0v 399.495n 0.0v 399.505n 1.8v 409.495n 1.8v 409.505n 1.8v 419.495n 1.8v 419.505n 1.8v 429.495n 1.8v 429.505n 1.8v 439.495n 1.8v 439.505n 1.8v 449.495n 1.8v 449.505n 1.8v 459.495n 1.8v 459.505n 0.0v 469.495n 0.0v 469.505n 1.8v 479.495n 1.8v 479.505n 1.8v 489.495n 1.8v 489.505n 1.8v 499.495n 1.8v 499.505n 1.8v 509.495n 1.8v 509.505n 1.8v 519.495n 1.8v 519.505n 1.8v 529.495n 1.8v 529.505n 1.8v 539.495n 1.8v 539.505n 0.0v 549.495n 0.0v 549.505n 0.0v 559.495n 0.0v 559.505n 0.0v 569.495n 0.0v 569.505n 0.0v 579.495n 0.0v 579.505n 0.0v 589.495n 0.0v 589.505n 0.0v 599.495n 0.0v 599.505n 0.0v 609.495n 0.0v 609.505n 0.0v 619.495n 0.0v 619.505n 0.0v 629.495n 0.0v 629.505n 0.0v 639.495n 0.0v 639.505n 0.0v 649.495n 0.0v 649.505n 0.0v 659.495n 0.0v 659.505n 0.0v 669.495n 0.0v 669.505n 0.0v 679.495n 0.0v 679.505n 0.0v 689.495n 0.0v 689.505n 1.8v 699.495n 1.8v 699.505n 1.8v 709.495n 1.8v 709.505n 1.8v 719.495n 1.8v 719.505n 1.8v 729.495n 1.8v 729.505n 1.8v 739.495n 1.8v 739.505n 1.8v 749.495n 1.8v 749.505n 1.8v 759.495n 1.8v 759.505n 1.8v 769.495n 1.8v 769.505n 1.8v 779.495n 1.8v 779.505n 0.0v 789.495n 0.0v 789.505n 0.0v 799.495n 0.0v 799.505n 0.0v 809.495n 0.0v 809.505n 0.0v 819.495n 0.0v 819.505n 0.0v 829.495n 0.0v 829.505n 1.8v 839.495n 1.8v 839.505n 1.8v 849.495n 1.8v 849.505n 1.8v 859.495n 1.8v 859.505n 1.8v 869.495n 1.8v 869.505n 1.8v 879.495n 1.8v 879.505n 0.0v 889.495n 0.0v 889.505n 0.0v 899.495n 0.0v 899.505n 0.0v 909.495n 0.0v 909.505n 0.0v 919.495n 0.0v 919.505n 0.0v 929.495n 0.0v 929.505n 0.0v 939.495n 0.0v 939.505n 0.0v 949.495n 0.0v 949.505n 0.0v 959.495n 0.0v 959.505n 0.0v 969.495n 0.0v 969.505n 0.0v 979.495n 0.0v 979.505n 0.0v 989.495n 0.0v 989.505n 0.0v 999.495n 0.0v 999.505n 0.0v 1009.495n 0.0v 1009.505n 0.0v 1019.495n 0.0v 1019.505n 0.0v 1029.495n 0.0v 1029.505n 0.0v 1039.495n 0.0v 1039.505n 0.0v 1049.495n 0.0v 1049.505n 0.0v 1059.495n 0.0v 1059.505n 0.0v 1069.495n 0.0v 1069.505n 0.0v 1079.495n 0.0v 1079.505n 1.8v 1089.495n 1.8v 1089.505n 0.0v 1099.495n 0.0v 1099.505n 0.0v 1109.495n 0.0v 1109.505n 0.0v 1119.495n 0.0v 1119.505n 0.0v 1129.495n 0.0v 1129.505n 0.0v 1139.495n 0.0v 1139.505n 0.0v 1149.495n 0.0v 1149.505n 0.0v 1159.495n 0.0v 1159.505n 0.0v 1169.495n 0.0v 1169.505n 0.0v 1179.495n 0.0v 1179.505n 0.0v 1189.495n 0.0v 1189.505n 0.0v 1199.495n 0.0v 1199.505n 0.0v 1209.495n 0.0v 1209.505n 0.0v 1219.495n 0.0v 1219.505n 0.0v 1229.495n 0.0v 1229.505n 0.0v 1239.495n 0.0v 1239.505n 0.0v 1249.495n 0.0v 1249.505n 0.0v 1259.495n 0.0v 1259.505n 1.8v 1269.495n 1.8v 1269.505n 1.8v 1279.495n 1.8v 1279.505n 1.8v 1289.495n 1.8v 1289.505n 1.8v 1299.495n 1.8v 1299.505n 1.8v 1309.495n 1.8v 1309.505n 0.0v 1319.495n 0.0v 1319.505n 0.0v 1329.495n 0.0v 1329.505n 0.0v 1339.495n 0.0v 1339.505n 0.0v 1349.495n 0.0v 1349.505n 0.0v 1359.495n 0.0v 1359.505n 1.8v 1369.495n 1.8v 1369.505n 1.8v 1379.495n 1.8v 1379.505n 1.8v 1389.495n 1.8v 1389.505n 1.8v 1399.495n 1.8v 1399.505n 1.8v 1409.495n 1.8v 1409.505n 0.0v 1419.495n 0.0v 1419.505n 0.0v 1429.495n 0.0v 1429.505n 1.8v 1439.495n 1.8v 1439.505n 1.8v 1449.495n 1.8v 1449.505n 1.8v 1459.495n 1.8v 1459.505n 1.8v 1469.495n 1.8v 1469.505n 1.8v 1479.495n 1.8v 1479.505n 1.8v 1489.495n 1.8v 1489.505n 1.8v 1499.495n 1.8v 1499.505n 1.8v 1509.495n 1.8v 1509.505n 1.8v 1519.495n 1.8v 1519.505n 1.8v 1529.495n 1.8v 1529.505n 1.8v 1539.495n 1.8v 1539.505n 1.8v 1549.495n 1.8v 1549.505n 1.8v 1559.495n 1.8v 1559.505n 1.8v 1569.495n 1.8v 1569.505n 1.8v 1579.495n 1.8v 1579.505n 0.0v 1589.495n 0.0v 1589.505n 1.8v 1599.495n 1.8v 1599.505n 1.8v 1609.495n 1.8v 1609.505n 1.8v 1619.495n 1.8v 1619.505n 1.8v 1629.495n 1.8v 1629.505n 1.8v 1639.495n 1.8v 1639.505n 1.8v 1649.495n 1.8v 1649.505n 1.8v 1659.495n 1.8v 1659.505n 1.8v 1669.495n 1.8v 1669.505n 1.8v 1679.495n 1.8v 1679.505n 1.8v 1689.495n 1.8v 1689.505n 1.8v 1699.495n 1.8v 1699.505n 0.0v 1709.495n 0.0v 1709.505n 1.8v 1719.495n 1.8v 1719.505n 1.8v 1729.495n 1.8v 1729.505n 1.8v 1739.495n 1.8v 1739.505n 1.8v 1749.495n 1.8v 1749.505n 1.8v 1759.495n 1.8v 1759.505n 1.8v 1769.495n 1.8v 1769.505n 1.8v 1779.495n 1.8v 1779.505n 1.8v 1789.495n 1.8v 1789.505n 1.8v 1799.495n 1.8v 1799.505n 0.0v 1809.495n 0.0v 1809.505n 0.0v 1819.495n 0.0v 1819.505n 0.0v 1829.495n 0.0v 1829.505n 0.0v 1839.495n 0.0v 1839.505n 0.0v 1849.495n 0.0v 1849.505n 0.0v 1859.495n 0.0v 1859.505n 1.8v 1869.495n 1.8v 1869.505n 1.8v 1879.495n 1.8v 1879.505n 1.8v 1889.495n 1.8v 1889.505n 1.8v 1899.495n 1.8v 1899.505n 1.8v 1909.495n 1.8v 1909.505n 0.0v 1919.495n 0.0v 1919.505n 0.0v 1929.495n 0.0v 1929.505n 0.0v 1939.495n 0.0v 1939.505n 0.0v 1949.495n 0.0v 1949.505n 0.0v 1959.495n 0.0v 1959.505n 1.8v 1969.495n 1.8v 1969.505n 1.8v 1979.495n 1.8v 1979.505n 1.8v 1989.495n 1.8v 1989.505n 1.8v 1999.495n 1.8v 1999.505n 1.8v 2009.495n 1.8v 2009.505n 1.8v 2019.495n 1.8v 2019.505n 1.8v 2029.495n 1.8v 2029.505n 0.0v 2039.495n 0.0v 2039.505n 0.0v 2049.495n 0.0v 2049.505n 0.0v )
* (time, data): [(0, 0), (10, 0), (20, 1), (30, 1), (40, 1), (50, 1), (60, 1), (70, 1), (80, 1), (90, 1), (100, 1), (110, 1), (120, 0), (130, 0), (140, 0), (150, 0), (160, 0), (170, 0), (180, 0), (190, 0), (200, 0), (210, 0), (220, 0), (230, 0), (240, 0), (250, 0), (260, 1), (270, 1), (280, 1), (290, 1), (300, 1), (310, 1), (320, 1), (330, 1), (340, 1), (350, 1), (360, 1), (370, 1), (380, 1), (390, 1), (400, 1), (410, 1), (420, 1), (430, 1), (440, 1), (450, 1), (460, 1), (470, 0), (480, 0), (490, 0), (500, 0), (510, 0), (520, 0), (530, 0), (540, 1), (550, 1), (560, 1), (570, 1), (580, 1), (590, 1), (600, 1), (610, 1), (620, 1), (630, 1), (640, 1), (650, 1), (660, 1), (670, 1), (680, 1), (690, 0), (700, 0), (710, 0), (720, 0), (730, 0), (740, 0), (750, 0), (760, 0), (770, 1), (780, 1), (790, 1), (800, 1), (810, 1), (820, 1), (830, 1), (840, 1), (850, 1), (860, 1), (870, 1), (880, 0), (890, 0), (900, 0), (910, 0), (920, 0), (930, 0), (940, 0), (950, 0), (960, 0), (970, 0), (980, 0), (990, 0), (1000, 1), (1010, 1), (1020, 1), (1030, 1), (1040, 1), (1050, 1), (1060, 1), (1070, 1), (1080, 0), (1090, 0), (1100, 0), (1110, 0), (1120, 0), (1130, 0), (1140, 0), (1150, 0), (1160, 0), (1170, 0), (1180, 0), (1190, 0), (1200, 0), (1210, 0), (1220, 0), (1230, 0), (1240, 0), (1250, 0), (1260, 1), (1270, 1), (1280, 1), (1290, 1), (1300, 0), (1310, 1), (1320, 1), (1330, 1), (1340, 1), (1350, 1), (1360, 0), (1370, 0), (1380, 0), (1390, 0), (1400, 0), (1410, 0), (1420, 0), (1430, 0), (1440, 1), (1450, 1), (1460, 1), (1470, 1), (1480, 1), (1490, 1), (1500, 1), (1510, 1), (1520, 1), (1530, 1), (1540, 1), (1550, 0), (1560, 0), (1570, 0), (1580, 1), (1590, 1), (1600, 1), (1610, 1), (1620, 1), (1630, 1), (1640, 1), (1650, 1), (1660, 1), (1670, 1), (1680, 1), (1690, 1), (1700, 0), (1710, 1), (1720, 1), (1730, 1), (1740, 1), (1750, 1), (1760, 1), (1770, 1), (1780, 1), (1790, 1), (1800, 1), (1810, 1), (1820, 1), (1830, 1), (1840, 0), (1850, 0), (1860, 0), (1870, 0), (1880, 0), (1890, 0), (1900, 0), (1910, 0), (1920, 0), (1930, 0), (1940, 0), (1950, 0), (1960, 1), (1970, 1), (1980, 1), (1990, 1), (2000, 1), (2010, 1), (2020, 1), (2030, 0), (2040, 0), (2050, 0)]
Vdin0_8  din0_8  0 PWL (0n 0.0v 9.495n 0.0v 9.505n 0.0v 19.495n 0.0v 19.505n 1.8v 29.495n 1.8v 29.505n 1.8v 39.495n 1.8v 39.505n 1.8v 49.495n 1.8v 49.505n 1.8v 59.495n 1.8v 59.505n 1.8v 69.495n 1.8v 69.505n 1.8v 79.495n 1.8v 79.505n 1.8v 89.495n 1.8v 89.505n 1.8v 99.495n 1.8v 99.505n 1.8v 109.495n 1.8v 109.505n 1.8v 119.495n 1.8v 119.505n 0.0v 129.495n 0.0v 129.505n 0.0v 139.495n 0.0v 139.505n 0.0v 149.495n 0.0v 149.505n 0.0v 159.495n 0.0v 159.505n 0.0v 169.495n 0.0v 169.505n 0.0v 179.495n 0.0v 179.505n 0.0v 189.495n 0.0v 189.505n 0.0v 199.495n 0.0v 199.505n 0.0v 209.495n 0.0v 209.505n 0.0v 219.495n 0.0v 219.505n 0.0v 229.495n 0.0v 229.505n 0.0v 239.495n 0.0v 239.505n 0.0v 249.495n 0.0v 249.505n 0.0v 259.495n 0.0v 259.505n 1.8v 269.495n 1.8v 269.505n 1.8v 279.495n 1.8v 279.505n 1.8v 289.495n 1.8v 289.505n 1.8v 299.495n 1.8v 299.505n 1.8v 309.495n 1.8v 309.505n 1.8v 319.495n 1.8v 319.505n 1.8v 329.495n 1.8v 329.505n 1.8v 339.495n 1.8v 339.505n 1.8v 349.495n 1.8v 349.505n 1.8v 359.495n 1.8v 359.505n 1.8v 369.495n 1.8v 369.505n 1.8v 379.495n 1.8v 379.505n 1.8v 389.495n 1.8v 389.505n 1.8v 399.495n 1.8v 399.505n 1.8v 409.495n 1.8v 409.505n 1.8v 419.495n 1.8v 419.505n 1.8v 429.495n 1.8v 429.505n 1.8v 439.495n 1.8v 439.505n 1.8v 449.495n 1.8v 449.505n 1.8v 459.495n 1.8v 459.505n 1.8v 469.495n 1.8v 469.505n 0.0v 479.495n 0.0v 479.505n 0.0v 489.495n 0.0v 489.505n 0.0v 499.495n 0.0v 499.505n 0.0v 509.495n 0.0v 509.505n 0.0v 519.495n 0.0v 519.505n 0.0v 529.495n 0.0v 529.505n 0.0v 539.495n 0.0v 539.505n 1.8v 549.495n 1.8v 549.505n 1.8v 559.495n 1.8v 559.505n 1.8v 569.495n 1.8v 569.505n 1.8v 579.495n 1.8v 579.505n 1.8v 589.495n 1.8v 589.505n 1.8v 599.495n 1.8v 599.505n 1.8v 609.495n 1.8v 609.505n 1.8v 619.495n 1.8v 619.505n 1.8v 629.495n 1.8v 629.505n 1.8v 639.495n 1.8v 639.505n 1.8v 649.495n 1.8v 649.505n 1.8v 659.495n 1.8v 659.505n 1.8v 669.495n 1.8v 669.505n 1.8v 679.495n 1.8v 679.505n 1.8v 689.495n 1.8v 689.505n 0.0v 699.495n 0.0v 699.505n 0.0v 709.495n 0.0v 709.505n 0.0v 719.495n 0.0v 719.505n 0.0v 729.495n 0.0v 729.505n 0.0v 739.495n 0.0v 739.505n 0.0v 749.495n 0.0v 749.505n 0.0v 759.495n 0.0v 759.505n 0.0v 769.495n 0.0v 769.505n 1.8v 779.495n 1.8v 779.505n 1.8v 789.495n 1.8v 789.505n 1.8v 799.495n 1.8v 799.505n 1.8v 809.495n 1.8v 809.505n 1.8v 819.495n 1.8v 819.505n 1.8v 829.495n 1.8v 829.505n 1.8v 839.495n 1.8v 839.505n 1.8v 849.495n 1.8v 849.505n 1.8v 859.495n 1.8v 859.505n 1.8v 869.495n 1.8v 869.505n 1.8v 879.495n 1.8v 879.505n 0.0v 889.495n 0.0v 889.505n 0.0v 899.495n 0.0v 899.505n 0.0v 909.495n 0.0v 909.505n 0.0v 919.495n 0.0v 919.505n 0.0v 929.495n 0.0v 929.505n 0.0v 939.495n 0.0v 939.505n 0.0v 949.495n 0.0v 949.505n 0.0v 959.495n 0.0v 959.505n 0.0v 969.495n 0.0v 969.505n 0.0v 979.495n 0.0v 979.505n 0.0v 989.495n 0.0v 989.505n 0.0v 999.495n 0.0v 999.505n 1.8v 1009.495n 1.8v 1009.505n 1.8v 1019.495n 1.8v 1019.505n 1.8v 1029.495n 1.8v 1029.505n 1.8v 1039.495n 1.8v 1039.505n 1.8v 1049.495n 1.8v 1049.505n 1.8v 1059.495n 1.8v 1059.505n 1.8v 1069.495n 1.8v 1069.505n 1.8v 1079.495n 1.8v 1079.505n 0.0v 1089.495n 0.0v 1089.505n 0.0v 1099.495n 0.0v 1099.505n 0.0v 1109.495n 0.0v 1109.505n 0.0v 1119.495n 0.0v 1119.505n 0.0v 1129.495n 0.0v 1129.505n 0.0v 1139.495n 0.0v 1139.505n 0.0v 1149.495n 0.0v 1149.505n 0.0v 1159.495n 0.0v 1159.505n 0.0v 1169.495n 0.0v 1169.505n 0.0v 1179.495n 0.0v 1179.505n 0.0v 1189.495n 0.0v 1189.505n 0.0v 1199.495n 0.0v 1199.505n 0.0v 1209.495n 0.0v 1209.505n 0.0v 1219.495n 0.0v 1219.505n 0.0v 1229.495n 0.0v 1229.505n 0.0v 1239.495n 0.0v 1239.505n 0.0v 1249.495n 0.0v 1249.505n 0.0v 1259.495n 0.0v 1259.505n 1.8v 1269.495n 1.8v 1269.505n 1.8v 1279.495n 1.8v 1279.505n 1.8v 1289.495n 1.8v 1289.505n 1.8v 1299.495n 1.8v 1299.505n 0.0v 1309.495n 0.0v 1309.505n 1.8v 1319.495n 1.8v 1319.505n 1.8v 1329.495n 1.8v 1329.505n 1.8v 1339.495n 1.8v 1339.505n 1.8v 1349.495n 1.8v 1349.505n 1.8v 1359.495n 1.8v 1359.505n 0.0v 1369.495n 0.0v 1369.505n 0.0v 1379.495n 0.0v 1379.505n 0.0v 1389.495n 0.0v 1389.505n 0.0v 1399.495n 0.0v 1399.505n 0.0v 1409.495n 0.0v 1409.505n 0.0v 1419.495n 0.0v 1419.505n 0.0v 1429.495n 0.0v 1429.505n 0.0v 1439.495n 0.0v 1439.505n 1.8v 1449.495n 1.8v 1449.505n 1.8v 1459.495n 1.8v 1459.505n 1.8v 1469.495n 1.8v 1469.505n 1.8v 1479.495n 1.8v 1479.505n 1.8v 1489.495n 1.8v 1489.505n 1.8v 1499.495n 1.8v 1499.505n 1.8v 1509.495n 1.8v 1509.505n 1.8v 1519.495n 1.8v 1519.505n 1.8v 1529.495n 1.8v 1529.505n 1.8v 1539.495n 1.8v 1539.505n 1.8v 1549.495n 1.8v 1549.505n 0.0v 1559.495n 0.0v 1559.505n 0.0v 1569.495n 0.0v 1569.505n 0.0v 1579.495n 0.0v 1579.505n 1.8v 1589.495n 1.8v 1589.505n 1.8v 1599.495n 1.8v 1599.505n 1.8v 1609.495n 1.8v 1609.505n 1.8v 1619.495n 1.8v 1619.505n 1.8v 1629.495n 1.8v 1629.505n 1.8v 1639.495n 1.8v 1639.505n 1.8v 1649.495n 1.8v 1649.505n 1.8v 1659.495n 1.8v 1659.505n 1.8v 1669.495n 1.8v 1669.505n 1.8v 1679.495n 1.8v 1679.505n 1.8v 1689.495n 1.8v 1689.505n 1.8v 1699.495n 1.8v 1699.505n 0.0v 1709.495n 0.0v 1709.505n 1.8v 1719.495n 1.8v 1719.505n 1.8v 1729.495n 1.8v 1729.505n 1.8v 1739.495n 1.8v 1739.505n 1.8v 1749.495n 1.8v 1749.505n 1.8v 1759.495n 1.8v 1759.505n 1.8v 1769.495n 1.8v 1769.505n 1.8v 1779.495n 1.8v 1779.505n 1.8v 1789.495n 1.8v 1789.505n 1.8v 1799.495n 1.8v 1799.505n 1.8v 1809.495n 1.8v 1809.505n 1.8v 1819.495n 1.8v 1819.505n 1.8v 1829.495n 1.8v 1829.505n 1.8v 1839.495n 1.8v 1839.505n 0.0v 1849.495n 0.0v 1849.505n 0.0v 1859.495n 0.0v 1859.505n 0.0v 1869.495n 0.0v 1869.505n 0.0v 1879.495n 0.0v 1879.505n 0.0v 1889.495n 0.0v 1889.505n 0.0v 1899.495n 0.0v 1899.505n 0.0v 1909.495n 0.0v 1909.505n 0.0v 1919.495n 0.0v 1919.505n 0.0v 1929.495n 0.0v 1929.505n 0.0v 1939.495n 0.0v 1939.505n 0.0v 1949.495n 0.0v 1949.505n 0.0v 1959.495n 0.0v 1959.505n 1.8v 1969.495n 1.8v 1969.505n 1.8v 1979.495n 1.8v 1979.505n 1.8v 1989.495n 1.8v 1989.505n 1.8v 1999.495n 1.8v 1999.505n 1.8v 2009.495n 1.8v 2009.505n 1.8v 2019.495n 1.8v 2019.505n 1.8v 2029.495n 1.8v 2029.505n 0.0v 2039.495n 0.0v 2039.505n 0.0v 2049.495n 0.0v 2049.505n 0.0v )
* (time, data): [(0, 0), (10, 1), (20, 0), (30, 0), (40, 0), (50, 0), (60, 0), (70, 0), (80, 1), (90, 1), (100, 1), (110, 1), (120, 1), (130, 1), (140, 1), (150, 1), (160, 1), (170, 1), (180, 1), (190, 1), (200, 1), (210, 1), (220, 1), (230, 1), (240, 1), (250, 1), (260, 1), (270, 1), (280, 0), (290, 0), (300, 0), (310, 0), (320, 0), (330, 0), (340, 0), (350, 0), (360, 0), (370, 0), (380, 0), (390, 0), (400, 1), (410, 1), (420, 1), (430, 1), (440, 1), (450, 0), (460, 1), (470, 0), (480, 0), (490, 0), (500, 0), (510, 0), (520, 0), (530, 0), (540, 1), (550, 1), (560, 1), (570, 1), (580, 1), (590, 0), (600, 0), (610, 0), (620, 0), (630, 0), (640, 0), (650, 0), (660, 1), (670, 1), (680, 1), (690, 1), (700, 1), (710, 1), (720, 1), (730, 1), (740, 1), (750, 1), (760, 1), (770, 1), (780, 0), (790, 0), (800, 0), (810, 0), (820, 0), (830, 0), (840, 0), (850, 0), (860, 0), (870, 0), (880, 0), (890, 0), (900, 0), (910, 0), (920, 0), (930, 0), (940, 1), (950, 1), (960, 1), (970, 1), (980, 1), (990, 1), (1000, 1), (1010, 1), (1020, 1), (1030, 1), (1040, 1), (1050, 1), (1060, 1), (1070, 1), (1080, 1), (1090, 1), (1100, 1), (1110, 1), (1120, 1), (1130, 1), (1140, 1), (1150, 1), (1160, 1), (1170, 1), (1180, 1), (1190, 1), (1200, 1), (1210, 1), (1220, 1), (1230, 1), (1240, 1), (1250, 1), (1260, 1), (1270, 1), (1280, 1), (1290, 1), (1300, 0), (1310, 0), (1320, 0), (1330, 0), (1340, 0), (1350, 0), (1360, 1), (1370, 1), (1380, 1), (1390, 1), (1400, 1), (1410, 1), (1420, 1), (1430, 0), (1440, 0), (1450, 0), (1460, 0), (1470, 1), (1480, 1), (1490, 0), (1500, 0), (1510, 0), (1520, 0), (1530, 0), (1540, 0), (1550, 1), (1560, 1), (1570, 1), (1580, 1), (1590, 0), (1600, 0), (1610, 0), (1620, 0), (1630, 0), (1640, 0), (1650, 0), (1660, 0), (1670, 0), (1680, 0), (1690, 0), (1700, 0), (1710, 0), (1720, 0), (1730, 1), (1740, 1), (1750, 1), (1760, 1), (1770, 1), (1780, 1), (1790, 1), (1800, 0), (1810, 0), (1820, 0), (1830, 0), (1840, 1), (1850, 1), (1860, 0), (1870, 0), (1880, 0), (1890, 0), (1900, 0), (1910, 0), (1920, 0), (1930, 0), (1940, 0), (1950, 0), (1960, 1), (1970, 1), (1980, 1), (1990, 1), (2000, 1), (2010, 1), (2020, 1), (2030, 1), (2040, 0), (2050, 0)]
Vdin0_9  din0_9  0 PWL (0n 0.0v 9.495n 0.0v 9.505n 1.8v 19.495n 1.8v 19.505n 0.0v 29.495n 0.0v 29.505n 0.0v 39.495n 0.0v 39.505n 0.0v 49.495n 0.0v 49.505n 0.0v 59.495n 0.0v 59.505n 0.0v 69.495n 0.0v 69.505n 0.0v 79.495n 0.0v 79.505n 1.8v 89.495n 1.8v 89.505n 1.8v 99.495n 1.8v 99.505n 1.8v 109.495n 1.8v 109.505n 1.8v 119.495n 1.8v 119.505n 1.8v 129.495n 1.8v 129.505n 1.8v 139.495n 1.8v 139.505n 1.8v 149.495n 1.8v 149.505n 1.8v 159.495n 1.8v 159.505n 1.8v 169.495n 1.8v 169.505n 1.8v 179.495n 1.8v 179.505n 1.8v 189.495n 1.8v 189.505n 1.8v 199.495n 1.8v 199.505n 1.8v 209.495n 1.8v 209.505n 1.8v 219.495n 1.8v 219.505n 1.8v 229.495n 1.8v 229.505n 1.8v 239.495n 1.8v 239.505n 1.8v 249.495n 1.8v 249.505n 1.8v 259.495n 1.8v 259.505n 1.8v 269.495n 1.8v 269.505n 1.8v 279.495n 1.8v 279.505n 0.0v 289.495n 0.0v 289.505n 0.0v 299.495n 0.0v 299.505n 0.0v 309.495n 0.0v 309.505n 0.0v 319.495n 0.0v 319.505n 0.0v 329.495n 0.0v 329.505n 0.0v 339.495n 0.0v 339.505n 0.0v 349.495n 0.0v 349.505n 0.0v 359.495n 0.0v 359.505n 0.0v 369.495n 0.0v 369.505n 0.0v 379.495n 0.0v 379.505n 0.0v 389.495n 0.0v 389.505n 0.0v 399.495n 0.0v 399.505n 1.8v 409.495n 1.8v 409.505n 1.8v 419.495n 1.8v 419.505n 1.8v 429.495n 1.8v 429.505n 1.8v 439.495n 1.8v 439.505n 1.8v 449.495n 1.8v 449.505n 0.0v 459.495n 0.0v 459.505n 1.8v 469.495n 1.8v 469.505n 0.0v 479.495n 0.0v 479.505n 0.0v 489.495n 0.0v 489.505n 0.0v 499.495n 0.0v 499.505n 0.0v 509.495n 0.0v 509.505n 0.0v 519.495n 0.0v 519.505n 0.0v 529.495n 0.0v 529.505n 0.0v 539.495n 0.0v 539.505n 1.8v 549.495n 1.8v 549.505n 1.8v 559.495n 1.8v 559.505n 1.8v 569.495n 1.8v 569.505n 1.8v 579.495n 1.8v 579.505n 1.8v 589.495n 1.8v 589.505n 0.0v 599.495n 0.0v 599.505n 0.0v 609.495n 0.0v 609.505n 0.0v 619.495n 0.0v 619.505n 0.0v 629.495n 0.0v 629.505n 0.0v 639.495n 0.0v 639.505n 0.0v 649.495n 0.0v 649.505n 0.0v 659.495n 0.0v 659.505n 1.8v 669.495n 1.8v 669.505n 1.8v 679.495n 1.8v 679.505n 1.8v 689.495n 1.8v 689.505n 1.8v 699.495n 1.8v 699.505n 1.8v 709.495n 1.8v 709.505n 1.8v 719.495n 1.8v 719.505n 1.8v 729.495n 1.8v 729.505n 1.8v 739.495n 1.8v 739.505n 1.8v 749.495n 1.8v 749.505n 1.8v 759.495n 1.8v 759.505n 1.8v 769.495n 1.8v 769.505n 1.8v 779.495n 1.8v 779.505n 0.0v 789.495n 0.0v 789.505n 0.0v 799.495n 0.0v 799.505n 0.0v 809.495n 0.0v 809.505n 0.0v 819.495n 0.0v 819.505n 0.0v 829.495n 0.0v 829.505n 0.0v 839.495n 0.0v 839.505n 0.0v 849.495n 0.0v 849.505n 0.0v 859.495n 0.0v 859.505n 0.0v 869.495n 0.0v 869.505n 0.0v 879.495n 0.0v 879.505n 0.0v 889.495n 0.0v 889.505n 0.0v 899.495n 0.0v 899.505n 0.0v 909.495n 0.0v 909.505n 0.0v 919.495n 0.0v 919.505n 0.0v 929.495n 0.0v 929.505n 0.0v 939.495n 0.0v 939.505n 1.8v 949.495n 1.8v 949.505n 1.8v 959.495n 1.8v 959.505n 1.8v 969.495n 1.8v 969.505n 1.8v 979.495n 1.8v 979.505n 1.8v 989.495n 1.8v 989.505n 1.8v 999.495n 1.8v 999.505n 1.8v 1009.495n 1.8v 1009.505n 1.8v 1019.495n 1.8v 1019.505n 1.8v 1029.495n 1.8v 1029.505n 1.8v 1039.495n 1.8v 1039.505n 1.8v 1049.495n 1.8v 1049.505n 1.8v 1059.495n 1.8v 1059.505n 1.8v 1069.495n 1.8v 1069.505n 1.8v 1079.495n 1.8v 1079.505n 1.8v 1089.495n 1.8v 1089.505n 1.8v 1099.495n 1.8v 1099.505n 1.8v 1109.495n 1.8v 1109.505n 1.8v 1119.495n 1.8v 1119.505n 1.8v 1129.495n 1.8v 1129.505n 1.8v 1139.495n 1.8v 1139.505n 1.8v 1149.495n 1.8v 1149.505n 1.8v 1159.495n 1.8v 1159.505n 1.8v 1169.495n 1.8v 1169.505n 1.8v 1179.495n 1.8v 1179.505n 1.8v 1189.495n 1.8v 1189.505n 1.8v 1199.495n 1.8v 1199.505n 1.8v 1209.495n 1.8v 1209.505n 1.8v 1219.495n 1.8v 1219.505n 1.8v 1229.495n 1.8v 1229.505n 1.8v 1239.495n 1.8v 1239.505n 1.8v 1249.495n 1.8v 1249.505n 1.8v 1259.495n 1.8v 1259.505n 1.8v 1269.495n 1.8v 1269.505n 1.8v 1279.495n 1.8v 1279.505n 1.8v 1289.495n 1.8v 1289.505n 1.8v 1299.495n 1.8v 1299.505n 0.0v 1309.495n 0.0v 1309.505n 0.0v 1319.495n 0.0v 1319.505n 0.0v 1329.495n 0.0v 1329.505n 0.0v 1339.495n 0.0v 1339.505n 0.0v 1349.495n 0.0v 1349.505n 0.0v 1359.495n 0.0v 1359.505n 1.8v 1369.495n 1.8v 1369.505n 1.8v 1379.495n 1.8v 1379.505n 1.8v 1389.495n 1.8v 1389.505n 1.8v 1399.495n 1.8v 1399.505n 1.8v 1409.495n 1.8v 1409.505n 1.8v 1419.495n 1.8v 1419.505n 1.8v 1429.495n 1.8v 1429.505n 0.0v 1439.495n 0.0v 1439.505n 0.0v 1449.495n 0.0v 1449.505n 0.0v 1459.495n 0.0v 1459.505n 0.0v 1469.495n 0.0v 1469.505n 1.8v 1479.495n 1.8v 1479.505n 1.8v 1489.495n 1.8v 1489.505n 0.0v 1499.495n 0.0v 1499.505n 0.0v 1509.495n 0.0v 1509.505n 0.0v 1519.495n 0.0v 1519.505n 0.0v 1529.495n 0.0v 1529.505n 0.0v 1539.495n 0.0v 1539.505n 0.0v 1549.495n 0.0v 1549.505n 1.8v 1559.495n 1.8v 1559.505n 1.8v 1569.495n 1.8v 1569.505n 1.8v 1579.495n 1.8v 1579.505n 1.8v 1589.495n 1.8v 1589.505n 0.0v 1599.495n 0.0v 1599.505n 0.0v 1609.495n 0.0v 1609.505n 0.0v 1619.495n 0.0v 1619.505n 0.0v 1629.495n 0.0v 1629.505n 0.0v 1639.495n 0.0v 1639.505n 0.0v 1649.495n 0.0v 1649.505n 0.0v 1659.495n 0.0v 1659.505n 0.0v 1669.495n 0.0v 1669.505n 0.0v 1679.495n 0.0v 1679.505n 0.0v 1689.495n 0.0v 1689.505n 0.0v 1699.495n 0.0v 1699.505n 0.0v 1709.495n 0.0v 1709.505n 0.0v 1719.495n 0.0v 1719.505n 0.0v 1729.495n 0.0v 1729.505n 1.8v 1739.495n 1.8v 1739.505n 1.8v 1749.495n 1.8v 1749.505n 1.8v 1759.495n 1.8v 1759.505n 1.8v 1769.495n 1.8v 1769.505n 1.8v 1779.495n 1.8v 1779.505n 1.8v 1789.495n 1.8v 1789.505n 1.8v 1799.495n 1.8v 1799.505n 0.0v 1809.495n 0.0v 1809.505n 0.0v 1819.495n 0.0v 1819.505n 0.0v 1829.495n 0.0v 1829.505n 0.0v 1839.495n 0.0v 1839.505n 1.8v 1849.495n 1.8v 1849.505n 1.8v 1859.495n 1.8v 1859.505n 0.0v 1869.495n 0.0v 1869.505n 0.0v 1879.495n 0.0v 1879.505n 0.0v 1889.495n 0.0v 1889.505n 0.0v 1899.495n 0.0v 1899.505n 0.0v 1909.495n 0.0v 1909.505n 0.0v 1919.495n 0.0v 1919.505n 0.0v 1929.495n 0.0v 1929.505n 0.0v 1939.495n 0.0v 1939.505n 0.0v 1949.495n 0.0v 1949.505n 0.0v 1959.495n 0.0v 1959.505n 1.8v 1969.495n 1.8v 1969.505n 1.8v 1979.495n 1.8v 1979.505n 1.8v 1989.495n 1.8v 1989.505n 1.8v 1999.495n 1.8v 1999.505n 1.8v 2009.495n 1.8v 2009.505n 1.8v 2019.495n 1.8v 2019.505n 1.8v 2029.495n 1.8v 2029.505n 1.8v 2039.495n 1.8v 2039.505n 0.0v 2049.495n 0.0v 2049.505n 0.0v )
* (time, data): [(0, 0), (10, 1), (20, 0), (30, 1), (40, 1), (50, 1), (60, 0), (70, 0), (80, 1), (90, 1), (100, 1), (110, 1), (120, 0), (130, 0), (140, 0), (150, 0), (160, 0), (170, 0), (180, 0), (190, 0), (200, 0), (210, 0), (220, 0), (230, 0), (240, 0), (250, 0), (260, 1), (270, 1), (280, 1), (290, 1), (300, 1), (310, 1), (320, 1), (330, 1), (340, 1), (350, 1), (360, 1), (370, 1), (380, 1), (390, 1), (400, 1), (410, 1), (420, 1), (430, 1), (440, 1), (450, 1), (460, 0), (470, 1), (480, 1), (490, 1), (500, 1), (510, 1), (520, 1), (530, 1), (540, 1), (550, 1), (560, 1), (570, 1), (580, 1), (590, 0), (600, 0), (610, 0), (620, 0), (630, 0), (640, 0), (650, 0), (660, 0), (670, 0), (680, 0), (690, 0), (700, 0), (710, 0), (720, 0), (730, 0), (740, 0), (750, 0), (760, 0), (770, 1), (780, 1), (790, 1), (800, 1), (810, 1), (820, 1), (830, 1), (840, 1), (850, 1), (860, 1), (870, 1), (880, 1), (890, 1), (900, 0), (910, 0), (920, 0), (930, 0), (940, 0), (950, 0), (960, 0), (970, 0), (980, 0), (990, 0), (1000, 1), (1010, 1), (1020, 1), (1030, 1), (1040, 1), (1050, 1), (1060, 1), (1070, 1), (1080, 1), (1090, 1), (1100, 1), (1110, 1), (1120, 1), (1130, 1), (1140, 0), (1150, 0), (1160, 0), (1170, 0), (1180, 0), (1190, 0), (1200, 0), (1210, 0), (1220, 0), (1230, 0), (1240, 0), (1250, 0), (1260, 0), (1270, 0), (1280, 0), (1290, 0), (1300, 1), (1310, 1), (1320, 1), (1330, 1), (1340, 1), (1350, 1), (1360, 1), (1370, 1), (1380, 1), (1390, 1), (1400, 1), (1410, 1), (1420, 1), (1430, 0), (1440, 0), (1450, 0), (1460, 1), (1470, 0), (1480, 0), (1490, 1), (1500, 1), (1510, 1), (1520, 1), (1530, 1), (1540, 1), (1550, 0), (1560, 0), (1570, 0), (1580, 1), (1590, 1), (1600, 1), (1610, 1), (1620, 1), (1630, 1), (1640, 1), (1650, 1), (1660, 1), (1670, 1), (1680, 1), (1690, 1), (1700, 1), (1710, 1), (1720, 1), (1730, 1), (1740, 1), (1750, 1), (1760, 1), (1770, 1), (1780, 1), (1790, 1), (1800, 0), (1810, 0), (1820, 0), (1830, 0), (1840, 1), (1850, 1), (1860, 1), (1870, 1), (1880, 1), (1890, 1), (1900, 1), (1910, 0), (1920, 0), (1930, 0), (1940, 0), (1950, 0), (1960, 0), (1970, 0), (1980, 0), (1990, 0), (2000, 0), (2010, 0), (2020, 0), (2030, 0), (2040, 0), (2050, 0)]
Vdin0_10  din0_10  0 PWL (0n 0.0v 9.495n 0.0v 9.505n 1.8v 19.495n 1.8v 19.505n 0.0v 29.495n 0.0v 29.505n 1.8v 39.495n 1.8v 39.505n 1.8v 49.495n 1.8v 49.505n 1.8v 59.495n 1.8v 59.505n 0.0v 69.495n 0.0v 69.505n 0.0v 79.495n 0.0v 79.505n 1.8v 89.495n 1.8v 89.505n 1.8v 99.495n 1.8v 99.505n 1.8v 109.495n 1.8v 109.505n 1.8v 119.495n 1.8v 119.505n 0.0v 129.495n 0.0v 129.505n 0.0v 139.495n 0.0v 139.505n 0.0v 149.495n 0.0v 149.505n 0.0v 159.495n 0.0v 159.505n 0.0v 169.495n 0.0v 169.505n 0.0v 179.495n 0.0v 179.505n 0.0v 189.495n 0.0v 189.505n 0.0v 199.495n 0.0v 199.505n 0.0v 209.495n 0.0v 209.505n 0.0v 219.495n 0.0v 219.505n 0.0v 229.495n 0.0v 229.505n 0.0v 239.495n 0.0v 239.505n 0.0v 249.495n 0.0v 249.505n 0.0v 259.495n 0.0v 259.505n 1.8v 269.495n 1.8v 269.505n 1.8v 279.495n 1.8v 279.505n 1.8v 289.495n 1.8v 289.505n 1.8v 299.495n 1.8v 299.505n 1.8v 309.495n 1.8v 309.505n 1.8v 319.495n 1.8v 319.505n 1.8v 329.495n 1.8v 329.505n 1.8v 339.495n 1.8v 339.505n 1.8v 349.495n 1.8v 349.505n 1.8v 359.495n 1.8v 359.505n 1.8v 369.495n 1.8v 369.505n 1.8v 379.495n 1.8v 379.505n 1.8v 389.495n 1.8v 389.505n 1.8v 399.495n 1.8v 399.505n 1.8v 409.495n 1.8v 409.505n 1.8v 419.495n 1.8v 419.505n 1.8v 429.495n 1.8v 429.505n 1.8v 439.495n 1.8v 439.505n 1.8v 449.495n 1.8v 449.505n 1.8v 459.495n 1.8v 459.505n 0.0v 469.495n 0.0v 469.505n 1.8v 479.495n 1.8v 479.505n 1.8v 489.495n 1.8v 489.505n 1.8v 499.495n 1.8v 499.505n 1.8v 509.495n 1.8v 509.505n 1.8v 519.495n 1.8v 519.505n 1.8v 529.495n 1.8v 529.505n 1.8v 539.495n 1.8v 539.505n 1.8v 549.495n 1.8v 549.505n 1.8v 559.495n 1.8v 559.505n 1.8v 569.495n 1.8v 569.505n 1.8v 579.495n 1.8v 579.505n 1.8v 589.495n 1.8v 589.505n 0.0v 599.495n 0.0v 599.505n 0.0v 609.495n 0.0v 609.505n 0.0v 619.495n 0.0v 619.505n 0.0v 629.495n 0.0v 629.505n 0.0v 639.495n 0.0v 639.505n 0.0v 649.495n 0.0v 649.505n 0.0v 659.495n 0.0v 659.505n 0.0v 669.495n 0.0v 669.505n 0.0v 679.495n 0.0v 679.505n 0.0v 689.495n 0.0v 689.505n 0.0v 699.495n 0.0v 699.505n 0.0v 709.495n 0.0v 709.505n 0.0v 719.495n 0.0v 719.505n 0.0v 729.495n 0.0v 729.505n 0.0v 739.495n 0.0v 739.505n 0.0v 749.495n 0.0v 749.505n 0.0v 759.495n 0.0v 759.505n 0.0v 769.495n 0.0v 769.505n 1.8v 779.495n 1.8v 779.505n 1.8v 789.495n 1.8v 789.505n 1.8v 799.495n 1.8v 799.505n 1.8v 809.495n 1.8v 809.505n 1.8v 819.495n 1.8v 819.505n 1.8v 829.495n 1.8v 829.505n 1.8v 839.495n 1.8v 839.505n 1.8v 849.495n 1.8v 849.505n 1.8v 859.495n 1.8v 859.505n 1.8v 869.495n 1.8v 869.505n 1.8v 879.495n 1.8v 879.505n 1.8v 889.495n 1.8v 889.505n 1.8v 899.495n 1.8v 899.505n 0.0v 909.495n 0.0v 909.505n 0.0v 919.495n 0.0v 919.505n 0.0v 929.495n 0.0v 929.505n 0.0v 939.495n 0.0v 939.505n 0.0v 949.495n 0.0v 949.505n 0.0v 959.495n 0.0v 959.505n 0.0v 969.495n 0.0v 969.505n 0.0v 979.495n 0.0v 979.505n 0.0v 989.495n 0.0v 989.505n 0.0v 999.495n 0.0v 999.505n 1.8v 1009.495n 1.8v 1009.505n 1.8v 1019.495n 1.8v 1019.505n 1.8v 1029.495n 1.8v 1029.505n 1.8v 1039.495n 1.8v 1039.505n 1.8v 1049.495n 1.8v 1049.505n 1.8v 1059.495n 1.8v 1059.505n 1.8v 1069.495n 1.8v 1069.505n 1.8v 1079.495n 1.8v 1079.505n 1.8v 1089.495n 1.8v 1089.505n 1.8v 1099.495n 1.8v 1099.505n 1.8v 1109.495n 1.8v 1109.505n 1.8v 1119.495n 1.8v 1119.505n 1.8v 1129.495n 1.8v 1129.505n 1.8v 1139.495n 1.8v 1139.505n 0.0v 1149.495n 0.0v 1149.505n 0.0v 1159.495n 0.0v 1159.505n 0.0v 1169.495n 0.0v 1169.505n 0.0v 1179.495n 0.0v 1179.505n 0.0v 1189.495n 0.0v 1189.505n 0.0v 1199.495n 0.0v 1199.505n 0.0v 1209.495n 0.0v 1209.505n 0.0v 1219.495n 0.0v 1219.505n 0.0v 1229.495n 0.0v 1229.505n 0.0v 1239.495n 0.0v 1239.505n 0.0v 1249.495n 0.0v 1249.505n 0.0v 1259.495n 0.0v 1259.505n 0.0v 1269.495n 0.0v 1269.505n 0.0v 1279.495n 0.0v 1279.505n 0.0v 1289.495n 0.0v 1289.505n 0.0v 1299.495n 0.0v 1299.505n 1.8v 1309.495n 1.8v 1309.505n 1.8v 1319.495n 1.8v 1319.505n 1.8v 1329.495n 1.8v 1329.505n 1.8v 1339.495n 1.8v 1339.505n 1.8v 1349.495n 1.8v 1349.505n 1.8v 1359.495n 1.8v 1359.505n 1.8v 1369.495n 1.8v 1369.505n 1.8v 1379.495n 1.8v 1379.505n 1.8v 1389.495n 1.8v 1389.505n 1.8v 1399.495n 1.8v 1399.505n 1.8v 1409.495n 1.8v 1409.505n 1.8v 1419.495n 1.8v 1419.505n 1.8v 1429.495n 1.8v 1429.505n 0.0v 1439.495n 0.0v 1439.505n 0.0v 1449.495n 0.0v 1449.505n 0.0v 1459.495n 0.0v 1459.505n 1.8v 1469.495n 1.8v 1469.505n 0.0v 1479.495n 0.0v 1479.505n 0.0v 1489.495n 0.0v 1489.505n 1.8v 1499.495n 1.8v 1499.505n 1.8v 1509.495n 1.8v 1509.505n 1.8v 1519.495n 1.8v 1519.505n 1.8v 1529.495n 1.8v 1529.505n 1.8v 1539.495n 1.8v 1539.505n 1.8v 1549.495n 1.8v 1549.505n 0.0v 1559.495n 0.0v 1559.505n 0.0v 1569.495n 0.0v 1569.505n 0.0v 1579.495n 0.0v 1579.505n 1.8v 1589.495n 1.8v 1589.505n 1.8v 1599.495n 1.8v 1599.505n 1.8v 1609.495n 1.8v 1609.505n 1.8v 1619.495n 1.8v 1619.505n 1.8v 1629.495n 1.8v 1629.505n 1.8v 1639.495n 1.8v 1639.505n 1.8v 1649.495n 1.8v 1649.505n 1.8v 1659.495n 1.8v 1659.505n 1.8v 1669.495n 1.8v 1669.505n 1.8v 1679.495n 1.8v 1679.505n 1.8v 1689.495n 1.8v 1689.505n 1.8v 1699.495n 1.8v 1699.505n 1.8v 1709.495n 1.8v 1709.505n 1.8v 1719.495n 1.8v 1719.505n 1.8v 1729.495n 1.8v 1729.505n 1.8v 1739.495n 1.8v 1739.505n 1.8v 1749.495n 1.8v 1749.505n 1.8v 1759.495n 1.8v 1759.505n 1.8v 1769.495n 1.8v 1769.505n 1.8v 1779.495n 1.8v 1779.505n 1.8v 1789.495n 1.8v 1789.505n 1.8v 1799.495n 1.8v 1799.505n 0.0v 1809.495n 0.0v 1809.505n 0.0v 1819.495n 0.0v 1819.505n 0.0v 1829.495n 0.0v 1829.505n 0.0v 1839.495n 0.0v 1839.505n 1.8v 1849.495n 1.8v 1849.505n 1.8v 1859.495n 1.8v 1859.505n 1.8v 1869.495n 1.8v 1869.505n 1.8v 1879.495n 1.8v 1879.505n 1.8v 1889.495n 1.8v 1889.505n 1.8v 1899.495n 1.8v 1899.505n 1.8v 1909.495n 1.8v 1909.505n 0.0v 1919.495n 0.0v 1919.505n 0.0v 1929.495n 0.0v 1929.505n 0.0v 1939.495n 0.0v 1939.505n 0.0v 1949.495n 0.0v 1949.505n 0.0v 1959.495n 0.0v 1959.505n 0.0v 1969.495n 0.0v 1969.505n 0.0v 1979.495n 0.0v 1979.505n 0.0v 1989.495n 0.0v 1989.505n 0.0v 1999.495n 0.0v 1999.505n 0.0v 2009.495n 0.0v 2009.505n 0.0v 2019.495n 0.0v 2019.505n 0.0v 2029.495n 0.0v 2029.505n 0.0v 2039.495n 0.0v 2039.505n 0.0v 2049.495n 0.0v 2049.505n 0.0v )
* (time, data): [(0, 0), (10, 0), (20, 1), (30, 1), (40, 1), (50, 1), (60, 0), (70, 0), (80, 1), (90, 1), (100, 1), (110, 0), (120, 1), (130, 1), (140, 1), (150, 1), (160, 1), (170, 1), (180, 1), (190, 1), (200, 1), (210, 1), (220, 1), (230, 1), (240, 1), (250, 1), (260, 0), (270, 0), (280, 0), (290, 0), (300, 0), (310, 0), (320, 0), (330, 0), (340, 0), (350, 0), (360, 0), (370, 0), (380, 0), (390, 0), (400, 0), (410, 0), (420, 0), (430, 0), (440, 0), (450, 0), (460, 0), (470, 0), (480, 0), (490, 0), (500, 0), (510, 0), (520, 0), (530, 0), (540, 0), (550, 0), (560, 0), (570, 0), (580, 0), (590, 1), (600, 1), (610, 1), (620, 1), (630, 1), (640, 1), (650, 1), (660, 0), (670, 0), (680, 0), (690, 0), (700, 0), (710, 0), (720, 0), (730, 0), (740, 0), (750, 0), (760, 0), (770, 1), (780, 1), (790, 1), (800, 1), (810, 1), (820, 1), (830, 1), (840, 1), (850, 1), (860, 1), (870, 1), (880, 1), (890, 0), (900, 0), (910, 0), (920, 0), (930, 0), (940, 0), (950, 0), (960, 0), (970, 0), (980, 0), (990, 0), (1000, 1), (1010, 1), (1020, 0), (1030, 0), (1040, 0), (1050, 0), (1060, 0), (1070, 0), (1080, 1), (1090, 1), (1100, 1), (1110, 1), (1120, 1), (1130, 1), (1140, 1), (1150, 1), (1160, 1), (1170, 1), (1180, 1), (1190, 1), (1200, 1), (1210, 1), (1220, 1), (1230, 1), (1240, 1), (1250, 1), (1260, 0), (1270, 0), (1280, 0), (1290, 0), (1300, 1), (1310, 0), (1320, 0), (1330, 0), (1340, 0), (1350, 0), (1360, 0), (1370, 0), (1380, 0), (1390, 0), (1400, 0), (1410, 0), (1420, 0), (1430, 1), (1440, 0), (1450, 0), (1460, 0), (1470, 0), (1480, 0), (1490, 1), (1500, 1), (1510, 1), (1520, 1), (1530, 1), (1540, 1), (1550, 0), (1560, 0), (1570, 0), (1580, 0), (1590, 1), (1600, 1), (1610, 1), (1620, 1), (1630, 1), (1640, 1), (1650, 1), (1660, 1), (1670, 1), (1680, 1), (1690, 1), (1700, 0), (1710, 1), (1720, 1), (1730, 1), (1740, 1), (1750, 1), (1760, 1), (1770, 1), (1780, 1), (1790, 1), (1800, 1), (1810, 1), (1820, 1), (1830, 1), (1840, 0), (1850, 0), (1860, 0), (1870, 0), (1880, 0), (1890, 0), (1900, 0), (1910, 0), (1920, 0), (1930, 0), (1940, 0), (1950, 0), (1960, 1), (1970, 1), (1980, 1), (1990, 1), (2000, 1), (2010, 1), (2020, 1), (2030, 0), (2040, 1), (2050, 1)]
Vdin0_11  din0_11  0 PWL (0n 0.0v 9.495n 0.0v 9.505n 0.0v 19.495n 0.0v 19.505n 1.8v 29.495n 1.8v 29.505n 1.8v 39.495n 1.8v 39.505n 1.8v 49.495n 1.8v 49.505n 1.8v 59.495n 1.8v 59.505n 0.0v 69.495n 0.0v 69.505n 0.0v 79.495n 0.0v 79.505n 1.8v 89.495n 1.8v 89.505n 1.8v 99.495n 1.8v 99.505n 1.8v 109.495n 1.8v 109.505n 0.0v 119.495n 0.0v 119.505n 1.8v 129.495n 1.8v 129.505n 1.8v 139.495n 1.8v 139.505n 1.8v 149.495n 1.8v 149.505n 1.8v 159.495n 1.8v 159.505n 1.8v 169.495n 1.8v 169.505n 1.8v 179.495n 1.8v 179.505n 1.8v 189.495n 1.8v 189.505n 1.8v 199.495n 1.8v 199.505n 1.8v 209.495n 1.8v 209.505n 1.8v 219.495n 1.8v 219.505n 1.8v 229.495n 1.8v 229.505n 1.8v 239.495n 1.8v 239.505n 1.8v 249.495n 1.8v 249.505n 1.8v 259.495n 1.8v 259.505n 0.0v 269.495n 0.0v 269.505n 0.0v 279.495n 0.0v 279.505n 0.0v 289.495n 0.0v 289.505n 0.0v 299.495n 0.0v 299.505n 0.0v 309.495n 0.0v 309.505n 0.0v 319.495n 0.0v 319.505n 0.0v 329.495n 0.0v 329.505n 0.0v 339.495n 0.0v 339.505n 0.0v 349.495n 0.0v 349.505n 0.0v 359.495n 0.0v 359.505n 0.0v 369.495n 0.0v 369.505n 0.0v 379.495n 0.0v 379.505n 0.0v 389.495n 0.0v 389.505n 0.0v 399.495n 0.0v 399.505n 0.0v 409.495n 0.0v 409.505n 0.0v 419.495n 0.0v 419.505n 0.0v 429.495n 0.0v 429.505n 0.0v 439.495n 0.0v 439.505n 0.0v 449.495n 0.0v 449.505n 0.0v 459.495n 0.0v 459.505n 0.0v 469.495n 0.0v 469.505n 0.0v 479.495n 0.0v 479.505n 0.0v 489.495n 0.0v 489.505n 0.0v 499.495n 0.0v 499.505n 0.0v 509.495n 0.0v 509.505n 0.0v 519.495n 0.0v 519.505n 0.0v 529.495n 0.0v 529.505n 0.0v 539.495n 0.0v 539.505n 0.0v 549.495n 0.0v 549.505n 0.0v 559.495n 0.0v 559.505n 0.0v 569.495n 0.0v 569.505n 0.0v 579.495n 0.0v 579.505n 0.0v 589.495n 0.0v 589.505n 1.8v 599.495n 1.8v 599.505n 1.8v 609.495n 1.8v 609.505n 1.8v 619.495n 1.8v 619.505n 1.8v 629.495n 1.8v 629.505n 1.8v 639.495n 1.8v 639.505n 1.8v 649.495n 1.8v 649.505n 1.8v 659.495n 1.8v 659.505n 0.0v 669.495n 0.0v 669.505n 0.0v 679.495n 0.0v 679.505n 0.0v 689.495n 0.0v 689.505n 0.0v 699.495n 0.0v 699.505n 0.0v 709.495n 0.0v 709.505n 0.0v 719.495n 0.0v 719.505n 0.0v 729.495n 0.0v 729.505n 0.0v 739.495n 0.0v 739.505n 0.0v 749.495n 0.0v 749.505n 0.0v 759.495n 0.0v 759.505n 0.0v 769.495n 0.0v 769.505n 1.8v 779.495n 1.8v 779.505n 1.8v 789.495n 1.8v 789.505n 1.8v 799.495n 1.8v 799.505n 1.8v 809.495n 1.8v 809.505n 1.8v 819.495n 1.8v 819.505n 1.8v 829.495n 1.8v 829.505n 1.8v 839.495n 1.8v 839.505n 1.8v 849.495n 1.8v 849.505n 1.8v 859.495n 1.8v 859.505n 1.8v 869.495n 1.8v 869.505n 1.8v 879.495n 1.8v 879.505n 1.8v 889.495n 1.8v 889.505n 0.0v 899.495n 0.0v 899.505n 0.0v 909.495n 0.0v 909.505n 0.0v 919.495n 0.0v 919.505n 0.0v 929.495n 0.0v 929.505n 0.0v 939.495n 0.0v 939.505n 0.0v 949.495n 0.0v 949.505n 0.0v 959.495n 0.0v 959.505n 0.0v 969.495n 0.0v 969.505n 0.0v 979.495n 0.0v 979.505n 0.0v 989.495n 0.0v 989.505n 0.0v 999.495n 0.0v 999.505n 1.8v 1009.495n 1.8v 1009.505n 1.8v 1019.495n 1.8v 1019.505n 0.0v 1029.495n 0.0v 1029.505n 0.0v 1039.495n 0.0v 1039.505n 0.0v 1049.495n 0.0v 1049.505n 0.0v 1059.495n 0.0v 1059.505n 0.0v 1069.495n 0.0v 1069.505n 0.0v 1079.495n 0.0v 1079.505n 1.8v 1089.495n 1.8v 1089.505n 1.8v 1099.495n 1.8v 1099.505n 1.8v 1109.495n 1.8v 1109.505n 1.8v 1119.495n 1.8v 1119.505n 1.8v 1129.495n 1.8v 1129.505n 1.8v 1139.495n 1.8v 1139.505n 1.8v 1149.495n 1.8v 1149.505n 1.8v 1159.495n 1.8v 1159.505n 1.8v 1169.495n 1.8v 1169.505n 1.8v 1179.495n 1.8v 1179.505n 1.8v 1189.495n 1.8v 1189.505n 1.8v 1199.495n 1.8v 1199.505n 1.8v 1209.495n 1.8v 1209.505n 1.8v 1219.495n 1.8v 1219.505n 1.8v 1229.495n 1.8v 1229.505n 1.8v 1239.495n 1.8v 1239.505n 1.8v 1249.495n 1.8v 1249.505n 1.8v 1259.495n 1.8v 1259.505n 0.0v 1269.495n 0.0v 1269.505n 0.0v 1279.495n 0.0v 1279.505n 0.0v 1289.495n 0.0v 1289.505n 0.0v 1299.495n 0.0v 1299.505n 1.8v 1309.495n 1.8v 1309.505n 0.0v 1319.495n 0.0v 1319.505n 0.0v 1329.495n 0.0v 1329.505n 0.0v 1339.495n 0.0v 1339.505n 0.0v 1349.495n 0.0v 1349.505n 0.0v 1359.495n 0.0v 1359.505n 0.0v 1369.495n 0.0v 1369.505n 0.0v 1379.495n 0.0v 1379.505n 0.0v 1389.495n 0.0v 1389.505n 0.0v 1399.495n 0.0v 1399.505n 0.0v 1409.495n 0.0v 1409.505n 0.0v 1419.495n 0.0v 1419.505n 0.0v 1429.495n 0.0v 1429.505n 1.8v 1439.495n 1.8v 1439.505n 0.0v 1449.495n 0.0v 1449.505n 0.0v 1459.495n 0.0v 1459.505n 0.0v 1469.495n 0.0v 1469.505n 0.0v 1479.495n 0.0v 1479.505n 0.0v 1489.495n 0.0v 1489.505n 1.8v 1499.495n 1.8v 1499.505n 1.8v 1509.495n 1.8v 1509.505n 1.8v 1519.495n 1.8v 1519.505n 1.8v 1529.495n 1.8v 1529.505n 1.8v 1539.495n 1.8v 1539.505n 1.8v 1549.495n 1.8v 1549.505n 0.0v 1559.495n 0.0v 1559.505n 0.0v 1569.495n 0.0v 1569.505n 0.0v 1579.495n 0.0v 1579.505n 0.0v 1589.495n 0.0v 1589.505n 1.8v 1599.495n 1.8v 1599.505n 1.8v 1609.495n 1.8v 1609.505n 1.8v 1619.495n 1.8v 1619.505n 1.8v 1629.495n 1.8v 1629.505n 1.8v 1639.495n 1.8v 1639.505n 1.8v 1649.495n 1.8v 1649.505n 1.8v 1659.495n 1.8v 1659.505n 1.8v 1669.495n 1.8v 1669.505n 1.8v 1679.495n 1.8v 1679.505n 1.8v 1689.495n 1.8v 1689.505n 1.8v 1699.495n 1.8v 1699.505n 0.0v 1709.495n 0.0v 1709.505n 1.8v 1719.495n 1.8v 1719.505n 1.8v 1729.495n 1.8v 1729.505n 1.8v 1739.495n 1.8v 1739.505n 1.8v 1749.495n 1.8v 1749.505n 1.8v 1759.495n 1.8v 1759.505n 1.8v 1769.495n 1.8v 1769.505n 1.8v 1779.495n 1.8v 1779.505n 1.8v 1789.495n 1.8v 1789.505n 1.8v 1799.495n 1.8v 1799.505n 1.8v 1809.495n 1.8v 1809.505n 1.8v 1819.495n 1.8v 1819.505n 1.8v 1829.495n 1.8v 1829.505n 1.8v 1839.495n 1.8v 1839.505n 0.0v 1849.495n 0.0v 1849.505n 0.0v 1859.495n 0.0v 1859.505n 0.0v 1869.495n 0.0v 1869.505n 0.0v 1879.495n 0.0v 1879.505n 0.0v 1889.495n 0.0v 1889.505n 0.0v 1899.495n 0.0v 1899.505n 0.0v 1909.495n 0.0v 1909.505n 0.0v 1919.495n 0.0v 1919.505n 0.0v 1929.495n 0.0v 1929.505n 0.0v 1939.495n 0.0v 1939.505n 0.0v 1949.495n 0.0v 1949.505n 0.0v 1959.495n 0.0v 1959.505n 1.8v 1969.495n 1.8v 1969.505n 1.8v 1979.495n 1.8v 1979.505n 1.8v 1989.495n 1.8v 1989.505n 1.8v 1999.495n 1.8v 1999.505n 1.8v 2009.495n 1.8v 2009.505n 1.8v 2019.495n 1.8v 2019.505n 1.8v 2029.495n 1.8v 2029.505n 0.0v 2039.495n 0.0v 2039.505n 1.8v 2049.495n 1.8v 2049.505n 1.8v )
* (time, data): [(0, 0), (10, 0), (20, 0), (30, 1), (40, 1), (50, 1), (60, 0), (70, 0), (80, 1), (90, 1), (100, 1), (110, 1), (120, 1), (130, 1), (140, 1), (150, 1), (160, 1), (170, 1), (180, 1), (190, 1), (200, 1), (210, 1), (220, 1), (230, 1), (240, 1), (250, 1), (260, 1), (270, 1), (280, 1), (290, 1), (300, 1), (310, 1), (320, 1), (330, 1), (340, 1), (350, 1), (360, 1), (370, 1), (380, 1), (390, 1), (400, 0), (410, 0), (420, 0), (430, 0), (440, 0), (450, 0), (460, 0), (470, 0), (480, 0), (490, 0), (500, 0), (510, 0), (520, 0), (530, 0), (540, 0), (550, 0), (560, 0), (570, 0), (580, 0), (590, 1), (600, 1), (610, 1), (620, 1), (630, 0), (640, 0), (650, 0), (660, 1), (670, 1), (680, 1), (690, 1), (700, 0), (710, 0), (720, 0), (730, 0), (740, 0), (750, 0), (760, 0), (770, 0), (780, 1), (790, 1), (800, 1), (810, 1), (820, 1), (830, 1), (840, 1), (850, 1), (860, 1), (870, 1), (880, 1), (890, 1), (900, 0), (910, 0), (920, 0), (930, 0), (940, 1), (950, 1), (960, 1), (970, 1), (980, 1), (990, 1), (1000, 0), (1010, 0), (1020, 1), (1030, 1), (1040, 1), (1050, 1), (1060, 1), (1070, 1), (1080, 1), (1090, 1), (1100, 1), (1110, 1), (1120, 1), (1130, 1), (1140, 0), (1150, 0), (1160, 0), (1170, 0), (1180, 0), (1190, 0), (1200, 0), (1210, 0), (1220, 0), (1230, 0), (1240, 0), (1250, 0), (1260, 1), (1270, 1), (1280, 1), (1290, 1), (1300, 0), (1310, 1), (1320, 1), (1330, 1), (1340, 1), (1350, 1), (1360, 0), (1370, 0), (1380, 0), (1390, 0), (1400, 0), (1410, 1), (1420, 1), (1430, 0), (1440, 1), (1450, 1), (1460, 1), (1470, 0), (1480, 0), (1490, 1), (1500, 1), (1510, 1), (1520, 1), (1530, 1), (1540, 1), (1550, 1), (1560, 1), (1570, 1), (1580, 1), (1590, 1), (1600, 1), (1610, 1), (1620, 1), (1630, 1), (1640, 1), (1650, 1), (1660, 1), (1670, 1), (1680, 1), (1690, 1), (1700, 1), (1710, 1), (1720, 1), (1730, 0), (1740, 0), (1750, 0), (1760, 0), (1770, 0), (1780, 0), (1790, 0), (1800, 0), (1810, 0), (1820, 0), (1830, 0), (1840, 1), (1850, 1), (1860, 0), (1870, 0), (1880, 0), (1890, 0), (1900, 0), (1910, 1), (1920, 1), (1930, 1), (1940, 1), (1950, 1), (1960, 0), (1970, 0), (1980, 0), (1990, 0), (2000, 0), (2010, 0), (2020, 0), (2030, 1), (2040, 1), (2050, 1)]
Vdin0_12  din0_12  0 PWL (0n 0.0v 9.495n 0.0v 9.505n 0.0v 19.495n 0.0v 19.505n 0.0v 29.495n 0.0v 29.505n 1.8v 39.495n 1.8v 39.505n 1.8v 49.495n 1.8v 49.505n 1.8v 59.495n 1.8v 59.505n 0.0v 69.495n 0.0v 69.505n 0.0v 79.495n 0.0v 79.505n 1.8v 89.495n 1.8v 89.505n 1.8v 99.495n 1.8v 99.505n 1.8v 109.495n 1.8v 109.505n 1.8v 119.495n 1.8v 119.505n 1.8v 129.495n 1.8v 129.505n 1.8v 139.495n 1.8v 139.505n 1.8v 149.495n 1.8v 149.505n 1.8v 159.495n 1.8v 159.505n 1.8v 169.495n 1.8v 169.505n 1.8v 179.495n 1.8v 179.505n 1.8v 189.495n 1.8v 189.505n 1.8v 199.495n 1.8v 199.505n 1.8v 209.495n 1.8v 209.505n 1.8v 219.495n 1.8v 219.505n 1.8v 229.495n 1.8v 229.505n 1.8v 239.495n 1.8v 239.505n 1.8v 249.495n 1.8v 249.505n 1.8v 259.495n 1.8v 259.505n 1.8v 269.495n 1.8v 269.505n 1.8v 279.495n 1.8v 279.505n 1.8v 289.495n 1.8v 289.505n 1.8v 299.495n 1.8v 299.505n 1.8v 309.495n 1.8v 309.505n 1.8v 319.495n 1.8v 319.505n 1.8v 329.495n 1.8v 329.505n 1.8v 339.495n 1.8v 339.505n 1.8v 349.495n 1.8v 349.505n 1.8v 359.495n 1.8v 359.505n 1.8v 369.495n 1.8v 369.505n 1.8v 379.495n 1.8v 379.505n 1.8v 389.495n 1.8v 389.505n 1.8v 399.495n 1.8v 399.505n 0.0v 409.495n 0.0v 409.505n 0.0v 419.495n 0.0v 419.505n 0.0v 429.495n 0.0v 429.505n 0.0v 439.495n 0.0v 439.505n 0.0v 449.495n 0.0v 449.505n 0.0v 459.495n 0.0v 459.505n 0.0v 469.495n 0.0v 469.505n 0.0v 479.495n 0.0v 479.505n 0.0v 489.495n 0.0v 489.505n 0.0v 499.495n 0.0v 499.505n 0.0v 509.495n 0.0v 509.505n 0.0v 519.495n 0.0v 519.505n 0.0v 529.495n 0.0v 529.505n 0.0v 539.495n 0.0v 539.505n 0.0v 549.495n 0.0v 549.505n 0.0v 559.495n 0.0v 559.505n 0.0v 569.495n 0.0v 569.505n 0.0v 579.495n 0.0v 579.505n 0.0v 589.495n 0.0v 589.505n 1.8v 599.495n 1.8v 599.505n 1.8v 609.495n 1.8v 609.505n 1.8v 619.495n 1.8v 619.505n 1.8v 629.495n 1.8v 629.505n 0.0v 639.495n 0.0v 639.505n 0.0v 649.495n 0.0v 649.505n 0.0v 659.495n 0.0v 659.505n 1.8v 669.495n 1.8v 669.505n 1.8v 679.495n 1.8v 679.505n 1.8v 689.495n 1.8v 689.505n 1.8v 699.495n 1.8v 699.505n 0.0v 709.495n 0.0v 709.505n 0.0v 719.495n 0.0v 719.505n 0.0v 729.495n 0.0v 729.505n 0.0v 739.495n 0.0v 739.505n 0.0v 749.495n 0.0v 749.505n 0.0v 759.495n 0.0v 759.505n 0.0v 769.495n 0.0v 769.505n 0.0v 779.495n 0.0v 779.505n 1.8v 789.495n 1.8v 789.505n 1.8v 799.495n 1.8v 799.505n 1.8v 809.495n 1.8v 809.505n 1.8v 819.495n 1.8v 819.505n 1.8v 829.495n 1.8v 829.505n 1.8v 839.495n 1.8v 839.505n 1.8v 849.495n 1.8v 849.505n 1.8v 859.495n 1.8v 859.505n 1.8v 869.495n 1.8v 869.505n 1.8v 879.495n 1.8v 879.505n 1.8v 889.495n 1.8v 889.505n 1.8v 899.495n 1.8v 899.505n 0.0v 909.495n 0.0v 909.505n 0.0v 919.495n 0.0v 919.505n 0.0v 929.495n 0.0v 929.505n 0.0v 939.495n 0.0v 939.505n 1.8v 949.495n 1.8v 949.505n 1.8v 959.495n 1.8v 959.505n 1.8v 969.495n 1.8v 969.505n 1.8v 979.495n 1.8v 979.505n 1.8v 989.495n 1.8v 989.505n 1.8v 999.495n 1.8v 999.505n 0.0v 1009.495n 0.0v 1009.505n 0.0v 1019.495n 0.0v 1019.505n 1.8v 1029.495n 1.8v 1029.505n 1.8v 1039.495n 1.8v 1039.505n 1.8v 1049.495n 1.8v 1049.505n 1.8v 1059.495n 1.8v 1059.505n 1.8v 1069.495n 1.8v 1069.505n 1.8v 1079.495n 1.8v 1079.505n 1.8v 1089.495n 1.8v 1089.505n 1.8v 1099.495n 1.8v 1099.505n 1.8v 1109.495n 1.8v 1109.505n 1.8v 1119.495n 1.8v 1119.505n 1.8v 1129.495n 1.8v 1129.505n 1.8v 1139.495n 1.8v 1139.505n 0.0v 1149.495n 0.0v 1149.505n 0.0v 1159.495n 0.0v 1159.505n 0.0v 1169.495n 0.0v 1169.505n 0.0v 1179.495n 0.0v 1179.505n 0.0v 1189.495n 0.0v 1189.505n 0.0v 1199.495n 0.0v 1199.505n 0.0v 1209.495n 0.0v 1209.505n 0.0v 1219.495n 0.0v 1219.505n 0.0v 1229.495n 0.0v 1229.505n 0.0v 1239.495n 0.0v 1239.505n 0.0v 1249.495n 0.0v 1249.505n 0.0v 1259.495n 0.0v 1259.505n 1.8v 1269.495n 1.8v 1269.505n 1.8v 1279.495n 1.8v 1279.505n 1.8v 1289.495n 1.8v 1289.505n 1.8v 1299.495n 1.8v 1299.505n 0.0v 1309.495n 0.0v 1309.505n 1.8v 1319.495n 1.8v 1319.505n 1.8v 1329.495n 1.8v 1329.505n 1.8v 1339.495n 1.8v 1339.505n 1.8v 1349.495n 1.8v 1349.505n 1.8v 1359.495n 1.8v 1359.505n 0.0v 1369.495n 0.0v 1369.505n 0.0v 1379.495n 0.0v 1379.505n 0.0v 1389.495n 0.0v 1389.505n 0.0v 1399.495n 0.0v 1399.505n 0.0v 1409.495n 0.0v 1409.505n 1.8v 1419.495n 1.8v 1419.505n 1.8v 1429.495n 1.8v 1429.505n 0.0v 1439.495n 0.0v 1439.505n 1.8v 1449.495n 1.8v 1449.505n 1.8v 1459.495n 1.8v 1459.505n 1.8v 1469.495n 1.8v 1469.505n 0.0v 1479.495n 0.0v 1479.505n 0.0v 1489.495n 0.0v 1489.505n 1.8v 1499.495n 1.8v 1499.505n 1.8v 1509.495n 1.8v 1509.505n 1.8v 1519.495n 1.8v 1519.505n 1.8v 1529.495n 1.8v 1529.505n 1.8v 1539.495n 1.8v 1539.505n 1.8v 1549.495n 1.8v 1549.505n 1.8v 1559.495n 1.8v 1559.505n 1.8v 1569.495n 1.8v 1569.505n 1.8v 1579.495n 1.8v 1579.505n 1.8v 1589.495n 1.8v 1589.505n 1.8v 1599.495n 1.8v 1599.505n 1.8v 1609.495n 1.8v 1609.505n 1.8v 1619.495n 1.8v 1619.505n 1.8v 1629.495n 1.8v 1629.505n 1.8v 1639.495n 1.8v 1639.505n 1.8v 1649.495n 1.8v 1649.505n 1.8v 1659.495n 1.8v 1659.505n 1.8v 1669.495n 1.8v 1669.505n 1.8v 1679.495n 1.8v 1679.505n 1.8v 1689.495n 1.8v 1689.505n 1.8v 1699.495n 1.8v 1699.505n 1.8v 1709.495n 1.8v 1709.505n 1.8v 1719.495n 1.8v 1719.505n 1.8v 1729.495n 1.8v 1729.505n 0.0v 1739.495n 0.0v 1739.505n 0.0v 1749.495n 0.0v 1749.505n 0.0v 1759.495n 0.0v 1759.505n 0.0v 1769.495n 0.0v 1769.505n 0.0v 1779.495n 0.0v 1779.505n 0.0v 1789.495n 0.0v 1789.505n 0.0v 1799.495n 0.0v 1799.505n 0.0v 1809.495n 0.0v 1809.505n 0.0v 1819.495n 0.0v 1819.505n 0.0v 1829.495n 0.0v 1829.505n 0.0v 1839.495n 0.0v 1839.505n 1.8v 1849.495n 1.8v 1849.505n 1.8v 1859.495n 1.8v 1859.505n 0.0v 1869.495n 0.0v 1869.505n 0.0v 1879.495n 0.0v 1879.505n 0.0v 1889.495n 0.0v 1889.505n 0.0v 1899.495n 0.0v 1899.505n 0.0v 1909.495n 0.0v 1909.505n 1.8v 1919.495n 1.8v 1919.505n 1.8v 1929.495n 1.8v 1929.505n 1.8v 1939.495n 1.8v 1939.505n 1.8v 1949.495n 1.8v 1949.505n 1.8v 1959.495n 1.8v 1959.505n 0.0v 1969.495n 0.0v 1969.505n 0.0v 1979.495n 0.0v 1979.505n 0.0v 1989.495n 0.0v 1989.505n 0.0v 1999.495n 0.0v 1999.505n 0.0v 2009.495n 0.0v 2009.505n 0.0v 2019.495n 0.0v 2019.505n 0.0v 2029.495n 0.0v 2029.505n 1.8v 2039.495n 1.8v 2039.505n 1.8v 2049.495n 1.8v 2049.505n 1.8v )
* (time, data): [(0, 0), (10, 1), (20, 0), (30, 0), (40, 0), (50, 0), (60, 0), (70, 0), (80, 1), (90, 1), (100, 1), (110, 1), (120, 1), (130, 1), (140, 1), (150, 1), (160, 1), (170, 1), (180, 1), (190, 1), (200, 1), (210, 1), (220, 1), (230, 1), (240, 1), (250, 1), (260, 1), (270, 1), (280, 0), (290, 0), (300, 0), (310, 0), (320, 0), (330, 0), (340, 0), (350, 0), (360, 0), (370, 0), (380, 0), (390, 0), (400, 1), (410, 1), (420, 1), (430, 1), (440, 1), (450, 1), (460, 0), (470, 1), (480, 1), (490, 1), (500, 1), (510, 1), (520, 1), (530, 1), (540, 1), (550, 1), (560, 1), (570, 1), (580, 1), (590, 0), (600, 1), (610, 1), (620, 1), (630, 1), (640, 1), (650, 1), (660, 1), (670, 1), (680, 1), (690, 1), (700, 1), (710, 1), (720, 1), (730, 1), (740, 1), (750, 1), (760, 1), (770, 0), (780, 1), (790, 1), (800, 1), (810, 1), (820, 1), (830, 1), (840, 1), (850, 1), (860, 1), (870, 1), (880, 1), (890, 0), (900, 1), (910, 1), (920, 1), (930, 1), (940, 0), (950, 0), (960, 0), (970, 0), (980, 0), (990, 0), (1000, 0), (1010, 0), (1020, 1), (1030, 1), (1040, 1), (1050, 1), (1060, 1), (1070, 1), (1080, 1), (1090, 0), (1100, 0), (1110, 0), (1120, 0), (1130, 0), (1140, 0), (1150, 0), (1160, 0), (1170, 0), (1180, 0), (1190, 0), (1200, 0), (1210, 0), (1220, 0), (1230, 0), (1240, 0), (1250, 0), (1260, 0), (1270, 0), (1280, 0), (1290, 0), (1300, 0), (1310, 1), (1320, 1), (1330, 1), (1340, 1), (1350, 1), (1360, 1), (1370, 1), (1380, 1), (1390, 1), (1400, 1), (1410, 1), (1420, 1), (1430, 0), (1440, 1), (1450, 1), (1460, 0), (1470, 0), (1480, 0), (1490, 0), (1500, 0), (1510, 0), (1520, 0), (1530, 0), (1540, 0), (1550, 0), (1560, 0), (1570, 0), (1580, 0), (1590, 1), (1600, 1), (1610, 1), (1620, 1), (1630, 0), (1640, 0), (1650, 0), (1660, 0), (1670, 0), (1680, 0), (1690, 0), (1700, 1), (1710, 1), (1720, 1), (1730, 0), (1740, 0), (1750, 0), (1760, 0), (1770, 0), (1780, 0), (1790, 0), (1800, 1), (1810, 1), (1820, 1), (1830, 1), (1840, 1), (1850, 1), (1860, 1), (1870, 1), (1880, 1), (1890, 1), (1900, 1), (1910, 1), (1920, 1), (1930, 1), (1940, 1), (1950, 1), (1960, 1), (1970, 1), (1980, 1), (1990, 1), (2000, 1), (2010, 1), (2020, 1), (2030, 1), (2040, 1), (2050, 1)]
Vdin0_13  din0_13  0 PWL (0n 0.0v 9.495n 0.0v 9.505n 1.8v 19.495n 1.8v 19.505n 0.0v 29.495n 0.0v 29.505n 0.0v 39.495n 0.0v 39.505n 0.0v 49.495n 0.0v 49.505n 0.0v 59.495n 0.0v 59.505n 0.0v 69.495n 0.0v 69.505n 0.0v 79.495n 0.0v 79.505n 1.8v 89.495n 1.8v 89.505n 1.8v 99.495n 1.8v 99.505n 1.8v 109.495n 1.8v 109.505n 1.8v 119.495n 1.8v 119.505n 1.8v 129.495n 1.8v 129.505n 1.8v 139.495n 1.8v 139.505n 1.8v 149.495n 1.8v 149.505n 1.8v 159.495n 1.8v 159.505n 1.8v 169.495n 1.8v 169.505n 1.8v 179.495n 1.8v 179.505n 1.8v 189.495n 1.8v 189.505n 1.8v 199.495n 1.8v 199.505n 1.8v 209.495n 1.8v 209.505n 1.8v 219.495n 1.8v 219.505n 1.8v 229.495n 1.8v 229.505n 1.8v 239.495n 1.8v 239.505n 1.8v 249.495n 1.8v 249.505n 1.8v 259.495n 1.8v 259.505n 1.8v 269.495n 1.8v 269.505n 1.8v 279.495n 1.8v 279.505n 0.0v 289.495n 0.0v 289.505n 0.0v 299.495n 0.0v 299.505n 0.0v 309.495n 0.0v 309.505n 0.0v 319.495n 0.0v 319.505n 0.0v 329.495n 0.0v 329.505n 0.0v 339.495n 0.0v 339.505n 0.0v 349.495n 0.0v 349.505n 0.0v 359.495n 0.0v 359.505n 0.0v 369.495n 0.0v 369.505n 0.0v 379.495n 0.0v 379.505n 0.0v 389.495n 0.0v 389.505n 0.0v 399.495n 0.0v 399.505n 1.8v 409.495n 1.8v 409.505n 1.8v 419.495n 1.8v 419.505n 1.8v 429.495n 1.8v 429.505n 1.8v 439.495n 1.8v 439.505n 1.8v 449.495n 1.8v 449.505n 1.8v 459.495n 1.8v 459.505n 0.0v 469.495n 0.0v 469.505n 1.8v 479.495n 1.8v 479.505n 1.8v 489.495n 1.8v 489.505n 1.8v 499.495n 1.8v 499.505n 1.8v 509.495n 1.8v 509.505n 1.8v 519.495n 1.8v 519.505n 1.8v 529.495n 1.8v 529.505n 1.8v 539.495n 1.8v 539.505n 1.8v 549.495n 1.8v 549.505n 1.8v 559.495n 1.8v 559.505n 1.8v 569.495n 1.8v 569.505n 1.8v 579.495n 1.8v 579.505n 1.8v 589.495n 1.8v 589.505n 0.0v 599.495n 0.0v 599.505n 1.8v 609.495n 1.8v 609.505n 1.8v 619.495n 1.8v 619.505n 1.8v 629.495n 1.8v 629.505n 1.8v 639.495n 1.8v 639.505n 1.8v 649.495n 1.8v 649.505n 1.8v 659.495n 1.8v 659.505n 1.8v 669.495n 1.8v 669.505n 1.8v 679.495n 1.8v 679.505n 1.8v 689.495n 1.8v 689.505n 1.8v 699.495n 1.8v 699.505n 1.8v 709.495n 1.8v 709.505n 1.8v 719.495n 1.8v 719.505n 1.8v 729.495n 1.8v 729.505n 1.8v 739.495n 1.8v 739.505n 1.8v 749.495n 1.8v 749.505n 1.8v 759.495n 1.8v 759.505n 1.8v 769.495n 1.8v 769.505n 0.0v 779.495n 0.0v 779.505n 1.8v 789.495n 1.8v 789.505n 1.8v 799.495n 1.8v 799.505n 1.8v 809.495n 1.8v 809.505n 1.8v 819.495n 1.8v 819.505n 1.8v 829.495n 1.8v 829.505n 1.8v 839.495n 1.8v 839.505n 1.8v 849.495n 1.8v 849.505n 1.8v 859.495n 1.8v 859.505n 1.8v 869.495n 1.8v 869.505n 1.8v 879.495n 1.8v 879.505n 1.8v 889.495n 1.8v 889.505n 0.0v 899.495n 0.0v 899.505n 1.8v 909.495n 1.8v 909.505n 1.8v 919.495n 1.8v 919.505n 1.8v 929.495n 1.8v 929.505n 1.8v 939.495n 1.8v 939.505n 0.0v 949.495n 0.0v 949.505n 0.0v 959.495n 0.0v 959.505n 0.0v 969.495n 0.0v 969.505n 0.0v 979.495n 0.0v 979.505n 0.0v 989.495n 0.0v 989.505n 0.0v 999.495n 0.0v 999.505n 0.0v 1009.495n 0.0v 1009.505n 0.0v 1019.495n 0.0v 1019.505n 1.8v 1029.495n 1.8v 1029.505n 1.8v 1039.495n 1.8v 1039.505n 1.8v 1049.495n 1.8v 1049.505n 1.8v 1059.495n 1.8v 1059.505n 1.8v 1069.495n 1.8v 1069.505n 1.8v 1079.495n 1.8v 1079.505n 1.8v 1089.495n 1.8v 1089.505n 0.0v 1099.495n 0.0v 1099.505n 0.0v 1109.495n 0.0v 1109.505n 0.0v 1119.495n 0.0v 1119.505n 0.0v 1129.495n 0.0v 1129.505n 0.0v 1139.495n 0.0v 1139.505n 0.0v 1149.495n 0.0v 1149.505n 0.0v 1159.495n 0.0v 1159.505n 0.0v 1169.495n 0.0v 1169.505n 0.0v 1179.495n 0.0v 1179.505n 0.0v 1189.495n 0.0v 1189.505n 0.0v 1199.495n 0.0v 1199.505n 0.0v 1209.495n 0.0v 1209.505n 0.0v 1219.495n 0.0v 1219.505n 0.0v 1229.495n 0.0v 1229.505n 0.0v 1239.495n 0.0v 1239.505n 0.0v 1249.495n 0.0v 1249.505n 0.0v 1259.495n 0.0v 1259.505n 0.0v 1269.495n 0.0v 1269.505n 0.0v 1279.495n 0.0v 1279.505n 0.0v 1289.495n 0.0v 1289.505n 0.0v 1299.495n 0.0v 1299.505n 0.0v 1309.495n 0.0v 1309.505n 1.8v 1319.495n 1.8v 1319.505n 1.8v 1329.495n 1.8v 1329.505n 1.8v 1339.495n 1.8v 1339.505n 1.8v 1349.495n 1.8v 1349.505n 1.8v 1359.495n 1.8v 1359.505n 1.8v 1369.495n 1.8v 1369.505n 1.8v 1379.495n 1.8v 1379.505n 1.8v 1389.495n 1.8v 1389.505n 1.8v 1399.495n 1.8v 1399.505n 1.8v 1409.495n 1.8v 1409.505n 1.8v 1419.495n 1.8v 1419.505n 1.8v 1429.495n 1.8v 1429.505n 0.0v 1439.495n 0.0v 1439.505n 1.8v 1449.495n 1.8v 1449.505n 1.8v 1459.495n 1.8v 1459.505n 0.0v 1469.495n 0.0v 1469.505n 0.0v 1479.495n 0.0v 1479.505n 0.0v 1489.495n 0.0v 1489.505n 0.0v 1499.495n 0.0v 1499.505n 0.0v 1509.495n 0.0v 1509.505n 0.0v 1519.495n 0.0v 1519.505n 0.0v 1529.495n 0.0v 1529.505n 0.0v 1539.495n 0.0v 1539.505n 0.0v 1549.495n 0.0v 1549.505n 0.0v 1559.495n 0.0v 1559.505n 0.0v 1569.495n 0.0v 1569.505n 0.0v 1579.495n 0.0v 1579.505n 0.0v 1589.495n 0.0v 1589.505n 1.8v 1599.495n 1.8v 1599.505n 1.8v 1609.495n 1.8v 1609.505n 1.8v 1619.495n 1.8v 1619.505n 1.8v 1629.495n 1.8v 1629.505n 0.0v 1639.495n 0.0v 1639.505n 0.0v 1649.495n 0.0v 1649.505n 0.0v 1659.495n 0.0v 1659.505n 0.0v 1669.495n 0.0v 1669.505n 0.0v 1679.495n 0.0v 1679.505n 0.0v 1689.495n 0.0v 1689.505n 0.0v 1699.495n 0.0v 1699.505n 1.8v 1709.495n 1.8v 1709.505n 1.8v 1719.495n 1.8v 1719.505n 1.8v 1729.495n 1.8v 1729.505n 0.0v 1739.495n 0.0v 1739.505n 0.0v 1749.495n 0.0v 1749.505n 0.0v 1759.495n 0.0v 1759.505n 0.0v 1769.495n 0.0v 1769.505n 0.0v 1779.495n 0.0v 1779.505n 0.0v 1789.495n 0.0v 1789.505n 0.0v 1799.495n 0.0v 1799.505n 1.8v 1809.495n 1.8v 1809.505n 1.8v 1819.495n 1.8v 1819.505n 1.8v 1829.495n 1.8v 1829.505n 1.8v 1839.495n 1.8v 1839.505n 1.8v 1849.495n 1.8v 1849.505n 1.8v 1859.495n 1.8v 1859.505n 1.8v 1869.495n 1.8v 1869.505n 1.8v 1879.495n 1.8v 1879.505n 1.8v 1889.495n 1.8v 1889.505n 1.8v 1899.495n 1.8v 1899.505n 1.8v 1909.495n 1.8v 1909.505n 1.8v 1919.495n 1.8v 1919.505n 1.8v 1929.495n 1.8v 1929.505n 1.8v 1939.495n 1.8v 1939.505n 1.8v 1949.495n 1.8v 1949.505n 1.8v 1959.495n 1.8v 1959.505n 1.8v 1969.495n 1.8v 1969.505n 1.8v 1979.495n 1.8v 1979.505n 1.8v 1989.495n 1.8v 1989.505n 1.8v 1999.495n 1.8v 1999.505n 1.8v 2009.495n 1.8v 2009.505n 1.8v 2019.495n 1.8v 2019.505n 1.8v 2029.495n 1.8v 2029.505n 1.8v 2039.495n 1.8v 2039.505n 1.8v 2049.495n 1.8v 2049.505n 1.8v )
* (time, data): [(0, 0), (10, 1), (20, 1), (30, 1), (40, 1), (50, 1), (60, 0), (70, 0), (80, 1), (90, 1), (100, 1), (110, 0), (120, 0), (130, 0), (140, 0), (150, 0), (160, 0), (170, 0), (180, 0), (190, 0), (200, 0), (210, 0), (220, 0), (230, 0), (240, 0), (250, 0), (260, 0), (270, 0), (280, 0), (290, 0), (300, 0), (310, 0), (320, 0), (330, 0), (340, 0), (350, 0), (360, 0), (370, 0), (380, 0), (390, 0), (400, 1), (410, 1), (420, 1), (430, 1), (440, 1), (450, 0), (460, 1), (470, 1), (480, 1), (490, 1), (500, 1), (510, 1), (520, 1), (530, 1), (540, 0), (550, 0), (560, 0), (570, 0), (580, 0), (590, 1), (600, 0), (610, 0), (620, 0), (630, 0), (640, 0), (650, 0), (660, 0), (670, 0), (680, 0), (690, 1), (700, 0), (710, 0), (720, 0), (730, 0), (740, 0), (750, 0), (760, 0), (770, 0), (780, 1), (790, 1), (800, 1), (810, 1), (820, 1), (830, 1), (840, 1), (850, 1), (860, 1), (870, 1), (880, 0), (890, 0), (900, 1), (910, 1), (920, 1), (930, 1), (940, 1), (950, 1), (960, 1), (970, 1), (980, 1), (990, 1), (1000, 0), (1010, 0), (1020, 1), (1030, 1), (1040, 1), (1050, 1), (1060, 1), (1070, 1), (1080, 1), (1090, 0), (1100, 0), (1110, 0), (1120, 0), (1130, 0), (1140, 0), (1150, 0), (1160, 0), (1170, 0), (1180, 0), (1190, 0), (1200, 0), (1210, 0), (1220, 0), (1230, 0), (1240, 0), (1250, 0), (1260, 0), (1270, 0), (1280, 0), (1290, 0), (1300, 0), (1310, 1), (1320, 1), (1330, 1), (1340, 1), (1350, 1), (1360, 1), (1370, 1), (1380, 1), (1390, 1), (1400, 1), (1410, 0), (1420, 0), (1430, 0), (1440, 1), (1450, 1), (1460, 1), (1470, 0), (1480, 0), (1490, 1), (1500, 1), (1510, 1), (1520, 1), (1530, 1), (1540, 1), (1550, 1), (1560, 1), (1570, 1), (1580, 1), (1590, 1), (1600, 1), (1610, 1), (1620, 1), (1630, 0), (1640, 0), (1650, 0), (1660, 0), (1670, 0), (1680, 0), (1690, 0), (1700, 0), (1710, 0), (1720, 0), (1730, 0), (1740, 0), (1750, 0), (1760, 0), (1770, 0), (1780, 0), (1790, 0), (1800, 0), (1810, 0), (1820, 0), (1830, 0), (1840, 1), (1850, 1), (1860, 1), (1870, 1), (1880, 1), (1890, 1), (1900, 1), (1910, 0), (1920, 0), (1930, 0), (1940, 0), (1950, 0), (1960, 0), (1970, 0), (1980, 0), (1990, 0), (2000, 0), (2010, 0), (2020, 0), (2030, 1), (2040, 0), (2050, 0)]
Vdin0_14  din0_14  0 PWL (0n 0.0v 9.495n 0.0v 9.505n 1.8v 19.495n 1.8v 19.505n 1.8v 29.495n 1.8v 29.505n 1.8v 39.495n 1.8v 39.505n 1.8v 49.495n 1.8v 49.505n 1.8v 59.495n 1.8v 59.505n 0.0v 69.495n 0.0v 69.505n 0.0v 79.495n 0.0v 79.505n 1.8v 89.495n 1.8v 89.505n 1.8v 99.495n 1.8v 99.505n 1.8v 109.495n 1.8v 109.505n 0.0v 119.495n 0.0v 119.505n 0.0v 129.495n 0.0v 129.505n 0.0v 139.495n 0.0v 139.505n 0.0v 149.495n 0.0v 149.505n 0.0v 159.495n 0.0v 159.505n 0.0v 169.495n 0.0v 169.505n 0.0v 179.495n 0.0v 179.505n 0.0v 189.495n 0.0v 189.505n 0.0v 199.495n 0.0v 199.505n 0.0v 209.495n 0.0v 209.505n 0.0v 219.495n 0.0v 219.505n 0.0v 229.495n 0.0v 229.505n 0.0v 239.495n 0.0v 239.505n 0.0v 249.495n 0.0v 249.505n 0.0v 259.495n 0.0v 259.505n 0.0v 269.495n 0.0v 269.505n 0.0v 279.495n 0.0v 279.505n 0.0v 289.495n 0.0v 289.505n 0.0v 299.495n 0.0v 299.505n 0.0v 309.495n 0.0v 309.505n 0.0v 319.495n 0.0v 319.505n 0.0v 329.495n 0.0v 329.505n 0.0v 339.495n 0.0v 339.505n 0.0v 349.495n 0.0v 349.505n 0.0v 359.495n 0.0v 359.505n 0.0v 369.495n 0.0v 369.505n 0.0v 379.495n 0.0v 379.505n 0.0v 389.495n 0.0v 389.505n 0.0v 399.495n 0.0v 399.505n 1.8v 409.495n 1.8v 409.505n 1.8v 419.495n 1.8v 419.505n 1.8v 429.495n 1.8v 429.505n 1.8v 439.495n 1.8v 439.505n 1.8v 449.495n 1.8v 449.505n 0.0v 459.495n 0.0v 459.505n 1.8v 469.495n 1.8v 469.505n 1.8v 479.495n 1.8v 479.505n 1.8v 489.495n 1.8v 489.505n 1.8v 499.495n 1.8v 499.505n 1.8v 509.495n 1.8v 509.505n 1.8v 519.495n 1.8v 519.505n 1.8v 529.495n 1.8v 529.505n 1.8v 539.495n 1.8v 539.505n 0.0v 549.495n 0.0v 549.505n 0.0v 559.495n 0.0v 559.505n 0.0v 569.495n 0.0v 569.505n 0.0v 579.495n 0.0v 579.505n 0.0v 589.495n 0.0v 589.505n 1.8v 599.495n 1.8v 599.505n 0.0v 609.495n 0.0v 609.505n 0.0v 619.495n 0.0v 619.505n 0.0v 629.495n 0.0v 629.505n 0.0v 639.495n 0.0v 639.505n 0.0v 649.495n 0.0v 649.505n 0.0v 659.495n 0.0v 659.505n 0.0v 669.495n 0.0v 669.505n 0.0v 679.495n 0.0v 679.505n 0.0v 689.495n 0.0v 689.505n 1.8v 699.495n 1.8v 699.505n 0.0v 709.495n 0.0v 709.505n 0.0v 719.495n 0.0v 719.505n 0.0v 729.495n 0.0v 729.505n 0.0v 739.495n 0.0v 739.505n 0.0v 749.495n 0.0v 749.505n 0.0v 759.495n 0.0v 759.505n 0.0v 769.495n 0.0v 769.505n 0.0v 779.495n 0.0v 779.505n 1.8v 789.495n 1.8v 789.505n 1.8v 799.495n 1.8v 799.505n 1.8v 809.495n 1.8v 809.505n 1.8v 819.495n 1.8v 819.505n 1.8v 829.495n 1.8v 829.505n 1.8v 839.495n 1.8v 839.505n 1.8v 849.495n 1.8v 849.505n 1.8v 859.495n 1.8v 859.505n 1.8v 869.495n 1.8v 869.505n 1.8v 879.495n 1.8v 879.505n 0.0v 889.495n 0.0v 889.505n 0.0v 899.495n 0.0v 899.505n 1.8v 909.495n 1.8v 909.505n 1.8v 919.495n 1.8v 919.505n 1.8v 929.495n 1.8v 929.505n 1.8v 939.495n 1.8v 939.505n 1.8v 949.495n 1.8v 949.505n 1.8v 959.495n 1.8v 959.505n 1.8v 969.495n 1.8v 969.505n 1.8v 979.495n 1.8v 979.505n 1.8v 989.495n 1.8v 989.505n 1.8v 999.495n 1.8v 999.505n 0.0v 1009.495n 0.0v 1009.505n 0.0v 1019.495n 0.0v 1019.505n 1.8v 1029.495n 1.8v 1029.505n 1.8v 1039.495n 1.8v 1039.505n 1.8v 1049.495n 1.8v 1049.505n 1.8v 1059.495n 1.8v 1059.505n 1.8v 1069.495n 1.8v 1069.505n 1.8v 1079.495n 1.8v 1079.505n 1.8v 1089.495n 1.8v 1089.505n 0.0v 1099.495n 0.0v 1099.505n 0.0v 1109.495n 0.0v 1109.505n 0.0v 1119.495n 0.0v 1119.505n 0.0v 1129.495n 0.0v 1129.505n 0.0v 1139.495n 0.0v 1139.505n 0.0v 1149.495n 0.0v 1149.505n 0.0v 1159.495n 0.0v 1159.505n 0.0v 1169.495n 0.0v 1169.505n 0.0v 1179.495n 0.0v 1179.505n 0.0v 1189.495n 0.0v 1189.505n 0.0v 1199.495n 0.0v 1199.505n 0.0v 1209.495n 0.0v 1209.505n 0.0v 1219.495n 0.0v 1219.505n 0.0v 1229.495n 0.0v 1229.505n 0.0v 1239.495n 0.0v 1239.505n 0.0v 1249.495n 0.0v 1249.505n 0.0v 1259.495n 0.0v 1259.505n 0.0v 1269.495n 0.0v 1269.505n 0.0v 1279.495n 0.0v 1279.505n 0.0v 1289.495n 0.0v 1289.505n 0.0v 1299.495n 0.0v 1299.505n 0.0v 1309.495n 0.0v 1309.505n 1.8v 1319.495n 1.8v 1319.505n 1.8v 1329.495n 1.8v 1329.505n 1.8v 1339.495n 1.8v 1339.505n 1.8v 1349.495n 1.8v 1349.505n 1.8v 1359.495n 1.8v 1359.505n 1.8v 1369.495n 1.8v 1369.505n 1.8v 1379.495n 1.8v 1379.505n 1.8v 1389.495n 1.8v 1389.505n 1.8v 1399.495n 1.8v 1399.505n 1.8v 1409.495n 1.8v 1409.505n 0.0v 1419.495n 0.0v 1419.505n 0.0v 1429.495n 0.0v 1429.505n 0.0v 1439.495n 0.0v 1439.505n 1.8v 1449.495n 1.8v 1449.505n 1.8v 1459.495n 1.8v 1459.505n 1.8v 1469.495n 1.8v 1469.505n 0.0v 1479.495n 0.0v 1479.505n 0.0v 1489.495n 0.0v 1489.505n 1.8v 1499.495n 1.8v 1499.505n 1.8v 1509.495n 1.8v 1509.505n 1.8v 1519.495n 1.8v 1519.505n 1.8v 1529.495n 1.8v 1529.505n 1.8v 1539.495n 1.8v 1539.505n 1.8v 1549.495n 1.8v 1549.505n 1.8v 1559.495n 1.8v 1559.505n 1.8v 1569.495n 1.8v 1569.505n 1.8v 1579.495n 1.8v 1579.505n 1.8v 1589.495n 1.8v 1589.505n 1.8v 1599.495n 1.8v 1599.505n 1.8v 1609.495n 1.8v 1609.505n 1.8v 1619.495n 1.8v 1619.505n 1.8v 1629.495n 1.8v 1629.505n 0.0v 1639.495n 0.0v 1639.505n 0.0v 1649.495n 0.0v 1649.505n 0.0v 1659.495n 0.0v 1659.505n 0.0v 1669.495n 0.0v 1669.505n 0.0v 1679.495n 0.0v 1679.505n 0.0v 1689.495n 0.0v 1689.505n 0.0v 1699.495n 0.0v 1699.505n 0.0v 1709.495n 0.0v 1709.505n 0.0v 1719.495n 0.0v 1719.505n 0.0v 1729.495n 0.0v 1729.505n 0.0v 1739.495n 0.0v 1739.505n 0.0v 1749.495n 0.0v 1749.505n 0.0v 1759.495n 0.0v 1759.505n 0.0v 1769.495n 0.0v 1769.505n 0.0v 1779.495n 0.0v 1779.505n 0.0v 1789.495n 0.0v 1789.505n 0.0v 1799.495n 0.0v 1799.505n 0.0v 1809.495n 0.0v 1809.505n 0.0v 1819.495n 0.0v 1819.505n 0.0v 1829.495n 0.0v 1829.505n 0.0v 1839.495n 0.0v 1839.505n 1.8v 1849.495n 1.8v 1849.505n 1.8v 1859.495n 1.8v 1859.505n 1.8v 1869.495n 1.8v 1869.505n 1.8v 1879.495n 1.8v 1879.505n 1.8v 1889.495n 1.8v 1889.505n 1.8v 1899.495n 1.8v 1899.505n 1.8v 1909.495n 1.8v 1909.505n 0.0v 1919.495n 0.0v 1919.505n 0.0v 1929.495n 0.0v 1929.505n 0.0v 1939.495n 0.0v 1939.505n 0.0v 1949.495n 0.0v 1949.505n 0.0v 1959.495n 0.0v 1959.505n 0.0v 1969.495n 0.0v 1969.505n 0.0v 1979.495n 0.0v 1979.505n 0.0v 1989.495n 0.0v 1989.505n 0.0v 1999.495n 0.0v 1999.505n 0.0v 2009.495n 0.0v 2009.505n 0.0v 2019.495n 0.0v 2019.505n 0.0v 2029.495n 0.0v 2029.505n 1.8v 2039.495n 1.8v 2039.505n 0.0v 2049.495n 0.0v 2049.505n 0.0v )
* (time, data): [(0, 0), (10, 0), (20, 0), (30, 1), (40, 1), (50, 1), (60, 1), (70, 1), (80, 1), (90, 1), (100, 1), (110, 1), (120, 1), (130, 1), (140, 1), (150, 1), (160, 1), (170, 1), (180, 1), (190, 1), (200, 1), (210, 1), (220, 1), (230, 1), (240, 1), (250, 1), (260, 0), (270, 0), (280, 0), (290, 0), (300, 0), (310, 0), (320, 0), (330, 0), (340, 0), (350, 0), (360, 0), (370, 0), (380, 0), (390, 0), (400, 1), (410, 1), (420, 1), (430, 1), (440, 1), (450, 1), (460, 1), (470, 0), (480, 0), (490, 0), (500, 0), (510, 0), (520, 0), (530, 0), (540, 0), (550, 0), (560, 0), (570, 0), (580, 0), (590, 0), (600, 0), (610, 0), (620, 0), (630, 0), (640, 0), (650, 0), (660, 1), (670, 1), (680, 1), (690, 1), (700, 1), (710, 1), (720, 1), (730, 1), (740, 1), (750, 1), (760, 1), (770, 0), (780, 0), (790, 0), (800, 0), (810, 0), (820, 0), (830, 1), (840, 1), (850, 1), (860, 1), (870, 1), (880, 0), (890, 0), (900, 0), (910, 0), (920, 0), (930, 0), (940, 1), (950, 1), (960, 1), (970, 1), (980, 1), (990, 1), (1000, 1), (1010, 1), (1020, 0), (1030, 0), (1040, 0), (1050, 0), (1060, 0), (1070, 0), (1080, 1), (1090, 1), (1100, 1), (1110, 1), (1120, 1), (1130, 1), (1140, 1), (1150, 1), (1160, 1), (1170, 1), (1180, 1), (1190, 1), (1200, 1), (1210, 1), (1220, 1), (1230, 1), (1240, 1), (1250, 1), (1260, 1), (1270, 1), (1280, 1), (1290, 1), (1300, 1), (1310, 1), (1320, 1), (1330, 1), (1340, 1), (1350, 1), (1360, 1), (1370, 1), (1380, 1), (1390, 1), (1400, 1), (1410, 1), (1420, 1), (1430, 0), (1440, 0), (1450, 0), (1460, 1), (1470, 0), (1480, 0), (1490, 1), (1500, 1), (1510, 1), (1520, 1), (1530, 1), (1540, 1), (1550, 0), (1560, 0), (1570, 0), (1580, 0), (1590, 0), (1600, 0), (1610, 0), (1620, 0), (1630, 0), (1640, 0), (1650, 0), (1660, 0), (1670, 0), (1680, 0), (1690, 0), (1700, 0), (1710, 1), (1720, 1), (1730, 1), (1740, 1), (1750, 1), (1760, 1), (1770, 1), (1780, 1), (1790, 1), (1800, 1), (1810, 1), (1820, 1), (1830, 1), (1840, 0), (1850, 0), (1860, 1), (1870, 1), (1880, 1), (1890, 1), (1900, 1), (1910, 0), (1920, 0), (1930, 0), (1940, 0), (1950, 0), (1960, 1), (1970, 1), (1980, 1), (1990, 1), (2000, 1), (2010, 1), (2020, 1), (2030, 0), (2040, 1), (2050, 1)]
Vdin0_15  din0_15  0 PWL (0n 0.0v 9.495n 0.0v 9.505n 0.0v 19.495n 0.0v 19.505n 0.0v 29.495n 0.0v 29.505n 1.8v 39.495n 1.8v 39.505n 1.8v 49.495n 1.8v 49.505n 1.8v 59.495n 1.8v 59.505n 1.8v 69.495n 1.8v 69.505n 1.8v 79.495n 1.8v 79.505n 1.8v 89.495n 1.8v 89.505n 1.8v 99.495n 1.8v 99.505n 1.8v 109.495n 1.8v 109.505n 1.8v 119.495n 1.8v 119.505n 1.8v 129.495n 1.8v 129.505n 1.8v 139.495n 1.8v 139.505n 1.8v 149.495n 1.8v 149.505n 1.8v 159.495n 1.8v 159.505n 1.8v 169.495n 1.8v 169.505n 1.8v 179.495n 1.8v 179.505n 1.8v 189.495n 1.8v 189.505n 1.8v 199.495n 1.8v 199.505n 1.8v 209.495n 1.8v 209.505n 1.8v 219.495n 1.8v 219.505n 1.8v 229.495n 1.8v 229.505n 1.8v 239.495n 1.8v 239.505n 1.8v 249.495n 1.8v 249.505n 1.8v 259.495n 1.8v 259.505n 0.0v 269.495n 0.0v 269.505n 0.0v 279.495n 0.0v 279.505n 0.0v 289.495n 0.0v 289.505n 0.0v 299.495n 0.0v 299.505n 0.0v 309.495n 0.0v 309.505n 0.0v 319.495n 0.0v 319.505n 0.0v 329.495n 0.0v 329.505n 0.0v 339.495n 0.0v 339.505n 0.0v 349.495n 0.0v 349.505n 0.0v 359.495n 0.0v 359.505n 0.0v 369.495n 0.0v 369.505n 0.0v 379.495n 0.0v 379.505n 0.0v 389.495n 0.0v 389.505n 0.0v 399.495n 0.0v 399.505n 1.8v 409.495n 1.8v 409.505n 1.8v 419.495n 1.8v 419.505n 1.8v 429.495n 1.8v 429.505n 1.8v 439.495n 1.8v 439.505n 1.8v 449.495n 1.8v 449.505n 1.8v 459.495n 1.8v 459.505n 1.8v 469.495n 1.8v 469.505n 0.0v 479.495n 0.0v 479.505n 0.0v 489.495n 0.0v 489.505n 0.0v 499.495n 0.0v 499.505n 0.0v 509.495n 0.0v 509.505n 0.0v 519.495n 0.0v 519.505n 0.0v 529.495n 0.0v 529.505n 0.0v 539.495n 0.0v 539.505n 0.0v 549.495n 0.0v 549.505n 0.0v 559.495n 0.0v 559.505n 0.0v 569.495n 0.0v 569.505n 0.0v 579.495n 0.0v 579.505n 0.0v 589.495n 0.0v 589.505n 0.0v 599.495n 0.0v 599.505n 0.0v 609.495n 0.0v 609.505n 0.0v 619.495n 0.0v 619.505n 0.0v 629.495n 0.0v 629.505n 0.0v 639.495n 0.0v 639.505n 0.0v 649.495n 0.0v 649.505n 0.0v 659.495n 0.0v 659.505n 1.8v 669.495n 1.8v 669.505n 1.8v 679.495n 1.8v 679.505n 1.8v 689.495n 1.8v 689.505n 1.8v 699.495n 1.8v 699.505n 1.8v 709.495n 1.8v 709.505n 1.8v 719.495n 1.8v 719.505n 1.8v 729.495n 1.8v 729.505n 1.8v 739.495n 1.8v 739.505n 1.8v 749.495n 1.8v 749.505n 1.8v 759.495n 1.8v 759.505n 1.8v 769.495n 1.8v 769.505n 0.0v 779.495n 0.0v 779.505n 0.0v 789.495n 0.0v 789.505n 0.0v 799.495n 0.0v 799.505n 0.0v 809.495n 0.0v 809.505n 0.0v 819.495n 0.0v 819.505n 0.0v 829.495n 0.0v 829.505n 1.8v 839.495n 1.8v 839.505n 1.8v 849.495n 1.8v 849.505n 1.8v 859.495n 1.8v 859.505n 1.8v 869.495n 1.8v 869.505n 1.8v 879.495n 1.8v 879.505n 0.0v 889.495n 0.0v 889.505n 0.0v 899.495n 0.0v 899.505n 0.0v 909.495n 0.0v 909.505n 0.0v 919.495n 0.0v 919.505n 0.0v 929.495n 0.0v 929.505n 0.0v 939.495n 0.0v 939.505n 1.8v 949.495n 1.8v 949.505n 1.8v 959.495n 1.8v 959.505n 1.8v 969.495n 1.8v 969.505n 1.8v 979.495n 1.8v 979.505n 1.8v 989.495n 1.8v 989.505n 1.8v 999.495n 1.8v 999.505n 1.8v 1009.495n 1.8v 1009.505n 1.8v 1019.495n 1.8v 1019.505n 0.0v 1029.495n 0.0v 1029.505n 0.0v 1039.495n 0.0v 1039.505n 0.0v 1049.495n 0.0v 1049.505n 0.0v 1059.495n 0.0v 1059.505n 0.0v 1069.495n 0.0v 1069.505n 0.0v 1079.495n 0.0v 1079.505n 1.8v 1089.495n 1.8v 1089.505n 1.8v 1099.495n 1.8v 1099.505n 1.8v 1109.495n 1.8v 1109.505n 1.8v 1119.495n 1.8v 1119.505n 1.8v 1129.495n 1.8v 1129.505n 1.8v 1139.495n 1.8v 1139.505n 1.8v 1149.495n 1.8v 1149.505n 1.8v 1159.495n 1.8v 1159.505n 1.8v 1169.495n 1.8v 1169.505n 1.8v 1179.495n 1.8v 1179.505n 1.8v 1189.495n 1.8v 1189.505n 1.8v 1199.495n 1.8v 1199.505n 1.8v 1209.495n 1.8v 1209.505n 1.8v 1219.495n 1.8v 1219.505n 1.8v 1229.495n 1.8v 1229.505n 1.8v 1239.495n 1.8v 1239.505n 1.8v 1249.495n 1.8v 1249.505n 1.8v 1259.495n 1.8v 1259.505n 1.8v 1269.495n 1.8v 1269.505n 1.8v 1279.495n 1.8v 1279.505n 1.8v 1289.495n 1.8v 1289.505n 1.8v 1299.495n 1.8v 1299.505n 1.8v 1309.495n 1.8v 1309.505n 1.8v 1319.495n 1.8v 1319.505n 1.8v 1329.495n 1.8v 1329.505n 1.8v 1339.495n 1.8v 1339.505n 1.8v 1349.495n 1.8v 1349.505n 1.8v 1359.495n 1.8v 1359.505n 1.8v 1369.495n 1.8v 1369.505n 1.8v 1379.495n 1.8v 1379.505n 1.8v 1389.495n 1.8v 1389.505n 1.8v 1399.495n 1.8v 1399.505n 1.8v 1409.495n 1.8v 1409.505n 1.8v 1419.495n 1.8v 1419.505n 1.8v 1429.495n 1.8v 1429.505n 0.0v 1439.495n 0.0v 1439.505n 0.0v 1449.495n 0.0v 1449.505n 0.0v 1459.495n 0.0v 1459.505n 1.8v 1469.495n 1.8v 1469.505n 0.0v 1479.495n 0.0v 1479.505n 0.0v 1489.495n 0.0v 1489.505n 1.8v 1499.495n 1.8v 1499.505n 1.8v 1509.495n 1.8v 1509.505n 1.8v 1519.495n 1.8v 1519.505n 1.8v 1529.495n 1.8v 1529.505n 1.8v 1539.495n 1.8v 1539.505n 1.8v 1549.495n 1.8v 1549.505n 0.0v 1559.495n 0.0v 1559.505n 0.0v 1569.495n 0.0v 1569.505n 0.0v 1579.495n 0.0v 1579.505n 0.0v 1589.495n 0.0v 1589.505n 0.0v 1599.495n 0.0v 1599.505n 0.0v 1609.495n 0.0v 1609.505n 0.0v 1619.495n 0.0v 1619.505n 0.0v 1629.495n 0.0v 1629.505n 0.0v 1639.495n 0.0v 1639.505n 0.0v 1649.495n 0.0v 1649.505n 0.0v 1659.495n 0.0v 1659.505n 0.0v 1669.495n 0.0v 1669.505n 0.0v 1679.495n 0.0v 1679.505n 0.0v 1689.495n 0.0v 1689.505n 0.0v 1699.495n 0.0v 1699.505n 0.0v 1709.495n 0.0v 1709.505n 1.8v 1719.495n 1.8v 1719.505n 1.8v 1729.495n 1.8v 1729.505n 1.8v 1739.495n 1.8v 1739.505n 1.8v 1749.495n 1.8v 1749.505n 1.8v 1759.495n 1.8v 1759.505n 1.8v 1769.495n 1.8v 1769.505n 1.8v 1779.495n 1.8v 1779.505n 1.8v 1789.495n 1.8v 1789.505n 1.8v 1799.495n 1.8v 1799.505n 1.8v 1809.495n 1.8v 1809.505n 1.8v 1819.495n 1.8v 1819.505n 1.8v 1829.495n 1.8v 1829.505n 1.8v 1839.495n 1.8v 1839.505n 0.0v 1849.495n 0.0v 1849.505n 0.0v 1859.495n 0.0v 1859.505n 1.8v 1869.495n 1.8v 1869.505n 1.8v 1879.495n 1.8v 1879.505n 1.8v 1889.495n 1.8v 1889.505n 1.8v 1899.495n 1.8v 1899.505n 1.8v 1909.495n 1.8v 1909.505n 0.0v 1919.495n 0.0v 1919.505n 0.0v 1929.495n 0.0v 1929.505n 0.0v 1939.495n 0.0v 1939.505n 0.0v 1949.495n 0.0v 1949.505n 0.0v 1959.495n 0.0v 1959.505n 1.8v 1969.495n 1.8v 1969.505n 1.8v 1979.495n 1.8v 1979.505n 1.8v 1989.495n 1.8v 1989.505n 1.8v 1999.495n 1.8v 1999.505n 1.8v 2009.495n 1.8v 2009.505n 1.8v 2019.495n 1.8v 2019.505n 1.8v 2029.495n 1.8v 2029.505n 0.0v 2039.495n 0.0v 2039.505n 1.8v 2049.495n 1.8v 2049.505n 1.8v )
* (time, data): [(0, 0), (10, 0), (20, 0), (30, 1), (40, 1), (50, 1), (60, 1), (70, 1), (80, 0), (90, 0), (100, 0), (110, 1), (120, 1), (130, 1), (140, 1), (150, 1), (160, 1), (170, 1), (180, 1), (190, 1), (200, 1), (210, 1), (220, 1), (230, 1), (240, 1), (250, 1), (260, 1), (270, 1), (280, 1), (290, 1), (300, 1), (310, 1), (320, 1), (330, 1), (340, 1), (350, 1), (360, 1), (370, 1), (380, 1), (390, 1), (400, 1), (410, 1), (420, 1), (430, 1), (440, 1), (450, 0), (460, 0), (470, 0), (480, 0), (490, 0), (500, 0), (510, 0), (520, 0), (530, 0), (540, 0), (550, 0), (560, 0), (570, 0), (580, 0), (590, 0), (600, 0), (610, 0), (620, 0), (630, 1), (640, 1), (650, 1), (660, 0), (670, 0), (680, 0), (690, 1), (700, 0), (710, 0), (720, 0), (730, 0), (740, 0), (750, 0), (760, 0), (770, 0), (780, 1), (790, 1), (800, 1), (810, 1), (820, 1), (830, 0), (840, 0), (850, 0), (860, 0), (870, 0), (880, 0), (890, 1), (900, 0), (910, 0), (920, 0), (930, 0), (940, 0), (950, 0), (960, 0), (970, 0), (980, 0), (990, 0), (1000, 1), (1010, 1), (1020, 1), (1030, 1), (1040, 1), (1050, 1), (1060, 1), (1070, 1), (1080, 0), (1090, 0), (1100, 0), (1110, 0), (1120, 0), (1130, 0), (1140, 1), (1150, 1), (1160, 1), (1170, 1), (1180, 1), (1190, 1), (1200, 1), (1210, 1), (1220, 1), (1230, 1), (1240, 1), (1250, 1), (1260, 0), (1270, 0), (1280, 0), (1290, 0), (1300, 0), (1310, 1), (1320, 1), (1330, 1), (1340, 1), (1350, 1), (1360, 1), (1370, 1), (1380, 1), (1390, 1), (1400, 1), (1410, 1), (1420, 1), (1430, 0), (1440, 1), (1450, 1), (1460, 1), (1470, 1), (1480, 1), (1490, 0), (1500, 0), (1510, 0), (1520, 0), (1530, 0), (1540, 0), (1550, 0), (1560, 0), (1570, 0), (1580, 0), (1590, 0), (1600, 0), (1610, 0), (1620, 0), (1630, 1), (1640, 1), (1650, 1), (1660, 1), (1670, 1), (1680, 1), (1690, 1), (1700, 1), (1710, 1), (1720, 1), (1730, 1), (1740, 1), (1750, 1), (1760, 1), (1770, 1), (1780, 1), (1790, 1), (1800, 1), (1810, 1), (1820, 1), (1830, 1), (1840, 1), (1850, 1), (1860, 0), (1870, 0), (1880, 0), (1890, 0), (1900, 0), (1910, 1), (1920, 1), (1930, 1), (1940, 1), (1950, 1), (1960, 1), (1970, 1), (1980, 1), (1990, 1), (2000, 1), (2010, 1), (2020, 1), (2030, 0), (2040, 0), (2050, 0)]
Vdin0_16  din0_16  0 PWL (0n 0.0v 9.495n 0.0v 9.505n 0.0v 19.495n 0.0v 19.505n 0.0v 29.495n 0.0v 29.505n 1.8v 39.495n 1.8v 39.505n 1.8v 49.495n 1.8v 49.505n 1.8v 59.495n 1.8v 59.505n 1.8v 69.495n 1.8v 69.505n 1.8v 79.495n 1.8v 79.505n 0.0v 89.495n 0.0v 89.505n 0.0v 99.495n 0.0v 99.505n 0.0v 109.495n 0.0v 109.505n 1.8v 119.495n 1.8v 119.505n 1.8v 129.495n 1.8v 129.505n 1.8v 139.495n 1.8v 139.505n 1.8v 149.495n 1.8v 149.505n 1.8v 159.495n 1.8v 159.505n 1.8v 169.495n 1.8v 169.505n 1.8v 179.495n 1.8v 179.505n 1.8v 189.495n 1.8v 189.505n 1.8v 199.495n 1.8v 199.505n 1.8v 209.495n 1.8v 209.505n 1.8v 219.495n 1.8v 219.505n 1.8v 229.495n 1.8v 229.505n 1.8v 239.495n 1.8v 239.505n 1.8v 249.495n 1.8v 249.505n 1.8v 259.495n 1.8v 259.505n 1.8v 269.495n 1.8v 269.505n 1.8v 279.495n 1.8v 279.505n 1.8v 289.495n 1.8v 289.505n 1.8v 299.495n 1.8v 299.505n 1.8v 309.495n 1.8v 309.505n 1.8v 319.495n 1.8v 319.505n 1.8v 329.495n 1.8v 329.505n 1.8v 339.495n 1.8v 339.505n 1.8v 349.495n 1.8v 349.505n 1.8v 359.495n 1.8v 359.505n 1.8v 369.495n 1.8v 369.505n 1.8v 379.495n 1.8v 379.505n 1.8v 389.495n 1.8v 389.505n 1.8v 399.495n 1.8v 399.505n 1.8v 409.495n 1.8v 409.505n 1.8v 419.495n 1.8v 419.505n 1.8v 429.495n 1.8v 429.505n 1.8v 439.495n 1.8v 439.505n 1.8v 449.495n 1.8v 449.505n 0.0v 459.495n 0.0v 459.505n 0.0v 469.495n 0.0v 469.505n 0.0v 479.495n 0.0v 479.505n 0.0v 489.495n 0.0v 489.505n 0.0v 499.495n 0.0v 499.505n 0.0v 509.495n 0.0v 509.505n 0.0v 519.495n 0.0v 519.505n 0.0v 529.495n 0.0v 529.505n 0.0v 539.495n 0.0v 539.505n 0.0v 549.495n 0.0v 549.505n 0.0v 559.495n 0.0v 559.505n 0.0v 569.495n 0.0v 569.505n 0.0v 579.495n 0.0v 579.505n 0.0v 589.495n 0.0v 589.505n 0.0v 599.495n 0.0v 599.505n 0.0v 609.495n 0.0v 609.505n 0.0v 619.495n 0.0v 619.505n 0.0v 629.495n 0.0v 629.505n 1.8v 639.495n 1.8v 639.505n 1.8v 649.495n 1.8v 649.505n 1.8v 659.495n 1.8v 659.505n 0.0v 669.495n 0.0v 669.505n 0.0v 679.495n 0.0v 679.505n 0.0v 689.495n 0.0v 689.505n 1.8v 699.495n 1.8v 699.505n 0.0v 709.495n 0.0v 709.505n 0.0v 719.495n 0.0v 719.505n 0.0v 729.495n 0.0v 729.505n 0.0v 739.495n 0.0v 739.505n 0.0v 749.495n 0.0v 749.505n 0.0v 759.495n 0.0v 759.505n 0.0v 769.495n 0.0v 769.505n 0.0v 779.495n 0.0v 779.505n 1.8v 789.495n 1.8v 789.505n 1.8v 799.495n 1.8v 799.505n 1.8v 809.495n 1.8v 809.505n 1.8v 819.495n 1.8v 819.505n 1.8v 829.495n 1.8v 829.505n 0.0v 839.495n 0.0v 839.505n 0.0v 849.495n 0.0v 849.505n 0.0v 859.495n 0.0v 859.505n 0.0v 869.495n 0.0v 869.505n 0.0v 879.495n 0.0v 879.505n 0.0v 889.495n 0.0v 889.505n 1.8v 899.495n 1.8v 899.505n 0.0v 909.495n 0.0v 909.505n 0.0v 919.495n 0.0v 919.505n 0.0v 929.495n 0.0v 929.505n 0.0v 939.495n 0.0v 939.505n 0.0v 949.495n 0.0v 949.505n 0.0v 959.495n 0.0v 959.505n 0.0v 969.495n 0.0v 969.505n 0.0v 979.495n 0.0v 979.505n 0.0v 989.495n 0.0v 989.505n 0.0v 999.495n 0.0v 999.505n 1.8v 1009.495n 1.8v 1009.505n 1.8v 1019.495n 1.8v 1019.505n 1.8v 1029.495n 1.8v 1029.505n 1.8v 1039.495n 1.8v 1039.505n 1.8v 1049.495n 1.8v 1049.505n 1.8v 1059.495n 1.8v 1059.505n 1.8v 1069.495n 1.8v 1069.505n 1.8v 1079.495n 1.8v 1079.505n 0.0v 1089.495n 0.0v 1089.505n 0.0v 1099.495n 0.0v 1099.505n 0.0v 1109.495n 0.0v 1109.505n 0.0v 1119.495n 0.0v 1119.505n 0.0v 1129.495n 0.0v 1129.505n 0.0v 1139.495n 0.0v 1139.505n 1.8v 1149.495n 1.8v 1149.505n 1.8v 1159.495n 1.8v 1159.505n 1.8v 1169.495n 1.8v 1169.505n 1.8v 1179.495n 1.8v 1179.505n 1.8v 1189.495n 1.8v 1189.505n 1.8v 1199.495n 1.8v 1199.505n 1.8v 1209.495n 1.8v 1209.505n 1.8v 1219.495n 1.8v 1219.505n 1.8v 1229.495n 1.8v 1229.505n 1.8v 1239.495n 1.8v 1239.505n 1.8v 1249.495n 1.8v 1249.505n 1.8v 1259.495n 1.8v 1259.505n 0.0v 1269.495n 0.0v 1269.505n 0.0v 1279.495n 0.0v 1279.505n 0.0v 1289.495n 0.0v 1289.505n 0.0v 1299.495n 0.0v 1299.505n 0.0v 1309.495n 0.0v 1309.505n 1.8v 1319.495n 1.8v 1319.505n 1.8v 1329.495n 1.8v 1329.505n 1.8v 1339.495n 1.8v 1339.505n 1.8v 1349.495n 1.8v 1349.505n 1.8v 1359.495n 1.8v 1359.505n 1.8v 1369.495n 1.8v 1369.505n 1.8v 1379.495n 1.8v 1379.505n 1.8v 1389.495n 1.8v 1389.505n 1.8v 1399.495n 1.8v 1399.505n 1.8v 1409.495n 1.8v 1409.505n 1.8v 1419.495n 1.8v 1419.505n 1.8v 1429.495n 1.8v 1429.505n 0.0v 1439.495n 0.0v 1439.505n 1.8v 1449.495n 1.8v 1449.505n 1.8v 1459.495n 1.8v 1459.505n 1.8v 1469.495n 1.8v 1469.505n 1.8v 1479.495n 1.8v 1479.505n 1.8v 1489.495n 1.8v 1489.505n 0.0v 1499.495n 0.0v 1499.505n 0.0v 1509.495n 0.0v 1509.505n 0.0v 1519.495n 0.0v 1519.505n 0.0v 1529.495n 0.0v 1529.505n 0.0v 1539.495n 0.0v 1539.505n 0.0v 1549.495n 0.0v 1549.505n 0.0v 1559.495n 0.0v 1559.505n 0.0v 1569.495n 0.0v 1569.505n 0.0v 1579.495n 0.0v 1579.505n 0.0v 1589.495n 0.0v 1589.505n 0.0v 1599.495n 0.0v 1599.505n 0.0v 1609.495n 0.0v 1609.505n 0.0v 1619.495n 0.0v 1619.505n 0.0v 1629.495n 0.0v 1629.505n 1.8v 1639.495n 1.8v 1639.505n 1.8v 1649.495n 1.8v 1649.505n 1.8v 1659.495n 1.8v 1659.505n 1.8v 1669.495n 1.8v 1669.505n 1.8v 1679.495n 1.8v 1679.505n 1.8v 1689.495n 1.8v 1689.505n 1.8v 1699.495n 1.8v 1699.505n 1.8v 1709.495n 1.8v 1709.505n 1.8v 1719.495n 1.8v 1719.505n 1.8v 1729.495n 1.8v 1729.505n 1.8v 1739.495n 1.8v 1739.505n 1.8v 1749.495n 1.8v 1749.505n 1.8v 1759.495n 1.8v 1759.505n 1.8v 1769.495n 1.8v 1769.505n 1.8v 1779.495n 1.8v 1779.505n 1.8v 1789.495n 1.8v 1789.505n 1.8v 1799.495n 1.8v 1799.505n 1.8v 1809.495n 1.8v 1809.505n 1.8v 1819.495n 1.8v 1819.505n 1.8v 1829.495n 1.8v 1829.505n 1.8v 1839.495n 1.8v 1839.505n 1.8v 1849.495n 1.8v 1849.505n 1.8v 1859.495n 1.8v 1859.505n 0.0v 1869.495n 0.0v 1869.505n 0.0v 1879.495n 0.0v 1879.505n 0.0v 1889.495n 0.0v 1889.505n 0.0v 1899.495n 0.0v 1899.505n 0.0v 1909.495n 0.0v 1909.505n 1.8v 1919.495n 1.8v 1919.505n 1.8v 1929.495n 1.8v 1929.505n 1.8v 1939.495n 1.8v 1939.505n 1.8v 1949.495n 1.8v 1949.505n 1.8v 1959.495n 1.8v 1959.505n 1.8v 1969.495n 1.8v 1969.505n 1.8v 1979.495n 1.8v 1979.505n 1.8v 1989.495n 1.8v 1989.505n 1.8v 1999.495n 1.8v 1999.505n 1.8v 2009.495n 1.8v 2009.505n 1.8v 2019.495n 1.8v 2019.505n 1.8v 2029.495n 1.8v 2029.505n 0.0v 2039.495n 0.0v 2039.505n 0.0v 2049.495n 0.0v 2049.505n 0.0v )
* (time, data): [(0, 0), (10, 0), (20, 1), (30, 0), (40, 0), (50, 0), (60, 1), (70, 1), (80, 1), (90, 1), (100, 1), (110, 1), (120, 1), (130, 1), (140, 1), (150, 1), (160, 1), (170, 1), (180, 1), (190, 1), (200, 1), (210, 1), (220, 1), (230, 1), (240, 1), (250, 1), (260, 0), (270, 0), (280, 0), (290, 0), (300, 0), (310, 0), (320, 0), (330, 0), (340, 0), (350, 0), (360, 0), (370, 0), (380, 0), (390, 0), (400, 0), (410, 0), (420, 0), (430, 0), (440, 0), (450, 1), (460, 1), (470, 0), (480, 0), (490, 0), (500, 0), (510, 0), (520, 0), (530, 0), (540, 1), (550, 1), (560, 1), (570, 1), (580, 1), (590, 0), (600, 1), (610, 1), (620, 1), (630, 0), (640, 0), (650, 0), (660, 0), (670, 0), (680, 0), (690, 1), (700, 1), (710, 1), (720, 1), (730, 1), (740, 1), (750, 1), (760, 1), (770, 0), (780, 1), (790, 1), (800, 1), (810, 1), (820, 1), (830, 1), (840, 1), (850, 1), (860, 1), (870, 1), (880, 1), (890, 1), (900, 0), (910, 0), (920, 0), (930, 0), (940, 1), (950, 1), (960, 1), (970, 1), (980, 1), (990, 1), (1000, 0), (1010, 0), (1020, 0), (1030, 0), (1040, 0), (1050, 0), (1060, 0), (1070, 0), (1080, 0), (1090, 1), (1100, 1), (1110, 1), (1120, 1), (1130, 1), (1140, 0), (1150, 0), (1160, 0), (1170, 0), (1180, 0), (1190, 0), (1200, 0), (1210, 0), (1220, 0), (1230, 0), (1240, 0), (1250, 0), (1260, 1), (1270, 1), (1280, 1), (1290, 1), (1300, 0), (1310, 1), (1320, 1), (1330, 1), (1340, 1), (1350, 1), (1360, 0), (1370, 0), (1380, 0), (1390, 0), (1400, 0), (1410, 1), (1420, 1), (1430, 1), (1440, 0), (1450, 0), (1460, 1), (1470, 1), (1480, 1), (1490, 0), (1500, 0), (1510, 0), (1520, 0), (1530, 0), (1540, 0), (1550, 0), (1560, 0), (1570, 0), (1580, 1), (1590, 0), (1600, 0), (1610, 0), (1620, 0), (1630, 1), (1640, 1), (1650, 1), (1660, 1), (1670, 1), (1680, 1), (1690, 1), (1700, 0), (1710, 1), (1720, 1), (1730, 1), (1740, 1), (1750, 1), (1760, 1), (1770, 1), (1780, 1), (1790, 1), (1800, 1), (1810, 1), (1820, 1), (1830, 1), (1840, 1), (1850, 1), (1860, 0), (1870, 0), (1880, 0), (1890, 0), (1900, 0), (1910, 0), (1920, 0), (1930, 0), (1940, 0), (1950, 0), (1960, 1), (1970, 1), (1980, 1), (1990, 1), (2000, 1), (2010, 1), (2020, 1), (2030, 0), (2040, 0), (2050, 0)]
Vdin0_17  din0_17  0 PWL (0n 0.0v 9.495n 0.0v 9.505n 0.0v 19.495n 0.0v 19.505n 1.8v 29.495n 1.8v 29.505n 0.0v 39.495n 0.0v 39.505n 0.0v 49.495n 0.0v 49.505n 0.0v 59.495n 0.0v 59.505n 1.8v 69.495n 1.8v 69.505n 1.8v 79.495n 1.8v 79.505n 1.8v 89.495n 1.8v 89.505n 1.8v 99.495n 1.8v 99.505n 1.8v 109.495n 1.8v 109.505n 1.8v 119.495n 1.8v 119.505n 1.8v 129.495n 1.8v 129.505n 1.8v 139.495n 1.8v 139.505n 1.8v 149.495n 1.8v 149.505n 1.8v 159.495n 1.8v 159.505n 1.8v 169.495n 1.8v 169.505n 1.8v 179.495n 1.8v 179.505n 1.8v 189.495n 1.8v 189.505n 1.8v 199.495n 1.8v 199.505n 1.8v 209.495n 1.8v 209.505n 1.8v 219.495n 1.8v 219.505n 1.8v 229.495n 1.8v 229.505n 1.8v 239.495n 1.8v 239.505n 1.8v 249.495n 1.8v 249.505n 1.8v 259.495n 1.8v 259.505n 0.0v 269.495n 0.0v 269.505n 0.0v 279.495n 0.0v 279.505n 0.0v 289.495n 0.0v 289.505n 0.0v 299.495n 0.0v 299.505n 0.0v 309.495n 0.0v 309.505n 0.0v 319.495n 0.0v 319.505n 0.0v 329.495n 0.0v 329.505n 0.0v 339.495n 0.0v 339.505n 0.0v 349.495n 0.0v 349.505n 0.0v 359.495n 0.0v 359.505n 0.0v 369.495n 0.0v 369.505n 0.0v 379.495n 0.0v 379.505n 0.0v 389.495n 0.0v 389.505n 0.0v 399.495n 0.0v 399.505n 0.0v 409.495n 0.0v 409.505n 0.0v 419.495n 0.0v 419.505n 0.0v 429.495n 0.0v 429.505n 0.0v 439.495n 0.0v 439.505n 0.0v 449.495n 0.0v 449.505n 1.8v 459.495n 1.8v 459.505n 1.8v 469.495n 1.8v 469.505n 0.0v 479.495n 0.0v 479.505n 0.0v 489.495n 0.0v 489.505n 0.0v 499.495n 0.0v 499.505n 0.0v 509.495n 0.0v 509.505n 0.0v 519.495n 0.0v 519.505n 0.0v 529.495n 0.0v 529.505n 0.0v 539.495n 0.0v 539.505n 1.8v 549.495n 1.8v 549.505n 1.8v 559.495n 1.8v 559.505n 1.8v 569.495n 1.8v 569.505n 1.8v 579.495n 1.8v 579.505n 1.8v 589.495n 1.8v 589.505n 0.0v 599.495n 0.0v 599.505n 1.8v 609.495n 1.8v 609.505n 1.8v 619.495n 1.8v 619.505n 1.8v 629.495n 1.8v 629.505n 0.0v 639.495n 0.0v 639.505n 0.0v 649.495n 0.0v 649.505n 0.0v 659.495n 0.0v 659.505n 0.0v 669.495n 0.0v 669.505n 0.0v 679.495n 0.0v 679.505n 0.0v 689.495n 0.0v 689.505n 1.8v 699.495n 1.8v 699.505n 1.8v 709.495n 1.8v 709.505n 1.8v 719.495n 1.8v 719.505n 1.8v 729.495n 1.8v 729.505n 1.8v 739.495n 1.8v 739.505n 1.8v 749.495n 1.8v 749.505n 1.8v 759.495n 1.8v 759.505n 1.8v 769.495n 1.8v 769.505n 0.0v 779.495n 0.0v 779.505n 1.8v 789.495n 1.8v 789.505n 1.8v 799.495n 1.8v 799.505n 1.8v 809.495n 1.8v 809.505n 1.8v 819.495n 1.8v 819.505n 1.8v 829.495n 1.8v 829.505n 1.8v 839.495n 1.8v 839.505n 1.8v 849.495n 1.8v 849.505n 1.8v 859.495n 1.8v 859.505n 1.8v 869.495n 1.8v 869.505n 1.8v 879.495n 1.8v 879.505n 1.8v 889.495n 1.8v 889.505n 1.8v 899.495n 1.8v 899.505n 0.0v 909.495n 0.0v 909.505n 0.0v 919.495n 0.0v 919.505n 0.0v 929.495n 0.0v 929.505n 0.0v 939.495n 0.0v 939.505n 1.8v 949.495n 1.8v 949.505n 1.8v 959.495n 1.8v 959.505n 1.8v 969.495n 1.8v 969.505n 1.8v 979.495n 1.8v 979.505n 1.8v 989.495n 1.8v 989.505n 1.8v 999.495n 1.8v 999.505n 0.0v 1009.495n 0.0v 1009.505n 0.0v 1019.495n 0.0v 1019.505n 0.0v 1029.495n 0.0v 1029.505n 0.0v 1039.495n 0.0v 1039.505n 0.0v 1049.495n 0.0v 1049.505n 0.0v 1059.495n 0.0v 1059.505n 0.0v 1069.495n 0.0v 1069.505n 0.0v 1079.495n 0.0v 1079.505n 0.0v 1089.495n 0.0v 1089.505n 1.8v 1099.495n 1.8v 1099.505n 1.8v 1109.495n 1.8v 1109.505n 1.8v 1119.495n 1.8v 1119.505n 1.8v 1129.495n 1.8v 1129.505n 1.8v 1139.495n 1.8v 1139.505n 0.0v 1149.495n 0.0v 1149.505n 0.0v 1159.495n 0.0v 1159.505n 0.0v 1169.495n 0.0v 1169.505n 0.0v 1179.495n 0.0v 1179.505n 0.0v 1189.495n 0.0v 1189.505n 0.0v 1199.495n 0.0v 1199.505n 0.0v 1209.495n 0.0v 1209.505n 0.0v 1219.495n 0.0v 1219.505n 0.0v 1229.495n 0.0v 1229.505n 0.0v 1239.495n 0.0v 1239.505n 0.0v 1249.495n 0.0v 1249.505n 0.0v 1259.495n 0.0v 1259.505n 1.8v 1269.495n 1.8v 1269.505n 1.8v 1279.495n 1.8v 1279.505n 1.8v 1289.495n 1.8v 1289.505n 1.8v 1299.495n 1.8v 1299.505n 0.0v 1309.495n 0.0v 1309.505n 1.8v 1319.495n 1.8v 1319.505n 1.8v 1329.495n 1.8v 1329.505n 1.8v 1339.495n 1.8v 1339.505n 1.8v 1349.495n 1.8v 1349.505n 1.8v 1359.495n 1.8v 1359.505n 0.0v 1369.495n 0.0v 1369.505n 0.0v 1379.495n 0.0v 1379.505n 0.0v 1389.495n 0.0v 1389.505n 0.0v 1399.495n 0.0v 1399.505n 0.0v 1409.495n 0.0v 1409.505n 1.8v 1419.495n 1.8v 1419.505n 1.8v 1429.495n 1.8v 1429.505n 1.8v 1439.495n 1.8v 1439.505n 0.0v 1449.495n 0.0v 1449.505n 0.0v 1459.495n 0.0v 1459.505n 1.8v 1469.495n 1.8v 1469.505n 1.8v 1479.495n 1.8v 1479.505n 1.8v 1489.495n 1.8v 1489.505n 0.0v 1499.495n 0.0v 1499.505n 0.0v 1509.495n 0.0v 1509.505n 0.0v 1519.495n 0.0v 1519.505n 0.0v 1529.495n 0.0v 1529.505n 0.0v 1539.495n 0.0v 1539.505n 0.0v 1549.495n 0.0v 1549.505n 0.0v 1559.495n 0.0v 1559.505n 0.0v 1569.495n 0.0v 1569.505n 0.0v 1579.495n 0.0v 1579.505n 1.8v 1589.495n 1.8v 1589.505n 0.0v 1599.495n 0.0v 1599.505n 0.0v 1609.495n 0.0v 1609.505n 0.0v 1619.495n 0.0v 1619.505n 0.0v 1629.495n 0.0v 1629.505n 1.8v 1639.495n 1.8v 1639.505n 1.8v 1649.495n 1.8v 1649.505n 1.8v 1659.495n 1.8v 1659.505n 1.8v 1669.495n 1.8v 1669.505n 1.8v 1679.495n 1.8v 1679.505n 1.8v 1689.495n 1.8v 1689.505n 1.8v 1699.495n 1.8v 1699.505n 0.0v 1709.495n 0.0v 1709.505n 1.8v 1719.495n 1.8v 1719.505n 1.8v 1729.495n 1.8v 1729.505n 1.8v 1739.495n 1.8v 1739.505n 1.8v 1749.495n 1.8v 1749.505n 1.8v 1759.495n 1.8v 1759.505n 1.8v 1769.495n 1.8v 1769.505n 1.8v 1779.495n 1.8v 1779.505n 1.8v 1789.495n 1.8v 1789.505n 1.8v 1799.495n 1.8v 1799.505n 1.8v 1809.495n 1.8v 1809.505n 1.8v 1819.495n 1.8v 1819.505n 1.8v 1829.495n 1.8v 1829.505n 1.8v 1839.495n 1.8v 1839.505n 1.8v 1849.495n 1.8v 1849.505n 1.8v 1859.495n 1.8v 1859.505n 0.0v 1869.495n 0.0v 1869.505n 0.0v 1879.495n 0.0v 1879.505n 0.0v 1889.495n 0.0v 1889.505n 0.0v 1899.495n 0.0v 1899.505n 0.0v 1909.495n 0.0v 1909.505n 0.0v 1919.495n 0.0v 1919.505n 0.0v 1929.495n 0.0v 1929.505n 0.0v 1939.495n 0.0v 1939.505n 0.0v 1949.495n 0.0v 1949.505n 0.0v 1959.495n 0.0v 1959.505n 1.8v 1969.495n 1.8v 1969.505n 1.8v 1979.495n 1.8v 1979.505n 1.8v 1989.495n 1.8v 1989.505n 1.8v 1999.495n 1.8v 1999.505n 1.8v 2009.495n 1.8v 2009.505n 1.8v 2019.495n 1.8v 2019.505n 1.8v 2029.495n 1.8v 2029.505n 0.0v 2039.495n 0.0v 2039.505n 0.0v 2049.495n 0.0v 2049.505n 0.0v )
* (time, data): [(0, 0), (10, 0), (20, 1), (30, 1), (40, 1), (50, 1), (60, 0), (70, 0), (80, 0), (90, 0), (100, 0), (110, 1), (120, 0), (130, 0), (140, 0), (150, 0), (160, 0), (170, 0), (180, 0), (190, 0), (200, 0), (210, 0), (220, 0), (230, 0), (240, 0), (250, 0), (260, 1), (270, 1), (280, 1), (290, 1), (300, 1), (310, 1), (320, 1), (330, 1), (340, 1), (350, 1), (360, 1), (370, 1), (380, 1), (390, 1), (400, 1), (410, 1), (420, 1), (430, 1), (440, 1), (450, 1), (460, 0), (470, 0), (480, 0), (490, 0), (500, 0), (510, 0), (520, 0), (530, 0), (540, 1), (550, 1), (560, 1), (570, 1), (580, 1), (590, 0), (600, 0), (610, 0), (620, 0), (630, 1), (640, 1), (650, 1), (660, 0), (670, 0), (680, 0), (690, 0), (700, 0), (710, 0), (720, 0), (730, 0), (740, 0), (750, 0), (760, 0), (770, 1), (780, 0), (790, 0), (800, 0), (810, 0), (820, 0), (830, 1), (840, 1), (850, 1), (860, 1), (870, 1), (880, 1), (890, 1), (900, 0), (910, 0), (920, 0), (930, 0), (940, 0), (950, 0), (960, 0), (970, 0), (980, 0), (990, 0), (1000, 1), (1010, 1), (1020, 1), (1030, 1), (1040, 1), (1050, 1), (1060, 1), (1070, 1), (1080, 0), (1090, 0), (1100, 0), (1110, 0), (1120, 0), (1130, 0), (1140, 0), (1150, 0), (1160, 0), (1170, 0), (1180, 0), (1190, 0), (1200, 0), (1210, 0), (1220, 0), (1230, 0), (1240, 0), (1250, 0), (1260, 1), (1270, 1), (1280, 1), (1290, 1), (1300, 1), (1310, 0), (1320, 0), (1330, 0), (1340, 0), (1350, 0), (1360, 0), (1370, 0), (1380, 0), (1390, 0), (1400, 0), (1410, 1), (1420, 1), (1430, 0), (1440, 0), (1450, 0), (1460, 0), (1470, 0), (1480, 0), (1490, 0), (1500, 0), (1510, 0), (1520, 0), (1530, 0), (1540, 0), (1550, 0), (1560, 0), (1570, 0), (1580, 0), (1590, 0), (1600, 0), (1610, 0), (1620, 0), (1630, 1), (1640, 1), (1650, 1), (1660, 1), (1670, 1), (1680, 1), (1690, 1), (1700, 1), (1710, 1), (1720, 1), (1730, 1), (1740, 1), (1750, 1), (1760, 1), (1770, 1), (1780, 1), (1790, 1), (1800, 1), (1810, 1), (1820, 1), (1830, 1), (1840, 0), (1850, 0), (1860, 0), (1870, 0), (1880, 0), (1890, 0), (1900, 0), (1910, 0), (1920, 0), (1930, 0), (1940, 0), (1950, 0), (1960, 0), (1970, 0), (1980, 0), (1990, 0), (2000, 0), (2010, 0), (2020, 0), (2030, 0), (2040, 0), (2050, 0)]
Vdin0_18  din0_18  0 PWL (0n 0.0v 9.495n 0.0v 9.505n 0.0v 19.495n 0.0v 19.505n 1.8v 29.495n 1.8v 29.505n 1.8v 39.495n 1.8v 39.505n 1.8v 49.495n 1.8v 49.505n 1.8v 59.495n 1.8v 59.505n 0.0v 69.495n 0.0v 69.505n 0.0v 79.495n 0.0v 79.505n 0.0v 89.495n 0.0v 89.505n 0.0v 99.495n 0.0v 99.505n 0.0v 109.495n 0.0v 109.505n 1.8v 119.495n 1.8v 119.505n 0.0v 129.495n 0.0v 129.505n 0.0v 139.495n 0.0v 139.505n 0.0v 149.495n 0.0v 149.505n 0.0v 159.495n 0.0v 159.505n 0.0v 169.495n 0.0v 169.505n 0.0v 179.495n 0.0v 179.505n 0.0v 189.495n 0.0v 189.505n 0.0v 199.495n 0.0v 199.505n 0.0v 209.495n 0.0v 209.505n 0.0v 219.495n 0.0v 219.505n 0.0v 229.495n 0.0v 229.505n 0.0v 239.495n 0.0v 239.505n 0.0v 249.495n 0.0v 249.505n 0.0v 259.495n 0.0v 259.505n 1.8v 269.495n 1.8v 269.505n 1.8v 279.495n 1.8v 279.505n 1.8v 289.495n 1.8v 289.505n 1.8v 299.495n 1.8v 299.505n 1.8v 309.495n 1.8v 309.505n 1.8v 319.495n 1.8v 319.505n 1.8v 329.495n 1.8v 329.505n 1.8v 339.495n 1.8v 339.505n 1.8v 349.495n 1.8v 349.505n 1.8v 359.495n 1.8v 359.505n 1.8v 369.495n 1.8v 369.505n 1.8v 379.495n 1.8v 379.505n 1.8v 389.495n 1.8v 389.505n 1.8v 399.495n 1.8v 399.505n 1.8v 409.495n 1.8v 409.505n 1.8v 419.495n 1.8v 419.505n 1.8v 429.495n 1.8v 429.505n 1.8v 439.495n 1.8v 439.505n 1.8v 449.495n 1.8v 449.505n 1.8v 459.495n 1.8v 459.505n 0.0v 469.495n 0.0v 469.505n 0.0v 479.495n 0.0v 479.505n 0.0v 489.495n 0.0v 489.505n 0.0v 499.495n 0.0v 499.505n 0.0v 509.495n 0.0v 509.505n 0.0v 519.495n 0.0v 519.505n 0.0v 529.495n 0.0v 529.505n 0.0v 539.495n 0.0v 539.505n 1.8v 549.495n 1.8v 549.505n 1.8v 559.495n 1.8v 559.505n 1.8v 569.495n 1.8v 569.505n 1.8v 579.495n 1.8v 579.505n 1.8v 589.495n 1.8v 589.505n 0.0v 599.495n 0.0v 599.505n 0.0v 609.495n 0.0v 609.505n 0.0v 619.495n 0.0v 619.505n 0.0v 629.495n 0.0v 629.505n 1.8v 639.495n 1.8v 639.505n 1.8v 649.495n 1.8v 649.505n 1.8v 659.495n 1.8v 659.505n 0.0v 669.495n 0.0v 669.505n 0.0v 679.495n 0.0v 679.505n 0.0v 689.495n 0.0v 689.505n 0.0v 699.495n 0.0v 699.505n 0.0v 709.495n 0.0v 709.505n 0.0v 719.495n 0.0v 719.505n 0.0v 729.495n 0.0v 729.505n 0.0v 739.495n 0.0v 739.505n 0.0v 749.495n 0.0v 749.505n 0.0v 759.495n 0.0v 759.505n 0.0v 769.495n 0.0v 769.505n 1.8v 779.495n 1.8v 779.505n 0.0v 789.495n 0.0v 789.505n 0.0v 799.495n 0.0v 799.505n 0.0v 809.495n 0.0v 809.505n 0.0v 819.495n 0.0v 819.505n 0.0v 829.495n 0.0v 829.505n 1.8v 839.495n 1.8v 839.505n 1.8v 849.495n 1.8v 849.505n 1.8v 859.495n 1.8v 859.505n 1.8v 869.495n 1.8v 869.505n 1.8v 879.495n 1.8v 879.505n 1.8v 889.495n 1.8v 889.505n 1.8v 899.495n 1.8v 899.505n 0.0v 909.495n 0.0v 909.505n 0.0v 919.495n 0.0v 919.505n 0.0v 929.495n 0.0v 929.505n 0.0v 939.495n 0.0v 939.505n 0.0v 949.495n 0.0v 949.505n 0.0v 959.495n 0.0v 959.505n 0.0v 969.495n 0.0v 969.505n 0.0v 979.495n 0.0v 979.505n 0.0v 989.495n 0.0v 989.505n 0.0v 999.495n 0.0v 999.505n 1.8v 1009.495n 1.8v 1009.505n 1.8v 1019.495n 1.8v 1019.505n 1.8v 1029.495n 1.8v 1029.505n 1.8v 1039.495n 1.8v 1039.505n 1.8v 1049.495n 1.8v 1049.505n 1.8v 1059.495n 1.8v 1059.505n 1.8v 1069.495n 1.8v 1069.505n 1.8v 1079.495n 1.8v 1079.505n 0.0v 1089.495n 0.0v 1089.505n 0.0v 1099.495n 0.0v 1099.505n 0.0v 1109.495n 0.0v 1109.505n 0.0v 1119.495n 0.0v 1119.505n 0.0v 1129.495n 0.0v 1129.505n 0.0v 1139.495n 0.0v 1139.505n 0.0v 1149.495n 0.0v 1149.505n 0.0v 1159.495n 0.0v 1159.505n 0.0v 1169.495n 0.0v 1169.505n 0.0v 1179.495n 0.0v 1179.505n 0.0v 1189.495n 0.0v 1189.505n 0.0v 1199.495n 0.0v 1199.505n 0.0v 1209.495n 0.0v 1209.505n 0.0v 1219.495n 0.0v 1219.505n 0.0v 1229.495n 0.0v 1229.505n 0.0v 1239.495n 0.0v 1239.505n 0.0v 1249.495n 0.0v 1249.505n 0.0v 1259.495n 0.0v 1259.505n 1.8v 1269.495n 1.8v 1269.505n 1.8v 1279.495n 1.8v 1279.505n 1.8v 1289.495n 1.8v 1289.505n 1.8v 1299.495n 1.8v 1299.505n 1.8v 1309.495n 1.8v 1309.505n 0.0v 1319.495n 0.0v 1319.505n 0.0v 1329.495n 0.0v 1329.505n 0.0v 1339.495n 0.0v 1339.505n 0.0v 1349.495n 0.0v 1349.505n 0.0v 1359.495n 0.0v 1359.505n 0.0v 1369.495n 0.0v 1369.505n 0.0v 1379.495n 0.0v 1379.505n 0.0v 1389.495n 0.0v 1389.505n 0.0v 1399.495n 0.0v 1399.505n 0.0v 1409.495n 0.0v 1409.505n 1.8v 1419.495n 1.8v 1419.505n 1.8v 1429.495n 1.8v 1429.505n 0.0v 1439.495n 0.0v 1439.505n 0.0v 1449.495n 0.0v 1449.505n 0.0v 1459.495n 0.0v 1459.505n 0.0v 1469.495n 0.0v 1469.505n 0.0v 1479.495n 0.0v 1479.505n 0.0v 1489.495n 0.0v 1489.505n 0.0v 1499.495n 0.0v 1499.505n 0.0v 1509.495n 0.0v 1509.505n 0.0v 1519.495n 0.0v 1519.505n 0.0v 1529.495n 0.0v 1529.505n 0.0v 1539.495n 0.0v 1539.505n 0.0v 1549.495n 0.0v 1549.505n 0.0v 1559.495n 0.0v 1559.505n 0.0v 1569.495n 0.0v 1569.505n 0.0v 1579.495n 0.0v 1579.505n 0.0v 1589.495n 0.0v 1589.505n 0.0v 1599.495n 0.0v 1599.505n 0.0v 1609.495n 0.0v 1609.505n 0.0v 1619.495n 0.0v 1619.505n 0.0v 1629.495n 0.0v 1629.505n 1.8v 1639.495n 1.8v 1639.505n 1.8v 1649.495n 1.8v 1649.505n 1.8v 1659.495n 1.8v 1659.505n 1.8v 1669.495n 1.8v 1669.505n 1.8v 1679.495n 1.8v 1679.505n 1.8v 1689.495n 1.8v 1689.505n 1.8v 1699.495n 1.8v 1699.505n 1.8v 1709.495n 1.8v 1709.505n 1.8v 1719.495n 1.8v 1719.505n 1.8v 1729.495n 1.8v 1729.505n 1.8v 1739.495n 1.8v 1739.505n 1.8v 1749.495n 1.8v 1749.505n 1.8v 1759.495n 1.8v 1759.505n 1.8v 1769.495n 1.8v 1769.505n 1.8v 1779.495n 1.8v 1779.505n 1.8v 1789.495n 1.8v 1789.505n 1.8v 1799.495n 1.8v 1799.505n 1.8v 1809.495n 1.8v 1809.505n 1.8v 1819.495n 1.8v 1819.505n 1.8v 1829.495n 1.8v 1829.505n 1.8v 1839.495n 1.8v 1839.505n 0.0v 1849.495n 0.0v 1849.505n 0.0v 1859.495n 0.0v 1859.505n 0.0v 1869.495n 0.0v 1869.505n 0.0v 1879.495n 0.0v 1879.505n 0.0v 1889.495n 0.0v 1889.505n 0.0v 1899.495n 0.0v 1899.505n 0.0v 1909.495n 0.0v 1909.505n 0.0v 1919.495n 0.0v 1919.505n 0.0v 1929.495n 0.0v 1929.505n 0.0v 1939.495n 0.0v 1939.505n 0.0v 1949.495n 0.0v 1949.505n 0.0v 1959.495n 0.0v 1959.505n 0.0v 1969.495n 0.0v 1969.505n 0.0v 1979.495n 0.0v 1979.505n 0.0v 1989.495n 0.0v 1989.505n 0.0v 1999.495n 0.0v 1999.505n 0.0v 2009.495n 0.0v 2009.505n 0.0v 2019.495n 0.0v 2019.505n 0.0v 2029.495n 0.0v 2029.505n 0.0v 2039.495n 0.0v 2039.505n 0.0v 2049.495n 0.0v 2049.505n 0.0v )
* (time, data): [(0, 0), (10, 0), (20, 1), (30, 0), (40, 0), (50, 0), (60, 1), (70, 1), (80, 0), (90, 0), (100, 0), (110, 0), (120, 1), (130, 1), (140, 1), (150, 1), (160, 1), (170, 1), (180, 1), (190, 1), (200, 1), (210, 1), (220, 1), (230, 1), (240, 1), (250, 1), (260, 0), (270, 0), (280, 0), (290, 0), (300, 0), (310, 0), (320, 0), (330, 0), (340, 0), (350, 0), (360, 0), (370, 0), (380, 0), (390, 0), (400, 0), (410, 0), (420, 0), (430, 0), (440, 0), (450, 0), (460, 1), (470, 1), (480, 1), (490, 1), (500, 1), (510, 1), (520, 1), (530, 1), (540, 1), (550, 1), (560, 1), (570, 1), (580, 1), (590, 0), (600, 1), (610, 1), (620, 1), (630, 0), (640, 0), (650, 0), (660, 1), (670, 1), (680, 1), (690, 1), (700, 1), (710, 1), (720, 1), (730, 1), (740, 1), (750, 1), (760, 1), (770, 0), (780, 1), (790, 1), (800, 1), (810, 1), (820, 1), (830, 0), (840, 0), (850, 0), (860, 0), (870, 0), (880, 0), (890, 0), (900, 0), (910, 0), (920, 0), (930, 0), (940, 0), (950, 0), (960, 0), (970, 0), (980, 0), (990, 0), (1000, 1), (1010, 1), (1020, 0), (1030, 0), (1040, 0), (1050, 0), (1060, 0), (1070, 0), (1080, 0), (1090, 1), (1100, 1), (1110, 1), (1120, 1), (1130, 1), (1140, 1), (1150, 1), (1160, 1), (1170, 1), (1180, 1), (1190, 1), (1200, 1), (1210, 1), (1220, 1), (1230, 1), (1240, 1), (1250, 1), (1260, 1), (1270, 1), (1280, 1), (1290, 1), (1300, 0), (1310, 0), (1320, 0), (1330, 0), (1340, 0), (1350, 0), (1360, 1), (1370, 1), (1380, 1), (1390, 1), (1400, 1), (1410, 0), (1420, 0), (1430, 0), (1440, 1), (1450, 1), (1460, 0), (1470, 0), (1480, 0), (1490, 0), (1500, 0), (1510, 0), (1520, 0), (1530, 0), (1540, 0), (1550, 0), (1560, 0), (1570, 0), (1580, 1), (1590, 0), (1600, 0), (1610, 0), (1620, 0), (1630, 0), (1640, 0), (1650, 0), (1660, 0), (1670, 0), (1680, 0), (1690, 0), (1700, 0), (1710, 0), (1720, 0), (1730, 0), (1740, 0), (1750, 0), (1760, 0), (1770, 0), (1780, 0), (1790, 0), (1800, 1), (1810, 1), (1820, 1), (1830, 1), (1840, 1), (1850, 1), (1860, 1), (1870, 1), (1880, 1), (1890, 1), (1900, 1), (1910, 1), (1920, 1), (1930, 1), (1940, 1), (1950, 1), (1960, 0), (1970, 0), (1980, 0), (1990, 0), (2000, 0), (2010, 0), (2020, 0), (2030, 1), (2040, 0), (2050, 0)]
Vdin0_19  din0_19  0 PWL (0n 0.0v 9.495n 0.0v 9.505n 0.0v 19.495n 0.0v 19.505n 1.8v 29.495n 1.8v 29.505n 0.0v 39.495n 0.0v 39.505n 0.0v 49.495n 0.0v 49.505n 0.0v 59.495n 0.0v 59.505n 1.8v 69.495n 1.8v 69.505n 1.8v 79.495n 1.8v 79.505n 0.0v 89.495n 0.0v 89.505n 0.0v 99.495n 0.0v 99.505n 0.0v 109.495n 0.0v 109.505n 0.0v 119.495n 0.0v 119.505n 1.8v 129.495n 1.8v 129.505n 1.8v 139.495n 1.8v 139.505n 1.8v 149.495n 1.8v 149.505n 1.8v 159.495n 1.8v 159.505n 1.8v 169.495n 1.8v 169.505n 1.8v 179.495n 1.8v 179.505n 1.8v 189.495n 1.8v 189.505n 1.8v 199.495n 1.8v 199.505n 1.8v 209.495n 1.8v 209.505n 1.8v 219.495n 1.8v 219.505n 1.8v 229.495n 1.8v 229.505n 1.8v 239.495n 1.8v 239.505n 1.8v 249.495n 1.8v 249.505n 1.8v 259.495n 1.8v 259.505n 0.0v 269.495n 0.0v 269.505n 0.0v 279.495n 0.0v 279.505n 0.0v 289.495n 0.0v 289.505n 0.0v 299.495n 0.0v 299.505n 0.0v 309.495n 0.0v 309.505n 0.0v 319.495n 0.0v 319.505n 0.0v 329.495n 0.0v 329.505n 0.0v 339.495n 0.0v 339.505n 0.0v 349.495n 0.0v 349.505n 0.0v 359.495n 0.0v 359.505n 0.0v 369.495n 0.0v 369.505n 0.0v 379.495n 0.0v 379.505n 0.0v 389.495n 0.0v 389.505n 0.0v 399.495n 0.0v 399.505n 0.0v 409.495n 0.0v 409.505n 0.0v 419.495n 0.0v 419.505n 0.0v 429.495n 0.0v 429.505n 0.0v 439.495n 0.0v 439.505n 0.0v 449.495n 0.0v 449.505n 0.0v 459.495n 0.0v 459.505n 1.8v 469.495n 1.8v 469.505n 1.8v 479.495n 1.8v 479.505n 1.8v 489.495n 1.8v 489.505n 1.8v 499.495n 1.8v 499.505n 1.8v 509.495n 1.8v 509.505n 1.8v 519.495n 1.8v 519.505n 1.8v 529.495n 1.8v 529.505n 1.8v 539.495n 1.8v 539.505n 1.8v 549.495n 1.8v 549.505n 1.8v 559.495n 1.8v 559.505n 1.8v 569.495n 1.8v 569.505n 1.8v 579.495n 1.8v 579.505n 1.8v 589.495n 1.8v 589.505n 0.0v 599.495n 0.0v 599.505n 1.8v 609.495n 1.8v 609.505n 1.8v 619.495n 1.8v 619.505n 1.8v 629.495n 1.8v 629.505n 0.0v 639.495n 0.0v 639.505n 0.0v 649.495n 0.0v 649.505n 0.0v 659.495n 0.0v 659.505n 1.8v 669.495n 1.8v 669.505n 1.8v 679.495n 1.8v 679.505n 1.8v 689.495n 1.8v 689.505n 1.8v 699.495n 1.8v 699.505n 1.8v 709.495n 1.8v 709.505n 1.8v 719.495n 1.8v 719.505n 1.8v 729.495n 1.8v 729.505n 1.8v 739.495n 1.8v 739.505n 1.8v 749.495n 1.8v 749.505n 1.8v 759.495n 1.8v 759.505n 1.8v 769.495n 1.8v 769.505n 0.0v 779.495n 0.0v 779.505n 1.8v 789.495n 1.8v 789.505n 1.8v 799.495n 1.8v 799.505n 1.8v 809.495n 1.8v 809.505n 1.8v 819.495n 1.8v 819.505n 1.8v 829.495n 1.8v 829.505n 0.0v 839.495n 0.0v 839.505n 0.0v 849.495n 0.0v 849.505n 0.0v 859.495n 0.0v 859.505n 0.0v 869.495n 0.0v 869.505n 0.0v 879.495n 0.0v 879.505n 0.0v 889.495n 0.0v 889.505n 0.0v 899.495n 0.0v 899.505n 0.0v 909.495n 0.0v 909.505n 0.0v 919.495n 0.0v 919.505n 0.0v 929.495n 0.0v 929.505n 0.0v 939.495n 0.0v 939.505n 0.0v 949.495n 0.0v 949.505n 0.0v 959.495n 0.0v 959.505n 0.0v 969.495n 0.0v 969.505n 0.0v 979.495n 0.0v 979.505n 0.0v 989.495n 0.0v 989.505n 0.0v 999.495n 0.0v 999.505n 1.8v 1009.495n 1.8v 1009.505n 1.8v 1019.495n 1.8v 1019.505n 0.0v 1029.495n 0.0v 1029.505n 0.0v 1039.495n 0.0v 1039.505n 0.0v 1049.495n 0.0v 1049.505n 0.0v 1059.495n 0.0v 1059.505n 0.0v 1069.495n 0.0v 1069.505n 0.0v 1079.495n 0.0v 1079.505n 0.0v 1089.495n 0.0v 1089.505n 1.8v 1099.495n 1.8v 1099.505n 1.8v 1109.495n 1.8v 1109.505n 1.8v 1119.495n 1.8v 1119.505n 1.8v 1129.495n 1.8v 1129.505n 1.8v 1139.495n 1.8v 1139.505n 1.8v 1149.495n 1.8v 1149.505n 1.8v 1159.495n 1.8v 1159.505n 1.8v 1169.495n 1.8v 1169.505n 1.8v 1179.495n 1.8v 1179.505n 1.8v 1189.495n 1.8v 1189.505n 1.8v 1199.495n 1.8v 1199.505n 1.8v 1209.495n 1.8v 1209.505n 1.8v 1219.495n 1.8v 1219.505n 1.8v 1229.495n 1.8v 1229.505n 1.8v 1239.495n 1.8v 1239.505n 1.8v 1249.495n 1.8v 1249.505n 1.8v 1259.495n 1.8v 1259.505n 1.8v 1269.495n 1.8v 1269.505n 1.8v 1279.495n 1.8v 1279.505n 1.8v 1289.495n 1.8v 1289.505n 1.8v 1299.495n 1.8v 1299.505n 0.0v 1309.495n 0.0v 1309.505n 0.0v 1319.495n 0.0v 1319.505n 0.0v 1329.495n 0.0v 1329.505n 0.0v 1339.495n 0.0v 1339.505n 0.0v 1349.495n 0.0v 1349.505n 0.0v 1359.495n 0.0v 1359.505n 1.8v 1369.495n 1.8v 1369.505n 1.8v 1379.495n 1.8v 1379.505n 1.8v 1389.495n 1.8v 1389.505n 1.8v 1399.495n 1.8v 1399.505n 1.8v 1409.495n 1.8v 1409.505n 0.0v 1419.495n 0.0v 1419.505n 0.0v 1429.495n 0.0v 1429.505n 0.0v 1439.495n 0.0v 1439.505n 1.8v 1449.495n 1.8v 1449.505n 1.8v 1459.495n 1.8v 1459.505n 0.0v 1469.495n 0.0v 1469.505n 0.0v 1479.495n 0.0v 1479.505n 0.0v 1489.495n 0.0v 1489.505n 0.0v 1499.495n 0.0v 1499.505n 0.0v 1509.495n 0.0v 1509.505n 0.0v 1519.495n 0.0v 1519.505n 0.0v 1529.495n 0.0v 1529.505n 0.0v 1539.495n 0.0v 1539.505n 0.0v 1549.495n 0.0v 1549.505n 0.0v 1559.495n 0.0v 1559.505n 0.0v 1569.495n 0.0v 1569.505n 0.0v 1579.495n 0.0v 1579.505n 1.8v 1589.495n 1.8v 1589.505n 0.0v 1599.495n 0.0v 1599.505n 0.0v 1609.495n 0.0v 1609.505n 0.0v 1619.495n 0.0v 1619.505n 0.0v 1629.495n 0.0v 1629.505n 0.0v 1639.495n 0.0v 1639.505n 0.0v 1649.495n 0.0v 1649.505n 0.0v 1659.495n 0.0v 1659.505n 0.0v 1669.495n 0.0v 1669.505n 0.0v 1679.495n 0.0v 1679.505n 0.0v 1689.495n 0.0v 1689.505n 0.0v 1699.495n 0.0v 1699.505n 0.0v 1709.495n 0.0v 1709.505n 0.0v 1719.495n 0.0v 1719.505n 0.0v 1729.495n 0.0v 1729.505n 0.0v 1739.495n 0.0v 1739.505n 0.0v 1749.495n 0.0v 1749.505n 0.0v 1759.495n 0.0v 1759.505n 0.0v 1769.495n 0.0v 1769.505n 0.0v 1779.495n 0.0v 1779.505n 0.0v 1789.495n 0.0v 1789.505n 0.0v 1799.495n 0.0v 1799.505n 1.8v 1809.495n 1.8v 1809.505n 1.8v 1819.495n 1.8v 1819.505n 1.8v 1829.495n 1.8v 1829.505n 1.8v 1839.495n 1.8v 1839.505n 1.8v 1849.495n 1.8v 1849.505n 1.8v 1859.495n 1.8v 1859.505n 1.8v 1869.495n 1.8v 1869.505n 1.8v 1879.495n 1.8v 1879.505n 1.8v 1889.495n 1.8v 1889.505n 1.8v 1899.495n 1.8v 1899.505n 1.8v 1909.495n 1.8v 1909.505n 1.8v 1919.495n 1.8v 1919.505n 1.8v 1929.495n 1.8v 1929.505n 1.8v 1939.495n 1.8v 1939.505n 1.8v 1949.495n 1.8v 1949.505n 1.8v 1959.495n 1.8v 1959.505n 0.0v 1969.495n 0.0v 1969.505n 0.0v 1979.495n 0.0v 1979.505n 0.0v 1989.495n 0.0v 1989.505n 0.0v 1999.495n 0.0v 1999.505n 0.0v 2009.495n 0.0v 2009.505n 0.0v 2019.495n 0.0v 2019.505n 0.0v 2029.495n 0.0v 2029.505n 1.8v 2039.495n 1.8v 2039.505n 0.0v 2049.495n 0.0v 2049.505n 0.0v )
* (time, data): [(0, 0), (10, 1), (20, 1), (30, 0), (40, 0), (50, 0), (60, 1), (70, 1), (80, 1), (90, 1), (100, 1), (110, 0), (120, 0), (130, 0), (140, 0), (150, 0), (160, 0), (170, 0), (180, 0), (190, 0), (200, 0), (210, 0), (220, 0), (230, 0), (240, 0), (250, 0), (260, 0), (270, 0), (280, 1), (290, 1), (300, 1), (310, 1), (320, 1), (330, 1), (340, 1), (350, 1), (360, 1), (370, 1), (380, 1), (390, 1), (400, 0), (410, 0), (420, 0), (430, 0), (440, 0), (450, 0), (460, 0), (470, 0), (480, 0), (490, 0), (500, 0), (510, 0), (520, 0), (530, 0), (540, 1), (550, 1), (560, 1), (570, 1), (580, 1), (590, 0), (600, 1), (610, 1), (620, 1), (630, 1), (640, 1), (650, 1), (660, 0), (670, 0), (680, 0), (690, 1), (700, 1), (710, 1), (720, 1), (730, 1), (740, 1), (750, 1), (760, 1), (770, 0), (780, 0), (790, 0), (800, 0), (810, 0), (820, 0), (830, 0), (840, 0), (850, 0), (860, 0), (870, 0), (880, 0), (890, 1), (900, 0), (910, 0), (920, 0), (930, 0), (940, 1), (950, 1), (960, 1), (970, 1), (980, 1), (990, 1), (1000, 1), (1010, 1), (1020, 0), (1030, 0), (1040, 0), (1050, 0), (1060, 0), (1070, 0), (1080, 1), (1090, 1), (1100, 1), (1110, 1), (1120, 1), (1130, 1), (1140, 1), (1150, 1), (1160, 1), (1170, 1), (1180, 1), (1190, 1), (1200, 1), (1210, 1), (1220, 1), (1230, 1), (1240, 1), (1250, 1), (1260, 0), (1270, 0), (1280, 0), (1290, 0), (1300, 0), (1310, 0), (1320, 0), (1330, 0), (1340, 0), (1350, 0), (1360, 1), (1370, 1), (1380, 1), (1390, 1), (1400, 1), (1410, 0), (1420, 0), (1430, 0), (1440, 1), (1450, 1), (1460, 0), (1470, 1), (1480, 1), (1490, 0), (1500, 0), (1510, 0), (1520, 0), (1530, 0), (1540, 0), (1550, 1), (1560, 1), (1570, 1), (1580, 0), (1590, 1), (1600, 1), (1610, 1), (1620, 1), (1630, 0), (1640, 0), (1650, 0), (1660, 0), (1670, 0), (1680, 0), (1690, 0), (1700, 0), (1710, 0), (1720, 0), (1730, 1), (1740, 1), (1750, 1), (1760, 1), (1770, 1), (1780, 1), (1790, 1), (1800, 1), (1810, 1), (1820, 1), (1830, 1), (1840, 0), (1850, 0), (1860, 0), (1870, 0), (1880, 0), (1890, 0), (1900, 0), (1910, 0), (1920, 0), (1930, 0), (1940, 0), (1950, 0), (1960, 0), (1970, 0), (1980, 0), (1990, 0), (2000, 0), (2010, 0), (2020, 0), (2030, 1), (2040, 1), (2050, 1)]
Vdin0_20  din0_20  0 PWL (0n 0.0v 9.495n 0.0v 9.505n 1.8v 19.495n 1.8v 19.505n 1.8v 29.495n 1.8v 29.505n 0.0v 39.495n 0.0v 39.505n 0.0v 49.495n 0.0v 49.505n 0.0v 59.495n 0.0v 59.505n 1.8v 69.495n 1.8v 69.505n 1.8v 79.495n 1.8v 79.505n 1.8v 89.495n 1.8v 89.505n 1.8v 99.495n 1.8v 99.505n 1.8v 109.495n 1.8v 109.505n 0.0v 119.495n 0.0v 119.505n 0.0v 129.495n 0.0v 129.505n 0.0v 139.495n 0.0v 139.505n 0.0v 149.495n 0.0v 149.505n 0.0v 159.495n 0.0v 159.505n 0.0v 169.495n 0.0v 169.505n 0.0v 179.495n 0.0v 179.505n 0.0v 189.495n 0.0v 189.505n 0.0v 199.495n 0.0v 199.505n 0.0v 209.495n 0.0v 209.505n 0.0v 219.495n 0.0v 219.505n 0.0v 229.495n 0.0v 229.505n 0.0v 239.495n 0.0v 239.505n 0.0v 249.495n 0.0v 249.505n 0.0v 259.495n 0.0v 259.505n 0.0v 269.495n 0.0v 269.505n 0.0v 279.495n 0.0v 279.505n 1.8v 289.495n 1.8v 289.505n 1.8v 299.495n 1.8v 299.505n 1.8v 309.495n 1.8v 309.505n 1.8v 319.495n 1.8v 319.505n 1.8v 329.495n 1.8v 329.505n 1.8v 339.495n 1.8v 339.505n 1.8v 349.495n 1.8v 349.505n 1.8v 359.495n 1.8v 359.505n 1.8v 369.495n 1.8v 369.505n 1.8v 379.495n 1.8v 379.505n 1.8v 389.495n 1.8v 389.505n 1.8v 399.495n 1.8v 399.505n 0.0v 409.495n 0.0v 409.505n 0.0v 419.495n 0.0v 419.505n 0.0v 429.495n 0.0v 429.505n 0.0v 439.495n 0.0v 439.505n 0.0v 449.495n 0.0v 449.505n 0.0v 459.495n 0.0v 459.505n 0.0v 469.495n 0.0v 469.505n 0.0v 479.495n 0.0v 479.505n 0.0v 489.495n 0.0v 489.505n 0.0v 499.495n 0.0v 499.505n 0.0v 509.495n 0.0v 509.505n 0.0v 519.495n 0.0v 519.505n 0.0v 529.495n 0.0v 529.505n 0.0v 539.495n 0.0v 539.505n 1.8v 549.495n 1.8v 549.505n 1.8v 559.495n 1.8v 559.505n 1.8v 569.495n 1.8v 569.505n 1.8v 579.495n 1.8v 579.505n 1.8v 589.495n 1.8v 589.505n 0.0v 599.495n 0.0v 599.505n 1.8v 609.495n 1.8v 609.505n 1.8v 619.495n 1.8v 619.505n 1.8v 629.495n 1.8v 629.505n 1.8v 639.495n 1.8v 639.505n 1.8v 649.495n 1.8v 649.505n 1.8v 659.495n 1.8v 659.505n 0.0v 669.495n 0.0v 669.505n 0.0v 679.495n 0.0v 679.505n 0.0v 689.495n 0.0v 689.505n 1.8v 699.495n 1.8v 699.505n 1.8v 709.495n 1.8v 709.505n 1.8v 719.495n 1.8v 719.505n 1.8v 729.495n 1.8v 729.505n 1.8v 739.495n 1.8v 739.505n 1.8v 749.495n 1.8v 749.505n 1.8v 759.495n 1.8v 759.505n 1.8v 769.495n 1.8v 769.505n 0.0v 779.495n 0.0v 779.505n 0.0v 789.495n 0.0v 789.505n 0.0v 799.495n 0.0v 799.505n 0.0v 809.495n 0.0v 809.505n 0.0v 819.495n 0.0v 819.505n 0.0v 829.495n 0.0v 829.505n 0.0v 839.495n 0.0v 839.505n 0.0v 849.495n 0.0v 849.505n 0.0v 859.495n 0.0v 859.505n 0.0v 869.495n 0.0v 869.505n 0.0v 879.495n 0.0v 879.505n 0.0v 889.495n 0.0v 889.505n 1.8v 899.495n 1.8v 899.505n 0.0v 909.495n 0.0v 909.505n 0.0v 919.495n 0.0v 919.505n 0.0v 929.495n 0.0v 929.505n 0.0v 939.495n 0.0v 939.505n 1.8v 949.495n 1.8v 949.505n 1.8v 959.495n 1.8v 959.505n 1.8v 969.495n 1.8v 969.505n 1.8v 979.495n 1.8v 979.505n 1.8v 989.495n 1.8v 989.505n 1.8v 999.495n 1.8v 999.505n 1.8v 1009.495n 1.8v 1009.505n 1.8v 1019.495n 1.8v 1019.505n 0.0v 1029.495n 0.0v 1029.505n 0.0v 1039.495n 0.0v 1039.505n 0.0v 1049.495n 0.0v 1049.505n 0.0v 1059.495n 0.0v 1059.505n 0.0v 1069.495n 0.0v 1069.505n 0.0v 1079.495n 0.0v 1079.505n 1.8v 1089.495n 1.8v 1089.505n 1.8v 1099.495n 1.8v 1099.505n 1.8v 1109.495n 1.8v 1109.505n 1.8v 1119.495n 1.8v 1119.505n 1.8v 1129.495n 1.8v 1129.505n 1.8v 1139.495n 1.8v 1139.505n 1.8v 1149.495n 1.8v 1149.505n 1.8v 1159.495n 1.8v 1159.505n 1.8v 1169.495n 1.8v 1169.505n 1.8v 1179.495n 1.8v 1179.505n 1.8v 1189.495n 1.8v 1189.505n 1.8v 1199.495n 1.8v 1199.505n 1.8v 1209.495n 1.8v 1209.505n 1.8v 1219.495n 1.8v 1219.505n 1.8v 1229.495n 1.8v 1229.505n 1.8v 1239.495n 1.8v 1239.505n 1.8v 1249.495n 1.8v 1249.505n 1.8v 1259.495n 1.8v 1259.505n 0.0v 1269.495n 0.0v 1269.505n 0.0v 1279.495n 0.0v 1279.505n 0.0v 1289.495n 0.0v 1289.505n 0.0v 1299.495n 0.0v 1299.505n 0.0v 1309.495n 0.0v 1309.505n 0.0v 1319.495n 0.0v 1319.505n 0.0v 1329.495n 0.0v 1329.505n 0.0v 1339.495n 0.0v 1339.505n 0.0v 1349.495n 0.0v 1349.505n 0.0v 1359.495n 0.0v 1359.505n 1.8v 1369.495n 1.8v 1369.505n 1.8v 1379.495n 1.8v 1379.505n 1.8v 1389.495n 1.8v 1389.505n 1.8v 1399.495n 1.8v 1399.505n 1.8v 1409.495n 1.8v 1409.505n 0.0v 1419.495n 0.0v 1419.505n 0.0v 1429.495n 0.0v 1429.505n 0.0v 1439.495n 0.0v 1439.505n 1.8v 1449.495n 1.8v 1449.505n 1.8v 1459.495n 1.8v 1459.505n 0.0v 1469.495n 0.0v 1469.505n 1.8v 1479.495n 1.8v 1479.505n 1.8v 1489.495n 1.8v 1489.505n 0.0v 1499.495n 0.0v 1499.505n 0.0v 1509.495n 0.0v 1509.505n 0.0v 1519.495n 0.0v 1519.505n 0.0v 1529.495n 0.0v 1529.505n 0.0v 1539.495n 0.0v 1539.505n 0.0v 1549.495n 0.0v 1549.505n 1.8v 1559.495n 1.8v 1559.505n 1.8v 1569.495n 1.8v 1569.505n 1.8v 1579.495n 1.8v 1579.505n 0.0v 1589.495n 0.0v 1589.505n 1.8v 1599.495n 1.8v 1599.505n 1.8v 1609.495n 1.8v 1609.505n 1.8v 1619.495n 1.8v 1619.505n 1.8v 1629.495n 1.8v 1629.505n 0.0v 1639.495n 0.0v 1639.505n 0.0v 1649.495n 0.0v 1649.505n 0.0v 1659.495n 0.0v 1659.505n 0.0v 1669.495n 0.0v 1669.505n 0.0v 1679.495n 0.0v 1679.505n 0.0v 1689.495n 0.0v 1689.505n 0.0v 1699.495n 0.0v 1699.505n 0.0v 1709.495n 0.0v 1709.505n 0.0v 1719.495n 0.0v 1719.505n 0.0v 1729.495n 0.0v 1729.505n 1.8v 1739.495n 1.8v 1739.505n 1.8v 1749.495n 1.8v 1749.505n 1.8v 1759.495n 1.8v 1759.505n 1.8v 1769.495n 1.8v 1769.505n 1.8v 1779.495n 1.8v 1779.505n 1.8v 1789.495n 1.8v 1789.505n 1.8v 1799.495n 1.8v 1799.505n 1.8v 1809.495n 1.8v 1809.505n 1.8v 1819.495n 1.8v 1819.505n 1.8v 1829.495n 1.8v 1829.505n 1.8v 1839.495n 1.8v 1839.505n 0.0v 1849.495n 0.0v 1849.505n 0.0v 1859.495n 0.0v 1859.505n 0.0v 1869.495n 0.0v 1869.505n 0.0v 1879.495n 0.0v 1879.505n 0.0v 1889.495n 0.0v 1889.505n 0.0v 1899.495n 0.0v 1899.505n 0.0v 1909.495n 0.0v 1909.505n 0.0v 1919.495n 0.0v 1919.505n 0.0v 1929.495n 0.0v 1929.505n 0.0v 1939.495n 0.0v 1939.505n 0.0v 1949.495n 0.0v 1949.505n 0.0v 1959.495n 0.0v 1959.505n 0.0v 1969.495n 0.0v 1969.505n 0.0v 1979.495n 0.0v 1979.505n 0.0v 1989.495n 0.0v 1989.505n 0.0v 1999.495n 0.0v 1999.505n 0.0v 2009.495n 0.0v 2009.505n 0.0v 2019.495n 0.0v 2019.505n 0.0v 2029.495n 0.0v 2029.505n 1.8v 2039.495n 1.8v 2039.505n 1.8v 2049.495n 1.8v 2049.505n 1.8v )
* (time, data): [(0, 0), (10, 1), (20, 0), (30, 1), (40, 1), (50, 1), (60, 1), (70, 1), (80, 0), (90, 0), (100, 0), (110, 0), (120, 0), (130, 0), (140, 0), (150, 0), (160, 0), (170, 0), (180, 0), (190, 0), (200, 0), (210, 0), (220, 0), (230, 0), (240, 0), (250, 0), (260, 1), (270, 1), (280, 1), (290, 1), (300, 1), (310, 1), (320, 1), (330, 1), (340, 1), (350, 1), (360, 1), (370, 1), (380, 1), (390, 1), (400, 0), (410, 0), (420, 0), (430, 0), (440, 0), (450, 0), (460, 0), (470, 0), (480, 0), (490, 0), (500, 0), (510, 0), (520, 0), (530, 0), (540, 1), (550, 1), (560, 1), (570, 1), (580, 1), (590, 0), (600, 1), (610, 1), (620, 1), (630, 1), (640, 1), (650, 1), (660, 1), (670, 1), (680, 1), (690, 1), (700, 1), (710, 1), (720, 1), (730, 1), (740, 1), (750, 1), (760, 1), (770, 0), (780, 0), (790, 0), (800, 0), (810, 0), (820, 0), (830, 1), (840, 1), (850, 1), (860, 1), (870, 1), (880, 0), (890, 0), (900, 1), (910, 1), (920, 1), (930, 1), (940, 0), (950, 0), (960, 0), (970, 0), (980, 0), (990, 0), (1000, 1), (1010, 1), (1020, 0), (1030, 0), (1040, 0), (1050, 0), (1060, 0), (1070, 0), (1080, 0), (1090, 0), (1100, 0), (1110, 0), (1120, 0), (1130, 0), (1140, 1), (1150, 1), (1160, 1), (1170, 1), (1180, 1), (1190, 1), (1200, 1), (1210, 1), (1220, 1), (1230, 1), (1240, 1), (1250, 1), (1260, 0), (1270, 0), (1280, 0), (1290, 0), (1300, 1), (1310, 1), (1320, 1), (1330, 1), (1340, 1), (1350, 1), (1360, 0), (1370, 0), (1380, 0), (1390, 0), (1400, 0), (1410, 1), (1420, 1), (1430, 1), (1440, 1), (1450, 1), (1460, 0), (1470, 1), (1480, 1), (1490, 0), (1500, 0), (1510, 0), (1520, 0), (1530, 0), (1540, 0), (1550, 0), (1560, 0), (1570, 0), (1580, 1), (1590, 0), (1600, 0), (1610, 0), (1620, 0), (1630, 1), (1640, 1), (1650, 1), (1660, 1), (1670, 1), (1680, 1), (1690, 1), (1700, 1), (1710, 0), (1720, 0), (1730, 0), (1740, 0), (1750, 0), (1760, 0), (1770, 0), (1780, 0), (1790, 0), (1800, 1), (1810, 1), (1820, 1), (1830, 1), (1840, 1), (1850, 1), (1860, 1), (1870, 1), (1880, 1), (1890, 1), (1900, 1), (1910, 0), (1920, 0), (1930, 0), (1940, 0), (1950, 0), (1960, 0), (1970, 0), (1980, 0), (1990, 0), (2000, 0), (2010, 0), (2020, 0), (2030, 0), (2040, 1), (2050, 1)]
Vdin0_21  din0_21  0 PWL (0n 0.0v 9.495n 0.0v 9.505n 1.8v 19.495n 1.8v 19.505n 0.0v 29.495n 0.0v 29.505n 1.8v 39.495n 1.8v 39.505n 1.8v 49.495n 1.8v 49.505n 1.8v 59.495n 1.8v 59.505n 1.8v 69.495n 1.8v 69.505n 1.8v 79.495n 1.8v 79.505n 0.0v 89.495n 0.0v 89.505n 0.0v 99.495n 0.0v 99.505n 0.0v 109.495n 0.0v 109.505n 0.0v 119.495n 0.0v 119.505n 0.0v 129.495n 0.0v 129.505n 0.0v 139.495n 0.0v 139.505n 0.0v 149.495n 0.0v 149.505n 0.0v 159.495n 0.0v 159.505n 0.0v 169.495n 0.0v 169.505n 0.0v 179.495n 0.0v 179.505n 0.0v 189.495n 0.0v 189.505n 0.0v 199.495n 0.0v 199.505n 0.0v 209.495n 0.0v 209.505n 0.0v 219.495n 0.0v 219.505n 0.0v 229.495n 0.0v 229.505n 0.0v 239.495n 0.0v 239.505n 0.0v 249.495n 0.0v 249.505n 0.0v 259.495n 0.0v 259.505n 1.8v 269.495n 1.8v 269.505n 1.8v 279.495n 1.8v 279.505n 1.8v 289.495n 1.8v 289.505n 1.8v 299.495n 1.8v 299.505n 1.8v 309.495n 1.8v 309.505n 1.8v 319.495n 1.8v 319.505n 1.8v 329.495n 1.8v 329.505n 1.8v 339.495n 1.8v 339.505n 1.8v 349.495n 1.8v 349.505n 1.8v 359.495n 1.8v 359.505n 1.8v 369.495n 1.8v 369.505n 1.8v 379.495n 1.8v 379.505n 1.8v 389.495n 1.8v 389.505n 1.8v 399.495n 1.8v 399.505n 0.0v 409.495n 0.0v 409.505n 0.0v 419.495n 0.0v 419.505n 0.0v 429.495n 0.0v 429.505n 0.0v 439.495n 0.0v 439.505n 0.0v 449.495n 0.0v 449.505n 0.0v 459.495n 0.0v 459.505n 0.0v 469.495n 0.0v 469.505n 0.0v 479.495n 0.0v 479.505n 0.0v 489.495n 0.0v 489.505n 0.0v 499.495n 0.0v 499.505n 0.0v 509.495n 0.0v 509.505n 0.0v 519.495n 0.0v 519.505n 0.0v 529.495n 0.0v 529.505n 0.0v 539.495n 0.0v 539.505n 1.8v 549.495n 1.8v 549.505n 1.8v 559.495n 1.8v 559.505n 1.8v 569.495n 1.8v 569.505n 1.8v 579.495n 1.8v 579.505n 1.8v 589.495n 1.8v 589.505n 0.0v 599.495n 0.0v 599.505n 1.8v 609.495n 1.8v 609.505n 1.8v 619.495n 1.8v 619.505n 1.8v 629.495n 1.8v 629.505n 1.8v 639.495n 1.8v 639.505n 1.8v 649.495n 1.8v 649.505n 1.8v 659.495n 1.8v 659.505n 1.8v 669.495n 1.8v 669.505n 1.8v 679.495n 1.8v 679.505n 1.8v 689.495n 1.8v 689.505n 1.8v 699.495n 1.8v 699.505n 1.8v 709.495n 1.8v 709.505n 1.8v 719.495n 1.8v 719.505n 1.8v 729.495n 1.8v 729.505n 1.8v 739.495n 1.8v 739.505n 1.8v 749.495n 1.8v 749.505n 1.8v 759.495n 1.8v 759.505n 1.8v 769.495n 1.8v 769.505n 0.0v 779.495n 0.0v 779.505n 0.0v 789.495n 0.0v 789.505n 0.0v 799.495n 0.0v 799.505n 0.0v 809.495n 0.0v 809.505n 0.0v 819.495n 0.0v 819.505n 0.0v 829.495n 0.0v 829.505n 1.8v 839.495n 1.8v 839.505n 1.8v 849.495n 1.8v 849.505n 1.8v 859.495n 1.8v 859.505n 1.8v 869.495n 1.8v 869.505n 1.8v 879.495n 1.8v 879.505n 0.0v 889.495n 0.0v 889.505n 0.0v 899.495n 0.0v 899.505n 1.8v 909.495n 1.8v 909.505n 1.8v 919.495n 1.8v 919.505n 1.8v 929.495n 1.8v 929.505n 1.8v 939.495n 1.8v 939.505n 0.0v 949.495n 0.0v 949.505n 0.0v 959.495n 0.0v 959.505n 0.0v 969.495n 0.0v 969.505n 0.0v 979.495n 0.0v 979.505n 0.0v 989.495n 0.0v 989.505n 0.0v 999.495n 0.0v 999.505n 1.8v 1009.495n 1.8v 1009.505n 1.8v 1019.495n 1.8v 1019.505n 0.0v 1029.495n 0.0v 1029.505n 0.0v 1039.495n 0.0v 1039.505n 0.0v 1049.495n 0.0v 1049.505n 0.0v 1059.495n 0.0v 1059.505n 0.0v 1069.495n 0.0v 1069.505n 0.0v 1079.495n 0.0v 1079.505n 0.0v 1089.495n 0.0v 1089.505n 0.0v 1099.495n 0.0v 1099.505n 0.0v 1109.495n 0.0v 1109.505n 0.0v 1119.495n 0.0v 1119.505n 0.0v 1129.495n 0.0v 1129.505n 0.0v 1139.495n 0.0v 1139.505n 1.8v 1149.495n 1.8v 1149.505n 1.8v 1159.495n 1.8v 1159.505n 1.8v 1169.495n 1.8v 1169.505n 1.8v 1179.495n 1.8v 1179.505n 1.8v 1189.495n 1.8v 1189.505n 1.8v 1199.495n 1.8v 1199.505n 1.8v 1209.495n 1.8v 1209.505n 1.8v 1219.495n 1.8v 1219.505n 1.8v 1229.495n 1.8v 1229.505n 1.8v 1239.495n 1.8v 1239.505n 1.8v 1249.495n 1.8v 1249.505n 1.8v 1259.495n 1.8v 1259.505n 0.0v 1269.495n 0.0v 1269.505n 0.0v 1279.495n 0.0v 1279.505n 0.0v 1289.495n 0.0v 1289.505n 0.0v 1299.495n 0.0v 1299.505n 1.8v 1309.495n 1.8v 1309.505n 1.8v 1319.495n 1.8v 1319.505n 1.8v 1329.495n 1.8v 1329.505n 1.8v 1339.495n 1.8v 1339.505n 1.8v 1349.495n 1.8v 1349.505n 1.8v 1359.495n 1.8v 1359.505n 0.0v 1369.495n 0.0v 1369.505n 0.0v 1379.495n 0.0v 1379.505n 0.0v 1389.495n 0.0v 1389.505n 0.0v 1399.495n 0.0v 1399.505n 0.0v 1409.495n 0.0v 1409.505n 1.8v 1419.495n 1.8v 1419.505n 1.8v 1429.495n 1.8v 1429.505n 1.8v 1439.495n 1.8v 1439.505n 1.8v 1449.495n 1.8v 1449.505n 1.8v 1459.495n 1.8v 1459.505n 0.0v 1469.495n 0.0v 1469.505n 1.8v 1479.495n 1.8v 1479.505n 1.8v 1489.495n 1.8v 1489.505n 0.0v 1499.495n 0.0v 1499.505n 0.0v 1509.495n 0.0v 1509.505n 0.0v 1519.495n 0.0v 1519.505n 0.0v 1529.495n 0.0v 1529.505n 0.0v 1539.495n 0.0v 1539.505n 0.0v 1549.495n 0.0v 1549.505n 0.0v 1559.495n 0.0v 1559.505n 0.0v 1569.495n 0.0v 1569.505n 0.0v 1579.495n 0.0v 1579.505n 1.8v 1589.495n 1.8v 1589.505n 0.0v 1599.495n 0.0v 1599.505n 0.0v 1609.495n 0.0v 1609.505n 0.0v 1619.495n 0.0v 1619.505n 0.0v 1629.495n 0.0v 1629.505n 1.8v 1639.495n 1.8v 1639.505n 1.8v 1649.495n 1.8v 1649.505n 1.8v 1659.495n 1.8v 1659.505n 1.8v 1669.495n 1.8v 1669.505n 1.8v 1679.495n 1.8v 1679.505n 1.8v 1689.495n 1.8v 1689.505n 1.8v 1699.495n 1.8v 1699.505n 1.8v 1709.495n 1.8v 1709.505n 0.0v 1719.495n 0.0v 1719.505n 0.0v 1729.495n 0.0v 1729.505n 0.0v 1739.495n 0.0v 1739.505n 0.0v 1749.495n 0.0v 1749.505n 0.0v 1759.495n 0.0v 1759.505n 0.0v 1769.495n 0.0v 1769.505n 0.0v 1779.495n 0.0v 1779.505n 0.0v 1789.495n 0.0v 1789.505n 0.0v 1799.495n 0.0v 1799.505n 1.8v 1809.495n 1.8v 1809.505n 1.8v 1819.495n 1.8v 1819.505n 1.8v 1829.495n 1.8v 1829.505n 1.8v 1839.495n 1.8v 1839.505n 1.8v 1849.495n 1.8v 1849.505n 1.8v 1859.495n 1.8v 1859.505n 1.8v 1869.495n 1.8v 1869.505n 1.8v 1879.495n 1.8v 1879.505n 1.8v 1889.495n 1.8v 1889.505n 1.8v 1899.495n 1.8v 1899.505n 1.8v 1909.495n 1.8v 1909.505n 0.0v 1919.495n 0.0v 1919.505n 0.0v 1929.495n 0.0v 1929.505n 0.0v 1939.495n 0.0v 1939.505n 0.0v 1949.495n 0.0v 1949.505n 0.0v 1959.495n 0.0v 1959.505n 0.0v 1969.495n 0.0v 1969.505n 0.0v 1979.495n 0.0v 1979.505n 0.0v 1989.495n 0.0v 1989.505n 0.0v 1999.495n 0.0v 1999.505n 0.0v 2009.495n 0.0v 2009.505n 0.0v 2019.495n 0.0v 2019.505n 0.0v 2029.495n 0.0v 2029.505n 0.0v 2039.495n 0.0v 2039.505n 1.8v 2049.495n 1.8v 2049.505n 1.8v )
* (time, data): [(0, 0), (10, 0), (20, 0), (30, 1), (40, 1), (50, 1), (60, 0), (70, 0), (80, 1), (90, 1), (100, 1), (110, 0), (120, 0), (130, 0), (140, 0), (150, 0), (160, 0), (170, 0), (180, 0), (190, 0), (200, 0), (210, 0), (220, 0), (230, 0), (240, 0), (250, 0), (260, 1), (270, 1), (280, 1), (290, 1), (300, 1), (310, 1), (320, 1), (330, 1), (340, 1), (350, 1), (360, 1), (370, 1), (380, 1), (390, 1), (400, 0), (410, 0), (420, 0), (430, 0), (440, 0), (450, 1), (460, 0), (470, 0), (480, 0), (490, 0), (500, 0), (510, 0), (520, 0), (530, 0), (540, 1), (550, 1), (560, 1), (570, 1), (580, 1), (590, 0), (600, 1), (610, 1), (620, 1), (630, 0), (640, 0), (650, 0), (660, 1), (670, 1), (680, 1), (690, 0), (700, 0), (710, 0), (720, 0), (730, 0), (740, 0), (750, 0), (760, 0), (770, 1), (780, 0), (790, 0), (800, 0), (810, 0), (820, 0), (830, 0), (840, 0), (850, 0), (860, 0), (870, 0), (880, 1), (890, 0), (900, 0), (910, 0), (920, 0), (930, 0), (940, 1), (950, 1), (960, 1), (970, 1), (980, 1), (990, 1), (1000, 1), (1010, 1), (1020, 1), (1030, 1), (1040, 1), (1050, 1), (1060, 1), (1070, 1), (1080, 1), (1090, 0), (1100, 0), (1110, 0), (1120, 0), (1130, 0), (1140, 0), (1150, 0), (1160, 0), (1170, 0), (1180, 0), (1190, 0), (1200, 0), (1210, 0), (1220, 0), (1230, 0), (1240, 0), (1250, 0), (1260, 0), (1270, 0), (1280, 0), (1290, 0), (1300, 0), (1310, 0), (1320, 0), (1330, 0), (1340, 0), (1350, 0), (1360, 1), (1370, 1), (1380, 1), (1390, 1), (1400, 1), (1410, 0), (1420, 0), (1430, 0), (1440, 1), (1450, 1), (1460, 1), (1470, 0), (1480, 0), (1490, 0), (1500, 0), (1510, 0), (1520, 0), (1530, 0), (1540, 0), (1550, 1), (1560, 1), (1570, 1), (1580, 1), (1590, 1), (1600, 1), (1610, 1), (1620, 1), (1630, 0), (1640, 0), (1650, 0), (1660, 0), (1670, 0), (1680, 0), (1690, 0), (1700, 1), (1710, 1), (1720, 1), (1730, 0), (1740, 0), (1750, 0), (1760, 0), (1770, 0), (1780, 0), (1790, 0), (1800, 0), (1810, 0), (1820, 0), (1830, 0), (1840, 1), (1850, 1), (1860, 0), (1870, 0), (1880, 0), (1890, 0), (1900, 0), (1910, 1), (1920, 1), (1930, 1), (1940, 1), (1950, 1), (1960, 1), (1970, 1), (1980, 1), (1990, 1), (2000, 1), (2010, 1), (2020, 1), (2030, 1), (2040, 1), (2050, 1)]
Vdin0_22  din0_22  0 PWL (0n 0.0v 9.495n 0.0v 9.505n 0.0v 19.495n 0.0v 19.505n 0.0v 29.495n 0.0v 29.505n 1.8v 39.495n 1.8v 39.505n 1.8v 49.495n 1.8v 49.505n 1.8v 59.495n 1.8v 59.505n 0.0v 69.495n 0.0v 69.505n 0.0v 79.495n 0.0v 79.505n 1.8v 89.495n 1.8v 89.505n 1.8v 99.495n 1.8v 99.505n 1.8v 109.495n 1.8v 109.505n 0.0v 119.495n 0.0v 119.505n 0.0v 129.495n 0.0v 129.505n 0.0v 139.495n 0.0v 139.505n 0.0v 149.495n 0.0v 149.505n 0.0v 159.495n 0.0v 159.505n 0.0v 169.495n 0.0v 169.505n 0.0v 179.495n 0.0v 179.505n 0.0v 189.495n 0.0v 189.505n 0.0v 199.495n 0.0v 199.505n 0.0v 209.495n 0.0v 209.505n 0.0v 219.495n 0.0v 219.505n 0.0v 229.495n 0.0v 229.505n 0.0v 239.495n 0.0v 239.505n 0.0v 249.495n 0.0v 249.505n 0.0v 259.495n 0.0v 259.505n 1.8v 269.495n 1.8v 269.505n 1.8v 279.495n 1.8v 279.505n 1.8v 289.495n 1.8v 289.505n 1.8v 299.495n 1.8v 299.505n 1.8v 309.495n 1.8v 309.505n 1.8v 319.495n 1.8v 319.505n 1.8v 329.495n 1.8v 329.505n 1.8v 339.495n 1.8v 339.505n 1.8v 349.495n 1.8v 349.505n 1.8v 359.495n 1.8v 359.505n 1.8v 369.495n 1.8v 369.505n 1.8v 379.495n 1.8v 379.505n 1.8v 389.495n 1.8v 389.505n 1.8v 399.495n 1.8v 399.505n 0.0v 409.495n 0.0v 409.505n 0.0v 419.495n 0.0v 419.505n 0.0v 429.495n 0.0v 429.505n 0.0v 439.495n 0.0v 439.505n 0.0v 449.495n 0.0v 449.505n 1.8v 459.495n 1.8v 459.505n 0.0v 469.495n 0.0v 469.505n 0.0v 479.495n 0.0v 479.505n 0.0v 489.495n 0.0v 489.505n 0.0v 499.495n 0.0v 499.505n 0.0v 509.495n 0.0v 509.505n 0.0v 519.495n 0.0v 519.505n 0.0v 529.495n 0.0v 529.505n 0.0v 539.495n 0.0v 539.505n 1.8v 549.495n 1.8v 549.505n 1.8v 559.495n 1.8v 559.505n 1.8v 569.495n 1.8v 569.505n 1.8v 579.495n 1.8v 579.505n 1.8v 589.495n 1.8v 589.505n 0.0v 599.495n 0.0v 599.505n 1.8v 609.495n 1.8v 609.505n 1.8v 619.495n 1.8v 619.505n 1.8v 629.495n 1.8v 629.505n 0.0v 639.495n 0.0v 639.505n 0.0v 649.495n 0.0v 649.505n 0.0v 659.495n 0.0v 659.505n 1.8v 669.495n 1.8v 669.505n 1.8v 679.495n 1.8v 679.505n 1.8v 689.495n 1.8v 689.505n 0.0v 699.495n 0.0v 699.505n 0.0v 709.495n 0.0v 709.505n 0.0v 719.495n 0.0v 719.505n 0.0v 729.495n 0.0v 729.505n 0.0v 739.495n 0.0v 739.505n 0.0v 749.495n 0.0v 749.505n 0.0v 759.495n 0.0v 759.505n 0.0v 769.495n 0.0v 769.505n 1.8v 779.495n 1.8v 779.505n 0.0v 789.495n 0.0v 789.505n 0.0v 799.495n 0.0v 799.505n 0.0v 809.495n 0.0v 809.505n 0.0v 819.495n 0.0v 819.505n 0.0v 829.495n 0.0v 829.505n 0.0v 839.495n 0.0v 839.505n 0.0v 849.495n 0.0v 849.505n 0.0v 859.495n 0.0v 859.505n 0.0v 869.495n 0.0v 869.505n 0.0v 879.495n 0.0v 879.505n 1.8v 889.495n 1.8v 889.505n 0.0v 899.495n 0.0v 899.505n 0.0v 909.495n 0.0v 909.505n 0.0v 919.495n 0.0v 919.505n 0.0v 929.495n 0.0v 929.505n 0.0v 939.495n 0.0v 939.505n 1.8v 949.495n 1.8v 949.505n 1.8v 959.495n 1.8v 959.505n 1.8v 969.495n 1.8v 969.505n 1.8v 979.495n 1.8v 979.505n 1.8v 989.495n 1.8v 989.505n 1.8v 999.495n 1.8v 999.505n 1.8v 1009.495n 1.8v 1009.505n 1.8v 1019.495n 1.8v 1019.505n 1.8v 1029.495n 1.8v 1029.505n 1.8v 1039.495n 1.8v 1039.505n 1.8v 1049.495n 1.8v 1049.505n 1.8v 1059.495n 1.8v 1059.505n 1.8v 1069.495n 1.8v 1069.505n 1.8v 1079.495n 1.8v 1079.505n 1.8v 1089.495n 1.8v 1089.505n 0.0v 1099.495n 0.0v 1099.505n 0.0v 1109.495n 0.0v 1109.505n 0.0v 1119.495n 0.0v 1119.505n 0.0v 1129.495n 0.0v 1129.505n 0.0v 1139.495n 0.0v 1139.505n 0.0v 1149.495n 0.0v 1149.505n 0.0v 1159.495n 0.0v 1159.505n 0.0v 1169.495n 0.0v 1169.505n 0.0v 1179.495n 0.0v 1179.505n 0.0v 1189.495n 0.0v 1189.505n 0.0v 1199.495n 0.0v 1199.505n 0.0v 1209.495n 0.0v 1209.505n 0.0v 1219.495n 0.0v 1219.505n 0.0v 1229.495n 0.0v 1229.505n 0.0v 1239.495n 0.0v 1239.505n 0.0v 1249.495n 0.0v 1249.505n 0.0v 1259.495n 0.0v 1259.505n 0.0v 1269.495n 0.0v 1269.505n 0.0v 1279.495n 0.0v 1279.505n 0.0v 1289.495n 0.0v 1289.505n 0.0v 1299.495n 0.0v 1299.505n 0.0v 1309.495n 0.0v 1309.505n 0.0v 1319.495n 0.0v 1319.505n 0.0v 1329.495n 0.0v 1329.505n 0.0v 1339.495n 0.0v 1339.505n 0.0v 1349.495n 0.0v 1349.505n 0.0v 1359.495n 0.0v 1359.505n 1.8v 1369.495n 1.8v 1369.505n 1.8v 1379.495n 1.8v 1379.505n 1.8v 1389.495n 1.8v 1389.505n 1.8v 1399.495n 1.8v 1399.505n 1.8v 1409.495n 1.8v 1409.505n 0.0v 1419.495n 0.0v 1419.505n 0.0v 1429.495n 0.0v 1429.505n 0.0v 1439.495n 0.0v 1439.505n 1.8v 1449.495n 1.8v 1449.505n 1.8v 1459.495n 1.8v 1459.505n 1.8v 1469.495n 1.8v 1469.505n 0.0v 1479.495n 0.0v 1479.505n 0.0v 1489.495n 0.0v 1489.505n 0.0v 1499.495n 0.0v 1499.505n 0.0v 1509.495n 0.0v 1509.505n 0.0v 1519.495n 0.0v 1519.505n 0.0v 1529.495n 0.0v 1529.505n 0.0v 1539.495n 0.0v 1539.505n 0.0v 1549.495n 0.0v 1549.505n 1.8v 1559.495n 1.8v 1559.505n 1.8v 1569.495n 1.8v 1569.505n 1.8v 1579.495n 1.8v 1579.505n 1.8v 1589.495n 1.8v 1589.505n 1.8v 1599.495n 1.8v 1599.505n 1.8v 1609.495n 1.8v 1609.505n 1.8v 1619.495n 1.8v 1619.505n 1.8v 1629.495n 1.8v 1629.505n 0.0v 1639.495n 0.0v 1639.505n 0.0v 1649.495n 0.0v 1649.505n 0.0v 1659.495n 0.0v 1659.505n 0.0v 1669.495n 0.0v 1669.505n 0.0v 1679.495n 0.0v 1679.505n 0.0v 1689.495n 0.0v 1689.505n 0.0v 1699.495n 0.0v 1699.505n 1.8v 1709.495n 1.8v 1709.505n 1.8v 1719.495n 1.8v 1719.505n 1.8v 1729.495n 1.8v 1729.505n 0.0v 1739.495n 0.0v 1739.505n 0.0v 1749.495n 0.0v 1749.505n 0.0v 1759.495n 0.0v 1759.505n 0.0v 1769.495n 0.0v 1769.505n 0.0v 1779.495n 0.0v 1779.505n 0.0v 1789.495n 0.0v 1789.505n 0.0v 1799.495n 0.0v 1799.505n 0.0v 1809.495n 0.0v 1809.505n 0.0v 1819.495n 0.0v 1819.505n 0.0v 1829.495n 0.0v 1829.505n 0.0v 1839.495n 0.0v 1839.505n 1.8v 1849.495n 1.8v 1849.505n 1.8v 1859.495n 1.8v 1859.505n 0.0v 1869.495n 0.0v 1869.505n 0.0v 1879.495n 0.0v 1879.505n 0.0v 1889.495n 0.0v 1889.505n 0.0v 1899.495n 0.0v 1899.505n 0.0v 1909.495n 0.0v 1909.505n 1.8v 1919.495n 1.8v 1919.505n 1.8v 1929.495n 1.8v 1929.505n 1.8v 1939.495n 1.8v 1939.505n 1.8v 1949.495n 1.8v 1949.505n 1.8v 1959.495n 1.8v 1959.505n 1.8v 1969.495n 1.8v 1969.505n 1.8v 1979.495n 1.8v 1979.505n 1.8v 1989.495n 1.8v 1989.505n 1.8v 1999.495n 1.8v 1999.505n 1.8v 2009.495n 1.8v 2009.505n 1.8v 2019.495n 1.8v 2019.505n 1.8v 2029.495n 1.8v 2029.505n 1.8v 2039.495n 1.8v 2039.505n 1.8v 2049.495n 1.8v 2049.505n 1.8v )
* (time, data): [(0, 0), (10, 1), (20, 0), (30, 0), (40, 0), (50, 0), (60, 1), (70, 1), (80, 0), (90, 0), (100, 0), (110, 1), (120, 1), (130, 1), (140, 1), (150, 1), (160, 1), (170, 1), (180, 1), (190, 1), (200, 1), (210, 1), (220, 1), (230, 1), (240, 1), (250, 1), (260, 0), (270, 0), (280, 1), (290, 1), (300, 1), (310, 1), (320, 1), (330, 1), (340, 1), (350, 1), (360, 1), (370, 1), (380, 1), (390, 1), (400, 1), (410, 1), (420, 1), (430, 1), (440, 1), (450, 1), (460, 1), (470, 1), (480, 1), (490, 1), (500, 1), (510, 1), (520, 1), (530, 1), (540, 0), (550, 0), (560, 0), (570, 0), (580, 0), (590, 0), (600, 1), (610, 1), (620, 1), (630, 0), (640, 0), (650, 0), (660, 1), (670, 1), (680, 1), (690, 1), (700, 0), (710, 0), (720, 0), (730, 0), (740, 0), (750, 0), (760, 0), (770, 0), (780, 1), (790, 1), (800, 1), (810, 1), (820, 1), (830, 0), (840, 0), (850, 0), (860, 0), (870, 0), (880, 1), (890, 0), (900, 0), (910, 0), (920, 0), (930, 0), (940, 0), (950, 0), (960, 0), (970, 0), (980, 0), (990, 0), (1000, 0), (1010, 0), (1020, 1), (1030, 1), (1040, 1), (1050, 1), (1060, 1), (1070, 1), (1080, 0), (1090, 1), (1100, 1), (1110, 1), (1120, 1), (1130, 1), (1140, 0), (1150, 0), (1160, 0), (1170, 0), (1180, 0), (1190, 0), (1200, 0), (1210, 0), (1220, 0), (1230, 0), (1240, 0), (1250, 0), (1260, 1), (1270, 1), (1280, 1), (1290, 1), (1300, 1), (1310, 0), (1320, 0), (1330, 0), (1340, 0), (1350, 0), (1360, 0), (1370, 0), (1380, 0), (1390, 0), (1400, 0), (1410, 1), (1420, 1), (1430, 0), (1440, 1), (1450, 1), (1460, 0), (1470, 1), (1480, 1), (1490, 0), (1500, 0), (1510, 0), (1520, 0), (1530, 0), (1540, 0), (1550, 0), (1560, 0), (1570, 0), (1580, 1), (1590, 1), (1600, 1), (1610, 1), (1620, 1), (1630, 1), (1640, 1), (1650, 1), (1660, 1), (1670, 1), (1680, 1), (1690, 1), (1700, 0), (1710, 0), (1720, 0), (1730, 0), (1740, 0), (1750, 0), (1760, 0), (1770, 0), (1780, 0), (1790, 0), (1800, 1), (1810, 1), (1820, 1), (1830, 1), (1840, 0), (1850, 0), (1860, 1), (1870, 1), (1880, 1), (1890, 1), (1900, 1), (1910, 0), (1920, 0), (1930, 0), (1940, 0), (1950, 0), (1960, 1), (1970, 1), (1980, 1), (1990, 1), (2000, 1), (2010, 1), (2020, 1), (2030, 0), (2040, 1), (2050, 1)]
Vdin0_23  din0_23  0 PWL (0n 0.0v 9.495n 0.0v 9.505n 1.8v 19.495n 1.8v 19.505n 0.0v 29.495n 0.0v 29.505n 0.0v 39.495n 0.0v 39.505n 0.0v 49.495n 0.0v 49.505n 0.0v 59.495n 0.0v 59.505n 1.8v 69.495n 1.8v 69.505n 1.8v 79.495n 1.8v 79.505n 0.0v 89.495n 0.0v 89.505n 0.0v 99.495n 0.0v 99.505n 0.0v 109.495n 0.0v 109.505n 1.8v 119.495n 1.8v 119.505n 1.8v 129.495n 1.8v 129.505n 1.8v 139.495n 1.8v 139.505n 1.8v 149.495n 1.8v 149.505n 1.8v 159.495n 1.8v 159.505n 1.8v 169.495n 1.8v 169.505n 1.8v 179.495n 1.8v 179.505n 1.8v 189.495n 1.8v 189.505n 1.8v 199.495n 1.8v 199.505n 1.8v 209.495n 1.8v 209.505n 1.8v 219.495n 1.8v 219.505n 1.8v 229.495n 1.8v 229.505n 1.8v 239.495n 1.8v 239.505n 1.8v 249.495n 1.8v 249.505n 1.8v 259.495n 1.8v 259.505n 0.0v 269.495n 0.0v 269.505n 0.0v 279.495n 0.0v 279.505n 1.8v 289.495n 1.8v 289.505n 1.8v 299.495n 1.8v 299.505n 1.8v 309.495n 1.8v 309.505n 1.8v 319.495n 1.8v 319.505n 1.8v 329.495n 1.8v 329.505n 1.8v 339.495n 1.8v 339.505n 1.8v 349.495n 1.8v 349.505n 1.8v 359.495n 1.8v 359.505n 1.8v 369.495n 1.8v 369.505n 1.8v 379.495n 1.8v 379.505n 1.8v 389.495n 1.8v 389.505n 1.8v 399.495n 1.8v 399.505n 1.8v 409.495n 1.8v 409.505n 1.8v 419.495n 1.8v 419.505n 1.8v 429.495n 1.8v 429.505n 1.8v 439.495n 1.8v 439.505n 1.8v 449.495n 1.8v 449.505n 1.8v 459.495n 1.8v 459.505n 1.8v 469.495n 1.8v 469.505n 1.8v 479.495n 1.8v 479.505n 1.8v 489.495n 1.8v 489.505n 1.8v 499.495n 1.8v 499.505n 1.8v 509.495n 1.8v 509.505n 1.8v 519.495n 1.8v 519.505n 1.8v 529.495n 1.8v 529.505n 1.8v 539.495n 1.8v 539.505n 0.0v 549.495n 0.0v 549.505n 0.0v 559.495n 0.0v 559.505n 0.0v 569.495n 0.0v 569.505n 0.0v 579.495n 0.0v 579.505n 0.0v 589.495n 0.0v 589.505n 0.0v 599.495n 0.0v 599.505n 1.8v 609.495n 1.8v 609.505n 1.8v 619.495n 1.8v 619.505n 1.8v 629.495n 1.8v 629.505n 0.0v 639.495n 0.0v 639.505n 0.0v 649.495n 0.0v 649.505n 0.0v 659.495n 0.0v 659.505n 1.8v 669.495n 1.8v 669.505n 1.8v 679.495n 1.8v 679.505n 1.8v 689.495n 1.8v 689.505n 1.8v 699.495n 1.8v 699.505n 0.0v 709.495n 0.0v 709.505n 0.0v 719.495n 0.0v 719.505n 0.0v 729.495n 0.0v 729.505n 0.0v 739.495n 0.0v 739.505n 0.0v 749.495n 0.0v 749.505n 0.0v 759.495n 0.0v 759.505n 0.0v 769.495n 0.0v 769.505n 0.0v 779.495n 0.0v 779.505n 1.8v 789.495n 1.8v 789.505n 1.8v 799.495n 1.8v 799.505n 1.8v 809.495n 1.8v 809.505n 1.8v 819.495n 1.8v 819.505n 1.8v 829.495n 1.8v 829.505n 0.0v 839.495n 0.0v 839.505n 0.0v 849.495n 0.0v 849.505n 0.0v 859.495n 0.0v 859.505n 0.0v 869.495n 0.0v 869.505n 0.0v 879.495n 0.0v 879.505n 1.8v 889.495n 1.8v 889.505n 0.0v 899.495n 0.0v 899.505n 0.0v 909.495n 0.0v 909.505n 0.0v 919.495n 0.0v 919.505n 0.0v 929.495n 0.0v 929.505n 0.0v 939.495n 0.0v 939.505n 0.0v 949.495n 0.0v 949.505n 0.0v 959.495n 0.0v 959.505n 0.0v 969.495n 0.0v 969.505n 0.0v 979.495n 0.0v 979.505n 0.0v 989.495n 0.0v 989.505n 0.0v 999.495n 0.0v 999.505n 0.0v 1009.495n 0.0v 1009.505n 0.0v 1019.495n 0.0v 1019.505n 1.8v 1029.495n 1.8v 1029.505n 1.8v 1039.495n 1.8v 1039.505n 1.8v 1049.495n 1.8v 1049.505n 1.8v 1059.495n 1.8v 1059.505n 1.8v 1069.495n 1.8v 1069.505n 1.8v 1079.495n 1.8v 1079.505n 0.0v 1089.495n 0.0v 1089.505n 1.8v 1099.495n 1.8v 1099.505n 1.8v 1109.495n 1.8v 1109.505n 1.8v 1119.495n 1.8v 1119.505n 1.8v 1129.495n 1.8v 1129.505n 1.8v 1139.495n 1.8v 1139.505n 0.0v 1149.495n 0.0v 1149.505n 0.0v 1159.495n 0.0v 1159.505n 0.0v 1169.495n 0.0v 1169.505n 0.0v 1179.495n 0.0v 1179.505n 0.0v 1189.495n 0.0v 1189.505n 0.0v 1199.495n 0.0v 1199.505n 0.0v 1209.495n 0.0v 1209.505n 0.0v 1219.495n 0.0v 1219.505n 0.0v 1229.495n 0.0v 1229.505n 0.0v 1239.495n 0.0v 1239.505n 0.0v 1249.495n 0.0v 1249.505n 0.0v 1259.495n 0.0v 1259.505n 1.8v 1269.495n 1.8v 1269.505n 1.8v 1279.495n 1.8v 1279.505n 1.8v 1289.495n 1.8v 1289.505n 1.8v 1299.495n 1.8v 1299.505n 1.8v 1309.495n 1.8v 1309.505n 0.0v 1319.495n 0.0v 1319.505n 0.0v 1329.495n 0.0v 1329.505n 0.0v 1339.495n 0.0v 1339.505n 0.0v 1349.495n 0.0v 1349.505n 0.0v 1359.495n 0.0v 1359.505n 0.0v 1369.495n 0.0v 1369.505n 0.0v 1379.495n 0.0v 1379.505n 0.0v 1389.495n 0.0v 1389.505n 0.0v 1399.495n 0.0v 1399.505n 0.0v 1409.495n 0.0v 1409.505n 1.8v 1419.495n 1.8v 1419.505n 1.8v 1429.495n 1.8v 1429.505n 0.0v 1439.495n 0.0v 1439.505n 1.8v 1449.495n 1.8v 1449.505n 1.8v 1459.495n 1.8v 1459.505n 0.0v 1469.495n 0.0v 1469.505n 1.8v 1479.495n 1.8v 1479.505n 1.8v 1489.495n 1.8v 1489.505n 0.0v 1499.495n 0.0v 1499.505n 0.0v 1509.495n 0.0v 1509.505n 0.0v 1519.495n 0.0v 1519.505n 0.0v 1529.495n 0.0v 1529.505n 0.0v 1539.495n 0.0v 1539.505n 0.0v 1549.495n 0.0v 1549.505n 0.0v 1559.495n 0.0v 1559.505n 0.0v 1569.495n 0.0v 1569.505n 0.0v 1579.495n 0.0v 1579.505n 1.8v 1589.495n 1.8v 1589.505n 1.8v 1599.495n 1.8v 1599.505n 1.8v 1609.495n 1.8v 1609.505n 1.8v 1619.495n 1.8v 1619.505n 1.8v 1629.495n 1.8v 1629.505n 1.8v 1639.495n 1.8v 1639.505n 1.8v 1649.495n 1.8v 1649.505n 1.8v 1659.495n 1.8v 1659.505n 1.8v 1669.495n 1.8v 1669.505n 1.8v 1679.495n 1.8v 1679.505n 1.8v 1689.495n 1.8v 1689.505n 1.8v 1699.495n 1.8v 1699.505n 0.0v 1709.495n 0.0v 1709.505n 0.0v 1719.495n 0.0v 1719.505n 0.0v 1729.495n 0.0v 1729.505n 0.0v 1739.495n 0.0v 1739.505n 0.0v 1749.495n 0.0v 1749.505n 0.0v 1759.495n 0.0v 1759.505n 0.0v 1769.495n 0.0v 1769.505n 0.0v 1779.495n 0.0v 1779.505n 0.0v 1789.495n 0.0v 1789.505n 0.0v 1799.495n 0.0v 1799.505n 1.8v 1809.495n 1.8v 1809.505n 1.8v 1819.495n 1.8v 1819.505n 1.8v 1829.495n 1.8v 1829.505n 1.8v 1839.495n 1.8v 1839.505n 0.0v 1849.495n 0.0v 1849.505n 0.0v 1859.495n 0.0v 1859.505n 1.8v 1869.495n 1.8v 1869.505n 1.8v 1879.495n 1.8v 1879.505n 1.8v 1889.495n 1.8v 1889.505n 1.8v 1899.495n 1.8v 1899.505n 1.8v 1909.495n 1.8v 1909.505n 0.0v 1919.495n 0.0v 1919.505n 0.0v 1929.495n 0.0v 1929.505n 0.0v 1939.495n 0.0v 1939.505n 0.0v 1949.495n 0.0v 1949.505n 0.0v 1959.495n 0.0v 1959.505n 1.8v 1969.495n 1.8v 1969.505n 1.8v 1979.495n 1.8v 1979.505n 1.8v 1989.495n 1.8v 1989.505n 1.8v 1999.495n 1.8v 1999.505n 1.8v 2009.495n 1.8v 2009.505n 1.8v 2019.495n 1.8v 2019.505n 1.8v 2029.495n 1.8v 2029.505n 0.0v 2039.495n 0.0v 2039.505n 1.8v 2049.495n 1.8v 2049.505n 1.8v )
* (time, data): [(0, 0), (10, 0), (20, 0), (30, 1), (40, 1), (50, 1), (60, 0), (70, 0), (80, 1), (90, 1), (100, 1), (110, 0), (120, 0), (130, 0), (140, 0), (150, 0), (160, 0), (170, 0), (180, 0), (190, 0), (200, 0), (210, 0), (220, 0), (230, 0), (240, 0), (250, 0), (260, 1), (270, 1), (280, 0), (290, 0), (300, 0), (310, 0), (320, 0), (330, 0), (340, 0), (350, 0), (360, 0), (370, 0), (380, 0), (390, 0), (400, 0), (410, 0), (420, 0), (430, 0), (440, 0), (450, 0), (460, 1), (470, 1), (480, 1), (490, 1), (500, 1), (510, 1), (520, 1), (530, 1), (540, 1), (550, 1), (560, 1), (570, 1), (580, 1), (590, 0), (600, 1), (610, 1), (620, 1), (630, 1), (640, 1), (650, 1), (660, 0), (670, 0), (680, 0), (690, 1), (700, 0), (710, 0), (720, 0), (730, 0), (740, 0), (750, 0), (760, 0), (770, 0), (780, 0), (790, 0), (800, 0), (810, 0), (820, 0), (830, 0), (840, 0), (850, 0), (860, 0), (870, 0), (880, 1), (890, 0), (900, 0), (910, 0), (920, 0), (930, 0), (940, 0), (950, 0), (960, 0), (970, 0), (980, 0), (990, 0), (1000, 0), (1010, 0), (1020, 1), (1030, 1), (1040, 1), (1050, 1), (1060, 1), (1070, 1), (1080, 1), (1090, 1), (1100, 1), (1110, 1), (1120, 1), (1130, 1), (1140, 1), (1150, 1), (1160, 1), (1170, 1), (1180, 1), (1190, 1), (1200, 1), (1210, 1), (1220, 1), (1230, 1), (1240, 1), (1250, 1), (1260, 1), (1270, 1), (1280, 1), (1290, 1), (1300, 1), (1310, 1), (1320, 1), (1330, 1), (1340, 1), (1350, 1), (1360, 1), (1370, 1), (1380, 1), (1390, 1), (1400, 1), (1410, 0), (1420, 0), (1430, 0), (1440, 0), (1450, 0), (1460, 0), (1470, 0), (1480, 0), (1490, 0), (1500, 0), (1510, 0), (1520, 0), (1530, 0), (1540, 0), (1550, 0), (1560, 0), (1570, 0), (1580, 1), (1590, 1), (1600, 1), (1610, 1), (1620, 1), (1630, 1), (1640, 1), (1650, 1), (1660, 1), (1670, 1), (1680, 1), (1690, 1), (1700, 1), (1710, 1), (1720, 1), (1730, 0), (1740, 0), (1750, 0), (1760, 0), (1770, 0), (1780, 0), (1790, 0), (1800, 0), (1810, 0), (1820, 0), (1830, 0), (1840, 1), (1850, 1), (1860, 1), (1870, 1), (1880, 1), (1890, 1), (1900, 1), (1910, 1), (1920, 1), (1930, 1), (1940, 1), (1950, 1), (1960, 0), (1970, 0), (1980, 0), (1990, 0), (2000, 0), (2010, 0), (2020, 0), (2030, 0), (2040, 1), (2050, 1)]
Vdin0_24  din0_24  0 PWL (0n 0.0v 9.495n 0.0v 9.505n 0.0v 19.495n 0.0v 19.505n 0.0v 29.495n 0.0v 29.505n 1.8v 39.495n 1.8v 39.505n 1.8v 49.495n 1.8v 49.505n 1.8v 59.495n 1.8v 59.505n 0.0v 69.495n 0.0v 69.505n 0.0v 79.495n 0.0v 79.505n 1.8v 89.495n 1.8v 89.505n 1.8v 99.495n 1.8v 99.505n 1.8v 109.495n 1.8v 109.505n 0.0v 119.495n 0.0v 119.505n 0.0v 129.495n 0.0v 129.505n 0.0v 139.495n 0.0v 139.505n 0.0v 149.495n 0.0v 149.505n 0.0v 159.495n 0.0v 159.505n 0.0v 169.495n 0.0v 169.505n 0.0v 179.495n 0.0v 179.505n 0.0v 189.495n 0.0v 189.505n 0.0v 199.495n 0.0v 199.505n 0.0v 209.495n 0.0v 209.505n 0.0v 219.495n 0.0v 219.505n 0.0v 229.495n 0.0v 229.505n 0.0v 239.495n 0.0v 239.505n 0.0v 249.495n 0.0v 249.505n 0.0v 259.495n 0.0v 259.505n 1.8v 269.495n 1.8v 269.505n 1.8v 279.495n 1.8v 279.505n 0.0v 289.495n 0.0v 289.505n 0.0v 299.495n 0.0v 299.505n 0.0v 309.495n 0.0v 309.505n 0.0v 319.495n 0.0v 319.505n 0.0v 329.495n 0.0v 329.505n 0.0v 339.495n 0.0v 339.505n 0.0v 349.495n 0.0v 349.505n 0.0v 359.495n 0.0v 359.505n 0.0v 369.495n 0.0v 369.505n 0.0v 379.495n 0.0v 379.505n 0.0v 389.495n 0.0v 389.505n 0.0v 399.495n 0.0v 399.505n 0.0v 409.495n 0.0v 409.505n 0.0v 419.495n 0.0v 419.505n 0.0v 429.495n 0.0v 429.505n 0.0v 439.495n 0.0v 439.505n 0.0v 449.495n 0.0v 449.505n 0.0v 459.495n 0.0v 459.505n 1.8v 469.495n 1.8v 469.505n 1.8v 479.495n 1.8v 479.505n 1.8v 489.495n 1.8v 489.505n 1.8v 499.495n 1.8v 499.505n 1.8v 509.495n 1.8v 509.505n 1.8v 519.495n 1.8v 519.505n 1.8v 529.495n 1.8v 529.505n 1.8v 539.495n 1.8v 539.505n 1.8v 549.495n 1.8v 549.505n 1.8v 559.495n 1.8v 559.505n 1.8v 569.495n 1.8v 569.505n 1.8v 579.495n 1.8v 579.505n 1.8v 589.495n 1.8v 589.505n 0.0v 599.495n 0.0v 599.505n 1.8v 609.495n 1.8v 609.505n 1.8v 619.495n 1.8v 619.505n 1.8v 629.495n 1.8v 629.505n 1.8v 639.495n 1.8v 639.505n 1.8v 649.495n 1.8v 649.505n 1.8v 659.495n 1.8v 659.505n 0.0v 669.495n 0.0v 669.505n 0.0v 679.495n 0.0v 679.505n 0.0v 689.495n 0.0v 689.505n 1.8v 699.495n 1.8v 699.505n 0.0v 709.495n 0.0v 709.505n 0.0v 719.495n 0.0v 719.505n 0.0v 729.495n 0.0v 729.505n 0.0v 739.495n 0.0v 739.505n 0.0v 749.495n 0.0v 749.505n 0.0v 759.495n 0.0v 759.505n 0.0v 769.495n 0.0v 769.505n 0.0v 779.495n 0.0v 779.505n 0.0v 789.495n 0.0v 789.505n 0.0v 799.495n 0.0v 799.505n 0.0v 809.495n 0.0v 809.505n 0.0v 819.495n 0.0v 819.505n 0.0v 829.495n 0.0v 829.505n 0.0v 839.495n 0.0v 839.505n 0.0v 849.495n 0.0v 849.505n 0.0v 859.495n 0.0v 859.505n 0.0v 869.495n 0.0v 869.505n 0.0v 879.495n 0.0v 879.505n 1.8v 889.495n 1.8v 889.505n 0.0v 899.495n 0.0v 899.505n 0.0v 909.495n 0.0v 909.505n 0.0v 919.495n 0.0v 919.505n 0.0v 929.495n 0.0v 929.505n 0.0v 939.495n 0.0v 939.505n 0.0v 949.495n 0.0v 949.505n 0.0v 959.495n 0.0v 959.505n 0.0v 969.495n 0.0v 969.505n 0.0v 979.495n 0.0v 979.505n 0.0v 989.495n 0.0v 989.505n 0.0v 999.495n 0.0v 999.505n 0.0v 1009.495n 0.0v 1009.505n 0.0v 1019.495n 0.0v 1019.505n 1.8v 1029.495n 1.8v 1029.505n 1.8v 1039.495n 1.8v 1039.505n 1.8v 1049.495n 1.8v 1049.505n 1.8v 1059.495n 1.8v 1059.505n 1.8v 1069.495n 1.8v 1069.505n 1.8v 1079.495n 1.8v 1079.505n 1.8v 1089.495n 1.8v 1089.505n 1.8v 1099.495n 1.8v 1099.505n 1.8v 1109.495n 1.8v 1109.505n 1.8v 1119.495n 1.8v 1119.505n 1.8v 1129.495n 1.8v 1129.505n 1.8v 1139.495n 1.8v 1139.505n 1.8v 1149.495n 1.8v 1149.505n 1.8v 1159.495n 1.8v 1159.505n 1.8v 1169.495n 1.8v 1169.505n 1.8v 1179.495n 1.8v 1179.505n 1.8v 1189.495n 1.8v 1189.505n 1.8v 1199.495n 1.8v 1199.505n 1.8v 1209.495n 1.8v 1209.505n 1.8v 1219.495n 1.8v 1219.505n 1.8v 1229.495n 1.8v 1229.505n 1.8v 1239.495n 1.8v 1239.505n 1.8v 1249.495n 1.8v 1249.505n 1.8v 1259.495n 1.8v 1259.505n 1.8v 1269.495n 1.8v 1269.505n 1.8v 1279.495n 1.8v 1279.505n 1.8v 1289.495n 1.8v 1289.505n 1.8v 1299.495n 1.8v 1299.505n 1.8v 1309.495n 1.8v 1309.505n 1.8v 1319.495n 1.8v 1319.505n 1.8v 1329.495n 1.8v 1329.505n 1.8v 1339.495n 1.8v 1339.505n 1.8v 1349.495n 1.8v 1349.505n 1.8v 1359.495n 1.8v 1359.505n 1.8v 1369.495n 1.8v 1369.505n 1.8v 1379.495n 1.8v 1379.505n 1.8v 1389.495n 1.8v 1389.505n 1.8v 1399.495n 1.8v 1399.505n 1.8v 1409.495n 1.8v 1409.505n 0.0v 1419.495n 0.0v 1419.505n 0.0v 1429.495n 0.0v 1429.505n 0.0v 1439.495n 0.0v 1439.505n 0.0v 1449.495n 0.0v 1449.505n 0.0v 1459.495n 0.0v 1459.505n 0.0v 1469.495n 0.0v 1469.505n 0.0v 1479.495n 0.0v 1479.505n 0.0v 1489.495n 0.0v 1489.505n 0.0v 1499.495n 0.0v 1499.505n 0.0v 1509.495n 0.0v 1509.505n 0.0v 1519.495n 0.0v 1519.505n 0.0v 1529.495n 0.0v 1529.505n 0.0v 1539.495n 0.0v 1539.505n 0.0v 1549.495n 0.0v 1549.505n 0.0v 1559.495n 0.0v 1559.505n 0.0v 1569.495n 0.0v 1569.505n 0.0v 1579.495n 0.0v 1579.505n 1.8v 1589.495n 1.8v 1589.505n 1.8v 1599.495n 1.8v 1599.505n 1.8v 1609.495n 1.8v 1609.505n 1.8v 1619.495n 1.8v 1619.505n 1.8v 1629.495n 1.8v 1629.505n 1.8v 1639.495n 1.8v 1639.505n 1.8v 1649.495n 1.8v 1649.505n 1.8v 1659.495n 1.8v 1659.505n 1.8v 1669.495n 1.8v 1669.505n 1.8v 1679.495n 1.8v 1679.505n 1.8v 1689.495n 1.8v 1689.505n 1.8v 1699.495n 1.8v 1699.505n 1.8v 1709.495n 1.8v 1709.505n 1.8v 1719.495n 1.8v 1719.505n 1.8v 1729.495n 1.8v 1729.505n 0.0v 1739.495n 0.0v 1739.505n 0.0v 1749.495n 0.0v 1749.505n 0.0v 1759.495n 0.0v 1759.505n 0.0v 1769.495n 0.0v 1769.505n 0.0v 1779.495n 0.0v 1779.505n 0.0v 1789.495n 0.0v 1789.505n 0.0v 1799.495n 0.0v 1799.505n 0.0v 1809.495n 0.0v 1809.505n 0.0v 1819.495n 0.0v 1819.505n 0.0v 1829.495n 0.0v 1829.505n 0.0v 1839.495n 0.0v 1839.505n 1.8v 1849.495n 1.8v 1849.505n 1.8v 1859.495n 1.8v 1859.505n 1.8v 1869.495n 1.8v 1869.505n 1.8v 1879.495n 1.8v 1879.505n 1.8v 1889.495n 1.8v 1889.505n 1.8v 1899.495n 1.8v 1899.505n 1.8v 1909.495n 1.8v 1909.505n 1.8v 1919.495n 1.8v 1919.505n 1.8v 1929.495n 1.8v 1929.505n 1.8v 1939.495n 1.8v 1939.505n 1.8v 1949.495n 1.8v 1949.505n 1.8v 1959.495n 1.8v 1959.505n 0.0v 1969.495n 0.0v 1969.505n 0.0v 1979.495n 0.0v 1979.505n 0.0v 1989.495n 0.0v 1989.505n 0.0v 1999.495n 0.0v 1999.505n 0.0v 2009.495n 0.0v 2009.505n 0.0v 2019.495n 0.0v 2019.505n 0.0v 2029.495n 0.0v 2029.505n 0.0v 2039.495n 0.0v 2039.505n 1.8v 2049.495n 1.8v 2049.505n 1.8v )
* (time, data): [(0, 0), (10, 1), (20, 1), (30, 1), (40, 1), (50, 1), (60, 0), (70, 0), (80, 0), (90, 0), (100, 0), (110, 1), (120, 1), (130, 1), (140, 1), (150, 1), (160, 1), (170, 1), (180, 1), (190, 1), (200, 1), (210, 1), (220, 1), (230, 1), (240, 1), (250, 1), (260, 0), (270, 0), (280, 0), (290, 0), (300, 0), (310, 0), (320, 0), (330, 0), (340, 0), (350, 0), (360, 0), (370, 0), (380, 0), (390, 0), (400, 1), (410, 1), (420, 1), (430, 1), (440, 1), (450, 0), (460, 1), (470, 0), (480, 0), (490, 0), (500, 0), (510, 0), (520, 0), (530, 0), (540, 0), (550, 0), (560, 0), (570, 0), (580, 0), (590, 1), (600, 0), (610, 0), (620, 0), (630, 1), (640, 1), (650, 1), (660, 0), (670, 0), (680, 0), (690, 0), (700, 0), (710, 0), (720, 0), (730, 0), (740, 0), (750, 0), (760, 0), (770, 1), (780, 0), (790, 0), (800, 0), (810, 0), (820, 0), (830, 0), (840, 0), (850, 0), (860, 0), (870, 0), (880, 0), (890, 0), (900, 1), (910, 1), (920, 1), (930, 1), (940, 1), (950, 1), (960, 1), (970, 1), (980, 1), (990, 1), (1000, 0), (1010, 0), (1020, 0), (1030, 0), (1040, 0), (1050, 0), (1060, 0), (1070, 0), (1080, 1), (1090, 0), (1100, 0), (1110, 0), (1120, 0), (1130, 0), (1140, 1), (1150, 1), (1160, 1), (1170, 1), (1180, 1), (1190, 1), (1200, 1), (1210, 1), (1220, 1), (1230, 1), (1240, 1), (1250, 1), (1260, 0), (1270, 0), (1280, 0), (1290, 0), (1300, 1), (1310, 0), (1320, 0), (1330, 0), (1340, 0), (1350, 0), (1360, 0), (1370, 0), (1380, 0), (1390, 0), (1400, 0), (1410, 0), (1420, 0), (1430, 0), (1440, 1), (1450, 1), (1460, 1), (1470, 0), (1480, 0), (1490, 1), (1500, 1), (1510, 1), (1520, 1), (1530, 1), (1540, 1), (1550, 1), (1560, 1), (1570, 1), (1580, 1), (1590, 1), (1600, 1), (1610, 1), (1620, 1), (1630, 1), (1640, 1), (1650, 1), (1660, 1), (1670, 1), (1680, 1), (1690, 1), (1700, 0), (1710, 0), (1720, 0), (1730, 1), (1740, 1), (1750, 1), (1760, 1), (1770, 1), (1780, 1), (1790, 1), (1800, 0), (1810, 0), (1820, 0), (1830, 0), (1840, 0), (1850, 0), (1860, 1), (1870, 1), (1880, 1), (1890, 1), (1900, 1), (1910, 0), (1920, 0), (1930, 0), (1940, 0), (1950, 0), (1960, 1), (1970, 1), (1980, 1), (1990, 1), (2000, 1), (2010, 1), (2020, 1), (2030, 1), (2040, 1), (2050, 1)]
Vdin0_25  din0_25  0 PWL (0n 0.0v 9.495n 0.0v 9.505n 1.8v 19.495n 1.8v 19.505n 1.8v 29.495n 1.8v 29.505n 1.8v 39.495n 1.8v 39.505n 1.8v 49.495n 1.8v 49.505n 1.8v 59.495n 1.8v 59.505n 0.0v 69.495n 0.0v 69.505n 0.0v 79.495n 0.0v 79.505n 0.0v 89.495n 0.0v 89.505n 0.0v 99.495n 0.0v 99.505n 0.0v 109.495n 0.0v 109.505n 1.8v 119.495n 1.8v 119.505n 1.8v 129.495n 1.8v 129.505n 1.8v 139.495n 1.8v 139.505n 1.8v 149.495n 1.8v 149.505n 1.8v 159.495n 1.8v 159.505n 1.8v 169.495n 1.8v 169.505n 1.8v 179.495n 1.8v 179.505n 1.8v 189.495n 1.8v 189.505n 1.8v 199.495n 1.8v 199.505n 1.8v 209.495n 1.8v 209.505n 1.8v 219.495n 1.8v 219.505n 1.8v 229.495n 1.8v 229.505n 1.8v 239.495n 1.8v 239.505n 1.8v 249.495n 1.8v 249.505n 1.8v 259.495n 1.8v 259.505n 0.0v 269.495n 0.0v 269.505n 0.0v 279.495n 0.0v 279.505n 0.0v 289.495n 0.0v 289.505n 0.0v 299.495n 0.0v 299.505n 0.0v 309.495n 0.0v 309.505n 0.0v 319.495n 0.0v 319.505n 0.0v 329.495n 0.0v 329.505n 0.0v 339.495n 0.0v 339.505n 0.0v 349.495n 0.0v 349.505n 0.0v 359.495n 0.0v 359.505n 0.0v 369.495n 0.0v 369.505n 0.0v 379.495n 0.0v 379.505n 0.0v 389.495n 0.0v 389.505n 0.0v 399.495n 0.0v 399.505n 1.8v 409.495n 1.8v 409.505n 1.8v 419.495n 1.8v 419.505n 1.8v 429.495n 1.8v 429.505n 1.8v 439.495n 1.8v 439.505n 1.8v 449.495n 1.8v 449.505n 0.0v 459.495n 0.0v 459.505n 1.8v 469.495n 1.8v 469.505n 0.0v 479.495n 0.0v 479.505n 0.0v 489.495n 0.0v 489.505n 0.0v 499.495n 0.0v 499.505n 0.0v 509.495n 0.0v 509.505n 0.0v 519.495n 0.0v 519.505n 0.0v 529.495n 0.0v 529.505n 0.0v 539.495n 0.0v 539.505n 0.0v 549.495n 0.0v 549.505n 0.0v 559.495n 0.0v 559.505n 0.0v 569.495n 0.0v 569.505n 0.0v 579.495n 0.0v 579.505n 0.0v 589.495n 0.0v 589.505n 1.8v 599.495n 1.8v 599.505n 0.0v 609.495n 0.0v 609.505n 0.0v 619.495n 0.0v 619.505n 0.0v 629.495n 0.0v 629.505n 1.8v 639.495n 1.8v 639.505n 1.8v 649.495n 1.8v 649.505n 1.8v 659.495n 1.8v 659.505n 0.0v 669.495n 0.0v 669.505n 0.0v 679.495n 0.0v 679.505n 0.0v 689.495n 0.0v 689.505n 0.0v 699.495n 0.0v 699.505n 0.0v 709.495n 0.0v 709.505n 0.0v 719.495n 0.0v 719.505n 0.0v 729.495n 0.0v 729.505n 0.0v 739.495n 0.0v 739.505n 0.0v 749.495n 0.0v 749.505n 0.0v 759.495n 0.0v 759.505n 0.0v 769.495n 0.0v 769.505n 1.8v 779.495n 1.8v 779.505n 0.0v 789.495n 0.0v 789.505n 0.0v 799.495n 0.0v 799.505n 0.0v 809.495n 0.0v 809.505n 0.0v 819.495n 0.0v 819.505n 0.0v 829.495n 0.0v 829.505n 0.0v 839.495n 0.0v 839.505n 0.0v 849.495n 0.0v 849.505n 0.0v 859.495n 0.0v 859.505n 0.0v 869.495n 0.0v 869.505n 0.0v 879.495n 0.0v 879.505n 0.0v 889.495n 0.0v 889.505n 0.0v 899.495n 0.0v 899.505n 1.8v 909.495n 1.8v 909.505n 1.8v 919.495n 1.8v 919.505n 1.8v 929.495n 1.8v 929.505n 1.8v 939.495n 1.8v 939.505n 1.8v 949.495n 1.8v 949.505n 1.8v 959.495n 1.8v 959.505n 1.8v 969.495n 1.8v 969.505n 1.8v 979.495n 1.8v 979.505n 1.8v 989.495n 1.8v 989.505n 1.8v 999.495n 1.8v 999.505n 0.0v 1009.495n 0.0v 1009.505n 0.0v 1019.495n 0.0v 1019.505n 0.0v 1029.495n 0.0v 1029.505n 0.0v 1039.495n 0.0v 1039.505n 0.0v 1049.495n 0.0v 1049.505n 0.0v 1059.495n 0.0v 1059.505n 0.0v 1069.495n 0.0v 1069.505n 0.0v 1079.495n 0.0v 1079.505n 1.8v 1089.495n 1.8v 1089.505n 0.0v 1099.495n 0.0v 1099.505n 0.0v 1109.495n 0.0v 1109.505n 0.0v 1119.495n 0.0v 1119.505n 0.0v 1129.495n 0.0v 1129.505n 0.0v 1139.495n 0.0v 1139.505n 1.8v 1149.495n 1.8v 1149.505n 1.8v 1159.495n 1.8v 1159.505n 1.8v 1169.495n 1.8v 1169.505n 1.8v 1179.495n 1.8v 1179.505n 1.8v 1189.495n 1.8v 1189.505n 1.8v 1199.495n 1.8v 1199.505n 1.8v 1209.495n 1.8v 1209.505n 1.8v 1219.495n 1.8v 1219.505n 1.8v 1229.495n 1.8v 1229.505n 1.8v 1239.495n 1.8v 1239.505n 1.8v 1249.495n 1.8v 1249.505n 1.8v 1259.495n 1.8v 1259.505n 0.0v 1269.495n 0.0v 1269.505n 0.0v 1279.495n 0.0v 1279.505n 0.0v 1289.495n 0.0v 1289.505n 0.0v 1299.495n 0.0v 1299.505n 1.8v 1309.495n 1.8v 1309.505n 0.0v 1319.495n 0.0v 1319.505n 0.0v 1329.495n 0.0v 1329.505n 0.0v 1339.495n 0.0v 1339.505n 0.0v 1349.495n 0.0v 1349.505n 0.0v 1359.495n 0.0v 1359.505n 0.0v 1369.495n 0.0v 1369.505n 0.0v 1379.495n 0.0v 1379.505n 0.0v 1389.495n 0.0v 1389.505n 0.0v 1399.495n 0.0v 1399.505n 0.0v 1409.495n 0.0v 1409.505n 0.0v 1419.495n 0.0v 1419.505n 0.0v 1429.495n 0.0v 1429.505n 0.0v 1439.495n 0.0v 1439.505n 1.8v 1449.495n 1.8v 1449.505n 1.8v 1459.495n 1.8v 1459.505n 1.8v 1469.495n 1.8v 1469.505n 0.0v 1479.495n 0.0v 1479.505n 0.0v 1489.495n 0.0v 1489.505n 1.8v 1499.495n 1.8v 1499.505n 1.8v 1509.495n 1.8v 1509.505n 1.8v 1519.495n 1.8v 1519.505n 1.8v 1529.495n 1.8v 1529.505n 1.8v 1539.495n 1.8v 1539.505n 1.8v 1549.495n 1.8v 1549.505n 1.8v 1559.495n 1.8v 1559.505n 1.8v 1569.495n 1.8v 1569.505n 1.8v 1579.495n 1.8v 1579.505n 1.8v 1589.495n 1.8v 1589.505n 1.8v 1599.495n 1.8v 1599.505n 1.8v 1609.495n 1.8v 1609.505n 1.8v 1619.495n 1.8v 1619.505n 1.8v 1629.495n 1.8v 1629.505n 1.8v 1639.495n 1.8v 1639.505n 1.8v 1649.495n 1.8v 1649.505n 1.8v 1659.495n 1.8v 1659.505n 1.8v 1669.495n 1.8v 1669.505n 1.8v 1679.495n 1.8v 1679.505n 1.8v 1689.495n 1.8v 1689.505n 1.8v 1699.495n 1.8v 1699.505n 0.0v 1709.495n 0.0v 1709.505n 0.0v 1719.495n 0.0v 1719.505n 0.0v 1729.495n 0.0v 1729.505n 1.8v 1739.495n 1.8v 1739.505n 1.8v 1749.495n 1.8v 1749.505n 1.8v 1759.495n 1.8v 1759.505n 1.8v 1769.495n 1.8v 1769.505n 1.8v 1779.495n 1.8v 1779.505n 1.8v 1789.495n 1.8v 1789.505n 1.8v 1799.495n 1.8v 1799.505n 0.0v 1809.495n 0.0v 1809.505n 0.0v 1819.495n 0.0v 1819.505n 0.0v 1829.495n 0.0v 1829.505n 0.0v 1839.495n 0.0v 1839.505n 0.0v 1849.495n 0.0v 1849.505n 0.0v 1859.495n 0.0v 1859.505n 1.8v 1869.495n 1.8v 1869.505n 1.8v 1879.495n 1.8v 1879.505n 1.8v 1889.495n 1.8v 1889.505n 1.8v 1899.495n 1.8v 1899.505n 1.8v 1909.495n 1.8v 1909.505n 0.0v 1919.495n 0.0v 1919.505n 0.0v 1929.495n 0.0v 1929.505n 0.0v 1939.495n 0.0v 1939.505n 0.0v 1949.495n 0.0v 1949.505n 0.0v 1959.495n 0.0v 1959.505n 1.8v 1969.495n 1.8v 1969.505n 1.8v 1979.495n 1.8v 1979.505n 1.8v 1989.495n 1.8v 1989.505n 1.8v 1999.495n 1.8v 1999.505n 1.8v 2009.495n 1.8v 2009.505n 1.8v 2019.495n 1.8v 2019.505n 1.8v 2029.495n 1.8v 2029.505n 1.8v 2039.495n 1.8v 2039.505n 1.8v 2049.495n 1.8v 2049.505n 1.8v )
* (time, data): [(0, 0), (10, 0), (20, 0), (30, 1), (40, 1), (50, 1), (60, 1), (70, 1), (80, 1), (90, 1), (100, 1), (110, 0), (120, 1), (130, 1), (140, 1), (150, 1), (160, 1), (170, 1), (180, 1), (190, 1), (200, 1), (210, 1), (220, 1), (230, 1), (240, 1), (250, 1), (260, 0), (270, 0), (280, 1), (290, 1), (300, 1), (310, 1), (320, 1), (330, 1), (340, 1), (350, 1), (360, 1), (370, 1), (380, 1), (390, 1), (400, 1), (410, 1), (420, 1), (430, 1), (440, 1), (450, 0), (460, 1), (470, 1), (480, 1), (490, 1), (500, 1), (510, 1), (520, 1), (530, 1), (540, 1), (550, 1), (560, 1), (570, 1), (580, 1), (590, 1), (600, 1), (610, 1), (620, 1), (630, 0), (640, 0), (650, 0), (660, 1), (670, 1), (680, 1), (690, 1), (700, 0), (710, 0), (720, 0), (730, 0), (740, 0), (750, 0), (760, 0), (770, 1), (780, 1), (790, 1), (800, 1), (810, 1), (820, 1), (830, 1), (840, 1), (850, 1), (860, 1), (870, 1), (880, 1), (890, 0), (900, 1), (910, 1), (920, 1), (930, 1), (940, 1), (950, 1), (960, 1), (970, 1), (980, 1), (990, 1), (1000, 1), (1010, 1), (1020, 1), (1030, 1), (1040, 1), (1050, 1), (1060, 1), (1070, 1), (1080, 1), (1090, 0), (1100, 0), (1110, 0), (1120, 0), (1130, 0), (1140, 1), (1150, 1), (1160, 1), (1170, 1), (1180, 1), (1190, 1), (1200, 1), (1210, 1), (1220, 1), (1230, 1), (1240, 1), (1250, 1), (1260, 0), (1270, 0), (1280, 0), (1290, 0), (1300, 1), (1310, 1), (1320, 1), (1330, 1), (1340, 1), (1350, 1), (1360, 1), (1370, 1), (1380, 1), (1390, 1), (1400, 1), (1410, 1), (1420, 1), (1430, 1), (1440, 0), (1450, 0), (1460, 1), (1470, 1), (1480, 1), (1490, 0), (1500, 0), (1510, 0), (1520, 0), (1530, 0), (1540, 0), (1550, 1), (1560, 1), (1570, 1), (1580, 0), (1590, 1), (1600, 1), (1610, 1), (1620, 1), (1630, 0), (1640, 0), (1650, 0), (1660, 0), (1670, 0), (1680, 0), (1690, 0), (1700, 0), (1710, 1), (1720, 1), (1730, 0), (1740, 0), (1750, 0), (1760, 0), (1770, 0), (1780, 0), (1790, 0), (1800, 1), (1810, 1), (1820, 1), (1830, 1), (1840, 0), (1850, 0), (1860, 1), (1870, 1), (1880, 1), (1890, 1), (1900, 1), (1910, 0), (1920, 0), (1930, 0), (1940, 0), (1950, 0), (1960, 0), (1970, 0), (1980, 0), (1990, 0), (2000, 0), (2010, 0), (2020, 0), (2030, 0), (2040, 0), (2050, 0)]
Vdin0_26  din0_26  0 PWL (0n 0.0v 9.495n 0.0v 9.505n 0.0v 19.495n 0.0v 19.505n 0.0v 29.495n 0.0v 29.505n 1.8v 39.495n 1.8v 39.505n 1.8v 49.495n 1.8v 49.505n 1.8v 59.495n 1.8v 59.505n 1.8v 69.495n 1.8v 69.505n 1.8v 79.495n 1.8v 79.505n 1.8v 89.495n 1.8v 89.505n 1.8v 99.495n 1.8v 99.505n 1.8v 109.495n 1.8v 109.505n 0.0v 119.495n 0.0v 119.505n 1.8v 129.495n 1.8v 129.505n 1.8v 139.495n 1.8v 139.505n 1.8v 149.495n 1.8v 149.505n 1.8v 159.495n 1.8v 159.505n 1.8v 169.495n 1.8v 169.505n 1.8v 179.495n 1.8v 179.505n 1.8v 189.495n 1.8v 189.505n 1.8v 199.495n 1.8v 199.505n 1.8v 209.495n 1.8v 209.505n 1.8v 219.495n 1.8v 219.505n 1.8v 229.495n 1.8v 229.505n 1.8v 239.495n 1.8v 239.505n 1.8v 249.495n 1.8v 249.505n 1.8v 259.495n 1.8v 259.505n 0.0v 269.495n 0.0v 269.505n 0.0v 279.495n 0.0v 279.505n 1.8v 289.495n 1.8v 289.505n 1.8v 299.495n 1.8v 299.505n 1.8v 309.495n 1.8v 309.505n 1.8v 319.495n 1.8v 319.505n 1.8v 329.495n 1.8v 329.505n 1.8v 339.495n 1.8v 339.505n 1.8v 349.495n 1.8v 349.505n 1.8v 359.495n 1.8v 359.505n 1.8v 369.495n 1.8v 369.505n 1.8v 379.495n 1.8v 379.505n 1.8v 389.495n 1.8v 389.505n 1.8v 399.495n 1.8v 399.505n 1.8v 409.495n 1.8v 409.505n 1.8v 419.495n 1.8v 419.505n 1.8v 429.495n 1.8v 429.505n 1.8v 439.495n 1.8v 439.505n 1.8v 449.495n 1.8v 449.505n 0.0v 459.495n 0.0v 459.505n 1.8v 469.495n 1.8v 469.505n 1.8v 479.495n 1.8v 479.505n 1.8v 489.495n 1.8v 489.505n 1.8v 499.495n 1.8v 499.505n 1.8v 509.495n 1.8v 509.505n 1.8v 519.495n 1.8v 519.505n 1.8v 529.495n 1.8v 529.505n 1.8v 539.495n 1.8v 539.505n 1.8v 549.495n 1.8v 549.505n 1.8v 559.495n 1.8v 559.505n 1.8v 569.495n 1.8v 569.505n 1.8v 579.495n 1.8v 579.505n 1.8v 589.495n 1.8v 589.505n 1.8v 599.495n 1.8v 599.505n 1.8v 609.495n 1.8v 609.505n 1.8v 619.495n 1.8v 619.505n 1.8v 629.495n 1.8v 629.505n 0.0v 639.495n 0.0v 639.505n 0.0v 649.495n 0.0v 649.505n 0.0v 659.495n 0.0v 659.505n 1.8v 669.495n 1.8v 669.505n 1.8v 679.495n 1.8v 679.505n 1.8v 689.495n 1.8v 689.505n 1.8v 699.495n 1.8v 699.505n 0.0v 709.495n 0.0v 709.505n 0.0v 719.495n 0.0v 719.505n 0.0v 729.495n 0.0v 729.505n 0.0v 739.495n 0.0v 739.505n 0.0v 749.495n 0.0v 749.505n 0.0v 759.495n 0.0v 759.505n 0.0v 769.495n 0.0v 769.505n 1.8v 779.495n 1.8v 779.505n 1.8v 789.495n 1.8v 789.505n 1.8v 799.495n 1.8v 799.505n 1.8v 809.495n 1.8v 809.505n 1.8v 819.495n 1.8v 819.505n 1.8v 829.495n 1.8v 829.505n 1.8v 839.495n 1.8v 839.505n 1.8v 849.495n 1.8v 849.505n 1.8v 859.495n 1.8v 859.505n 1.8v 869.495n 1.8v 869.505n 1.8v 879.495n 1.8v 879.505n 1.8v 889.495n 1.8v 889.505n 0.0v 899.495n 0.0v 899.505n 1.8v 909.495n 1.8v 909.505n 1.8v 919.495n 1.8v 919.505n 1.8v 929.495n 1.8v 929.505n 1.8v 939.495n 1.8v 939.505n 1.8v 949.495n 1.8v 949.505n 1.8v 959.495n 1.8v 959.505n 1.8v 969.495n 1.8v 969.505n 1.8v 979.495n 1.8v 979.505n 1.8v 989.495n 1.8v 989.505n 1.8v 999.495n 1.8v 999.505n 1.8v 1009.495n 1.8v 1009.505n 1.8v 1019.495n 1.8v 1019.505n 1.8v 1029.495n 1.8v 1029.505n 1.8v 1039.495n 1.8v 1039.505n 1.8v 1049.495n 1.8v 1049.505n 1.8v 1059.495n 1.8v 1059.505n 1.8v 1069.495n 1.8v 1069.505n 1.8v 1079.495n 1.8v 1079.505n 1.8v 1089.495n 1.8v 1089.505n 0.0v 1099.495n 0.0v 1099.505n 0.0v 1109.495n 0.0v 1109.505n 0.0v 1119.495n 0.0v 1119.505n 0.0v 1129.495n 0.0v 1129.505n 0.0v 1139.495n 0.0v 1139.505n 1.8v 1149.495n 1.8v 1149.505n 1.8v 1159.495n 1.8v 1159.505n 1.8v 1169.495n 1.8v 1169.505n 1.8v 1179.495n 1.8v 1179.505n 1.8v 1189.495n 1.8v 1189.505n 1.8v 1199.495n 1.8v 1199.505n 1.8v 1209.495n 1.8v 1209.505n 1.8v 1219.495n 1.8v 1219.505n 1.8v 1229.495n 1.8v 1229.505n 1.8v 1239.495n 1.8v 1239.505n 1.8v 1249.495n 1.8v 1249.505n 1.8v 1259.495n 1.8v 1259.505n 0.0v 1269.495n 0.0v 1269.505n 0.0v 1279.495n 0.0v 1279.505n 0.0v 1289.495n 0.0v 1289.505n 0.0v 1299.495n 0.0v 1299.505n 1.8v 1309.495n 1.8v 1309.505n 1.8v 1319.495n 1.8v 1319.505n 1.8v 1329.495n 1.8v 1329.505n 1.8v 1339.495n 1.8v 1339.505n 1.8v 1349.495n 1.8v 1349.505n 1.8v 1359.495n 1.8v 1359.505n 1.8v 1369.495n 1.8v 1369.505n 1.8v 1379.495n 1.8v 1379.505n 1.8v 1389.495n 1.8v 1389.505n 1.8v 1399.495n 1.8v 1399.505n 1.8v 1409.495n 1.8v 1409.505n 1.8v 1419.495n 1.8v 1419.505n 1.8v 1429.495n 1.8v 1429.505n 1.8v 1439.495n 1.8v 1439.505n 0.0v 1449.495n 0.0v 1449.505n 0.0v 1459.495n 0.0v 1459.505n 1.8v 1469.495n 1.8v 1469.505n 1.8v 1479.495n 1.8v 1479.505n 1.8v 1489.495n 1.8v 1489.505n 0.0v 1499.495n 0.0v 1499.505n 0.0v 1509.495n 0.0v 1509.505n 0.0v 1519.495n 0.0v 1519.505n 0.0v 1529.495n 0.0v 1529.505n 0.0v 1539.495n 0.0v 1539.505n 0.0v 1549.495n 0.0v 1549.505n 1.8v 1559.495n 1.8v 1559.505n 1.8v 1569.495n 1.8v 1569.505n 1.8v 1579.495n 1.8v 1579.505n 0.0v 1589.495n 0.0v 1589.505n 1.8v 1599.495n 1.8v 1599.505n 1.8v 1609.495n 1.8v 1609.505n 1.8v 1619.495n 1.8v 1619.505n 1.8v 1629.495n 1.8v 1629.505n 0.0v 1639.495n 0.0v 1639.505n 0.0v 1649.495n 0.0v 1649.505n 0.0v 1659.495n 0.0v 1659.505n 0.0v 1669.495n 0.0v 1669.505n 0.0v 1679.495n 0.0v 1679.505n 0.0v 1689.495n 0.0v 1689.505n 0.0v 1699.495n 0.0v 1699.505n 0.0v 1709.495n 0.0v 1709.505n 1.8v 1719.495n 1.8v 1719.505n 1.8v 1729.495n 1.8v 1729.505n 0.0v 1739.495n 0.0v 1739.505n 0.0v 1749.495n 0.0v 1749.505n 0.0v 1759.495n 0.0v 1759.505n 0.0v 1769.495n 0.0v 1769.505n 0.0v 1779.495n 0.0v 1779.505n 0.0v 1789.495n 0.0v 1789.505n 0.0v 1799.495n 0.0v 1799.505n 1.8v 1809.495n 1.8v 1809.505n 1.8v 1819.495n 1.8v 1819.505n 1.8v 1829.495n 1.8v 1829.505n 1.8v 1839.495n 1.8v 1839.505n 0.0v 1849.495n 0.0v 1849.505n 0.0v 1859.495n 0.0v 1859.505n 1.8v 1869.495n 1.8v 1869.505n 1.8v 1879.495n 1.8v 1879.505n 1.8v 1889.495n 1.8v 1889.505n 1.8v 1899.495n 1.8v 1899.505n 1.8v 1909.495n 1.8v 1909.505n 0.0v 1919.495n 0.0v 1919.505n 0.0v 1929.495n 0.0v 1929.505n 0.0v 1939.495n 0.0v 1939.505n 0.0v 1949.495n 0.0v 1949.505n 0.0v 1959.495n 0.0v 1959.505n 0.0v 1969.495n 0.0v 1969.505n 0.0v 1979.495n 0.0v 1979.505n 0.0v 1989.495n 0.0v 1989.505n 0.0v 1999.495n 0.0v 1999.505n 0.0v 2009.495n 0.0v 2009.505n 0.0v 2019.495n 0.0v 2019.505n 0.0v 2029.495n 0.0v 2029.505n 0.0v 2039.495n 0.0v 2039.505n 0.0v 2049.495n 0.0v 2049.505n 0.0v )
* (time, data): [(0, 0), (10, 1), (20, 1), (30, 0), (40, 0), (50, 0), (60, 1), (70, 1), (80, 1), (90, 1), (100, 1), (110, 1), (120, 0), (130, 0), (140, 0), (150, 0), (160, 0), (170, 0), (180, 0), (190, 0), (200, 0), (210, 0), (220, 0), (230, 0), (240, 0), (250, 0), (260, 1), (270, 1), (280, 1), (290, 1), (300, 1), (310, 1), (320, 1), (330, 1), (340, 1), (350, 1), (360, 1), (370, 1), (380, 1), (390, 1), (400, 0), (410, 0), (420, 0), (430, 0), (440, 0), (450, 1), (460, 1), (470, 0), (480, 0), (490, 0), (500, 0), (510, 0), (520, 0), (530, 0), (540, 0), (550, 0), (560, 0), (570, 0), (580, 0), (590, 1), (600, 0), (610, 0), (620, 0), (630, 0), (640, 0), (650, 0), (660, 1), (670, 1), (680, 1), (690, 1), (700, 1), (710, 1), (720, 1), (730, 1), (740, 1), (750, 1), (760, 1), (770, 1), (780, 0), (790, 0), (800, 0), (810, 0), (820, 0), (830, 1), (840, 1), (850, 1), (860, 1), (870, 1), (880, 0), (890, 1), (900, 0), (910, 0), (920, 0), (930, 0), (940, 1), (950, 1), (960, 1), (970, 1), (980, 1), (990, 1), (1000, 0), (1010, 0), (1020, 1), (1030, 1), (1040, 1), (1050, 1), (1060, 1), (1070, 1), (1080, 1), (1090, 1), (1100, 1), (1110, 1), (1120, 1), (1130, 1), (1140, 1), (1150, 1), (1160, 1), (1170, 1), (1180, 1), (1190, 1), (1200, 1), (1210, 1), (1220, 1), (1230, 1), (1240, 1), (1250, 1), (1260, 1), (1270, 1), (1280, 1), (1290, 1), (1300, 0), (1310, 0), (1320, 0), (1330, 0), (1340, 0), (1350, 0), (1360, 0), (1370, 0), (1380, 0), (1390, 0), (1400, 0), (1410, 1), (1420, 1), (1430, 1), (1440, 0), (1450, 0), (1460, 1), (1470, 0), (1480, 0), (1490, 1), (1500, 1), (1510, 1), (1520, 1), (1530, 1), (1540, 1), (1550, 1), (1560, 1), (1570, 1), (1580, 0), (1590, 1), (1600, 1), (1610, 1), (1620, 1), (1630, 0), (1640, 0), (1650, 0), (1660, 0), (1670, 0), (1680, 0), (1690, 0), (1700, 0), (1710, 1), (1720, 1), (1730, 0), (1740, 0), (1750, 0), (1760, 0), (1770, 0), (1780, 0), (1790, 0), (1800, 0), (1810, 0), (1820, 0), (1830, 0), (1840, 1), (1850, 1), (1860, 1), (1870, 1), (1880, 1), (1890, 1), (1900, 1), (1910, 1), (1920, 1), (1930, 1), (1940, 1), (1950, 1), (1960, 1), (1970, 1), (1980, 1), (1990, 1), (2000, 1), (2010, 1), (2020, 1), (2030, 0), (2040, 1), (2050, 1)]
Vdin0_27  din0_27  0 PWL (0n 0.0v 9.495n 0.0v 9.505n 1.8v 19.495n 1.8v 19.505n 1.8v 29.495n 1.8v 29.505n 0.0v 39.495n 0.0v 39.505n 0.0v 49.495n 0.0v 49.505n 0.0v 59.495n 0.0v 59.505n 1.8v 69.495n 1.8v 69.505n 1.8v 79.495n 1.8v 79.505n 1.8v 89.495n 1.8v 89.505n 1.8v 99.495n 1.8v 99.505n 1.8v 109.495n 1.8v 109.505n 1.8v 119.495n 1.8v 119.505n 0.0v 129.495n 0.0v 129.505n 0.0v 139.495n 0.0v 139.505n 0.0v 149.495n 0.0v 149.505n 0.0v 159.495n 0.0v 159.505n 0.0v 169.495n 0.0v 169.505n 0.0v 179.495n 0.0v 179.505n 0.0v 189.495n 0.0v 189.505n 0.0v 199.495n 0.0v 199.505n 0.0v 209.495n 0.0v 209.505n 0.0v 219.495n 0.0v 219.505n 0.0v 229.495n 0.0v 229.505n 0.0v 239.495n 0.0v 239.505n 0.0v 249.495n 0.0v 249.505n 0.0v 259.495n 0.0v 259.505n 1.8v 269.495n 1.8v 269.505n 1.8v 279.495n 1.8v 279.505n 1.8v 289.495n 1.8v 289.505n 1.8v 299.495n 1.8v 299.505n 1.8v 309.495n 1.8v 309.505n 1.8v 319.495n 1.8v 319.505n 1.8v 329.495n 1.8v 329.505n 1.8v 339.495n 1.8v 339.505n 1.8v 349.495n 1.8v 349.505n 1.8v 359.495n 1.8v 359.505n 1.8v 369.495n 1.8v 369.505n 1.8v 379.495n 1.8v 379.505n 1.8v 389.495n 1.8v 389.505n 1.8v 399.495n 1.8v 399.505n 0.0v 409.495n 0.0v 409.505n 0.0v 419.495n 0.0v 419.505n 0.0v 429.495n 0.0v 429.505n 0.0v 439.495n 0.0v 439.505n 0.0v 449.495n 0.0v 449.505n 1.8v 459.495n 1.8v 459.505n 1.8v 469.495n 1.8v 469.505n 0.0v 479.495n 0.0v 479.505n 0.0v 489.495n 0.0v 489.505n 0.0v 499.495n 0.0v 499.505n 0.0v 509.495n 0.0v 509.505n 0.0v 519.495n 0.0v 519.505n 0.0v 529.495n 0.0v 529.505n 0.0v 539.495n 0.0v 539.505n 0.0v 549.495n 0.0v 549.505n 0.0v 559.495n 0.0v 559.505n 0.0v 569.495n 0.0v 569.505n 0.0v 579.495n 0.0v 579.505n 0.0v 589.495n 0.0v 589.505n 1.8v 599.495n 1.8v 599.505n 0.0v 609.495n 0.0v 609.505n 0.0v 619.495n 0.0v 619.505n 0.0v 629.495n 0.0v 629.505n 0.0v 639.495n 0.0v 639.505n 0.0v 649.495n 0.0v 649.505n 0.0v 659.495n 0.0v 659.505n 1.8v 669.495n 1.8v 669.505n 1.8v 679.495n 1.8v 679.505n 1.8v 689.495n 1.8v 689.505n 1.8v 699.495n 1.8v 699.505n 1.8v 709.495n 1.8v 709.505n 1.8v 719.495n 1.8v 719.505n 1.8v 729.495n 1.8v 729.505n 1.8v 739.495n 1.8v 739.505n 1.8v 749.495n 1.8v 749.505n 1.8v 759.495n 1.8v 759.505n 1.8v 769.495n 1.8v 769.505n 1.8v 779.495n 1.8v 779.505n 0.0v 789.495n 0.0v 789.505n 0.0v 799.495n 0.0v 799.505n 0.0v 809.495n 0.0v 809.505n 0.0v 819.495n 0.0v 819.505n 0.0v 829.495n 0.0v 829.505n 1.8v 839.495n 1.8v 839.505n 1.8v 849.495n 1.8v 849.505n 1.8v 859.495n 1.8v 859.505n 1.8v 869.495n 1.8v 869.505n 1.8v 879.495n 1.8v 879.505n 0.0v 889.495n 0.0v 889.505n 1.8v 899.495n 1.8v 899.505n 0.0v 909.495n 0.0v 909.505n 0.0v 919.495n 0.0v 919.505n 0.0v 929.495n 0.0v 929.505n 0.0v 939.495n 0.0v 939.505n 1.8v 949.495n 1.8v 949.505n 1.8v 959.495n 1.8v 959.505n 1.8v 969.495n 1.8v 969.505n 1.8v 979.495n 1.8v 979.505n 1.8v 989.495n 1.8v 989.505n 1.8v 999.495n 1.8v 999.505n 0.0v 1009.495n 0.0v 1009.505n 0.0v 1019.495n 0.0v 1019.505n 1.8v 1029.495n 1.8v 1029.505n 1.8v 1039.495n 1.8v 1039.505n 1.8v 1049.495n 1.8v 1049.505n 1.8v 1059.495n 1.8v 1059.505n 1.8v 1069.495n 1.8v 1069.505n 1.8v 1079.495n 1.8v 1079.505n 1.8v 1089.495n 1.8v 1089.505n 1.8v 1099.495n 1.8v 1099.505n 1.8v 1109.495n 1.8v 1109.505n 1.8v 1119.495n 1.8v 1119.505n 1.8v 1129.495n 1.8v 1129.505n 1.8v 1139.495n 1.8v 1139.505n 1.8v 1149.495n 1.8v 1149.505n 1.8v 1159.495n 1.8v 1159.505n 1.8v 1169.495n 1.8v 1169.505n 1.8v 1179.495n 1.8v 1179.505n 1.8v 1189.495n 1.8v 1189.505n 1.8v 1199.495n 1.8v 1199.505n 1.8v 1209.495n 1.8v 1209.505n 1.8v 1219.495n 1.8v 1219.505n 1.8v 1229.495n 1.8v 1229.505n 1.8v 1239.495n 1.8v 1239.505n 1.8v 1249.495n 1.8v 1249.505n 1.8v 1259.495n 1.8v 1259.505n 1.8v 1269.495n 1.8v 1269.505n 1.8v 1279.495n 1.8v 1279.505n 1.8v 1289.495n 1.8v 1289.505n 1.8v 1299.495n 1.8v 1299.505n 0.0v 1309.495n 0.0v 1309.505n 0.0v 1319.495n 0.0v 1319.505n 0.0v 1329.495n 0.0v 1329.505n 0.0v 1339.495n 0.0v 1339.505n 0.0v 1349.495n 0.0v 1349.505n 0.0v 1359.495n 0.0v 1359.505n 0.0v 1369.495n 0.0v 1369.505n 0.0v 1379.495n 0.0v 1379.505n 0.0v 1389.495n 0.0v 1389.505n 0.0v 1399.495n 0.0v 1399.505n 0.0v 1409.495n 0.0v 1409.505n 1.8v 1419.495n 1.8v 1419.505n 1.8v 1429.495n 1.8v 1429.505n 1.8v 1439.495n 1.8v 1439.505n 0.0v 1449.495n 0.0v 1449.505n 0.0v 1459.495n 0.0v 1459.505n 1.8v 1469.495n 1.8v 1469.505n 0.0v 1479.495n 0.0v 1479.505n 0.0v 1489.495n 0.0v 1489.505n 1.8v 1499.495n 1.8v 1499.505n 1.8v 1509.495n 1.8v 1509.505n 1.8v 1519.495n 1.8v 1519.505n 1.8v 1529.495n 1.8v 1529.505n 1.8v 1539.495n 1.8v 1539.505n 1.8v 1549.495n 1.8v 1549.505n 1.8v 1559.495n 1.8v 1559.505n 1.8v 1569.495n 1.8v 1569.505n 1.8v 1579.495n 1.8v 1579.505n 0.0v 1589.495n 0.0v 1589.505n 1.8v 1599.495n 1.8v 1599.505n 1.8v 1609.495n 1.8v 1609.505n 1.8v 1619.495n 1.8v 1619.505n 1.8v 1629.495n 1.8v 1629.505n 0.0v 1639.495n 0.0v 1639.505n 0.0v 1649.495n 0.0v 1649.505n 0.0v 1659.495n 0.0v 1659.505n 0.0v 1669.495n 0.0v 1669.505n 0.0v 1679.495n 0.0v 1679.505n 0.0v 1689.495n 0.0v 1689.505n 0.0v 1699.495n 0.0v 1699.505n 0.0v 1709.495n 0.0v 1709.505n 1.8v 1719.495n 1.8v 1719.505n 1.8v 1729.495n 1.8v 1729.505n 0.0v 1739.495n 0.0v 1739.505n 0.0v 1749.495n 0.0v 1749.505n 0.0v 1759.495n 0.0v 1759.505n 0.0v 1769.495n 0.0v 1769.505n 0.0v 1779.495n 0.0v 1779.505n 0.0v 1789.495n 0.0v 1789.505n 0.0v 1799.495n 0.0v 1799.505n 0.0v 1809.495n 0.0v 1809.505n 0.0v 1819.495n 0.0v 1819.505n 0.0v 1829.495n 0.0v 1829.505n 0.0v 1839.495n 0.0v 1839.505n 1.8v 1849.495n 1.8v 1849.505n 1.8v 1859.495n 1.8v 1859.505n 1.8v 1869.495n 1.8v 1869.505n 1.8v 1879.495n 1.8v 1879.505n 1.8v 1889.495n 1.8v 1889.505n 1.8v 1899.495n 1.8v 1899.505n 1.8v 1909.495n 1.8v 1909.505n 1.8v 1919.495n 1.8v 1919.505n 1.8v 1929.495n 1.8v 1929.505n 1.8v 1939.495n 1.8v 1939.505n 1.8v 1949.495n 1.8v 1949.505n 1.8v 1959.495n 1.8v 1959.505n 1.8v 1969.495n 1.8v 1969.505n 1.8v 1979.495n 1.8v 1979.505n 1.8v 1989.495n 1.8v 1989.505n 1.8v 1999.495n 1.8v 1999.505n 1.8v 2009.495n 1.8v 2009.505n 1.8v 2019.495n 1.8v 2019.505n 1.8v 2029.495n 1.8v 2029.505n 0.0v 2039.495n 0.0v 2039.505n 1.8v 2049.495n 1.8v 2049.505n 1.8v )
* (time, data): [(0, 0), (10, 1), (20, 1), (30, 0), (40, 0), (50, 0), (60, 1), (70, 1), (80, 1), (90, 1), (100, 1), (110, 1), (120, 0), (130, 0), (140, 0), (150, 0), (160, 0), (170, 0), (180, 0), (190, 0), (200, 0), (210, 0), (220, 0), (230, 0), (240, 0), (250, 0), (260, 0), (270, 0), (280, 1), (290, 1), (300, 1), (310, 1), (320, 1), (330, 1), (340, 1), (350, 1), (360, 1), (370, 1), (380, 1), (390, 1), (400, 1), (410, 1), (420, 1), (430, 1), (440, 1), (450, 0), (460, 0), (470, 0), (480, 0), (490, 0), (500, 0), (510, 0), (520, 0), (530, 0), (540, 1), (550, 1), (560, 1), (570, 1), (580, 1), (590, 1), (600, 0), (610, 0), (620, 0), (630, 0), (640, 0), (650, 0), (660, 1), (670, 1), (680, 1), (690, 0), (700, 1), (710, 1), (720, 1), (730, 1), (740, 1), (750, 1), (760, 1), (770, 1), (780, 1), (790, 1), (800, 1), (810, 1), (820, 1), (830, 0), (840, 0), (850, 0), (860, 0), (870, 0), (880, 0), (890, 0), (900, 0), (910, 0), (920, 0), (930, 0), (940, 1), (950, 1), (960, 1), (970, 1), (980, 1), (990, 1), (1000, 0), (1010, 0), (1020, 0), (1030, 0), (1040, 0), (1050, 0), (1060, 0), (1070, 0), (1080, 1), (1090, 0), (1100, 0), (1110, 0), (1120, 0), (1130, 0), (1140, 1), (1150, 1), (1160, 1), (1170, 1), (1180, 1), (1190, 1), (1200, 1), (1210, 1), (1220, 1), (1230, 1), (1240, 1), (1250, 1), (1260, 0), (1270, 0), (1280, 0), (1290, 0), (1300, 1), (1310, 0), (1320, 0), (1330, 0), (1340, 0), (1350, 0), (1360, 1), (1370, 1), (1380, 1), (1390, 1), (1400, 1), (1410, 0), (1420, 0), (1430, 0), (1440, 1), (1450, 1), (1460, 0), (1470, 0), (1480, 0), (1490, 1), (1500, 1), (1510, 1), (1520, 1), (1530, 1), (1540, 1), (1550, 0), (1560, 0), (1570, 0), (1580, 1), (1590, 1), (1600, 1), (1610, 1), (1620, 1), (1630, 0), (1640, 0), (1650, 0), (1660, 0), (1670, 0), (1680, 0), (1690, 0), (1700, 0), (1710, 1), (1720, 1), (1730, 1), (1740, 1), (1750, 1), (1760, 1), (1770, 1), (1780, 1), (1790, 1), (1800, 0), (1810, 0), (1820, 0), (1830, 0), (1840, 0), (1850, 0), (1860, 0), (1870, 0), (1880, 0), (1890, 0), (1900, 0), (1910, 1), (1920, 1), (1930, 1), (1940, 1), (1950, 1), (1960, 0), (1970, 0), (1980, 0), (1990, 0), (2000, 0), (2010, 0), (2020, 0), (2030, 1), (2040, 1), (2050, 1)]
Vdin0_28  din0_28  0 PWL (0n 0.0v 9.495n 0.0v 9.505n 1.8v 19.495n 1.8v 19.505n 1.8v 29.495n 1.8v 29.505n 0.0v 39.495n 0.0v 39.505n 0.0v 49.495n 0.0v 49.505n 0.0v 59.495n 0.0v 59.505n 1.8v 69.495n 1.8v 69.505n 1.8v 79.495n 1.8v 79.505n 1.8v 89.495n 1.8v 89.505n 1.8v 99.495n 1.8v 99.505n 1.8v 109.495n 1.8v 109.505n 1.8v 119.495n 1.8v 119.505n 0.0v 129.495n 0.0v 129.505n 0.0v 139.495n 0.0v 139.505n 0.0v 149.495n 0.0v 149.505n 0.0v 159.495n 0.0v 159.505n 0.0v 169.495n 0.0v 169.505n 0.0v 179.495n 0.0v 179.505n 0.0v 189.495n 0.0v 189.505n 0.0v 199.495n 0.0v 199.505n 0.0v 209.495n 0.0v 209.505n 0.0v 219.495n 0.0v 219.505n 0.0v 229.495n 0.0v 229.505n 0.0v 239.495n 0.0v 239.505n 0.0v 249.495n 0.0v 249.505n 0.0v 259.495n 0.0v 259.505n 0.0v 269.495n 0.0v 269.505n 0.0v 279.495n 0.0v 279.505n 1.8v 289.495n 1.8v 289.505n 1.8v 299.495n 1.8v 299.505n 1.8v 309.495n 1.8v 309.505n 1.8v 319.495n 1.8v 319.505n 1.8v 329.495n 1.8v 329.505n 1.8v 339.495n 1.8v 339.505n 1.8v 349.495n 1.8v 349.505n 1.8v 359.495n 1.8v 359.505n 1.8v 369.495n 1.8v 369.505n 1.8v 379.495n 1.8v 379.505n 1.8v 389.495n 1.8v 389.505n 1.8v 399.495n 1.8v 399.505n 1.8v 409.495n 1.8v 409.505n 1.8v 419.495n 1.8v 419.505n 1.8v 429.495n 1.8v 429.505n 1.8v 439.495n 1.8v 439.505n 1.8v 449.495n 1.8v 449.505n 0.0v 459.495n 0.0v 459.505n 0.0v 469.495n 0.0v 469.505n 0.0v 479.495n 0.0v 479.505n 0.0v 489.495n 0.0v 489.505n 0.0v 499.495n 0.0v 499.505n 0.0v 509.495n 0.0v 509.505n 0.0v 519.495n 0.0v 519.505n 0.0v 529.495n 0.0v 529.505n 0.0v 539.495n 0.0v 539.505n 1.8v 549.495n 1.8v 549.505n 1.8v 559.495n 1.8v 559.505n 1.8v 569.495n 1.8v 569.505n 1.8v 579.495n 1.8v 579.505n 1.8v 589.495n 1.8v 589.505n 1.8v 599.495n 1.8v 599.505n 0.0v 609.495n 0.0v 609.505n 0.0v 619.495n 0.0v 619.505n 0.0v 629.495n 0.0v 629.505n 0.0v 639.495n 0.0v 639.505n 0.0v 649.495n 0.0v 649.505n 0.0v 659.495n 0.0v 659.505n 1.8v 669.495n 1.8v 669.505n 1.8v 679.495n 1.8v 679.505n 1.8v 689.495n 1.8v 689.505n 0.0v 699.495n 0.0v 699.505n 1.8v 709.495n 1.8v 709.505n 1.8v 719.495n 1.8v 719.505n 1.8v 729.495n 1.8v 729.505n 1.8v 739.495n 1.8v 739.505n 1.8v 749.495n 1.8v 749.505n 1.8v 759.495n 1.8v 759.505n 1.8v 769.495n 1.8v 769.505n 1.8v 779.495n 1.8v 779.505n 1.8v 789.495n 1.8v 789.505n 1.8v 799.495n 1.8v 799.505n 1.8v 809.495n 1.8v 809.505n 1.8v 819.495n 1.8v 819.505n 1.8v 829.495n 1.8v 829.505n 0.0v 839.495n 0.0v 839.505n 0.0v 849.495n 0.0v 849.505n 0.0v 859.495n 0.0v 859.505n 0.0v 869.495n 0.0v 869.505n 0.0v 879.495n 0.0v 879.505n 0.0v 889.495n 0.0v 889.505n 0.0v 899.495n 0.0v 899.505n 0.0v 909.495n 0.0v 909.505n 0.0v 919.495n 0.0v 919.505n 0.0v 929.495n 0.0v 929.505n 0.0v 939.495n 0.0v 939.505n 1.8v 949.495n 1.8v 949.505n 1.8v 959.495n 1.8v 959.505n 1.8v 969.495n 1.8v 969.505n 1.8v 979.495n 1.8v 979.505n 1.8v 989.495n 1.8v 989.505n 1.8v 999.495n 1.8v 999.505n 0.0v 1009.495n 0.0v 1009.505n 0.0v 1019.495n 0.0v 1019.505n 0.0v 1029.495n 0.0v 1029.505n 0.0v 1039.495n 0.0v 1039.505n 0.0v 1049.495n 0.0v 1049.505n 0.0v 1059.495n 0.0v 1059.505n 0.0v 1069.495n 0.0v 1069.505n 0.0v 1079.495n 0.0v 1079.505n 1.8v 1089.495n 1.8v 1089.505n 0.0v 1099.495n 0.0v 1099.505n 0.0v 1109.495n 0.0v 1109.505n 0.0v 1119.495n 0.0v 1119.505n 0.0v 1129.495n 0.0v 1129.505n 0.0v 1139.495n 0.0v 1139.505n 1.8v 1149.495n 1.8v 1149.505n 1.8v 1159.495n 1.8v 1159.505n 1.8v 1169.495n 1.8v 1169.505n 1.8v 1179.495n 1.8v 1179.505n 1.8v 1189.495n 1.8v 1189.505n 1.8v 1199.495n 1.8v 1199.505n 1.8v 1209.495n 1.8v 1209.505n 1.8v 1219.495n 1.8v 1219.505n 1.8v 1229.495n 1.8v 1229.505n 1.8v 1239.495n 1.8v 1239.505n 1.8v 1249.495n 1.8v 1249.505n 1.8v 1259.495n 1.8v 1259.505n 0.0v 1269.495n 0.0v 1269.505n 0.0v 1279.495n 0.0v 1279.505n 0.0v 1289.495n 0.0v 1289.505n 0.0v 1299.495n 0.0v 1299.505n 1.8v 1309.495n 1.8v 1309.505n 0.0v 1319.495n 0.0v 1319.505n 0.0v 1329.495n 0.0v 1329.505n 0.0v 1339.495n 0.0v 1339.505n 0.0v 1349.495n 0.0v 1349.505n 0.0v 1359.495n 0.0v 1359.505n 1.8v 1369.495n 1.8v 1369.505n 1.8v 1379.495n 1.8v 1379.505n 1.8v 1389.495n 1.8v 1389.505n 1.8v 1399.495n 1.8v 1399.505n 1.8v 1409.495n 1.8v 1409.505n 0.0v 1419.495n 0.0v 1419.505n 0.0v 1429.495n 0.0v 1429.505n 0.0v 1439.495n 0.0v 1439.505n 1.8v 1449.495n 1.8v 1449.505n 1.8v 1459.495n 1.8v 1459.505n 0.0v 1469.495n 0.0v 1469.505n 0.0v 1479.495n 0.0v 1479.505n 0.0v 1489.495n 0.0v 1489.505n 1.8v 1499.495n 1.8v 1499.505n 1.8v 1509.495n 1.8v 1509.505n 1.8v 1519.495n 1.8v 1519.505n 1.8v 1529.495n 1.8v 1529.505n 1.8v 1539.495n 1.8v 1539.505n 1.8v 1549.495n 1.8v 1549.505n 0.0v 1559.495n 0.0v 1559.505n 0.0v 1569.495n 0.0v 1569.505n 0.0v 1579.495n 0.0v 1579.505n 1.8v 1589.495n 1.8v 1589.505n 1.8v 1599.495n 1.8v 1599.505n 1.8v 1609.495n 1.8v 1609.505n 1.8v 1619.495n 1.8v 1619.505n 1.8v 1629.495n 1.8v 1629.505n 0.0v 1639.495n 0.0v 1639.505n 0.0v 1649.495n 0.0v 1649.505n 0.0v 1659.495n 0.0v 1659.505n 0.0v 1669.495n 0.0v 1669.505n 0.0v 1679.495n 0.0v 1679.505n 0.0v 1689.495n 0.0v 1689.505n 0.0v 1699.495n 0.0v 1699.505n 0.0v 1709.495n 0.0v 1709.505n 1.8v 1719.495n 1.8v 1719.505n 1.8v 1729.495n 1.8v 1729.505n 1.8v 1739.495n 1.8v 1739.505n 1.8v 1749.495n 1.8v 1749.505n 1.8v 1759.495n 1.8v 1759.505n 1.8v 1769.495n 1.8v 1769.505n 1.8v 1779.495n 1.8v 1779.505n 1.8v 1789.495n 1.8v 1789.505n 1.8v 1799.495n 1.8v 1799.505n 0.0v 1809.495n 0.0v 1809.505n 0.0v 1819.495n 0.0v 1819.505n 0.0v 1829.495n 0.0v 1829.505n 0.0v 1839.495n 0.0v 1839.505n 0.0v 1849.495n 0.0v 1849.505n 0.0v 1859.495n 0.0v 1859.505n 0.0v 1869.495n 0.0v 1869.505n 0.0v 1879.495n 0.0v 1879.505n 0.0v 1889.495n 0.0v 1889.505n 0.0v 1899.495n 0.0v 1899.505n 0.0v 1909.495n 0.0v 1909.505n 1.8v 1919.495n 1.8v 1919.505n 1.8v 1929.495n 1.8v 1929.505n 1.8v 1939.495n 1.8v 1939.505n 1.8v 1949.495n 1.8v 1949.505n 1.8v 1959.495n 1.8v 1959.505n 0.0v 1969.495n 0.0v 1969.505n 0.0v 1979.495n 0.0v 1979.505n 0.0v 1989.495n 0.0v 1989.505n 0.0v 1999.495n 0.0v 1999.505n 0.0v 2009.495n 0.0v 2009.505n 0.0v 2019.495n 0.0v 2019.505n 0.0v 2029.495n 0.0v 2029.505n 1.8v 2039.495n 1.8v 2039.505n 1.8v 2049.495n 1.8v 2049.505n 1.8v )
* (time, data): [(0, 0), (10, 0), (20, 1), (30, 0), (40, 0), (50, 0), (60, 0), (70, 0), (80, 0), (90, 0), (100, 0), (110, 1), (120, 0), (130, 0), (140, 0), (150, 0), (160, 0), (170, 0), (180, 0), (190, 0), (200, 0), (210, 0), (220, 0), (230, 0), (240, 0), (250, 0), (260, 1), (270, 1), (280, 1), (290, 1), (300, 1), (310, 1), (320, 1), (330, 1), (340, 1), (350, 1), (360, 1), (370, 1), (380, 1), (390, 1), (400, 0), (410, 0), (420, 0), (430, 0), (440, 0), (450, 0), (460, 0), (470, 1), (480, 1), (490, 1), (500, 1), (510, 1), (520, 1), (530, 1), (540, 1), (550, 1), (560, 1), (570, 1), (580, 1), (590, 1), (600, 0), (610, 0), (620, 0), (630, 0), (640, 0), (650, 0), (660, 0), (670, 0), (680, 0), (690, 1), (700, 1), (710, 1), (720, 1), (730, 1), (740, 1), (750, 1), (760, 1), (770, 0), (780, 1), (790, 1), (800, 1), (810, 1), (820, 1), (830, 0), (840, 0), (850, 0), (860, 0), (870, 0), (880, 1), (890, 0), (900, 0), (910, 0), (920, 0), (930, 0), (940, 0), (950, 0), (960, 0), (970, 0), (980, 0), (990, 0), (1000, 0), (1010, 0), (1020, 0), (1030, 0), (1040, 0), (1050, 0), (1060, 0), (1070, 0), (1080, 0), (1090, 0), (1100, 0), (1110, 0), (1120, 0), (1130, 0), (1140, 0), (1150, 0), (1160, 0), (1170, 0), (1180, 0), (1190, 0), (1200, 0), (1210, 0), (1220, 0), (1230, 0), (1240, 0), (1250, 0), (1260, 0), (1270, 0), (1280, 0), (1290, 0), (1300, 1), (1310, 0), (1320, 0), (1330, 0), (1340, 0), (1350, 0), (1360, 0), (1370, 0), (1380, 0), (1390, 0), (1400, 0), (1410, 1), (1420, 1), (1430, 1), (1440, 1), (1450, 1), (1460, 1), (1470, 1), (1480, 1), (1490, 1), (1500, 1), (1510, 1), (1520, 1), (1530, 1), (1540, 1), (1550, 0), (1560, 0), (1570, 0), (1580, 1), (1590, 1), (1600, 1), (1610, 1), (1620, 1), (1630, 0), (1640, 0), (1650, 0), (1660, 0), (1670, 0), (1680, 0), (1690, 0), (1700, 1), (1710, 0), (1720, 0), (1730, 0), (1740, 0), (1750, 0), (1760, 0), (1770, 0), (1780, 0), (1790, 0), (1800, 1), (1810, 1), (1820, 1), (1830, 1), (1840, 0), (1850, 0), (1860, 0), (1870, 0), (1880, 0), (1890, 0), (1900, 0), (1910, 1), (1920, 1), (1930, 1), (1940, 1), (1950, 1), (1960, 0), (1970, 0), (1980, 0), (1990, 0), (2000, 0), (2010, 0), (2020, 0), (2030, 0), (2040, 0), (2050, 0)]
Vdin0_29  din0_29  0 PWL (0n 0.0v 9.495n 0.0v 9.505n 0.0v 19.495n 0.0v 19.505n 1.8v 29.495n 1.8v 29.505n 0.0v 39.495n 0.0v 39.505n 0.0v 49.495n 0.0v 49.505n 0.0v 59.495n 0.0v 59.505n 0.0v 69.495n 0.0v 69.505n 0.0v 79.495n 0.0v 79.505n 0.0v 89.495n 0.0v 89.505n 0.0v 99.495n 0.0v 99.505n 0.0v 109.495n 0.0v 109.505n 1.8v 119.495n 1.8v 119.505n 0.0v 129.495n 0.0v 129.505n 0.0v 139.495n 0.0v 139.505n 0.0v 149.495n 0.0v 149.505n 0.0v 159.495n 0.0v 159.505n 0.0v 169.495n 0.0v 169.505n 0.0v 179.495n 0.0v 179.505n 0.0v 189.495n 0.0v 189.505n 0.0v 199.495n 0.0v 199.505n 0.0v 209.495n 0.0v 209.505n 0.0v 219.495n 0.0v 219.505n 0.0v 229.495n 0.0v 229.505n 0.0v 239.495n 0.0v 239.505n 0.0v 249.495n 0.0v 249.505n 0.0v 259.495n 0.0v 259.505n 1.8v 269.495n 1.8v 269.505n 1.8v 279.495n 1.8v 279.505n 1.8v 289.495n 1.8v 289.505n 1.8v 299.495n 1.8v 299.505n 1.8v 309.495n 1.8v 309.505n 1.8v 319.495n 1.8v 319.505n 1.8v 329.495n 1.8v 329.505n 1.8v 339.495n 1.8v 339.505n 1.8v 349.495n 1.8v 349.505n 1.8v 359.495n 1.8v 359.505n 1.8v 369.495n 1.8v 369.505n 1.8v 379.495n 1.8v 379.505n 1.8v 389.495n 1.8v 389.505n 1.8v 399.495n 1.8v 399.505n 0.0v 409.495n 0.0v 409.505n 0.0v 419.495n 0.0v 419.505n 0.0v 429.495n 0.0v 429.505n 0.0v 439.495n 0.0v 439.505n 0.0v 449.495n 0.0v 449.505n 0.0v 459.495n 0.0v 459.505n 0.0v 469.495n 0.0v 469.505n 1.8v 479.495n 1.8v 479.505n 1.8v 489.495n 1.8v 489.505n 1.8v 499.495n 1.8v 499.505n 1.8v 509.495n 1.8v 509.505n 1.8v 519.495n 1.8v 519.505n 1.8v 529.495n 1.8v 529.505n 1.8v 539.495n 1.8v 539.505n 1.8v 549.495n 1.8v 549.505n 1.8v 559.495n 1.8v 559.505n 1.8v 569.495n 1.8v 569.505n 1.8v 579.495n 1.8v 579.505n 1.8v 589.495n 1.8v 589.505n 1.8v 599.495n 1.8v 599.505n 0.0v 609.495n 0.0v 609.505n 0.0v 619.495n 0.0v 619.505n 0.0v 629.495n 0.0v 629.505n 0.0v 639.495n 0.0v 639.505n 0.0v 649.495n 0.0v 649.505n 0.0v 659.495n 0.0v 659.505n 0.0v 669.495n 0.0v 669.505n 0.0v 679.495n 0.0v 679.505n 0.0v 689.495n 0.0v 689.505n 1.8v 699.495n 1.8v 699.505n 1.8v 709.495n 1.8v 709.505n 1.8v 719.495n 1.8v 719.505n 1.8v 729.495n 1.8v 729.505n 1.8v 739.495n 1.8v 739.505n 1.8v 749.495n 1.8v 749.505n 1.8v 759.495n 1.8v 759.505n 1.8v 769.495n 1.8v 769.505n 0.0v 779.495n 0.0v 779.505n 1.8v 789.495n 1.8v 789.505n 1.8v 799.495n 1.8v 799.505n 1.8v 809.495n 1.8v 809.505n 1.8v 819.495n 1.8v 819.505n 1.8v 829.495n 1.8v 829.505n 0.0v 839.495n 0.0v 839.505n 0.0v 849.495n 0.0v 849.505n 0.0v 859.495n 0.0v 859.505n 0.0v 869.495n 0.0v 869.505n 0.0v 879.495n 0.0v 879.505n 1.8v 889.495n 1.8v 889.505n 0.0v 899.495n 0.0v 899.505n 0.0v 909.495n 0.0v 909.505n 0.0v 919.495n 0.0v 919.505n 0.0v 929.495n 0.0v 929.505n 0.0v 939.495n 0.0v 939.505n 0.0v 949.495n 0.0v 949.505n 0.0v 959.495n 0.0v 959.505n 0.0v 969.495n 0.0v 969.505n 0.0v 979.495n 0.0v 979.505n 0.0v 989.495n 0.0v 989.505n 0.0v 999.495n 0.0v 999.505n 0.0v 1009.495n 0.0v 1009.505n 0.0v 1019.495n 0.0v 1019.505n 0.0v 1029.495n 0.0v 1029.505n 0.0v 1039.495n 0.0v 1039.505n 0.0v 1049.495n 0.0v 1049.505n 0.0v 1059.495n 0.0v 1059.505n 0.0v 1069.495n 0.0v 1069.505n 0.0v 1079.495n 0.0v 1079.505n 0.0v 1089.495n 0.0v 1089.505n 0.0v 1099.495n 0.0v 1099.505n 0.0v 1109.495n 0.0v 1109.505n 0.0v 1119.495n 0.0v 1119.505n 0.0v 1129.495n 0.0v 1129.505n 0.0v 1139.495n 0.0v 1139.505n 0.0v 1149.495n 0.0v 1149.505n 0.0v 1159.495n 0.0v 1159.505n 0.0v 1169.495n 0.0v 1169.505n 0.0v 1179.495n 0.0v 1179.505n 0.0v 1189.495n 0.0v 1189.505n 0.0v 1199.495n 0.0v 1199.505n 0.0v 1209.495n 0.0v 1209.505n 0.0v 1219.495n 0.0v 1219.505n 0.0v 1229.495n 0.0v 1229.505n 0.0v 1239.495n 0.0v 1239.505n 0.0v 1249.495n 0.0v 1249.505n 0.0v 1259.495n 0.0v 1259.505n 0.0v 1269.495n 0.0v 1269.505n 0.0v 1279.495n 0.0v 1279.505n 0.0v 1289.495n 0.0v 1289.505n 0.0v 1299.495n 0.0v 1299.505n 1.8v 1309.495n 1.8v 1309.505n 0.0v 1319.495n 0.0v 1319.505n 0.0v 1329.495n 0.0v 1329.505n 0.0v 1339.495n 0.0v 1339.505n 0.0v 1349.495n 0.0v 1349.505n 0.0v 1359.495n 0.0v 1359.505n 0.0v 1369.495n 0.0v 1369.505n 0.0v 1379.495n 0.0v 1379.505n 0.0v 1389.495n 0.0v 1389.505n 0.0v 1399.495n 0.0v 1399.505n 0.0v 1409.495n 0.0v 1409.505n 1.8v 1419.495n 1.8v 1419.505n 1.8v 1429.495n 1.8v 1429.505n 1.8v 1439.495n 1.8v 1439.505n 1.8v 1449.495n 1.8v 1449.505n 1.8v 1459.495n 1.8v 1459.505n 1.8v 1469.495n 1.8v 1469.505n 1.8v 1479.495n 1.8v 1479.505n 1.8v 1489.495n 1.8v 1489.505n 1.8v 1499.495n 1.8v 1499.505n 1.8v 1509.495n 1.8v 1509.505n 1.8v 1519.495n 1.8v 1519.505n 1.8v 1529.495n 1.8v 1529.505n 1.8v 1539.495n 1.8v 1539.505n 1.8v 1549.495n 1.8v 1549.505n 0.0v 1559.495n 0.0v 1559.505n 0.0v 1569.495n 0.0v 1569.505n 0.0v 1579.495n 0.0v 1579.505n 1.8v 1589.495n 1.8v 1589.505n 1.8v 1599.495n 1.8v 1599.505n 1.8v 1609.495n 1.8v 1609.505n 1.8v 1619.495n 1.8v 1619.505n 1.8v 1629.495n 1.8v 1629.505n 0.0v 1639.495n 0.0v 1639.505n 0.0v 1649.495n 0.0v 1649.505n 0.0v 1659.495n 0.0v 1659.505n 0.0v 1669.495n 0.0v 1669.505n 0.0v 1679.495n 0.0v 1679.505n 0.0v 1689.495n 0.0v 1689.505n 0.0v 1699.495n 0.0v 1699.505n 1.8v 1709.495n 1.8v 1709.505n 0.0v 1719.495n 0.0v 1719.505n 0.0v 1729.495n 0.0v 1729.505n 0.0v 1739.495n 0.0v 1739.505n 0.0v 1749.495n 0.0v 1749.505n 0.0v 1759.495n 0.0v 1759.505n 0.0v 1769.495n 0.0v 1769.505n 0.0v 1779.495n 0.0v 1779.505n 0.0v 1789.495n 0.0v 1789.505n 0.0v 1799.495n 0.0v 1799.505n 1.8v 1809.495n 1.8v 1809.505n 1.8v 1819.495n 1.8v 1819.505n 1.8v 1829.495n 1.8v 1829.505n 1.8v 1839.495n 1.8v 1839.505n 0.0v 1849.495n 0.0v 1849.505n 0.0v 1859.495n 0.0v 1859.505n 0.0v 1869.495n 0.0v 1869.505n 0.0v 1879.495n 0.0v 1879.505n 0.0v 1889.495n 0.0v 1889.505n 0.0v 1899.495n 0.0v 1899.505n 0.0v 1909.495n 0.0v 1909.505n 1.8v 1919.495n 1.8v 1919.505n 1.8v 1929.495n 1.8v 1929.505n 1.8v 1939.495n 1.8v 1939.505n 1.8v 1949.495n 1.8v 1949.505n 1.8v 1959.495n 1.8v 1959.505n 0.0v 1969.495n 0.0v 1969.505n 0.0v 1979.495n 0.0v 1979.505n 0.0v 1989.495n 0.0v 1989.505n 0.0v 1999.495n 0.0v 1999.505n 0.0v 2009.495n 0.0v 2009.505n 0.0v 2019.495n 0.0v 2019.505n 0.0v 2029.495n 0.0v 2029.505n 0.0v 2039.495n 0.0v 2039.505n 0.0v 2049.495n 0.0v 2049.505n 0.0v )
* (time, data): [(0, 0), (10, 0), (20, 0), (30, 0), (40, 0), (50, 0), (60, 0), (70, 0), (80, 1), (90, 1), (100, 1), (110, 0), (120, 1), (130, 1), (140, 1), (150, 1), (160, 1), (170, 1), (180, 1), (190, 1), (200, 1), (210, 1), (220, 1), (230, 1), (240, 1), (250, 1), (260, 1), (270, 1), (280, 1), (290, 1), (300, 1), (310, 1), (320, 1), (330, 1), (340, 1), (350, 1), (360, 1), (370, 1), (380, 1), (390, 1), (400, 0), (410, 0), (420, 0), (430, 0), (440, 0), (450, 1), (460, 1), (470, 0), (480, 0), (490, 0), (500, 0), (510, 0), (520, 0), (530, 0), (540, 1), (550, 1), (560, 1), (570, 1), (580, 1), (590, 0), (600, 0), (610, 0), (620, 0), (630, 1), (640, 1), (650, 1), (660, 0), (670, 0), (680, 0), (690, 0), (700, 1), (710, 1), (720, 1), (730, 1), (740, 1), (750, 1), (760, 1), (770, 0), (780, 1), (790, 1), (800, 1), (810, 1), (820, 1), (830, 0), (840, 0), (850, 0), (860, 0), (870, 0), (880, 1), (890, 0), (900, 0), (910, 0), (920, 0), (930, 0), (940, 0), (950, 0), (960, 0), (970, 0), (980, 0), (990, 0), (1000, 1), (1010, 1), (1020, 1), (1030, 1), (1040, 1), (1050, 1), (1060, 1), (1070, 1), (1080, 0), (1090, 0), (1100, 0), (1110, 0), (1120, 0), (1130, 0), (1140, 1), (1150, 1), (1160, 1), (1170, 1), (1180, 1), (1190, 1), (1200, 1), (1210, 1), (1220, 1), (1230, 1), (1240, 1), (1250, 1), (1260, 1), (1270, 1), (1280, 1), (1290, 1), (1300, 0), (1310, 1), (1320, 1), (1330, 1), (1340, 1), (1350, 1), (1360, 0), (1370, 0), (1380, 0), (1390, 0), (1400, 0), (1410, 0), (1420, 0), (1430, 1), (1440, 1), (1450, 1), (1460, 1), (1470, 1), (1480, 1), (1490, 1), (1500, 1), (1510, 1), (1520, 1), (1530, 1), (1540, 1), (1550, 1), (1560, 1), (1570, 1), (1580, 0), (1590, 0), (1600, 0), (1610, 0), (1620, 0), (1630, 0), (1640, 0), (1650, 0), (1660, 0), (1670, 0), (1680, 0), (1690, 0), (1700, 0), (1710, 0), (1720, 0), (1730, 1), (1740, 1), (1750, 1), (1760, 1), (1770, 1), (1780, 1), (1790, 1), (1800, 1), (1810, 1), (1820, 1), (1830, 1), (1840, 0), (1850, 0), (1860, 1), (1870, 1), (1880, 1), (1890, 1), (1900, 1), (1910, 0), (1920, 0), (1930, 0), (1940, 0), (1950, 0), (1960, 0), (1970, 0), (1980, 0), (1990, 0), (2000, 0), (2010, 0), (2020, 0), (2030, 1), (2040, 1), (2050, 1)]
Vdin0_30  din0_30  0 PWL (0n 0.0v 9.495n 0.0v 9.505n 0.0v 19.495n 0.0v 19.505n 0.0v 29.495n 0.0v 29.505n 0.0v 39.495n 0.0v 39.505n 0.0v 49.495n 0.0v 49.505n 0.0v 59.495n 0.0v 59.505n 0.0v 69.495n 0.0v 69.505n 0.0v 79.495n 0.0v 79.505n 1.8v 89.495n 1.8v 89.505n 1.8v 99.495n 1.8v 99.505n 1.8v 109.495n 1.8v 109.505n 0.0v 119.495n 0.0v 119.505n 1.8v 129.495n 1.8v 129.505n 1.8v 139.495n 1.8v 139.505n 1.8v 149.495n 1.8v 149.505n 1.8v 159.495n 1.8v 159.505n 1.8v 169.495n 1.8v 169.505n 1.8v 179.495n 1.8v 179.505n 1.8v 189.495n 1.8v 189.505n 1.8v 199.495n 1.8v 199.505n 1.8v 209.495n 1.8v 209.505n 1.8v 219.495n 1.8v 219.505n 1.8v 229.495n 1.8v 229.505n 1.8v 239.495n 1.8v 239.505n 1.8v 249.495n 1.8v 249.505n 1.8v 259.495n 1.8v 259.505n 1.8v 269.495n 1.8v 269.505n 1.8v 279.495n 1.8v 279.505n 1.8v 289.495n 1.8v 289.505n 1.8v 299.495n 1.8v 299.505n 1.8v 309.495n 1.8v 309.505n 1.8v 319.495n 1.8v 319.505n 1.8v 329.495n 1.8v 329.505n 1.8v 339.495n 1.8v 339.505n 1.8v 349.495n 1.8v 349.505n 1.8v 359.495n 1.8v 359.505n 1.8v 369.495n 1.8v 369.505n 1.8v 379.495n 1.8v 379.505n 1.8v 389.495n 1.8v 389.505n 1.8v 399.495n 1.8v 399.505n 0.0v 409.495n 0.0v 409.505n 0.0v 419.495n 0.0v 419.505n 0.0v 429.495n 0.0v 429.505n 0.0v 439.495n 0.0v 439.505n 0.0v 449.495n 0.0v 449.505n 1.8v 459.495n 1.8v 459.505n 1.8v 469.495n 1.8v 469.505n 0.0v 479.495n 0.0v 479.505n 0.0v 489.495n 0.0v 489.505n 0.0v 499.495n 0.0v 499.505n 0.0v 509.495n 0.0v 509.505n 0.0v 519.495n 0.0v 519.505n 0.0v 529.495n 0.0v 529.505n 0.0v 539.495n 0.0v 539.505n 1.8v 549.495n 1.8v 549.505n 1.8v 559.495n 1.8v 559.505n 1.8v 569.495n 1.8v 569.505n 1.8v 579.495n 1.8v 579.505n 1.8v 589.495n 1.8v 589.505n 0.0v 599.495n 0.0v 599.505n 0.0v 609.495n 0.0v 609.505n 0.0v 619.495n 0.0v 619.505n 0.0v 629.495n 0.0v 629.505n 1.8v 639.495n 1.8v 639.505n 1.8v 649.495n 1.8v 649.505n 1.8v 659.495n 1.8v 659.505n 0.0v 669.495n 0.0v 669.505n 0.0v 679.495n 0.0v 679.505n 0.0v 689.495n 0.0v 689.505n 0.0v 699.495n 0.0v 699.505n 1.8v 709.495n 1.8v 709.505n 1.8v 719.495n 1.8v 719.505n 1.8v 729.495n 1.8v 729.505n 1.8v 739.495n 1.8v 739.505n 1.8v 749.495n 1.8v 749.505n 1.8v 759.495n 1.8v 759.505n 1.8v 769.495n 1.8v 769.505n 0.0v 779.495n 0.0v 779.505n 1.8v 789.495n 1.8v 789.505n 1.8v 799.495n 1.8v 799.505n 1.8v 809.495n 1.8v 809.505n 1.8v 819.495n 1.8v 819.505n 1.8v 829.495n 1.8v 829.505n 0.0v 839.495n 0.0v 839.505n 0.0v 849.495n 0.0v 849.505n 0.0v 859.495n 0.0v 859.505n 0.0v 869.495n 0.0v 869.505n 0.0v 879.495n 0.0v 879.505n 1.8v 889.495n 1.8v 889.505n 0.0v 899.495n 0.0v 899.505n 0.0v 909.495n 0.0v 909.505n 0.0v 919.495n 0.0v 919.505n 0.0v 929.495n 0.0v 929.505n 0.0v 939.495n 0.0v 939.505n 0.0v 949.495n 0.0v 949.505n 0.0v 959.495n 0.0v 959.505n 0.0v 969.495n 0.0v 969.505n 0.0v 979.495n 0.0v 979.505n 0.0v 989.495n 0.0v 989.505n 0.0v 999.495n 0.0v 999.505n 1.8v 1009.495n 1.8v 1009.505n 1.8v 1019.495n 1.8v 1019.505n 1.8v 1029.495n 1.8v 1029.505n 1.8v 1039.495n 1.8v 1039.505n 1.8v 1049.495n 1.8v 1049.505n 1.8v 1059.495n 1.8v 1059.505n 1.8v 1069.495n 1.8v 1069.505n 1.8v 1079.495n 1.8v 1079.505n 0.0v 1089.495n 0.0v 1089.505n 0.0v 1099.495n 0.0v 1099.505n 0.0v 1109.495n 0.0v 1109.505n 0.0v 1119.495n 0.0v 1119.505n 0.0v 1129.495n 0.0v 1129.505n 0.0v 1139.495n 0.0v 1139.505n 1.8v 1149.495n 1.8v 1149.505n 1.8v 1159.495n 1.8v 1159.505n 1.8v 1169.495n 1.8v 1169.505n 1.8v 1179.495n 1.8v 1179.505n 1.8v 1189.495n 1.8v 1189.505n 1.8v 1199.495n 1.8v 1199.505n 1.8v 1209.495n 1.8v 1209.505n 1.8v 1219.495n 1.8v 1219.505n 1.8v 1229.495n 1.8v 1229.505n 1.8v 1239.495n 1.8v 1239.505n 1.8v 1249.495n 1.8v 1249.505n 1.8v 1259.495n 1.8v 1259.505n 1.8v 1269.495n 1.8v 1269.505n 1.8v 1279.495n 1.8v 1279.505n 1.8v 1289.495n 1.8v 1289.505n 1.8v 1299.495n 1.8v 1299.505n 0.0v 1309.495n 0.0v 1309.505n 1.8v 1319.495n 1.8v 1319.505n 1.8v 1329.495n 1.8v 1329.505n 1.8v 1339.495n 1.8v 1339.505n 1.8v 1349.495n 1.8v 1349.505n 1.8v 1359.495n 1.8v 1359.505n 0.0v 1369.495n 0.0v 1369.505n 0.0v 1379.495n 0.0v 1379.505n 0.0v 1389.495n 0.0v 1389.505n 0.0v 1399.495n 0.0v 1399.505n 0.0v 1409.495n 0.0v 1409.505n 0.0v 1419.495n 0.0v 1419.505n 0.0v 1429.495n 0.0v 1429.505n 1.8v 1439.495n 1.8v 1439.505n 1.8v 1449.495n 1.8v 1449.505n 1.8v 1459.495n 1.8v 1459.505n 1.8v 1469.495n 1.8v 1469.505n 1.8v 1479.495n 1.8v 1479.505n 1.8v 1489.495n 1.8v 1489.505n 1.8v 1499.495n 1.8v 1499.505n 1.8v 1509.495n 1.8v 1509.505n 1.8v 1519.495n 1.8v 1519.505n 1.8v 1529.495n 1.8v 1529.505n 1.8v 1539.495n 1.8v 1539.505n 1.8v 1549.495n 1.8v 1549.505n 1.8v 1559.495n 1.8v 1559.505n 1.8v 1569.495n 1.8v 1569.505n 1.8v 1579.495n 1.8v 1579.505n 0.0v 1589.495n 0.0v 1589.505n 0.0v 1599.495n 0.0v 1599.505n 0.0v 1609.495n 0.0v 1609.505n 0.0v 1619.495n 0.0v 1619.505n 0.0v 1629.495n 0.0v 1629.505n 0.0v 1639.495n 0.0v 1639.505n 0.0v 1649.495n 0.0v 1649.505n 0.0v 1659.495n 0.0v 1659.505n 0.0v 1669.495n 0.0v 1669.505n 0.0v 1679.495n 0.0v 1679.505n 0.0v 1689.495n 0.0v 1689.505n 0.0v 1699.495n 0.0v 1699.505n 0.0v 1709.495n 0.0v 1709.505n 0.0v 1719.495n 0.0v 1719.505n 0.0v 1729.495n 0.0v 1729.505n 1.8v 1739.495n 1.8v 1739.505n 1.8v 1749.495n 1.8v 1749.505n 1.8v 1759.495n 1.8v 1759.505n 1.8v 1769.495n 1.8v 1769.505n 1.8v 1779.495n 1.8v 1779.505n 1.8v 1789.495n 1.8v 1789.505n 1.8v 1799.495n 1.8v 1799.505n 1.8v 1809.495n 1.8v 1809.505n 1.8v 1819.495n 1.8v 1819.505n 1.8v 1829.495n 1.8v 1829.505n 1.8v 1839.495n 1.8v 1839.505n 0.0v 1849.495n 0.0v 1849.505n 0.0v 1859.495n 0.0v 1859.505n 1.8v 1869.495n 1.8v 1869.505n 1.8v 1879.495n 1.8v 1879.505n 1.8v 1889.495n 1.8v 1889.505n 1.8v 1899.495n 1.8v 1899.505n 1.8v 1909.495n 1.8v 1909.505n 0.0v 1919.495n 0.0v 1919.505n 0.0v 1929.495n 0.0v 1929.505n 0.0v 1939.495n 0.0v 1939.505n 0.0v 1949.495n 0.0v 1949.505n 0.0v 1959.495n 0.0v 1959.505n 0.0v 1969.495n 0.0v 1969.505n 0.0v 1979.495n 0.0v 1979.505n 0.0v 1989.495n 0.0v 1989.505n 0.0v 1999.495n 0.0v 1999.505n 0.0v 2009.495n 0.0v 2009.505n 0.0v 2019.495n 0.0v 2019.505n 0.0v 2029.495n 0.0v 2029.505n 1.8v 2039.495n 1.8v 2039.505n 1.8v 2049.495n 1.8v 2049.505n 1.8v )
* (time, data): [(0, 0), (10, 1), (20, 0), (30, 0), (40, 0), (50, 0), (60, 0), (70, 0), (80, 0), (90, 0), (100, 0), (110, 0), (120, 0), (130, 0), (140, 0), (150, 0), (160, 0), (170, 0), (180, 0), (190, 0), (200, 0), (210, 0), (220, 0), (230, 0), (240, 0), (250, 0), (260, 0), (270, 0), (280, 1), (290, 1), (300, 1), (310, 1), (320, 1), (330, 1), (340, 1), (350, 1), (360, 1), (370, 1), (380, 1), (390, 1), (400, 1), (410, 1), (420, 1), (430, 1), (440, 1), (450, 0), (460, 0), (470, 1), (480, 1), (490, 1), (500, 1), (510, 1), (520, 1), (530, 1), (540, 0), (550, 0), (560, 0), (570, 0), (580, 0), (590, 1), (600, 1), (610, 1), (620, 1), (630, 0), (640, 0), (650, 0), (660, 0), (670, 0), (680, 0), (690, 0), (700, 0), (710, 0), (720, 0), (730, 0), (740, 0), (750, 0), (760, 0), (770, 1), (780, 1), (790, 1), (800, 1), (810, 1), (820, 1), (830, 0), (840, 0), (850, 0), (860, 0), (870, 0), (880, 1), (890, 1), (900, 1), (910, 1), (920, 1), (930, 1), (940, 1), (950, 1), (960, 1), (970, 1), (980, 1), (990, 1), (1000, 1), (1010, 1), (1020, 1), (1030, 1), (1040, 1), (1050, 1), (1060, 1), (1070, 1), (1080, 0), (1090, 1), (1100, 1), (1110, 1), (1120, 1), (1130, 1), (1140, 0), (1150, 0), (1160, 0), (1170, 0), (1180, 0), (1190, 0), (1200, 0), (1210, 0), (1220, 0), (1230, 0), (1240, 0), (1250, 0), (1260, 0), (1270, 0), (1280, 0), (1290, 0), (1300, 0), (1310, 1), (1320, 1), (1330, 1), (1340, 1), (1350, 1), (1360, 0), (1370, 0), (1380, 0), (1390, 0), (1400, 0), (1410, 0), (1420, 0), (1430, 1), (1440, 1), (1450, 1), (1460, 0), (1470, 1), (1480, 1), (1490, 1), (1500, 1), (1510, 1), (1520, 1), (1530, 1), (1540, 1), (1550, 0), (1560, 0), (1570, 0), (1580, 0), (1590, 1), (1600, 1), (1610, 1), (1620, 1), (1630, 1), (1640, 1), (1650, 1), (1660, 1), (1670, 1), (1680, 1), (1690, 1), (1700, 1), (1710, 1), (1720, 1), (1730, 1), (1740, 1), (1750, 1), (1760, 1), (1770, 1), (1780, 1), (1790, 1), (1800, 1), (1810, 1), (1820, 1), (1830, 1), (1840, 0), (1850, 0), (1860, 1), (1870, 1), (1880, 1), (1890, 1), (1900, 1), (1910, 1), (1920, 1), (1930, 1), (1940, 1), (1950, 1), (1960, 1), (1970, 1), (1980, 1), (1990, 1), (2000, 1), (2010, 1), (2020, 1), (2030, 1), (2040, 1), (2050, 1)]
Vdin0_31  din0_31  0 PWL (0n 0.0v 9.495n 0.0v 9.505n 1.8v 19.495n 1.8v 19.505n 0.0v 29.495n 0.0v 29.505n 0.0v 39.495n 0.0v 39.505n 0.0v 49.495n 0.0v 49.505n 0.0v 59.495n 0.0v 59.505n 0.0v 69.495n 0.0v 69.505n 0.0v 79.495n 0.0v 79.505n 0.0v 89.495n 0.0v 89.505n 0.0v 99.495n 0.0v 99.505n 0.0v 109.495n 0.0v 109.505n 0.0v 119.495n 0.0v 119.505n 0.0v 129.495n 0.0v 129.505n 0.0v 139.495n 0.0v 139.505n 0.0v 149.495n 0.0v 149.505n 0.0v 159.495n 0.0v 159.505n 0.0v 169.495n 0.0v 169.505n 0.0v 179.495n 0.0v 179.505n 0.0v 189.495n 0.0v 189.505n 0.0v 199.495n 0.0v 199.505n 0.0v 209.495n 0.0v 209.505n 0.0v 219.495n 0.0v 219.505n 0.0v 229.495n 0.0v 229.505n 0.0v 239.495n 0.0v 239.505n 0.0v 249.495n 0.0v 249.505n 0.0v 259.495n 0.0v 259.505n 0.0v 269.495n 0.0v 269.505n 0.0v 279.495n 0.0v 279.505n 1.8v 289.495n 1.8v 289.505n 1.8v 299.495n 1.8v 299.505n 1.8v 309.495n 1.8v 309.505n 1.8v 319.495n 1.8v 319.505n 1.8v 329.495n 1.8v 329.505n 1.8v 339.495n 1.8v 339.505n 1.8v 349.495n 1.8v 349.505n 1.8v 359.495n 1.8v 359.505n 1.8v 369.495n 1.8v 369.505n 1.8v 379.495n 1.8v 379.505n 1.8v 389.495n 1.8v 389.505n 1.8v 399.495n 1.8v 399.505n 1.8v 409.495n 1.8v 409.505n 1.8v 419.495n 1.8v 419.505n 1.8v 429.495n 1.8v 429.505n 1.8v 439.495n 1.8v 439.505n 1.8v 449.495n 1.8v 449.505n 0.0v 459.495n 0.0v 459.505n 0.0v 469.495n 0.0v 469.505n 1.8v 479.495n 1.8v 479.505n 1.8v 489.495n 1.8v 489.505n 1.8v 499.495n 1.8v 499.505n 1.8v 509.495n 1.8v 509.505n 1.8v 519.495n 1.8v 519.505n 1.8v 529.495n 1.8v 529.505n 1.8v 539.495n 1.8v 539.505n 0.0v 549.495n 0.0v 549.505n 0.0v 559.495n 0.0v 559.505n 0.0v 569.495n 0.0v 569.505n 0.0v 579.495n 0.0v 579.505n 0.0v 589.495n 0.0v 589.505n 1.8v 599.495n 1.8v 599.505n 1.8v 609.495n 1.8v 609.505n 1.8v 619.495n 1.8v 619.505n 1.8v 629.495n 1.8v 629.505n 0.0v 639.495n 0.0v 639.505n 0.0v 649.495n 0.0v 649.505n 0.0v 659.495n 0.0v 659.505n 0.0v 669.495n 0.0v 669.505n 0.0v 679.495n 0.0v 679.505n 0.0v 689.495n 0.0v 689.505n 0.0v 699.495n 0.0v 699.505n 0.0v 709.495n 0.0v 709.505n 0.0v 719.495n 0.0v 719.505n 0.0v 729.495n 0.0v 729.505n 0.0v 739.495n 0.0v 739.505n 0.0v 749.495n 0.0v 749.505n 0.0v 759.495n 0.0v 759.505n 0.0v 769.495n 0.0v 769.505n 1.8v 779.495n 1.8v 779.505n 1.8v 789.495n 1.8v 789.505n 1.8v 799.495n 1.8v 799.505n 1.8v 809.495n 1.8v 809.505n 1.8v 819.495n 1.8v 819.505n 1.8v 829.495n 1.8v 829.505n 0.0v 839.495n 0.0v 839.505n 0.0v 849.495n 0.0v 849.505n 0.0v 859.495n 0.0v 859.505n 0.0v 869.495n 0.0v 869.505n 0.0v 879.495n 0.0v 879.505n 1.8v 889.495n 1.8v 889.505n 1.8v 899.495n 1.8v 899.505n 1.8v 909.495n 1.8v 909.505n 1.8v 919.495n 1.8v 919.505n 1.8v 929.495n 1.8v 929.505n 1.8v 939.495n 1.8v 939.505n 1.8v 949.495n 1.8v 949.505n 1.8v 959.495n 1.8v 959.505n 1.8v 969.495n 1.8v 969.505n 1.8v 979.495n 1.8v 979.505n 1.8v 989.495n 1.8v 989.505n 1.8v 999.495n 1.8v 999.505n 1.8v 1009.495n 1.8v 1009.505n 1.8v 1019.495n 1.8v 1019.505n 1.8v 1029.495n 1.8v 1029.505n 1.8v 1039.495n 1.8v 1039.505n 1.8v 1049.495n 1.8v 1049.505n 1.8v 1059.495n 1.8v 1059.505n 1.8v 1069.495n 1.8v 1069.505n 1.8v 1079.495n 1.8v 1079.505n 0.0v 1089.495n 0.0v 1089.505n 1.8v 1099.495n 1.8v 1099.505n 1.8v 1109.495n 1.8v 1109.505n 1.8v 1119.495n 1.8v 1119.505n 1.8v 1129.495n 1.8v 1129.505n 1.8v 1139.495n 1.8v 1139.505n 0.0v 1149.495n 0.0v 1149.505n 0.0v 1159.495n 0.0v 1159.505n 0.0v 1169.495n 0.0v 1169.505n 0.0v 1179.495n 0.0v 1179.505n 0.0v 1189.495n 0.0v 1189.505n 0.0v 1199.495n 0.0v 1199.505n 0.0v 1209.495n 0.0v 1209.505n 0.0v 1219.495n 0.0v 1219.505n 0.0v 1229.495n 0.0v 1229.505n 0.0v 1239.495n 0.0v 1239.505n 0.0v 1249.495n 0.0v 1249.505n 0.0v 1259.495n 0.0v 1259.505n 0.0v 1269.495n 0.0v 1269.505n 0.0v 1279.495n 0.0v 1279.505n 0.0v 1289.495n 0.0v 1289.505n 0.0v 1299.495n 0.0v 1299.505n 0.0v 1309.495n 0.0v 1309.505n 1.8v 1319.495n 1.8v 1319.505n 1.8v 1329.495n 1.8v 1329.505n 1.8v 1339.495n 1.8v 1339.505n 1.8v 1349.495n 1.8v 1349.505n 1.8v 1359.495n 1.8v 1359.505n 0.0v 1369.495n 0.0v 1369.505n 0.0v 1379.495n 0.0v 1379.505n 0.0v 1389.495n 0.0v 1389.505n 0.0v 1399.495n 0.0v 1399.505n 0.0v 1409.495n 0.0v 1409.505n 0.0v 1419.495n 0.0v 1419.505n 0.0v 1429.495n 0.0v 1429.505n 1.8v 1439.495n 1.8v 1439.505n 1.8v 1449.495n 1.8v 1449.505n 1.8v 1459.495n 1.8v 1459.505n 0.0v 1469.495n 0.0v 1469.505n 1.8v 1479.495n 1.8v 1479.505n 1.8v 1489.495n 1.8v 1489.505n 1.8v 1499.495n 1.8v 1499.505n 1.8v 1509.495n 1.8v 1509.505n 1.8v 1519.495n 1.8v 1519.505n 1.8v 1529.495n 1.8v 1529.505n 1.8v 1539.495n 1.8v 1539.505n 1.8v 1549.495n 1.8v 1549.505n 0.0v 1559.495n 0.0v 1559.505n 0.0v 1569.495n 0.0v 1569.505n 0.0v 1579.495n 0.0v 1579.505n 0.0v 1589.495n 0.0v 1589.505n 1.8v 1599.495n 1.8v 1599.505n 1.8v 1609.495n 1.8v 1609.505n 1.8v 1619.495n 1.8v 1619.505n 1.8v 1629.495n 1.8v 1629.505n 1.8v 1639.495n 1.8v 1639.505n 1.8v 1649.495n 1.8v 1649.505n 1.8v 1659.495n 1.8v 1659.505n 1.8v 1669.495n 1.8v 1669.505n 1.8v 1679.495n 1.8v 1679.505n 1.8v 1689.495n 1.8v 1689.505n 1.8v 1699.495n 1.8v 1699.505n 1.8v 1709.495n 1.8v 1709.505n 1.8v 1719.495n 1.8v 1719.505n 1.8v 1729.495n 1.8v 1729.505n 1.8v 1739.495n 1.8v 1739.505n 1.8v 1749.495n 1.8v 1749.505n 1.8v 1759.495n 1.8v 1759.505n 1.8v 1769.495n 1.8v 1769.505n 1.8v 1779.495n 1.8v 1779.505n 1.8v 1789.495n 1.8v 1789.505n 1.8v 1799.495n 1.8v 1799.505n 1.8v 1809.495n 1.8v 1809.505n 1.8v 1819.495n 1.8v 1819.505n 1.8v 1829.495n 1.8v 1829.505n 1.8v 1839.495n 1.8v 1839.505n 0.0v 1849.495n 0.0v 1849.505n 0.0v 1859.495n 0.0v 1859.505n 1.8v 1869.495n 1.8v 1869.505n 1.8v 1879.495n 1.8v 1879.505n 1.8v 1889.495n 1.8v 1889.505n 1.8v 1899.495n 1.8v 1899.505n 1.8v 1909.495n 1.8v 1909.505n 1.8v 1919.495n 1.8v 1919.505n 1.8v 1929.495n 1.8v 1929.505n 1.8v 1939.495n 1.8v 1939.505n 1.8v 1949.495n 1.8v 1949.505n 1.8v 1959.495n 1.8v 1959.505n 1.8v 1969.495n 1.8v 1969.505n 1.8v 1979.495n 1.8v 1979.505n 1.8v 1989.495n 1.8v 1989.505n 1.8v 1999.495n 1.8v 1999.505n 1.8v 2009.495n 1.8v 2009.505n 1.8v 2019.495n 1.8v 2019.505n 1.8v 2029.495n 1.8v 2029.505n 1.8v 2039.495n 1.8v 2039.505n 1.8v 2049.495n 1.8v 2049.505n 1.8v )
* (time, data): [(0, 0), (10, 0), (20, 0), (30, 0), (40, 0), (50, 0), (60, 0), (70, 0), (80, 0), (90, 0), (100, 0), (110, 0), (120, 0), (130, 0), (140, 0), (150, 0), (160, 0), (170, 0), (180, 0), (190, 0), (200, 0), (210, 0), (220, 0), (230, 0), (240, 0), (250, 0), (260, 0), (270, 0), (280, 0), (290, 0), (300, 0), (310, 0), (320, 0), (330, 0), (340, 0), (350, 0), (360, 0), (370, 0), (380, 0), (390, 0), (400, 0), (410, 0), (420, 0), (430, 0), (440, 0), (450, 0), (460, 0), (470, 0), (480, 0), (490, 0), (500, 0), (510, 0), (520, 0), (530, 0), (540, 0), (550, 0), (560, 0), (570, 0), (580, 0), (590, 0), (600, 0), (610, 0), (620, 0), (630, 0), (640, 0), (650, 0), (660, 0), (670, 0), (680, 0), (690, 0), (700, 0), (710, 0), (720, 0), (730, 0), (740, 0), (750, 0), (760, 0), (770, 0), (780, 0), (790, 0), (800, 0), (810, 0), (820, 0), (830, 0), (840, 0), (850, 0), (860, 0), (870, 0), (880, 0), (890, 0), (900, 0), (910, 0), (920, 0), (930, 0), (940, 0), (950, 0), (960, 0), (970, 0), (980, 0), (990, 0), (1000, 0), (1010, 0), (1020, 0), (1030, 0), (1040, 0), (1050, 0), (1060, 0), (1070, 0), (1080, 0), (1090, 0), (1100, 0), (1110, 0), (1120, 0), (1130, 0), (1140, 0), (1150, 0), (1160, 0), (1170, 0), (1180, 0), (1190, 0), (1200, 0), (1210, 0), (1220, 0), (1230, 0), (1240, 0), (1250, 0), (1260, 0), (1270, 0), (1280, 0), (1290, 0), (1300, 0), (1310, 0), (1320, 0), (1330, 0), (1340, 0), (1350, 0), (1360, 0), (1370, 0), (1380, 0), (1390, 0), (1400, 0), (1410, 0), (1420, 0), (1430, 0), (1440, 0), (1450, 0), (1460, 0), (1470, 0), (1480, 0), (1490, 0), (1500, 0), (1510, 0), (1520, 0), (1530, 0), (1540, 0), (1550, 0), (1560, 0), (1570, 0), (1580, 0), (1590, 0), (1600, 0), (1610, 0), (1620, 0), (1630, 0), (1640, 0), (1650, 0), (1660, 0), (1670, 0), (1680, 0), (1690, 0), (1700, 0), (1710, 0), (1720, 0), (1730, 0), (1740, 0), (1750, 0), (1760, 0), (1770, 0), (1780, 0), (1790, 0), (1800, 0), (1810, 0), (1820, 0), (1830, 0), (1840, 0), (1850, 0), (1860, 0), (1870, 0), (1880, 0), (1890, 0), (1900, 0), (1910, 0), (1920, 0), (1930, 0), (1940, 0), (1950, 0), (1960, 0), (1970, 0), (1980, 0), (1990, 0), (2000, 0), (2010, 0), (2020, 0), (2030, 0), (2040, 0), (2050, 0)]
Vdin0_32  din0_32  0 PWL (0n 0.0v 9.495n 0.0v 9.505n 0.0v 19.495n 0.0v 19.505n 0.0v 29.495n 0.0v 29.505n 0.0v 39.495n 0.0v 39.505n 0.0v 49.495n 0.0v 49.505n 0.0v 59.495n 0.0v 59.505n 0.0v 69.495n 0.0v 69.505n 0.0v 79.495n 0.0v 79.505n 0.0v 89.495n 0.0v 89.505n 0.0v 99.495n 0.0v 99.505n 0.0v 109.495n 0.0v 109.505n 0.0v 119.495n 0.0v 119.505n 0.0v 129.495n 0.0v 129.505n 0.0v 139.495n 0.0v 139.505n 0.0v 149.495n 0.0v 149.505n 0.0v 159.495n 0.0v 159.505n 0.0v 169.495n 0.0v 169.505n 0.0v 179.495n 0.0v 179.505n 0.0v 189.495n 0.0v 189.505n 0.0v 199.495n 0.0v 199.505n 0.0v 209.495n 0.0v 209.505n 0.0v 219.495n 0.0v 219.505n 0.0v 229.495n 0.0v 229.505n 0.0v 239.495n 0.0v 239.505n 0.0v 249.495n 0.0v 249.505n 0.0v 259.495n 0.0v 259.505n 0.0v 269.495n 0.0v 269.505n 0.0v 279.495n 0.0v 279.505n 0.0v 289.495n 0.0v 289.505n 0.0v 299.495n 0.0v 299.505n 0.0v 309.495n 0.0v 309.505n 0.0v 319.495n 0.0v 319.505n 0.0v 329.495n 0.0v 329.505n 0.0v 339.495n 0.0v 339.505n 0.0v 349.495n 0.0v 349.505n 0.0v 359.495n 0.0v 359.505n 0.0v 369.495n 0.0v 369.505n 0.0v 379.495n 0.0v 379.505n 0.0v 389.495n 0.0v 389.505n 0.0v 399.495n 0.0v 399.505n 0.0v 409.495n 0.0v 409.505n 0.0v 419.495n 0.0v 419.505n 0.0v 429.495n 0.0v 429.505n 0.0v 439.495n 0.0v 439.505n 0.0v 449.495n 0.0v 449.505n 0.0v 459.495n 0.0v 459.505n 0.0v 469.495n 0.0v 469.505n 0.0v 479.495n 0.0v 479.505n 0.0v 489.495n 0.0v 489.505n 0.0v 499.495n 0.0v 499.505n 0.0v 509.495n 0.0v 509.505n 0.0v 519.495n 0.0v 519.505n 0.0v 529.495n 0.0v 529.505n 0.0v 539.495n 0.0v 539.505n 0.0v 549.495n 0.0v 549.505n 0.0v 559.495n 0.0v 559.505n 0.0v 569.495n 0.0v 569.505n 0.0v 579.495n 0.0v 579.505n 0.0v 589.495n 0.0v 589.505n 0.0v 599.495n 0.0v 599.505n 0.0v 609.495n 0.0v 609.505n 0.0v 619.495n 0.0v 619.505n 0.0v 629.495n 0.0v 629.505n 0.0v 639.495n 0.0v 639.505n 0.0v 649.495n 0.0v 649.505n 0.0v 659.495n 0.0v 659.505n 0.0v 669.495n 0.0v 669.505n 0.0v 679.495n 0.0v 679.505n 0.0v 689.495n 0.0v 689.505n 0.0v 699.495n 0.0v 699.505n 0.0v 709.495n 0.0v 709.505n 0.0v 719.495n 0.0v 719.505n 0.0v 729.495n 0.0v 729.505n 0.0v 739.495n 0.0v 739.505n 0.0v 749.495n 0.0v 749.505n 0.0v 759.495n 0.0v 759.505n 0.0v 769.495n 0.0v 769.505n 0.0v 779.495n 0.0v 779.505n 0.0v 789.495n 0.0v 789.505n 0.0v 799.495n 0.0v 799.505n 0.0v 809.495n 0.0v 809.505n 0.0v 819.495n 0.0v 819.505n 0.0v 829.495n 0.0v 829.505n 0.0v 839.495n 0.0v 839.505n 0.0v 849.495n 0.0v 849.505n 0.0v 859.495n 0.0v 859.505n 0.0v 869.495n 0.0v 869.505n 0.0v 879.495n 0.0v 879.505n 0.0v 889.495n 0.0v 889.505n 0.0v 899.495n 0.0v 899.505n 0.0v 909.495n 0.0v 909.505n 0.0v 919.495n 0.0v 919.505n 0.0v 929.495n 0.0v 929.505n 0.0v 939.495n 0.0v 939.505n 0.0v 949.495n 0.0v 949.505n 0.0v 959.495n 0.0v 959.505n 0.0v 969.495n 0.0v 969.505n 0.0v 979.495n 0.0v 979.505n 0.0v 989.495n 0.0v 989.505n 0.0v 999.495n 0.0v 999.505n 0.0v 1009.495n 0.0v 1009.505n 0.0v 1019.495n 0.0v 1019.505n 0.0v 1029.495n 0.0v 1029.505n 0.0v 1039.495n 0.0v 1039.505n 0.0v 1049.495n 0.0v 1049.505n 0.0v 1059.495n 0.0v 1059.505n 0.0v 1069.495n 0.0v 1069.505n 0.0v 1079.495n 0.0v 1079.505n 0.0v 1089.495n 0.0v 1089.505n 0.0v 1099.495n 0.0v 1099.505n 0.0v 1109.495n 0.0v 1109.505n 0.0v 1119.495n 0.0v 1119.505n 0.0v 1129.495n 0.0v 1129.505n 0.0v 1139.495n 0.0v 1139.505n 0.0v 1149.495n 0.0v 1149.505n 0.0v 1159.495n 0.0v 1159.505n 0.0v 1169.495n 0.0v 1169.505n 0.0v 1179.495n 0.0v 1179.505n 0.0v 1189.495n 0.0v 1189.505n 0.0v 1199.495n 0.0v 1199.505n 0.0v 1209.495n 0.0v 1209.505n 0.0v 1219.495n 0.0v 1219.505n 0.0v 1229.495n 0.0v 1229.505n 0.0v 1239.495n 0.0v 1239.505n 0.0v 1249.495n 0.0v 1249.505n 0.0v 1259.495n 0.0v 1259.505n 0.0v 1269.495n 0.0v 1269.505n 0.0v 1279.495n 0.0v 1279.505n 0.0v 1289.495n 0.0v 1289.505n 0.0v 1299.495n 0.0v 1299.505n 0.0v 1309.495n 0.0v 1309.505n 0.0v 1319.495n 0.0v 1319.505n 0.0v 1329.495n 0.0v 1329.505n 0.0v 1339.495n 0.0v 1339.505n 0.0v 1349.495n 0.0v 1349.505n 0.0v 1359.495n 0.0v 1359.505n 0.0v 1369.495n 0.0v 1369.505n 0.0v 1379.495n 0.0v 1379.505n 0.0v 1389.495n 0.0v 1389.505n 0.0v 1399.495n 0.0v 1399.505n 0.0v 1409.495n 0.0v 1409.505n 0.0v 1419.495n 0.0v 1419.505n 0.0v 1429.495n 0.0v 1429.505n 0.0v 1439.495n 0.0v 1439.505n 0.0v 1449.495n 0.0v 1449.505n 0.0v 1459.495n 0.0v 1459.505n 0.0v 1469.495n 0.0v 1469.505n 0.0v 1479.495n 0.0v 1479.505n 0.0v 1489.495n 0.0v 1489.505n 0.0v 1499.495n 0.0v 1499.505n 0.0v 1509.495n 0.0v 1509.505n 0.0v 1519.495n 0.0v 1519.505n 0.0v 1529.495n 0.0v 1529.505n 0.0v 1539.495n 0.0v 1539.505n 0.0v 1549.495n 0.0v 1549.505n 0.0v 1559.495n 0.0v 1559.505n 0.0v 1569.495n 0.0v 1569.505n 0.0v 1579.495n 0.0v 1579.505n 0.0v 1589.495n 0.0v 1589.505n 0.0v 1599.495n 0.0v 1599.505n 0.0v 1609.495n 0.0v 1609.505n 0.0v 1619.495n 0.0v 1619.505n 0.0v 1629.495n 0.0v 1629.505n 0.0v 1639.495n 0.0v 1639.505n 0.0v 1649.495n 0.0v 1649.505n 0.0v 1659.495n 0.0v 1659.505n 0.0v 1669.495n 0.0v 1669.505n 0.0v 1679.495n 0.0v 1679.505n 0.0v 1689.495n 0.0v 1689.505n 0.0v 1699.495n 0.0v 1699.505n 0.0v 1709.495n 0.0v 1709.505n 0.0v 1719.495n 0.0v 1719.505n 0.0v 1729.495n 0.0v 1729.505n 0.0v 1739.495n 0.0v 1739.505n 0.0v 1749.495n 0.0v 1749.505n 0.0v 1759.495n 0.0v 1759.505n 0.0v 1769.495n 0.0v 1769.505n 0.0v 1779.495n 0.0v 1779.505n 0.0v 1789.495n 0.0v 1789.505n 0.0v 1799.495n 0.0v 1799.505n 0.0v 1809.495n 0.0v 1809.505n 0.0v 1819.495n 0.0v 1819.505n 0.0v 1829.495n 0.0v 1829.505n 0.0v 1839.495n 0.0v 1839.505n 0.0v 1849.495n 0.0v 1849.505n 0.0v 1859.495n 0.0v 1859.505n 0.0v 1869.495n 0.0v 1869.505n 0.0v 1879.495n 0.0v 1879.505n 0.0v 1889.495n 0.0v 1889.505n 0.0v 1899.495n 0.0v 1899.505n 0.0v 1909.495n 0.0v 1909.505n 0.0v 1919.495n 0.0v 1919.505n 0.0v 1929.495n 0.0v 1929.505n 0.0v 1939.495n 0.0v 1939.505n 0.0v 1949.495n 0.0v 1949.505n 0.0v 1959.495n 0.0v 1959.505n 0.0v 1969.495n 0.0v 1969.505n 0.0v 1979.495n 0.0v 1979.505n 0.0v 1989.495n 0.0v 1989.505n 0.0v 1999.495n 0.0v 1999.505n 0.0v 2009.495n 0.0v 2009.505n 0.0v 2019.495n 0.0v 2019.505n 0.0v 2029.495n 0.0v 2029.505n 0.0v 2039.495n 0.0v 2039.505n 0.0v 2049.495n 0.0v 2049.505n 0.0v )
* (time, data): [(0, 0), (10, 1), (20, 1), (30, 1), (40, 1), (50, 1), (60, 0), (70, 1), (80, 0), (90, 1), (100, 1), (110, 0), (120, 1), (130, 0), (140, 0), (150, 1), (160, 0), (170, 1), (180, 1), (190, 1), (200, 1), (210, 1), (220, 0), (230, 0), (240, 1), (250, 0), (260, 0), (270, 0), (280, 0), (290, 1), (300, 1), (310, 0), (320, 1), (330, 1), (340, 0), (350, 1), (360, 0), (370, 1), (380, 1), (390, 1), (400, 0), (410, 1), (420, 1), (430, 1), (440, 1), (450, 1), (460, 1), (470, 1), (480, 1), (490, 0), (500, 0), (510, 1), (520, 0), (530, 1), (540, 0), (550, 0), (560, 0), (570, 0), (580, 1), (590, 0), (600, 0), (610, 1), (620, 1), (630, 0), (640, 0), (650, 0), (660, 0), (670, 0), (680, 1), (690, 1), (700, 1), (710, 1), (720, 0), (730, 0), (740, 0), (750, 0), (760, 0), (770, 1), (780, 1), (790, 0), (800, 0), (810, 0), (820, 0), (830, 0), (840, 0), (850, 0), (860, 0), (870, 0), (880, 0), (890, 1), (900, 1), (910, 1), (920, 0), (930, 0), (940, 1), (950, 1), (960, 1), (970, 1), (980, 1), (990, 1), (1000, 0), (1010, 0), (1020, 0), (1030, 0), (1040, 0), (1050, 1), (1060, 0), (1070, 0), (1080, 0), (1090, 1), (1100, 0), (1110, 0), (1120, 0), (1130, 0), (1140, 0), (1150, 0), (1160, 0), (1170, 0), (1180, 0), (1190, 1), (1200, 0), (1210, 0), (1220, 1), (1230, 1), (1240, 1), (1250, 1), (1260, 1), (1270, 1), (1280, 1), (1290, 1), (1300, 0), (1310, 1), (1320, 1), (1330, 0), (1340, 0), (1350, 1), (1360, 1), (1370, 1), (1380, 0), (1390, 1), (1400, 1), (1410, 0), (1420, 0), (1430, 1), (1440, 1), (1450, 1), (1460, 0), (1470, 1), (1480, 1), (1490, 0), (1500, 1), (1510, 0), (1520, 0), (1530, 1), (1540, 1), (1550, 0), (1560, 0), (1570, 0), (1580, 0), (1590, 1), (1600, 1), (1610, 0), (1620, 0), (1630, 1), (1640, 1), (1650, 0), (1660, 0), (1670, 0), (1680, 0), (1690, 0), (1700, 1), (1710, 1), (1720, 1), (1730, 0), (1740, 1), (1750, 1), (1760, 0), (1770, 1), (1780, 1), (1790, 0), (1800, 0), (1810, 1), (1820, 1), (1830, 1), (1840, 0), (1850, 0), (1860, 1), (1870, 1), (1880, 0), (1890, 0), (1900, 0), (1910, 1), (1920, 1), (1930, 0), (1940, 1), (1950, 1), (1960, 0), (1970, 0), (1980, 1), (1990, 1), (2000, 1), (2010, 0), (2020, 0), (2030, 0), (2040, 1), (2050, 1)]
Va0_0  a0_0  0 PWL (0n 0.0v 9.495n 0.0v 9.505n 1.8v 19.495n 1.8v 19.505n 1.8v 29.495n 1.8v 29.505n 1.8v 39.495n 1.8v 39.505n 1.8v 49.495n 1.8v 49.505n 1.8v 59.495n 1.8v 59.505n 0.0v 69.495n 0.0v 69.505n 1.8v 79.495n 1.8v 79.505n 0.0v 89.495n 0.0v 89.505n 1.8v 99.495n 1.8v 99.505n 1.8v 109.495n 1.8v 109.505n 0.0v 119.495n 0.0v 119.505n 1.8v 129.495n 1.8v 129.505n 0.0v 139.495n 0.0v 139.505n 0.0v 149.495n 0.0v 149.505n 1.8v 159.495n 1.8v 159.505n 0.0v 169.495n 0.0v 169.505n 1.8v 179.495n 1.8v 179.505n 1.8v 189.495n 1.8v 189.505n 1.8v 199.495n 1.8v 199.505n 1.8v 209.495n 1.8v 209.505n 1.8v 219.495n 1.8v 219.505n 0.0v 229.495n 0.0v 229.505n 0.0v 239.495n 0.0v 239.505n 1.8v 249.495n 1.8v 249.505n 0.0v 259.495n 0.0v 259.505n 0.0v 269.495n 0.0v 269.505n 0.0v 279.495n 0.0v 279.505n 0.0v 289.495n 0.0v 289.505n 1.8v 299.495n 1.8v 299.505n 1.8v 309.495n 1.8v 309.505n 0.0v 319.495n 0.0v 319.505n 1.8v 329.495n 1.8v 329.505n 1.8v 339.495n 1.8v 339.505n 0.0v 349.495n 0.0v 349.505n 1.8v 359.495n 1.8v 359.505n 0.0v 369.495n 0.0v 369.505n 1.8v 379.495n 1.8v 379.505n 1.8v 389.495n 1.8v 389.505n 1.8v 399.495n 1.8v 399.505n 0.0v 409.495n 0.0v 409.505n 1.8v 419.495n 1.8v 419.505n 1.8v 429.495n 1.8v 429.505n 1.8v 439.495n 1.8v 439.505n 1.8v 449.495n 1.8v 449.505n 1.8v 459.495n 1.8v 459.505n 1.8v 469.495n 1.8v 469.505n 1.8v 479.495n 1.8v 479.505n 1.8v 489.495n 1.8v 489.505n 0.0v 499.495n 0.0v 499.505n 0.0v 509.495n 0.0v 509.505n 1.8v 519.495n 1.8v 519.505n 0.0v 529.495n 0.0v 529.505n 1.8v 539.495n 1.8v 539.505n 0.0v 549.495n 0.0v 549.505n 0.0v 559.495n 0.0v 559.505n 0.0v 569.495n 0.0v 569.505n 0.0v 579.495n 0.0v 579.505n 1.8v 589.495n 1.8v 589.505n 0.0v 599.495n 0.0v 599.505n 0.0v 609.495n 0.0v 609.505n 1.8v 619.495n 1.8v 619.505n 1.8v 629.495n 1.8v 629.505n 0.0v 639.495n 0.0v 639.505n 0.0v 649.495n 0.0v 649.505n 0.0v 659.495n 0.0v 659.505n 0.0v 669.495n 0.0v 669.505n 0.0v 679.495n 0.0v 679.505n 1.8v 689.495n 1.8v 689.505n 1.8v 699.495n 1.8v 699.505n 1.8v 709.495n 1.8v 709.505n 1.8v 719.495n 1.8v 719.505n 0.0v 729.495n 0.0v 729.505n 0.0v 739.495n 0.0v 739.505n 0.0v 749.495n 0.0v 749.505n 0.0v 759.495n 0.0v 759.505n 0.0v 769.495n 0.0v 769.505n 1.8v 779.495n 1.8v 779.505n 1.8v 789.495n 1.8v 789.505n 0.0v 799.495n 0.0v 799.505n 0.0v 809.495n 0.0v 809.505n 0.0v 819.495n 0.0v 819.505n 0.0v 829.495n 0.0v 829.505n 0.0v 839.495n 0.0v 839.505n 0.0v 849.495n 0.0v 849.505n 0.0v 859.495n 0.0v 859.505n 0.0v 869.495n 0.0v 869.505n 0.0v 879.495n 0.0v 879.505n 0.0v 889.495n 0.0v 889.505n 1.8v 899.495n 1.8v 899.505n 1.8v 909.495n 1.8v 909.505n 1.8v 919.495n 1.8v 919.505n 0.0v 929.495n 0.0v 929.505n 0.0v 939.495n 0.0v 939.505n 1.8v 949.495n 1.8v 949.505n 1.8v 959.495n 1.8v 959.505n 1.8v 969.495n 1.8v 969.505n 1.8v 979.495n 1.8v 979.505n 1.8v 989.495n 1.8v 989.505n 1.8v 999.495n 1.8v 999.505n 0.0v 1009.495n 0.0v 1009.505n 0.0v 1019.495n 0.0v 1019.505n 0.0v 1029.495n 0.0v 1029.505n 0.0v 1039.495n 0.0v 1039.505n 0.0v 1049.495n 0.0v 1049.505n 1.8v 1059.495n 1.8v 1059.505n 0.0v 1069.495n 0.0v 1069.505n 0.0v 1079.495n 0.0v 1079.505n 0.0v 1089.495n 0.0v 1089.505n 1.8v 1099.495n 1.8v 1099.505n 0.0v 1109.495n 0.0v 1109.505n 0.0v 1119.495n 0.0v 1119.505n 0.0v 1129.495n 0.0v 1129.505n 0.0v 1139.495n 0.0v 1139.505n 0.0v 1149.495n 0.0v 1149.505n 0.0v 1159.495n 0.0v 1159.505n 0.0v 1169.495n 0.0v 1169.505n 0.0v 1179.495n 0.0v 1179.505n 0.0v 1189.495n 0.0v 1189.505n 1.8v 1199.495n 1.8v 1199.505n 0.0v 1209.495n 0.0v 1209.505n 0.0v 1219.495n 0.0v 1219.505n 1.8v 1229.495n 1.8v 1229.505n 1.8v 1239.495n 1.8v 1239.505n 1.8v 1249.495n 1.8v 1249.505n 1.8v 1259.495n 1.8v 1259.505n 1.8v 1269.495n 1.8v 1269.505n 1.8v 1279.495n 1.8v 1279.505n 1.8v 1289.495n 1.8v 1289.505n 1.8v 1299.495n 1.8v 1299.505n 0.0v 1309.495n 0.0v 1309.505n 1.8v 1319.495n 1.8v 1319.505n 1.8v 1329.495n 1.8v 1329.505n 0.0v 1339.495n 0.0v 1339.505n 0.0v 1349.495n 0.0v 1349.505n 1.8v 1359.495n 1.8v 1359.505n 1.8v 1369.495n 1.8v 1369.505n 1.8v 1379.495n 1.8v 1379.505n 0.0v 1389.495n 0.0v 1389.505n 1.8v 1399.495n 1.8v 1399.505n 1.8v 1409.495n 1.8v 1409.505n 0.0v 1419.495n 0.0v 1419.505n 0.0v 1429.495n 0.0v 1429.505n 1.8v 1439.495n 1.8v 1439.505n 1.8v 1449.495n 1.8v 1449.505n 1.8v 1459.495n 1.8v 1459.505n 0.0v 1469.495n 0.0v 1469.505n 1.8v 1479.495n 1.8v 1479.505n 1.8v 1489.495n 1.8v 1489.505n 0.0v 1499.495n 0.0v 1499.505n 1.8v 1509.495n 1.8v 1509.505n 0.0v 1519.495n 0.0v 1519.505n 0.0v 1529.495n 0.0v 1529.505n 1.8v 1539.495n 1.8v 1539.505n 1.8v 1549.495n 1.8v 1549.505n 0.0v 1559.495n 0.0v 1559.505n 0.0v 1569.495n 0.0v 1569.505n 0.0v 1579.495n 0.0v 1579.505n 0.0v 1589.495n 0.0v 1589.505n 1.8v 1599.495n 1.8v 1599.505n 1.8v 1609.495n 1.8v 1609.505n 0.0v 1619.495n 0.0v 1619.505n 0.0v 1629.495n 0.0v 1629.505n 1.8v 1639.495n 1.8v 1639.505n 1.8v 1649.495n 1.8v 1649.505n 0.0v 1659.495n 0.0v 1659.505n 0.0v 1669.495n 0.0v 1669.505n 0.0v 1679.495n 0.0v 1679.505n 0.0v 1689.495n 0.0v 1689.505n 0.0v 1699.495n 0.0v 1699.505n 1.8v 1709.495n 1.8v 1709.505n 1.8v 1719.495n 1.8v 1719.505n 1.8v 1729.495n 1.8v 1729.505n 0.0v 1739.495n 0.0v 1739.505n 1.8v 1749.495n 1.8v 1749.505n 1.8v 1759.495n 1.8v 1759.505n 0.0v 1769.495n 0.0v 1769.505n 1.8v 1779.495n 1.8v 1779.505n 1.8v 1789.495n 1.8v 1789.505n 0.0v 1799.495n 0.0v 1799.505n 0.0v 1809.495n 0.0v 1809.505n 1.8v 1819.495n 1.8v 1819.505n 1.8v 1829.495n 1.8v 1829.505n 1.8v 1839.495n 1.8v 1839.505n 0.0v 1849.495n 0.0v 1849.505n 0.0v 1859.495n 0.0v 1859.505n 1.8v 1869.495n 1.8v 1869.505n 1.8v 1879.495n 1.8v 1879.505n 0.0v 1889.495n 0.0v 1889.505n 0.0v 1899.495n 0.0v 1899.505n 0.0v 1909.495n 0.0v 1909.505n 1.8v 1919.495n 1.8v 1919.505n 1.8v 1929.495n 1.8v 1929.505n 0.0v 1939.495n 0.0v 1939.505n 1.8v 1949.495n 1.8v 1949.505n 1.8v 1959.495n 1.8v 1959.505n 0.0v 1969.495n 0.0v 1969.505n 0.0v 1979.495n 0.0v 1979.505n 1.8v 1989.495n 1.8v 1989.505n 1.8v 1999.495n 1.8v 1999.505n 1.8v 2009.495n 1.8v 2009.505n 0.0v 2019.495n 0.0v 2019.505n 0.0v 2029.495n 0.0v 2029.505n 0.0v 2039.495n 0.0v 2039.505n 1.8v 2049.495n 1.8v 2049.505n 1.8v )
* (time, data): [(0, 0), (10, 1), (20, 1), (30, 1), (40, 1), (50, 1), (60, 0), (70, 1), (80, 0), (90, 1), (100, 1), (110, 0), (120, 1), (130, 0), (140, 0), (150, 1), (160, 0), (170, 1), (180, 1), (190, 1), (200, 1), (210, 1), (220, 0), (230, 0), (240, 1), (250, 0), (260, 0), (270, 0), (280, 0), (290, 1), (300, 1), (310, 0), (320, 1), (330, 1), (340, 0), (350, 1), (360, 0), (370, 1), (380, 1), (390, 1), (400, 0), (410, 1), (420, 1), (430, 1), (440, 1), (450, 1), (460, 1), (470, 1), (480, 1), (490, 0), (500, 0), (510, 1), (520, 0), (530, 1), (540, 0), (550, 0), (560, 0), (570, 0), (580, 1), (590, 0), (600, 0), (610, 1), (620, 1), (630, 0), (640, 0), (650, 0), (660, 0), (670, 0), (680, 1), (690, 1), (700, 1), (710, 1), (720, 0), (730, 0), (740, 0), (750, 0), (760, 0), (770, 1), (780, 1), (790, 0), (800, 0), (810, 0), (820, 0), (830, 0), (840, 0), (850, 0), (860, 0), (870, 0), (880, 0), (890, 1), (900, 1), (910, 1), (920, 0), (930, 0), (940, 1), (950, 1), (960, 1), (970, 1), (980, 1), (990, 1), (1000, 0), (1010, 0), (1020, 0), (1030, 0), (1040, 0), (1050, 1), (1060, 0), (1070, 0), (1080, 0), (1090, 1), (1100, 0), (1110, 0), (1120, 0), (1130, 0), (1140, 0), (1150, 0), (1160, 0), (1170, 0), (1180, 0), (1190, 1), (1200, 0), (1210, 0), (1220, 1), (1230, 1), (1240, 1), (1250, 1), (1260, 1), (1270, 1), (1280, 1), (1290, 1), (1300, 0), (1310, 1), (1320, 1), (1330, 0), (1340, 0), (1350, 1), (1360, 1), (1370, 1), (1380, 0), (1390, 1), (1400, 1), (1410, 0), (1420, 0), (1430, 1), (1440, 1), (1450, 1), (1460, 0), (1470, 1), (1480, 1), (1490, 0), (1500, 1), (1510, 0), (1520, 0), (1530, 1), (1540, 1), (1550, 0), (1560, 0), (1570, 0), (1580, 0), (1590, 1), (1600, 1), (1610, 0), (1620, 0), (1630, 1), (1640, 1), (1650, 0), (1660, 0), (1670, 0), (1680, 0), (1690, 0), (1700, 1), (1710, 1), (1720, 1), (1730, 0), (1740, 1), (1750, 1), (1760, 0), (1770, 1), (1780, 1), (1790, 0), (1800, 0), (1810, 1), (1820, 1), (1830, 1), (1840, 0), (1850, 0), (1860, 1), (1870, 1), (1880, 0), (1890, 0), (1900, 0), (1910, 1), (1920, 1), (1930, 0), (1940, 1), (1950, 1), (1960, 0), (1970, 0), (1980, 1), (1990, 1), (2000, 1), (2010, 0), (2020, 0), (2030, 0), (2040, 1), (2050, 1)]
Va0_1  a0_1  0 PWL (0n 0.0v 9.495n 0.0v 9.505n 1.8v 19.495n 1.8v 19.505n 1.8v 29.495n 1.8v 29.505n 1.8v 39.495n 1.8v 39.505n 1.8v 49.495n 1.8v 49.505n 1.8v 59.495n 1.8v 59.505n 0.0v 69.495n 0.0v 69.505n 1.8v 79.495n 1.8v 79.505n 0.0v 89.495n 0.0v 89.505n 1.8v 99.495n 1.8v 99.505n 1.8v 109.495n 1.8v 109.505n 0.0v 119.495n 0.0v 119.505n 1.8v 129.495n 1.8v 129.505n 0.0v 139.495n 0.0v 139.505n 0.0v 149.495n 0.0v 149.505n 1.8v 159.495n 1.8v 159.505n 0.0v 169.495n 0.0v 169.505n 1.8v 179.495n 1.8v 179.505n 1.8v 189.495n 1.8v 189.505n 1.8v 199.495n 1.8v 199.505n 1.8v 209.495n 1.8v 209.505n 1.8v 219.495n 1.8v 219.505n 0.0v 229.495n 0.0v 229.505n 0.0v 239.495n 0.0v 239.505n 1.8v 249.495n 1.8v 249.505n 0.0v 259.495n 0.0v 259.505n 0.0v 269.495n 0.0v 269.505n 0.0v 279.495n 0.0v 279.505n 0.0v 289.495n 0.0v 289.505n 1.8v 299.495n 1.8v 299.505n 1.8v 309.495n 1.8v 309.505n 0.0v 319.495n 0.0v 319.505n 1.8v 329.495n 1.8v 329.505n 1.8v 339.495n 1.8v 339.505n 0.0v 349.495n 0.0v 349.505n 1.8v 359.495n 1.8v 359.505n 0.0v 369.495n 0.0v 369.505n 1.8v 379.495n 1.8v 379.505n 1.8v 389.495n 1.8v 389.505n 1.8v 399.495n 1.8v 399.505n 0.0v 409.495n 0.0v 409.505n 1.8v 419.495n 1.8v 419.505n 1.8v 429.495n 1.8v 429.505n 1.8v 439.495n 1.8v 439.505n 1.8v 449.495n 1.8v 449.505n 1.8v 459.495n 1.8v 459.505n 1.8v 469.495n 1.8v 469.505n 1.8v 479.495n 1.8v 479.505n 1.8v 489.495n 1.8v 489.505n 0.0v 499.495n 0.0v 499.505n 0.0v 509.495n 0.0v 509.505n 1.8v 519.495n 1.8v 519.505n 0.0v 529.495n 0.0v 529.505n 1.8v 539.495n 1.8v 539.505n 0.0v 549.495n 0.0v 549.505n 0.0v 559.495n 0.0v 559.505n 0.0v 569.495n 0.0v 569.505n 0.0v 579.495n 0.0v 579.505n 1.8v 589.495n 1.8v 589.505n 0.0v 599.495n 0.0v 599.505n 0.0v 609.495n 0.0v 609.505n 1.8v 619.495n 1.8v 619.505n 1.8v 629.495n 1.8v 629.505n 0.0v 639.495n 0.0v 639.505n 0.0v 649.495n 0.0v 649.505n 0.0v 659.495n 0.0v 659.505n 0.0v 669.495n 0.0v 669.505n 0.0v 679.495n 0.0v 679.505n 1.8v 689.495n 1.8v 689.505n 1.8v 699.495n 1.8v 699.505n 1.8v 709.495n 1.8v 709.505n 1.8v 719.495n 1.8v 719.505n 0.0v 729.495n 0.0v 729.505n 0.0v 739.495n 0.0v 739.505n 0.0v 749.495n 0.0v 749.505n 0.0v 759.495n 0.0v 759.505n 0.0v 769.495n 0.0v 769.505n 1.8v 779.495n 1.8v 779.505n 1.8v 789.495n 1.8v 789.505n 0.0v 799.495n 0.0v 799.505n 0.0v 809.495n 0.0v 809.505n 0.0v 819.495n 0.0v 819.505n 0.0v 829.495n 0.0v 829.505n 0.0v 839.495n 0.0v 839.505n 0.0v 849.495n 0.0v 849.505n 0.0v 859.495n 0.0v 859.505n 0.0v 869.495n 0.0v 869.505n 0.0v 879.495n 0.0v 879.505n 0.0v 889.495n 0.0v 889.505n 1.8v 899.495n 1.8v 899.505n 1.8v 909.495n 1.8v 909.505n 1.8v 919.495n 1.8v 919.505n 0.0v 929.495n 0.0v 929.505n 0.0v 939.495n 0.0v 939.505n 1.8v 949.495n 1.8v 949.505n 1.8v 959.495n 1.8v 959.505n 1.8v 969.495n 1.8v 969.505n 1.8v 979.495n 1.8v 979.505n 1.8v 989.495n 1.8v 989.505n 1.8v 999.495n 1.8v 999.505n 0.0v 1009.495n 0.0v 1009.505n 0.0v 1019.495n 0.0v 1019.505n 0.0v 1029.495n 0.0v 1029.505n 0.0v 1039.495n 0.0v 1039.505n 0.0v 1049.495n 0.0v 1049.505n 1.8v 1059.495n 1.8v 1059.505n 0.0v 1069.495n 0.0v 1069.505n 0.0v 1079.495n 0.0v 1079.505n 0.0v 1089.495n 0.0v 1089.505n 1.8v 1099.495n 1.8v 1099.505n 0.0v 1109.495n 0.0v 1109.505n 0.0v 1119.495n 0.0v 1119.505n 0.0v 1129.495n 0.0v 1129.505n 0.0v 1139.495n 0.0v 1139.505n 0.0v 1149.495n 0.0v 1149.505n 0.0v 1159.495n 0.0v 1159.505n 0.0v 1169.495n 0.0v 1169.505n 0.0v 1179.495n 0.0v 1179.505n 0.0v 1189.495n 0.0v 1189.505n 1.8v 1199.495n 1.8v 1199.505n 0.0v 1209.495n 0.0v 1209.505n 0.0v 1219.495n 0.0v 1219.505n 1.8v 1229.495n 1.8v 1229.505n 1.8v 1239.495n 1.8v 1239.505n 1.8v 1249.495n 1.8v 1249.505n 1.8v 1259.495n 1.8v 1259.505n 1.8v 1269.495n 1.8v 1269.505n 1.8v 1279.495n 1.8v 1279.505n 1.8v 1289.495n 1.8v 1289.505n 1.8v 1299.495n 1.8v 1299.505n 0.0v 1309.495n 0.0v 1309.505n 1.8v 1319.495n 1.8v 1319.505n 1.8v 1329.495n 1.8v 1329.505n 0.0v 1339.495n 0.0v 1339.505n 0.0v 1349.495n 0.0v 1349.505n 1.8v 1359.495n 1.8v 1359.505n 1.8v 1369.495n 1.8v 1369.505n 1.8v 1379.495n 1.8v 1379.505n 0.0v 1389.495n 0.0v 1389.505n 1.8v 1399.495n 1.8v 1399.505n 1.8v 1409.495n 1.8v 1409.505n 0.0v 1419.495n 0.0v 1419.505n 0.0v 1429.495n 0.0v 1429.505n 1.8v 1439.495n 1.8v 1439.505n 1.8v 1449.495n 1.8v 1449.505n 1.8v 1459.495n 1.8v 1459.505n 0.0v 1469.495n 0.0v 1469.505n 1.8v 1479.495n 1.8v 1479.505n 1.8v 1489.495n 1.8v 1489.505n 0.0v 1499.495n 0.0v 1499.505n 1.8v 1509.495n 1.8v 1509.505n 0.0v 1519.495n 0.0v 1519.505n 0.0v 1529.495n 0.0v 1529.505n 1.8v 1539.495n 1.8v 1539.505n 1.8v 1549.495n 1.8v 1549.505n 0.0v 1559.495n 0.0v 1559.505n 0.0v 1569.495n 0.0v 1569.505n 0.0v 1579.495n 0.0v 1579.505n 0.0v 1589.495n 0.0v 1589.505n 1.8v 1599.495n 1.8v 1599.505n 1.8v 1609.495n 1.8v 1609.505n 0.0v 1619.495n 0.0v 1619.505n 0.0v 1629.495n 0.0v 1629.505n 1.8v 1639.495n 1.8v 1639.505n 1.8v 1649.495n 1.8v 1649.505n 0.0v 1659.495n 0.0v 1659.505n 0.0v 1669.495n 0.0v 1669.505n 0.0v 1679.495n 0.0v 1679.505n 0.0v 1689.495n 0.0v 1689.505n 0.0v 1699.495n 0.0v 1699.505n 1.8v 1709.495n 1.8v 1709.505n 1.8v 1719.495n 1.8v 1719.505n 1.8v 1729.495n 1.8v 1729.505n 0.0v 1739.495n 0.0v 1739.505n 1.8v 1749.495n 1.8v 1749.505n 1.8v 1759.495n 1.8v 1759.505n 0.0v 1769.495n 0.0v 1769.505n 1.8v 1779.495n 1.8v 1779.505n 1.8v 1789.495n 1.8v 1789.505n 0.0v 1799.495n 0.0v 1799.505n 0.0v 1809.495n 0.0v 1809.505n 1.8v 1819.495n 1.8v 1819.505n 1.8v 1829.495n 1.8v 1829.505n 1.8v 1839.495n 1.8v 1839.505n 0.0v 1849.495n 0.0v 1849.505n 0.0v 1859.495n 0.0v 1859.505n 1.8v 1869.495n 1.8v 1869.505n 1.8v 1879.495n 1.8v 1879.505n 0.0v 1889.495n 0.0v 1889.505n 0.0v 1899.495n 0.0v 1899.505n 0.0v 1909.495n 0.0v 1909.505n 1.8v 1919.495n 1.8v 1919.505n 1.8v 1929.495n 1.8v 1929.505n 0.0v 1939.495n 0.0v 1939.505n 1.8v 1949.495n 1.8v 1949.505n 1.8v 1959.495n 1.8v 1959.505n 0.0v 1969.495n 0.0v 1969.505n 0.0v 1979.495n 0.0v 1979.505n 1.8v 1989.495n 1.8v 1989.505n 1.8v 1999.495n 1.8v 1999.505n 1.8v 2009.495n 1.8v 2009.505n 0.0v 2019.495n 0.0v 2019.505n 0.0v 2029.495n 0.0v 2029.505n 0.0v 2039.495n 0.0v 2039.505n 1.8v 2049.495n 1.8v 2049.505n 1.8v )
* (time, data): [(0, 0), (10, 1), (20, 1), (30, 1), (40, 1), (50, 1), (60, 0), (70, 1), (80, 0), (90, 1), (100, 1), (110, 0), (120, 1), (130, 0), (140, 0), (150, 1), (160, 0), (170, 1), (180, 1), (190, 1), (200, 1), (210, 1), (220, 0), (230, 0), (240, 1), (250, 0), (260, 0), (270, 0), (280, 0), (290, 1), (300, 1), (310, 0), (320, 1), (330, 1), (340, 0), (350, 1), (360, 0), (370, 1), (380, 1), (390, 1), (400, 0), (410, 1), (420, 1), (430, 1), (440, 1), (450, 1), (460, 1), (470, 1), (480, 1), (490, 0), (500, 0), (510, 1), (520, 0), (530, 1), (540, 0), (550, 0), (560, 0), (570, 0), (580, 1), (590, 0), (600, 0), (610, 1), (620, 1), (630, 0), (640, 0), (650, 0), (660, 0), (670, 0), (680, 1), (690, 1), (700, 1), (710, 1), (720, 0), (730, 0), (740, 0), (750, 0), (760, 0), (770, 1), (780, 1), (790, 0), (800, 0), (810, 0), (820, 0), (830, 0), (840, 0), (850, 0), (860, 0), (870, 0), (880, 0), (890, 1), (900, 1), (910, 1), (920, 0), (930, 0), (940, 1), (950, 1), (960, 1), (970, 1), (980, 1), (990, 1), (1000, 0), (1010, 0), (1020, 0), (1030, 0), (1040, 0), (1050, 1), (1060, 0), (1070, 0), (1080, 0), (1090, 1), (1100, 0), (1110, 0), (1120, 0), (1130, 0), (1140, 0), (1150, 0), (1160, 0), (1170, 0), (1180, 0), (1190, 1), (1200, 0), (1210, 0), (1220, 1), (1230, 1), (1240, 1), (1250, 1), (1260, 1), (1270, 1), (1280, 1), (1290, 1), (1300, 0), (1310, 1), (1320, 1), (1330, 0), (1340, 0), (1350, 1), (1360, 1), (1370, 1), (1380, 0), (1390, 1), (1400, 1), (1410, 0), (1420, 0), (1430, 1), (1440, 1), (1450, 1), (1460, 0), (1470, 1), (1480, 1), (1490, 0), (1500, 1), (1510, 0), (1520, 0), (1530, 1), (1540, 1), (1550, 0), (1560, 0), (1570, 0), (1580, 0), (1590, 1), (1600, 1), (1610, 0), (1620, 0), (1630, 1), (1640, 1), (1650, 0), (1660, 0), (1670, 0), (1680, 0), (1690, 0), (1700, 1), (1710, 1), (1720, 1), (1730, 0), (1740, 1), (1750, 1), (1760, 0), (1770, 1), (1780, 1), (1790, 0), (1800, 0), (1810, 1), (1820, 1), (1830, 1), (1840, 0), (1850, 0), (1860, 1), (1870, 1), (1880, 0), (1890, 0), (1900, 0), (1910, 1), (1920, 1), (1930, 0), (1940, 1), (1950, 1), (1960, 0), (1970, 0), (1980, 1), (1990, 1), (2000, 1), (2010, 0), (2020, 0), (2030, 0), (2040, 1), (2050, 1)]
Va0_2  a0_2  0 PWL (0n 0.0v 9.495n 0.0v 9.505n 1.8v 19.495n 1.8v 19.505n 1.8v 29.495n 1.8v 29.505n 1.8v 39.495n 1.8v 39.505n 1.8v 49.495n 1.8v 49.505n 1.8v 59.495n 1.8v 59.505n 0.0v 69.495n 0.0v 69.505n 1.8v 79.495n 1.8v 79.505n 0.0v 89.495n 0.0v 89.505n 1.8v 99.495n 1.8v 99.505n 1.8v 109.495n 1.8v 109.505n 0.0v 119.495n 0.0v 119.505n 1.8v 129.495n 1.8v 129.505n 0.0v 139.495n 0.0v 139.505n 0.0v 149.495n 0.0v 149.505n 1.8v 159.495n 1.8v 159.505n 0.0v 169.495n 0.0v 169.505n 1.8v 179.495n 1.8v 179.505n 1.8v 189.495n 1.8v 189.505n 1.8v 199.495n 1.8v 199.505n 1.8v 209.495n 1.8v 209.505n 1.8v 219.495n 1.8v 219.505n 0.0v 229.495n 0.0v 229.505n 0.0v 239.495n 0.0v 239.505n 1.8v 249.495n 1.8v 249.505n 0.0v 259.495n 0.0v 259.505n 0.0v 269.495n 0.0v 269.505n 0.0v 279.495n 0.0v 279.505n 0.0v 289.495n 0.0v 289.505n 1.8v 299.495n 1.8v 299.505n 1.8v 309.495n 1.8v 309.505n 0.0v 319.495n 0.0v 319.505n 1.8v 329.495n 1.8v 329.505n 1.8v 339.495n 1.8v 339.505n 0.0v 349.495n 0.0v 349.505n 1.8v 359.495n 1.8v 359.505n 0.0v 369.495n 0.0v 369.505n 1.8v 379.495n 1.8v 379.505n 1.8v 389.495n 1.8v 389.505n 1.8v 399.495n 1.8v 399.505n 0.0v 409.495n 0.0v 409.505n 1.8v 419.495n 1.8v 419.505n 1.8v 429.495n 1.8v 429.505n 1.8v 439.495n 1.8v 439.505n 1.8v 449.495n 1.8v 449.505n 1.8v 459.495n 1.8v 459.505n 1.8v 469.495n 1.8v 469.505n 1.8v 479.495n 1.8v 479.505n 1.8v 489.495n 1.8v 489.505n 0.0v 499.495n 0.0v 499.505n 0.0v 509.495n 0.0v 509.505n 1.8v 519.495n 1.8v 519.505n 0.0v 529.495n 0.0v 529.505n 1.8v 539.495n 1.8v 539.505n 0.0v 549.495n 0.0v 549.505n 0.0v 559.495n 0.0v 559.505n 0.0v 569.495n 0.0v 569.505n 0.0v 579.495n 0.0v 579.505n 1.8v 589.495n 1.8v 589.505n 0.0v 599.495n 0.0v 599.505n 0.0v 609.495n 0.0v 609.505n 1.8v 619.495n 1.8v 619.505n 1.8v 629.495n 1.8v 629.505n 0.0v 639.495n 0.0v 639.505n 0.0v 649.495n 0.0v 649.505n 0.0v 659.495n 0.0v 659.505n 0.0v 669.495n 0.0v 669.505n 0.0v 679.495n 0.0v 679.505n 1.8v 689.495n 1.8v 689.505n 1.8v 699.495n 1.8v 699.505n 1.8v 709.495n 1.8v 709.505n 1.8v 719.495n 1.8v 719.505n 0.0v 729.495n 0.0v 729.505n 0.0v 739.495n 0.0v 739.505n 0.0v 749.495n 0.0v 749.505n 0.0v 759.495n 0.0v 759.505n 0.0v 769.495n 0.0v 769.505n 1.8v 779.495n 1.8v 779.505n 1.8v 789.495n 1.8v 789.505n 0.0v 799.495n 0.0v 799.505n 0.0v 809.495n 0.0v 809.505n 0.0v 819.495n 0.0v 819.505n 0.0v 829.495n 0.0v 829.505n 0.0v 839.495n 0.0v 839.505n 0.0v 849.495n 0.0v 849.505n 0.0v 859.495n 0.0v 859.505n 0.0v 869.495n 0.0v 869.505n 0.0v 879.495n 0.0v 879.505n 0.0v 889.495n 0.0v 889.505n 1.8v 899.495n 1.8v 899.505n 1.8v 909.495n 1.8v 909.505n 1.8v 919.495n 1.8v 919.505n 0.0v 929.495n 0.0v 929.505n 0.0v 939.495n 0.0v 939.505n 1.8v 949.495n 1.8v 949.505n 1.8v 959.495n 1.8v 959.505n 1.8v 969.495n 1.8v 969.505n 1.8v 979.495n 1.8v 979.505n 1.8v 989.495n 1.8v 989.505n 1.8v 999.495n 1.8v 999.505n 0.0v 1009.495n 0.0v 1009.505n 0.0v 1019.495n 0.0v 1019.505n 0.0v 1029.495n 0.0v 1029.505n 0.0v 1039.495n 0.0v 1039.505n 0.0v 1049.495n 0.0v 1049.505n 1.8v 1059.495n 1.8v 1059.505n 0.0v 1069.495n 0.0v 1069.505n 0.0v 1079.495n 0.0v 1079.505n 0.0v 1089.495n 0.0v 1089.505n 1.8v 1099.495n 1.8v 1099.505n 0.0v 1109.495n 0.0v 1109.505n 0.0v 1119.495n 0.0v 1119.505n 0.0v 1129.495n 0.0v 1129.505n 0.0v 1139.495n 0.0v 1139.505n 0.0v 1149.495n 0.0v 1149.505n 0.0v 1159.495n 0.0v 1159.505n 0.0v 1169.495n 0.0v 1169.505n 0.0v 1179.495n 0.0v 1179.505n 0.0v 1189.495n 0.0v 1189.505n 1.8v 1199.495n 1.8v 1199.505n 0.0v 1209.495n 0.0v 1209.505n 0.0v 1219.495n 0.0v 1219.505n 1.8v 1229.495n 1.8v 1229.505n 1.8v 1239.495n 1.8v 1239.505n 1.8v 1249.495n 1.8v 1249.505n 1.8v 1259.495n 1.8v 1259.505n 1.8v 1269.495n 1.8v 1269.505n 1.8v 1279.495n 1.8v 1279.505n 1.8v 1289.495n 1.8v 1289.505n 1.8v 1299.495n 1.8v 1299.505n 0.0v 1309.495n 0.0v 1309.505n 1.8v 1319.495n 1.8v 1319.505n 1.8v 1329.495n 1.8v 1329.505n 0.0v 1339.495n 0.0v 1339.505n 0.0v 1349.495n 0.0v 1349.505n 1.8v 1359.495n 1.8v 1359.505n 1.8v 1369.495n 1.8v 1369.505n 1.8v 1379.495n 1.8v 1379.505n 0.0v 1389.495n 0.0v 1389.505n 1.8v 1399.495n 1.8v 1399.505n 1.8v 1409.495n 1.8v 1409.505n 0.0v 1419.495n 0.0v 1419.505n 0.0v 1429.495n 0.0v 1429.505n 1.8v 1439.495n 1.8v 1439.505n 1.8v 1449.495n 1.8v 1449.505n 1.8v 1459.495n 1.8v 1459.505n 0.0v 1469.495n 0.0v 1469.505n 1.8v 1479.495n 1.8v 1479.505n 1.8v 1489.495n 1.8v 1489.505n 0.0v 1499.495n 0.0v 1499.505n 1.8v 1509.495n 1.8v 1509.505n 0.0v 1519.495n 0.0v 1519.505n 0.0v 1529.495n 0.0v 1529.505n 1.8v 1539.495n 1.8v 1539.505n 1.8v 1549.495n 1.8v 1549.505n 0.0v 1559.495n 0.0v 1559.505n 0.0v 1569.495n 0.0v 1569.505n 0.0v 1579.495n 0.0v 1579.505n 0.0v 1589.495n 0.0v 1589.505n 1.8v 1599.495n 1.8v 1599.505n 1.8v 1609.495n 1.8v 1609.505n 0.0v 1619.495n 0.0v 1619.505n 0.0v 1629.495n 0.0v 1629.505n 1.8v 1639.495n 1.8v 1639.505n 1.8v 1649.495n 1.8v 1649.505n 0.0v 1659.495n 0.0v 1659.505n 0.0v 1669.495n 0.0v 1669.505n 0.0v 1679.495n 0.0v 1679.505n 0.0v 1689.495n 0.0v 1689.505n 0.0v 1699.495n 0.0v 1699.505n 1.8v 1709.495n 1.8v 1709.505n 1.8v 1719.495n 1.8v 1719.505n 1.8v 1729.495n 1.8v 1729.505n 0.0v 1739.495n 0.0v 1739.505n 1.8v 1749.495n 1.8v 1749.505n 1.8v 1759.495n 1.8v 1759.505n 0.0v 1769.495n 0.0v 1769.505n 1.8v 1779.495n 1.8v 1779.505n 1.8v 1789.495n 1.8v 1789.505n 0.0v 1799.495n 0.0v 1799.505n 0.0v 1809.495n 0.0v 1809.505n 1.8v 1819.495n 1.8v 1819.505n 1.8v 1829.495n 1.8v 1829.505n 1.8v 1839.495n 1.8v 1839.505n 0.0v 1849.495n 0.0v 1849.505n 0.0v 1859.495n 0.0v 1859.505n 1.8v 1869.495n 1.8v 1869.505n 1.8v 1879.495n 1.8v 1879.505n 0.0v 1889.495n 0.0v 1889.505n 0.0v 1899.495n 0.0v 1899.505n 0.0v 1909.495n 0.0v 1909.505n 1.8v 1919.495n 1.8v 1919.505n 1.8v 1929.495n 1.8v 1929.505n 0.0v 1939.495n 0.0v 1939.505n 1.8v 1949.495n 1.8v 1949.505n 1.8v 1959.495n 1.8v 1959.505n 0.0v 1969.495n 0.0v 1969.505n 0.0v 1979.495n 0.0v 1979.505n 1.8v 1989.495n 1.8v 1989.505n 1.8v 1999.495n 1.8v 1999.505n 1.8v 2009.495n 1.8v 2009.505n 0.0v 2019.495n 0.0v 2019.505n 0.0v 2029.495n 0.0v 2029.505n 0.0v 2039.495n 0.0v 2039.505n 1.8v 2049.495n 1.8v 2049.505n 1.8v )
* (time, data): [(0, 0), (10, 1), (20, 1), (30, 1), (40, 1), (50, 1), (60, 0), (70, 1), (80, 0), (90, 1), (100, 1), (110, 0), (120, 1), (130, 0), (140, 0), (150, 1), (160, 0), (170, 1), (180, 1), (190, 1), (200, 1), (210, 1), (220, 0), (230, 0), (240, 1), (250, 0), (260, 0), (270, 0), (280, 0), (290, 1), (300, 1), (310, 0), (320, 1), (330, 1), (340, 0), (350, 1), (360, 0), (370, 1), (380, 1), (390, 1), (400, 0), (410, 1), (420, 1), (430, 1), (440, 1), (450, 1), (460, 1), (470, 1), (480, 1), (490, 0), (500, 0), (510, 1), (520, 0), (530, 1), (540, 0), (550, 0), (560, 0), (570, 0), (580, 1), (590, 0), (600, 0), (610, 1), (620, 1), (630, 0), (640, 0), (650, 0), (660, 0), (670, 0), (680, 1), (690, 1), (700, 1), (710, 1), (720, 0), (730, 0), (740, 0), (750, 0), (760, 0), (770, 1), (780, 1), (790, 0), (800, 0), (810, 0), (820, 0), (830, 0), (840, 0), (850, 0), (860, 0), (870, 0), (880, 0), (890, 1), (900, 1), (910, 1), (920, 0), (930, 0), (940, 1), (950, 1), (960, 1), (970, 1), (980, 1), (990, 1), (1000, 0), (1010, 0), (1020, 0), (1030, 0), (1040, 0), (1050, 1), (1060, 0), (1070, 0), (1080, 0), (1090, 1), (1100, 0), (1110, 0), (1120, 0), (1130, 0), (1140, 0), (1150, 0), (1160, 0), (1170, 0), (1180, 0), (1190, 1), (1200, 0), (1210, 0), (1220, 1), (1230, 1), (1240, 1), (1250, 1), (1260, 1), (1270, 1), (1280, 1), (1290, 1), (1300, 0), (1310, 1), (1320, 1), (1330, 0), (1340, 0), (1350, 1), (1360, 1), (1370, 1), (1380, 0), (1390, 1), (1400, 1), (1410, 0), (1420, 0), (1430, 1), (1440, 1), (1450, 1), (1460, 0), (1470, 1), (1480, 1), (1490, 0), (1500, 1), (1510, 0), (1520, 0), (1530, 1), (1540, 1), (1550, 0), (1560, 0), (1570, 0), (1580, 0), (1590, 1), (1600, 1), (1610, 0), (1620, 0), (1630, 1), (1640, 1), (1650, 0), (1660, 0), (1670, 0), (1680, 0), (1690, 0), (1700, 1), (1710, 1), (1720, 1), (1730, 0), (1740, 1), (1750, 1), (1760, 0), (1770, 1), (1780, 1), (1790, 0), (1800, 0), (1810, 1), (1820, 1), (1830, 1), (1840, 0), (1850, 0), (1860, 1), (1870, 1), (1880, 0), (1890, 0), (1900, 0), (1910, 1), (1920, 1), (1930, 0), (1940, 1), (1950, 1), (1960, 0), (1970, 0), (1980, 1), (1990, 1), (2000, 1), (2010, 0), (2020, 0), (2030, 0), (2040, 1), (2050, 1)]
Va0_3  a0_3  0 PWL (0n 0.0v 9.495n 0.0v 9.505n 1.8v 19.495n 1.8v 19.505n 1.8v 29.495n 1.8v 29.505n 1.8v 39.495n 1.8v 39.505n 1.8v 49.495n 1.8v 49.505n 1.8v 59.495n 1.8v 59.505n 0.0v 69.495n 0.0v 69.505n 1.8v 79.495n 1.8v 79.505n 0.0v 89.495n 0.0v 89.505n 1.8v 99.495n 1.8v 99.505n 1.8v 109.495n 1.8v 109.505n 0.0v 119.495n 0.0v 119.505n 1.8v 129.495n 1.8v 129.505n 0.0v 139.495n 0.0v 139.505n 0.0v 149.495n 0.0v 149.505n 1.8v 159.495n 1.8v 159.505n 0.0v 169.495n 0.0v 169.505n 1.8v 179.495n 1.8v 179.505n 1.8v 189.495n 1.8v 189.505n 1.8v 199.495n 1.8v 199.505n 1.8v 209.495n 1.8v 209.505n 1.8v 219.495n 1.8v 219.505n 0.0v 229.495n 0.0v 229.505n 0.0v 239.495n 0.0v 239.505n 1.8v 249.495n 1.8v 249.505n 0.0v 259.495n 0.0v 259.505n 0.0v 269.495n 0.0v 269.505n 0.0v 279.495n 0.0v 279.505n 0.0v 289.495n 0.0v 289.505n 1.8v 299.495n 1.8v 299.505n 1.8v 309.495n 1.8v 309.505n 0.0v 319.495n 0.0v 319.505n 1.8v 329.495n 1.8v 329.505n 1.8v 339.495n 1.8v 339.505n 0.0v 349.495n 0.0v 349.505n 1.8v 359.495n 1.8v 359.505n 0.0v 369.495n 0.0v 369.505n 1.8v 379.495n 1.8v 379.505n 1.8v 389.495n 1.8v 389.505n 1.8v 399.495n 1.8v 399.505n 0.0v 409.495n 0.0v 409.505n 1.8v 419.495n 1.8v 419.505n 1.8v 429.495n 1.8v 429.505n 1.8v 439.495n 1.8v 439.505n 1.8v 449.495n 1.8v 449.505n 1.8v 459.495n 1.8v 459.505n 1.8v 469.495n 1.8v 469.505n 1.8v 479.495n 1.8v 479.505n 1.8v 489.495n 1.8v 489.505n 0.0v 499.495n 0.0v 499.505n 0.0v 509.495n 0.0v 509.505n 1.8v 519.495n 1.8v 519.505n 0.0v 529.495n 0.0v 529.505n 1.8v 539.495n 1.8v 539.505n 0.0v 549.495n 0.0v 549.505n 0.0v 559.495n 0.0v 559.505n 0.0v 569.495n 0.0v 569.505n 0.0v 579.495n 0.0v 579.505n 1.8v 589.495n 1.8v 589.505n 0.0v 599.495n 0.0v 599.505n 0.0v 609.495n 0.0v 609.505n 1.8v 619.495n 1.8v 619.505n 1.8v 629.495n 1.8v 629.505n 0.0v 639.495n 0.0v 639.505n 0.0v 649.495n 0.0v 649.505n 0.0v 659.495n 0.0v 659.505n 0.0v 669.495n 0.0v 669.505n 0.0v 679.495n 0.0v 679.505n 1.8v 689.495n 1.8v 689.505n 1.8v 699.495n 1.8v 699.505n 1.8v 709.495n 1.8v 709.505n 1.8v 719.495n 1.8v 719.505n 0.0v 729.495n 0.0v 729.505n 0.0v 739.495n 0.0v 739.505n 0.0v 749.495n 0.0v 749.505n 0.0v 759.495n 0.0v 759.505n 0.0v 769.495n 0.0v 769.505n 1.8v 779.495n 1.8v 779.505n 1.8v 789.495n 1.8v 789.505n 0.0v 799.495n 0.0v 799.505n 0.0v 809.495n 0.0v 809.505n 0.0v 819.495n 0.0v 819.505n 0.0v 829.495n 0.0v 829.505n 0.0v 839.495n 0.0v 839.505n 0.0v 849.495n 0.0v 849.505n 0.0v 859.495n 0.0v 859.505n 0.0v 869.495n 0.0v 869.505n 0.0v 879.495n 0.0v 879.505n 0.0v 889.495n 0.0v 889.505n 1.8v 899.495n 1.8v 899.505n 1.8v 909.495n 1.8v 909.505n 1.8v 919.495n 1.8v 919.505n 0.0v 929.495n 0.0v 929.505n 0.0v 939.495n 0.0v 939.505n 1.8v 949.495n 1.8v 949.505n 1.8v 959.495n 1.8v 959.505n 1.8v 969.495n 1.8v 969.505n 1.8v 979.495n 1.8v 979.505n 1.8v 989.495n 1.8v 989.505n 1.8v 999.495n 1.8v 999.505n 0.0v 1009.495n 0.0v 1009.505n 0.0v 1019.495n 0.0v 1019.505n 0.0v 1029.495n 0.0v 1029.505n 0.0v 1039.495n 0.0v 1039.505n 0.0v 1049.495n 0.0v 1049.505n 1.8v 1059.495n 1.8v 1059.505n 0.0v 1069.495n 0.0v 1069.505n 0.0v 1079.495n 0.0v 1079.505n 0.0v 1089.495n 0.0v 1089.505n 1.8v 1099.495n 1.8v 1099.505n 0.0v 1109.495n 0.0v 1109.505n 0.0v 1119.495n 0.0v 1119.505n 0.0v 1129.495n 0.0v 1129.505n 0.0v 1139.495n 0.0v 1139.505n 0.0v 1149.495n 0.0v 1149.505n 0.0v 1159.495n 0.0v 1159.505n 0.0v 1169.495n 0.0v 1169.505n 0.0v 1179.495n 0.0v 1179.505n 0.0v 1189.495n 0.0v 1189.505n 1.8v 1199.495n 1.8v 1199.505n 0.0v 1209.495n 0.0v 1209.505n 0.0v 1219.495n 0.0v 1219.505n 1.8v 1229.495n 1.8v 1229.505n 1.8v 1239.495n 1.8v 1239.505n 1.8v 1249.495n 1.8v 1249.505n 1.8v 1259.495n 1.8v 1259.505n 1.8v 1269.495n 1.8v 1269.505n 1.8v 1279.495n 1.8v 1279.505n 1.8v 1289.495n 1.8v 1289.505n 1.8v 1299.495n 1.8v 1299.505n 0.0v 1309.495n 0.0v 1309.505n 1.8v 1319.495n 1.8v 1319.505n 1.8v 1329.495n 1.8v 1329.505n 0.0v 1339.495n 0.0v 1339.505n 0.0v 1349.495n 0.0v 1349.505n 1.8v 1359.495n 1.8v 1359.505n 1.8v 1369.495n 1.8v 1369.505n 1.8v 1379.495n 1.8v 1379.505n 0.0v 1389.495n 0.0v 1389.505n 1.8v 1399.495n 1.8v 1399.505n 1.8v 1409.495n 1.8v 1409.505n 0.0v 1419.495n 0.0v 1419.505n 0.0v 1429.495n 0.0v 1429.505n 1.8v 1439.495n 1.8v 1439.505n 1.8v 1449.495n 1.8v 1449.505n 1.8v 1459.495n 1.8v 1459.505n 0.0v 1469.495n 0.0v 1469.505n 1.8v 1479.495n 1.8v 1479.505n 1.8v 1489.495n 1.8v 1489.505n 0.0v 1499.495n 0.0v 1499.505n 1.8v 1509.495n 1.8v 1509.505n 0.0v 1519.495n 0.0v 1519.505n 0.0v 1529.495n 0.0v 1529.505n 1.8v 1539.495n 1.8v 1539.505n 1.8v 1549.495n 1.8v 1549.505n 0.0v 1559.495n 0.0v 1559.505n 0.0v 1569.495n 0.0v 1569.505n 0.0v 1579.495n 0.0v 1579.505n 0.0v 1589.495n 0.0v 1589.505n 1.8v 1599.495n 1.8v 1599.505n 1.8v 1609.495n 1.8v 1609.505n 0.0v 1619.495n 0.0v 1619.505n 0.0v 1629.495n 0.0v 1629.505n 1.8v 1639.495n 1.8v 1639.505n 1.8v 1649.495n 1.8v 1649.505n 0.0v 1659.495n 0.0v 1659.505n 0.0v 1669.495n 0.0v 1669.505n 0.0v 1679.495n 0.0v 1679.505n 0.0v 1689.495n 0.0v 1689.505n 0.0v 1699.495n 0.0v 1699.505n 1.8v 1709.495n 1.8v 1709.505n 1.8v 1719.495n 1.8v 1719.505n 1.8v 1729.495n 1.8v 1729.505n 0.0v 1739.495n 0.0v 1739.505n 1.8v 1749.495n 1.8v 1749.505n 1.8v 1759.495n 1.8v 1759.505n 0.0v 1769.495n 0.0v 1769.505n 1.8v 1779.495n 1.8v 1779.505n 1.8v 1789.495n 1.8v 1789.505n 0.0v 1799.495n 0.0v 1799.505n 0.0v 1809.495n 0.0v 1809.505n 1.8v 1819.495n 1.8v 1819.505n 1.8v 1829.495n 1.8v 1829.505n 1.8v 1839.495n 1.8v 1839.505n 0.0v 1849.495n 0.0v 1849.505n 0.0v 1859.495n 0.0v 1859.505n 1.8v 1869.495n 1.8v 1869.505n 1.8v 1879.495n 1.8v 1879.505n 0.0v 1889.495n 0.0v 1889.505n 0.0v 1899.495n 0.0v 1899.505n 0.0v 1909.495n 0.0v 1909.505n 1.8v 1919.495n 1.8v 1919.505n 1.8v 1929.495n 1.8v 1929.505n 0.0v 1939.495n 0.0v 1939.505n 1.8v 1949.495n 1.8v 1949.505n 1.8v 1959.495n 1.8v 1959.505n 0.0v 1969.495n 0.0v 1969.505n 0.0v 1979.495n 0.0v 1979.505n 1.8v 1989.495n 1.8v 1989.505n 1.8v 1999.495n 1.8v 1999.505n 1.8v 2009.495n 1.8v 2009.505n 0.0v 2019.495n 0.0v 2019.505n 0.0v 2029.495n 0.0v 2029.505n 0.0v 2039.495n 0.0v 2039.505n 1.8v 2049.495n 1.8v 2049.505n 1.8v )
* (time, data): [(0, 0), (10, 0), (20, 0), (30, 0), (40, 0), (50, 0), (60, 0), (70, 0), (80, 0), (90, 0), (100, 0), (110, 0), (120, 0), (130, 0), (140, 0), (150, 0), (160, 0), (170, 0), (180, 0), (190, 0), (200, 0), (210, 0), (220, 0), (230, 0), (240, 0), (250, 0), (260, 0), (270, 0), (280, 0), (290, 0), (300, 0), (310, 0), (320, 0), (330, 0), (340, 0), (350, 0), (360, 0), (370, 0), (380, 0), (390, 0), (400, 0), (410, 0), (420, 0), (430, 0), (440, 0), (450, 0), (460, 0), (470, 0), (480, 0), (490, 0), (500, 0), (510, 0), (520, 0), (530, 0), (540, 0), (550, 0), (560, 0), (570, 0), (580, 0), (590, 0), (600, 0), (610, 0), (620, 0), (630, 0), (640, 0), (650, 0), (660, 0), (670, 0), (680, 0), (690, 0), (700, 0), (710, 0), (720, 0), (730, 0), (740, 0), (750, 0), (760, 0), (770, 0), (780, 0), (790, 0), (800, 0), (810, 0), (820, 0), (830, 0), (840, 0), (850, 0), (860, 0), (870, 0), (880, 0), (890, 0), (900, 0), (910, 0), (920, 0), (930, 0), (940, 0), (950, 0), (960, 0), (970, 0), (980, 0), (990, 0), (1000, 0), (1010, 0), (1020, 0), (1030, 0), (1040, 0), (1050, 0), (1060, 0), (1070, 0), (1080, 0), (1090, 0), (1100, 0), (1110, 0), (1120, 0), (1130, 0), (1140, 0), (1150, 0), (1160, 0), (1170, 0), (1180, 0), (1190, 0), (1200, 0), (1210, 0), (1220, 0), (1230, 0), (1240, 0), (1250, 0), (1260, 0), (1270, 0), (1280, 0), (1290, 0), (1300, 0), (1310, 0), (1320, 0), (1330, 0), (1340, 0), (1350, 0), (1360, 0), (1370, 0), (1380, 0), (1390, 0), (1400, 0), (1410, 0), (1420, 0), (1430, 0), (1440, 0), (1450, 0), (1460, 0), (1470, 0), (1480, 0), (1490, 0), (1500, 0), (1510, 0), (1520, 0), (1530, 0), (1540, 0), (1550, 0), (1560, 0), (1570, 0), (1580, 0), (1590, 0), (1600, 0), (1610, 0), (1620, 0), (1630, 0), (1640, 0), (1650, 0), (1660, 0), (1670, 0), (1680, 0), (1690, 0), (1700, 0), (1710, 0), (1720, 0), (1730, 0), (1740, 0), (1750, 0), (1760, 0), (1770, 0), (1780, 0), (1790, 0), (1800, 0), (1810, 0), (1820, 0), (1830, 0), (1840, 0), (1850, 0), (1860, 0), (1870, 0), (1880, 0), (1890, 0), (1900, 0), (1910, 0), (1920, 0), (1930, 0), (1940, 0), (1950, 0), (1960, 0), (1970, 0), (1980, 0), (1990, 0), (2000, 0), (2010, 0), (2020, 0), (2030, 0), (2040, 0), (2050, 0)]
Va0_4  a0_4  0 PWL (0n 0.0v 9.495n 0.0v 9.505n 0.0v 19.495n 0.0v 19.505n 0.0v 29.495n 0.0v 29.505n 0.0v 39.495n 0.0v 39.505n 0.0v 49.495n 0.0v 49.505n 0.0v 59.495n 0.0v 59.505n 0.0v 69.495n 0.0v 69.505n 0.0v 79.495n 0.0v 79.505n 0.0v 89.495n 0.0v 89.505n 0.0v 99.495n 0.0v 99.505n 0.0v 109.495n 0.0v 109.505n 0.0v 119.495n 0.0v 119.505n 0.0v 129.495n 0.0v 129.505n 0.0v 139.495n 0.0v 139.505n 0.0v 149.495n 0.0v 149.505n 0.0v 159.495n 0.0v 159.505n 0.0v 169.495n 0.0v 169.505n 0.0v 179.495n 0.0v 179.505n 0.0v 189.495n 0.0v 189.505n 0.0v 199.495n 0.0v 199.505n 0.0v 209.495n 0.0v 209.505n 0.0v 219.495n 0.0v 219.505n 0.0v 229.495n 0.0v 229.505n 0.0v 239.495n 0.0v 239.505n 0.0v 249.495n 0.0v 249.505n 0.0v 259.495n 0.0v 259.505n 0.0v 269.495n 0.0v 269.505n 0.0v 279.495n 0.0v 279.505n 0.0v 289.495n 0.0v 289.505n 0.0v 299.495n 0.0v 299.505n 0.0v 309.495n 0.0v 309.505n 0.0v 319.495n 0.0v 319.505n 0.0v 329.495n 0.0v 329.505n 0.0v 339.495n 0.0v 339.505n 0.0v 349.495n 0.0v 349.505n 0.0v 359.495n 0.0v 359.505n 0.0v 369.495n 0.0v 369.505n 0.0v 379.495n 0.0v 379.505n 0.0v 389.495n 0.0v 389.505n 0.0v 399.495n 0.0v 399.505n 0.0v 409.495n 0.0v 409.505n 0.0v 419.495n 0.0v 419.505n 0.0v 429.495n 0.0v 429.505n 0.0v 439.495n 0.0v 439.505n 0.0v 449.495n 0.0v 449.505n 0.0v 459.495n 0.0v 459.505n 0.0v 469.495n 0.0v 469.505n 0.0v 479.495n 0.0v 479.505n 0.0v 489.495n 0.0v 489.505n 0.0v 499.495n 0.0v 499.505n 0.0v 509.495n 0.0v 509.505n 0.0v 519.495n 0.0v 519.505n 0.0v 529.495n 0.0v 529.505n 0.0v 539.495n 0.0v 539.505n 0.0v 549.495n 0.0v 549.505n 0.0v 559.495n 0.0v 559.505n 0.0v 569.495n 0.0v 569.505n 0.0v 579.495n 0.0v 579.505n 0.0v 589.495n 0.0v 589.505n 0.0v 599.495n 0.0v 599.505n 0.0v 609.495n 0.0v 609.505n 0.0v 619.495n 0.0v 619.505n 0.0v 629.495n 0.0v 629.505n 0.0v 639.495n 0.0v 639.505n 0.0v 649.495n 0.0v 649.505n 0.0v 659.495n 0.0v 659.505n 0.0v 669.495n 0.0v 669.505n 0.0v 679.495n 0.0v 679.505n 0.0v 689.495n 0.0v 689.505n 0.0v 699.495n 0.0v 699.505n 0.0v 709.495n 0.0v 709.505n 0.0v 719.495n 0.0v 719.505n 0.0v 729.495n 0.0v 729.505n 0.0v 739.495n 0.0v 739.505n 0.0v 749.495n 0.0v 749.505n 0.0v 759.495n 0.0v 759.505n 0.0v 769.495n 0.0v 769.505n 0.0v 779.495n 0.0v 779.505n 0.0v 789.495n 0.0v 789.505n 0.0v 799.495n 0.0v 799.505n 0.0v 809.495n 0.0v 809.505n 0.0v 819.495n 0.0v 819.505n 0.0v 829.495n 0.0v 829.505n 0.0v 839.495n 0.0v 839.505n 0.0v 849.495n 0.0v 849.505n 0.0v 859.495n 0.0v 859.505n 0.0v 869.495n 0.0v 869.505n 0.0v 879.495n 0.0v 879.505n 0.0v 889.495n 0.0v 889.505n 0.0v 899.495n 0.0v 899.505n 0.0v 909.495n 0.0v 909.505n 0.0v 919.495n 0.0v 919.505n 0.0v 929.495n 0.0v 929.505n 0.0v 939.495n 0.0v 939.505n 0.0v 949.495n 0.0v 949.505n 0.0v 959.495n 0.0v 959.505n 0.0v 969.495n 0.0v 969.505n 0.0v 979.495n 0.0v 979.505n 0.0v 989.495n 0.0v 989.505n 0.0v 999.495n 0.0v 999.505n 0.0v 1009.495n 0.0v 1009.505n 0.0v 1019.495n 0.0v 1019.505n 0.0v 1029.495n 0.0v 1029.505n 0.0v 1039.495n 0.0v 1039.505n 0.0v 1049.495n 0.0v 1049.505n 0.0v 1059.495n 0.0v 1059.505n 0.0v 1069.495n 0.0v 1069.505n 0.0v 1079.495n 0.0v 1079.505n 0.0v 1089.495n 0.0v 1089.505n 0.0v 1099.495n 0.0v 1099.505n 0.0v 1109.495n 0.0v 1109.505n 0.0v 1119.495n 0.0v 1119.505n 0.0v 1129.495n 0.0v 1129.505n 0.0v 1139.495n 0.0v 1139.505n 0.0v 1149.495n 0.0v 1149.505n 0.0v 1159.495n 0.0v 1159.505n 0.0v 1169.495n 0.0v 1169.505n 0.0v 1179.495n 0.0v 1179.505n 0.0v 1189.495n 0.0v 1189.505n 0.0v 1199.495n 0.0v 1199.505n 0.0v 1209.495n 0.0v 1209.505n 0.0v 1219.495n 0.0v 1219.505n 0.0v 1229.495n 0.0v 1229.505n 0.0v 1239.495n 0.0v 1239.505n 0.0v 1249.495n 0.0v 1249.505n 0.0v 1259.495n 0.0v 1259.505n 0.0v 1269.495n 0.0v 1269.505n 0.0v 1279.495n 0.0v 1279.505n 0.0v 1289.495n 0.0v 1289.505n 0.0v 1299.495n 0.0v 1299.505n 0.0v 1309.495n 0.0v 1309.505n 0.0v 1319.495n 0.0v 1319.505n 0.0v 1329.495n 0.0v 1329.505n 0.0v 1339.495n 0.0v 1339.505n 0.0v 1349.495n 0.0v 1349.505n 0.0v 1359.495n 0.0v 1359.505n 0.0v 1369.495n 0.0v 1369.505n 0.0v 1379.495n 0.0v 1379.505n 0.0v 1389.495n 0.0v 1389.505n 0.0v 1399.495n 0.0v 1399.505n 0.0v 1409.495n 0.0v 1409.505n 0.0v 1419.495n 0.0v 1419.505n 0.0v 1429.495n 0.0v 1429.505n 0.0v 1439.495n 0.0v 1439.505n 0.0v 1449.495n 0.0v 1449.505n 0.0v 1459.495n 0.0v 1459.505n 0.0v 1469.495n 0.0v 1469.505n 0.0v 1479.495n 0.0v 1479.505n 0.0v 1489.495n 0.0v 1489.505n 0.0v 1499.495n 0.0v 1499.505n 0.0v 1509.495n 0.0v 1509.505n 0.0v 1519.495n 0.0v 1519.505n 0.0v 1529.495n 0.0v 1529.505n 0.0v 1539.495n 0.0v 1539.505n 0.0v 1549.495n 0.0v 1549.505n 0.0v 1559.495n 0.0v 1559.505n 0.0v 1569.495n 0.0v 1569.505n 0.0v 1579.495n 0.0v 1579.505n 0.0v 1589.495n 0.0v 1589.505n 0.0v 1599.495n 0.0v 1599.505n 0.0v 1609.495n 0.0v 1609.505n 0.0v 1619.495n 0.0v 1619.505n 0.0v 1629.495n 0.0v 1629.505n 0.0v 1639.495n 0.0v 1639.505n 0.0v 1649.495n 0.0v 1649.505n 0.0v 1659.495n 0.0v 1659.505n 0.0v 1669.495n 0.0v 1669.505n 0.0v 1679.495n 0.0v 1679.505n 0.0v 1689.495n 0.0v 1689.505n 0.0v 1699.495n 0.0v 1699.505n 0.0v 1709.495n 0.0v 1709.505n 0.0v 1719.495n 0.0v 1719.505n 0.0v 1729.495n 0.0v 1729.505n 0.0v 1739.495n 0.0v 1739.505n 0.0v 1749.495n 0.0v 1749.505n 0.0v 1759.495n 0.0v 1759.505n 0.0v 1769.495n 0.0v 1769.505n 0.0v 1779.495n 0.0v 1779.505n 0.0v 1789.495n 0.0v 1789.505n 0.0v 1799.495n 0.0v 1799.505n 0.0v 1809.495n 0.0v 1809.505n 0.0v 1819.495n 0.0v 1819.505n 0.0v 1829.495n 0.0v 1829.505n 0.0v 1839.495n 0.0v 1839.505n 0.0v 1849.495n 0.0v 1849.505n 0.0v 1859.495n 0.0v 1859.505n 0.0v 1869.495n 0.0v 1869.505n 0.0v 1879.495n 0.0v 1879.505n 0.0v 1889.495n 0.0v 1889.505n 0.0v 1899.495n 0.0v 1899.505n 0.0v 1909.495n 0.0v 1909.505n 0.0v 1919.495n 0.0v 1919.505n 0.0v 1929.495n 0.0v 1929.505n 0.0v 1939.495n 0.0v 1939.505n 0.0v 1949.495n 0.0v 1949.505n 0.0v 1959.495n 0.0v 1959.505n 0.0v 1969.495n 0.0v 1969.505n 0.0v 1979.495n 0.0v 1979.505n 0.0v 1989.495n 0.0v 1989.505n 0.0v 1999.495n 0.0v 1999.505n 0.0v 2009.495n 0.0v 2009.505n 0.0v 2019.495n 0.0v 2019.505n 0.0v 2029.495n 0.0v 2029.505n 0.0v 2039.495n 0.0v 2039.505n 0.0v 2049.495n 0.0v 2049.505n 0.0v )

 * Generation of control signals
* (time, data): [(0, 1), (10, 0), (20, 0), (30, 0), (40, 0), (50, 0), (60, 0), (70, 0), (80, 0), (90, 0), (100, 1), (110, 0), (120, 0), (130, 0), (140, 0), (150, 0), (160, 0), (170, 0), (180, 0), (190, 1), (200, 1), (210, 1), (220, 0), (230, 0), (240, 0), (250, 0), (260, 0), (270, 0), (280, 0), (290, 0), (300, 1), (310, 0), (320, 0), (330, 1), (340, 0), (350, 0), (360, 0), (370, 0), (380, 0), (390, 1), (400, 0), (410, 0), (420, 1), (430, 0), (440, 0), (450, 0), (460, 0), (470, 0), (480, 0), (490, 0), (500, 1), (510, 0), (520, 0), (530, 0), (540, 0), (550, 0), (560, 1), (570, 1), (580, 0), (590, 0), (600, 0), (610, 0), (620, 1), (630, 0), (640, 1), (650, 0), (660, 0), (670, 1), (680, 0), (690, 0), (700, 0), (710, 0), (720, 0), (730, 0), (740, 1), (750, 1), (760, 0), (770, 0), (780, 0), (790, 0), (800, 0), (810, 0), (820, 1), (830, 0), (840, 0), (850, 1), (860, 0), (870, 0), (880, 0), (890, 0), (900, 0), (910, 1), (920, 0), (930, 0), (940, 0), (950, 0), (960, 0), (970, 1), (980, 0), (990, 0), (1000, 0), (1010, 0), (1020, 0), (1030, 1), (1040, 0), (1050, 0), (1060, 0), (1070, 1), (1080, 0), (1090, 0), (1100, 0), (1110, 1), (1120, 1), (1130, 1), (1140, 0), (1150, 0), (1160, 0), (1170, 1), (1180, 0), (1190, 0), (1200, 0), (1210, 1), (1220, 0), (1230, 1), (1240, 1), (1250, 0), (1260, 0), (1270, 0), (1280, 1), (1290, 1), (1300, 0), (1310, 0), (1320, 0), (1330, 0), (1340, 1), (1350, 0), (1360, 0), (1370, 1), (1380, 0), (1390, 0), (1400, 1), (1410, 0), (1420, 0), (1430, 0), (1440, 0), (1450, 0), (1460, 0), (1470, 0), (1480, 1), (1490, 0), (1500, 0), (1510, 0), (1520, 1), (1530, 0), (1540, 0), (1550, 0), (1560, 0), (1570, 0), (1580, 0), (1590, 0), (1600, 0), (1610, 0), (1620, 1), (1630, 0), (1640, 1), (1650, 0), (1660, 1), (1670, 0), (1680, 1), (1690, 1), (1700, 0), (1710, 0), (1720, 1), (1730, 0), (1740, 0), (1750, 0), (1760, 0), (1770, 0), (1780, 1), (1790, 0), (1800, 0), (1810, 0), (1820, 0), (1830, 0), (1840, 0), (1850, 0), (1860, 0), (1870, 0), (1880, 0), (1890, 1), (1900, 1), (1910, 0), (1920, 0), (1930, 0), (1940, 0), (1950, 0), (1960, 0), (1970, 1), (1980, 0), (1990, 1), (2000, 1), (2010, 0), (2020, 1), (2030, 0), (2040, 0), (2050, 1)]
VCSB0 CSB0 0 PWL (0n 1.8v 9.495n 1.8v 9.505n 0.0v 19.495n 0.0v 19.505n 0.0v 29.495n 0.0v 29.505n 0.0v 39.495n 0.0v 39.505n 0.0v 49.495n 0.0v 49.505n 0.0v 59.495n 0.0v 59.505n 0.0v 69.495n 0.0v 69.505n 0.0v 79.495n 0.0v 79.505n 0.0v 89.495n 0.0v 89.505n 0.0v 99.495n 0.0v 99.505n 1.8v 109.495n 1.8v 109.505n 0.0v 119.495n 0.0v 119.505n 0.0v 129.495n 0.0v 129.505n 0.0v 139.495n 0.0v 139.505n 0.0v 149.495n 0.0v 149.505n 0.0v 159.495n 0.0v 159.505n 0.0v 169.495n 0.0v 169.505n 0.0v 179.495n 0.0v 179.505n 0.0v 189.495n 0.0v 189.505n 1.8v 199.495n 1.8v 199.505n 1.8v 209.495n 1.8v 209.505n 1.8v 219.495n 1.8v 219.505n 0.0v 229.495n 0.0v 229.505n 0.0v 239.495n 0.0v 239.505n 0.0v 249.495n 0.0v 249.505n 0.0v 259.495n 0.0v 259.505n 0.0v 269.495n 0.0v 269.505n 0.0v 279.495n 0.0v 279.505n 0.0v 289.495n 0.0v 289.505n 0.0v 299.495n 0.0v 299.505n 1.8v 309.495n 1.8v 309.505n 0.0v 319.495n 0.0v 319.505n 0.0v 329.495n 0.0v 329.505n 1.8v 339.495n 1.8v 339.505n 0.0v 349.495n 0.0v 349.505n 0.0v 359.495n 0.0v 359.505n 0.0v 369.495n 0.0v 369.505n 0.0v 379.495n 0.0v 379.505n 0.0v 389.495n 0.0v 389.505n 1.8v 399.495n 1.8v 399.505n 0.0v 409.495n 0.0v 409.505n 0.0v 419.495n 0.0v 419.505n 1.8v 429.495n 1.8v 429.505n 0.0v 439.495n 0.0v 439.505n 0.0v 449.495n 0.0v 449.505n 0.0v 459.495n 0.0v 459.505n 0.0v 469.495n 0.0v 469.505n 0.0v 479.495n 0.0v 479.505n 0.0v 489.495n 0.0v 489.505n 0.0v 499.495n 0.0v 499.505n 1.8v 509.495n 1.8v 509.505n 0.0v 519.495n 0.0v 519.505n 0.0v 529.495n 0.0v 529.505n 0.0v 539.495n 0.0v 539.505n 0.0v 549.495n 0.0v 549.505n 0.0v 559.495n 0.0v 559.505n 1.8v 569.495n 1.8v 569.505n 1.8v 579.495n 1.8v 579.505n 0.0v 589.495n 0.0v 589.505n 0.0v 599.495n 0.0v 599.505n 0.0v 609.495n 0.0v 609.505n 0.0v 619.495n 0.0v 619.505n 1.8v 629.495n 1.8v 629.505n 0.0v 639.495n 0.0v 639.505n 1.8v 649.495n 1.8v 649.505n 0.0v 659.495n 0.0v 659.505n 0.0v 669.495n 0.0v 669.505n 1.8v 679.495n 1.8v 679.505n 0.0v 689.495n 0.0v 689.505n 0.0v 699.495n 0.0v 699.505n 0.0v 709.495n 0.0v 709.505n 0.0v 719.495n 0.0v 719.505n 0.0v 729.495n 0.0v 729.505n 0.0v 739.495n 0.0v 739.505n 1.8v 749.495n 1.8v 749.505n 1.8v 759.495n 1.8v 759.505n 0.0v 769.495n 0.0v 769.505n 0.0v 779.495n 0.0v 779.505n 0.0v 789.495n 0.0v 789.505n 0.0v 799.495n 0.0v 799.505n 0.0v 809.495n 0.0v 809.505n 0.0v 819.495n 0.0v 819.505n 1.8v 829.495n 1.8v 829.505n 0.0v 839.495n 0.0v 839.505n 0.0v 849.495n 0.0v 849.505n 1.8v 859.495n 1.8v 859.505n 0.0v 869.495n 0.0v 869.505n 0.0v 879.495n 0.0v 879.505n 0.0v 889.495n 0.0v 889.505n 0.0v 899.495n 0.0v 899.505n 0.0v 909.495n 0.0v 909.505n 1.8v 919.495n 1.8v 919.505n 0.0v 929.495n 0.0v 929.505n 0.0v 939.495n 0.0v 939.505n 0.0v 949.495n 0.0v 949.505n 0.0v 959.495n 0.0v 959.505n 0.0v 969.495n 0.0v 969.505n 1.8v 979.495n 1.8v 979.505n 0.0v 989.495n 0.0v 989.505n 0.0v 999.495n 0.0v 999.505n 0.0v 1009.495n 0.0v 1009.505n 0.0v 1019.495n 0.0v 1019.505n 0.0v 1029.495n 0.0v 1029.505n 1.8v 1039.495n 1.8v 1039.505n 0.0v 1049.495n 0.0v 1049.505n 0.0v 1059.495n 0.0v 1059.505n 0.0v 1069.495n 0.0v 1069.505n 1.8v 1079.495n 1.8v 1079.505n 0.0v 1089.495n 0.0v 1089.505n 0.0v 1099.495n 0.0v 1099.505n 0.0v 1109.495n 0.0v 1109.505n 1.8v 1119.495n 1.8v 1119.505n 1.8v 1129.495n 1.8v 1129.505n 1.8v 1139.495n 1.8v 1139.505n 0.0v 1149.495n 0.0v 1149.505n 0.0v 1159.495n 0.0v 1159.505n 0.0v 1169.495n 0.0v 1169.505n 1.8v 1179.495n 1.8v 1179.505n 0.0v 1189.495n 0.0v 1189.505n 0.0v 1199.495n 0.0v 1199.505n 0.0v 1209.495n 0.0v 1209.505n 1.8v 1219.495n 1.8v 1219.505n 0.0v 1229.495n 0.0v 1229.505n 1.8v 1239.495n 1.8v 1239.505n 1.8v 1249.495n 1.8v 1249.505n 0.0v 1259.495n 0.0v 1259.505n 0.0v 1269.495n 0.0v 1269.505n 0.0v 1279.495n 0.0v 1279.505n 1.8v 1289.495n 1.8v 1289.505n 1.8v 1299.495n 1.8v 1299.505n 0.0v 1309.495n 0.0v 1309.505n 0.0v 1319.495n 0.0v 1319.505n 0.0v 1329.495n 0.0v 1329.505n 0.0v 1339.495n 0.0v 1339.505n 1.8v 1349.495n 1.8v 1349.505n 0.0v 1359.495n 0.0v 1359.505n 0.0v 1369.495n 0.0v 1369.505n 1.8v 1379.495n 1.8v 1379.505n 0.0v 1389.495n 0.0v 1389.505n 0.0v 1399.495n 0.0v 1399.505n 1.8v 1409.495n 1.8v 1409.505n 0.0v 1419.495n 0.0v 1419.505n 0.0v 1429.495n 0.0v 1429.505n 0.0v 1439.495n 0.0v 1439.505n 0.0v 1449.495n 0.0v 1449.505n 0.0v 1459.495n 0.0v 1459.505n 0.0v 1469.495n 0.0v 1469.505n 0.0v 1479.495n 0.0v 1479.505n 1.8v 1489.495n 1.8v 1489.505n 0.0v 1499.495n 0.0v 1499.505n 0.0v 1509.495n 0.0v 1509.505n 0.0v 1519.495n 0.0v 1519.505n 1.8v 1529.495n 1.8v 1529.505n 0.0v 1539.495n 0.0v 1539.505n 0.0v 1549.495n 0.0v 1549.505n 0.0v 1559.495n 0.0v 1559.505n 0.0v 1569.495n 0.0v 1569.505n 0.0v 1579.495n 0.0v 1579.505n 0.0v 1589.495n 0.0v 1589.505n 0.0v 1599.495n 0.0v 1599.505n 0.0v 1609.495n 0.0v 1609.505n 0.0v 1619.495n 0.0v 1619.505n 1.8v 1629.495n 1.8v 1629.505n 0.0v 1639.495n 0.0v 1639.505n 1.8v 1649.495n 1.8v 1649.505n 0.0v 1659.495n 0.0v 1659.505n 1.8v 1669.495n 1.8v 1669.505n 0.0v 1679.495n 0.0v 1679.505n 1.8v 1689.495n 1.8v 1689.505n 1.8v 1699.495n 1.8v 1699.505n 0.0v 1709.495n 0.0v 1709.505n 0.0v 1719.495n 0.0v 1719.505n 1.8v 1729.495n 1.8v 1729.505n 0.0v 1739.495n 0.0v 1739.505n 0.0v 1749.495n 0.0v 1749.505n 0.0v 1759.495n 0.0v 1759.505n 0.0v 1769.495n 0.0v 1769.505n 0.0v 1779.495n 0.0v 1779.505n 1.8v 1789.495n 1.8v 1789.505n 0.0v 1799.495n 0.0v 1799.505n 0.0v 1809.495n 0.0v 1809.505n 0.0v 1819.495n 0.0v 1819.505n 0.0v 1829.495n 0.0v 1829.505n 0.0v 1839.495n 0.0v 1839.505n 0.0v 1849.495n 0.0v 1849.505n 0.0v 1859.495n 0.0v 1859.505n 0.0v 1869.495n 0.0v 1869.505n 0.0v 1879.495n 0.0v 1879.505n 0.0v 1889.495n 0.0v 1889.505n 1.8v 1899.495n 1.8v 1899.505n 1.8v 1909.495n 1.8v 1909.505n 0.0v 1919.495n 0.0v 1919.505n 0.0v 1929.495n 0.0v 1929.505n 0.0v 1939.495n 0.0v 1939.505n 0.0v 1949.495n 0.0v 1949.505n 0.0v 1959.495n 0.0v 1959.505n 0.0v 1969.495n 0.0v 1969.505n 1.8v 1979.495n 1.8v 1979.505n 0.0v 1989.495n 0.0v 1989.505n 1.8v 1999.495n 1.8v 1999.505n 1.8v 2009.495n 1.8v 2009.505n 0.0v 2019.495n 0.0v 2019.505n 1.8v 2029.495n 1.8v 2029.505n 0.0v 2039.495n 0.0v 2039.505n 0.0v 2049.495n 0.0v 2049.505n 1.8v )
* (time, data): [(0, 1), (10, 0), (20, 0), (30, 0), (40, 1), (50, 1), (60, 0), (70, 1), (80, 0), (90, 1), (100, 1), (110, 0), (120, 0), (130, 1), (140, 1), (150, 1), (160, 1), (170, 1), (180, 1), (190, 1), (200, 1), (210, 1), (220, 1), (230, 1), (240, 1), (250, 1), (260, 0), (270, 1), (280, 0), (290, 1), (300, 1), (310, 1), (320, 1), (330, 1), (340, 1), (350, 1), (360, 1), (370, 1), (380, 1), (390, 1), (400, 0), (410, 1), (420, 1), (430, 1), (440, 1), (450, 0), (460, 0), (470, 0), (480, 1), (490, 1), (500, 1), (510, 1), (520, 1), (530, 1), (540, 0), (550, 1), (560, 1), (570, 1), (580, 1), (590, 0), (600, 0), (610, 1), (620, 1), (630, 0), (640, 1), (650, 1), (660, 0), (670, 1), (680, 1), (690, 0), (700, 0), (710, 1), (720, 1), (730, 1), (740, 1), (750, 1), (760, 1), (770, 0), (780, 0), (790, 1), (800, 1), (810, 1), (820, 1), (830, 0), (840, 1), (850, 1), (860, 1), (870, 1), (880, 0), (890, 0), (900, 0), (910, 1), (920, 1), (930, 1), (940, 0), (950, 1), (960, 1), (970, 1), (980, 1), (990, 1), (1000, 0), (1010, 1), (1020, 0), (1030, 1), (1040, 1), (1050, 1), (1060, 1), (1070, 1), (1080, 0), (1090, 0), (1100, 1), (1110, 1), (1120, 1), (1130, 1), (1140, 0), (1150, 1), (1160, 1), (1170, 1), (1180, 1), (1190, 1), (1200, 1), (1210, 1), (1220, 1), (1230, 1), (1240, 1), (1250, 1), (1260, 0), (1270, 1), (1280, 1), (1290, 1), (1300, 0), (1310, 0), (1320, 1), (1330, 1), (1340, 1), (1350, 1), (1360, 0), (1370, 1), (1380, 1), (1390, 1), (1400, 1), (1410, 0), (1420, 1), (1430, 0), (1440, 0), (1450, 1), (1460, 0), (1470, 0), (1480, 1), (1490, 0), (1500, 1), (1510, 1), (1520, 1), (1530, 1), (1540, 1), (1550, 0), (1560, 1), (1570, 1), (1580, 0), (1590, 0), (1600, 1), (1610, 1), (1620, 1), (1630, 0), (1640, 1), (1650, 1), (1660, 1), (1670, 1), (1680, 1), (1690, 1), (1700, 0), (1710, 0), (1720, 1), (1730, 0), (1740, 1), (1750, 1), (1760, 1), (1770, 1), (1780, 1), (1790, 1), (1800, 0), (1810, 1), (1820, 1), (1830, 1), (1840, 0), (1850, 1), (1860, 0), (1870, 1), (1880, 1), (1890, 1), (1900, 1), (1910, 0), (1920, 1), (1930, 1), (1940, 1), (1950, 1), (1960, 0), (1970, 1), (1980, 1), (1990, 1), (2000, 1), (2010, 1), (2020, 1), (2030, 0), (2040, 0), (2050, 1)]
VWEB0 WEB0 0 PWL (0n 1.8v 9.495n 1.8v 9.505n 0.0v 19.495n 0.0v 19.505n 0.0v 29.495n 0.0v 29.505n 0.0v 39.495n 0.0v 39.505n 1.8v 49.495n 1.8v 49.505n 1.8v 59.495n 1.8v 59.505n 0.0v 69.495n 0.0v 69.505n 1.8v 79.495n 1.8v 79.505n 0.0v 89.495n 0.0v 89.505n 1.8v 99.495n 1.8v 99.505n 1.8v 109.495n 1.8v 109.505n 0.0v 119.495n 0.0v 119.505n 0.0v 129.495n 0.0v 129.505n 1.8v 139.495n 1.8v 139.505n 1.8v 149.495n 1.8v 149.505n 1.8v 159.495n 1.8v 159.505n 1.8v 169.495n 1.8v 169.505n 1.8v 179.495n 1.8v 179.505n 1.8v 189.495n 1.8v 189.505n 1.8v 199.495n 1.8v 199.505n 1.8v 209.495n 1.8v 209.505n 1.8v 219.495n 1.8v 219.505n 1.8v 229.495n 1.8v 229.505n 1.8v 239.495n 1.8v 239.505n 1.8v 249.495n 1.8v 249.505n 1.8v 259.495n 1.8v 259.505n 0.0v 269.495n 0.0v 269.505n 1.8v 279.495n 1.8v 279.505n 0.0v 289.495n 0.0v 289.505n 1.8v 299.495n 1.8v 299.505n 1.8v 309.495n 1.8v 309.505n 1.8v 319.495n 1.8v 319.505n 1.8v 329.495n 1.8v 329.505n 1.8v 339.495n 1.8v 339.505n 1.8v 349.495n 1.8v 349.505n 1.8v 359.495n 1.8v 359.505n 1.8v 369.495n 1.8v 369.505n 1.8v 379.495n 1.8v 379.505n 1.8v 389.495n 1.8v 389.505n 1.8v 399.495n 1.8v 399.505n 0.0v 409.495n 0.0v 409.505n 1.8v 419.495n 1.8v 419.505n 1.8v 429.495n 1.8v 429.505n 1.8v 439.495n 1.8v 439.505n 1.8v 449.495n 1.8v 449.505n 0.0v 459.495n 0.0v 459.505n 0.0v 469.495n 0.0v 469.505n 0.0v 479.495n 0.0v 479.505n 1.8v 489.495n 1.8v 489.505n 1.8v 499.495n 1.8v 499.505n 1.8v 509.495n 1.8v 509.505n 1.8v 519.495n 1.8v 519.505n 1.8v 529.495n 1.8v 529.505n 1.8v 539.495n 1.8v 539.505n 0.0v 549.495n 0.0v 549.505n 1.8v 559.495n 1.8v 559.505n 1.8v 569.495n 1.8v 569.505n 1.8v 579.495n 1.8v 579.505n 1.8v 589.495n 1.8v 589.505n 0.0v 599.495n 0.0v 599.505n 0.0v 609.495n 0.0v 609.505n 1.8v 619.495n 1.8v 619.505n 1.8v 629.495n 1.8v 629.505n 0.0v 639.495n 0.0v 639.505n 1.8v 649.495n 1.8v 649.505n 1.8v 659.495n 1.8v 659.505n 0.0v 669.495n 0.0v 669.505n 1.8v 679.495n 1.8v 679.505n 1.8v 689.495n 1.8v 689.505n 0.0v 699.495n 0.0v 699.505n 0.0v 709.495n 0.0v 709.505n 1.8v 719.495n 1.8v 719.505n 1.8v 729.495n 1.8v 729.505n 1.8v 739.495n 1.8v 739.505n 1.8v 749.495n 1.8v 749.505n 1.8v 759.495n 1.8v 759.505n 1.8v 769.495n 1.8v 769.505n 0.0v 779.495n 0.0v 779.505n 0.0v 789.495n 0.0v 789.505n 1.8v 799.495n 1.8v 799.505n 1.8v 809.495n 1.8v 809.505n 1.8v 819.495n 1.8v 819.505n 1.8v 829.495n 1.8v 829.505n 0.0v 839.495n 0.0v 839.505n 1.8v 849.495n 1.8v 849.505n 1.8v 859.495n 1.8v 859.505n 1.8v 869.495n 1.8v 869.505n 1.8v 879.495n 1.8v 879.505n 0.0v 889.495n 0.0v 889.505n 0.0v 899.495n 0.0v 899.505n 0.0v 909.495n 0.0v 909.505n 1.8v 919.495n 1.8v 919.505n 1.8v 929.495n 1.8v 929.505n 1.8v 939.495n 1.8v 939.505n 0.0v 949.495n 0.0v 949.505n 1.8v 959.495n 1.8v 959.505n 1.8v 969.495n 1.8v 969.505n 1.8v 979.495n 1.8v 979.505n 1.8v 989.495n 1.8v 989.505n 1.8v 999.495n 1.8v 999.505n 0.0v 1009.495n 0.0v 1009.505n 1.8v 1019.495n 1.8v 1019.505n 0.0v 1029.495n 0.0v 1029.505n 1.8v 1039.495n 1.8v 1039.505n 1.8v 1049.495n 1.8v 1049.505n 1.8v 1059.495n 1.8v 1059.505n 1.8v 1069.495n 1.8v 1069.505n 1.8v 1079.495n 1.8v 1079.505n 0.0v 1089.495n 0.0v 1089.505n 0.0v 1099.495n 0.0v 1099.505n 1.8v 1109.495n 1.8v 1109.505n 1.8v 1119.495n 1.8v 1119.505n 1.8v 1129.495n 1.8v 1129.505n 1.8v 1139.495n 1.8v 1139.505n 0.0v 1149.495n 0.0v 1149.505n 1.8v 1159.495n 1.8v 1159.505n 1.8v 1169.495n 1.8v 1169.505n 1.8v 1179.495n 1.8v 1179.505n 1.8v 1189.495n 1.8v 1189.505n 1.8v 1199.495n 1.8v 1199.505n 1.8v 1209.495n 1.8v 1209.505n 1.8v 1219.495n 1.8v 1219.505n 1.8v 1229.495n 1.8v 1229.505n 1.8v 1239.495n 1.8v 1239.505n 1.8v 1249.495n 1.8v 1249.505n 1.8v 1259.495n 1.8v 1259.505n 0.0v 1269.495n 0.0v 1269.505n 1.8v 1279.495n 1.8v 1279.505n 1.8v 1289.495n 1.8v 1289.505n 1.8v 1299.495n 1.8v 1299.505n 0.0v 1309.495n 0.0v 1309.505n 0.0v 1319.495n 0.0v 1319.505n 1.8v 1329.495n 1.8v 1329.505n 1.8v 1339.495n 1.8v 1339.505n 1.8v 1349.495n 1.8v 1349.505n 1.8v 1359.495n 1.8v 1359.505n 0.0v 1369.495n 0.0v 1369.505n 1.8v 1379.495n 1.8v 1379.505n 1.8v 1389.495n 1.8v 1389.505n 1.8v 1399.495n 1.8v 1399.505n 1.8v 1409.495n 1.8v 1409.505n 0.0v 1419.495n 0.0v 1419.505n 1.8v 1429.495n 1.8v 1429.505n 0.0v 1439.495n 0.0v 1439.505n 0.0v 1449.495n 0.0v 1449.505n 1.8v 1459.495n 1.8v 1459.505n 0.0v 1469.495n 0.0v 1469.505n 0.0v 1479.495n 0.0v 1479.505n 1.8v 1489.495n 1.8v 1489.505n 0.0v 1499.495n 0.0v 1499.505n 1.8v 1509.495n 1.8v 1509.505n 1.8v 1519.495n 1.8v 1519.505n 1.8v 1529.495n 1.8v 1529.505n 1.8v 1539.495n 1.8v 1539.505n 1.8v 1549.495n 1.8v 1549.505n 0.0v 1559.495n 0.0v 1559.505n 1.8v 1569.495n 1.8v 1569.505n 1.8v 1579.495n 1.8v 1579.505n 0.0v 1589.495n 0.0v 1589.505n 0.0v 1599.495n 0.0v 1599.505n 1.8v 1609.495n 1.8v 1609.505n 1.8v 1619.495n 1.8v 1619.505n 1.8v 1629.495n 1.8v 1629.505n 0.0v 1639.495n 0.0v 1639.505n 1.8v 1649.495n 1.8v 1649.505n 1.8v 1659.495n 1.8v 1659.505n 1.8v 1669.495n 1.8v 1669.505n 1.8v 1679.495n 1.8v 1679.505n 1.8v 1689.495n 1.8v 1689.505n 1.8v 1699.495n 1.8v 1699.505n 0.0v 1709.495n 0.0v 1709.505n 0.0v 1719.495n 0.0v 1719.505n 1.8v 1729.495n 1.8v 1729.505n 0.0v 1739.495n 0.0v 1739.505n 1.8v 1749.495n 1.8v 1749.505n 1.8v 1759.495n 1.8v 1759.505n 1.8v 1769.495n 1.8v 1769.505n 1.8v 1779.495n 1.8v 1779.505n 1.8v 1789.495n 1.8v 1789.505n 1.8v 1799.495n 1.8v 1799.505n 0.0v 1809.495n 0.0v 1809.505n 1.8v 1819.495n 1.8v 1819.505n 1.8v 1829.495n 1.8v 1829.505n 1.8v 1839.495n 1.8v 1839.505n 0.0v 1849.495n 0.0v 1849.505n 1.8v 1859.495n 1.8v 1859.505n 0.0v 1869.495n 0.0v 1869.505n 1.8v 1879.495n 1.8v 1879.505n 1.8v 1889.495n 1.8v 1889.505n 1.8v 1899.495n 1.8v 1899.505n 1.8v 1909.495n 1.8v 1909.505n 0.0v 1919.495n 0.0v 1919.505n 1.8v 1929.495n 1.8v 1929.505n 1.8v 1939.495n 1.8v 1939.505n 1.8v 1949.495n 1.8v 1949.505n 1.8v 1959.495n 1.8v 1959.505n 0.0v 1969.495n 0.0v 1969.505n 1.8v 1979.495n 1.8v 1979.505n 1.8v 1989.495n 1.8v 1989.505n 1.8v 1999.495n 1.8v 1999.505n 1.8v 2009.495n 1.8v 2009.505n 1.8v 2019.495n 1.8v 2019.505n 1.8v 2029.495n 1.8v 2029.505n 0.0v 2039.495n 0.0v 2039.505n 0.0v 2049.495n 0.0v 2049.505n 1.8v )

* Generation of spare enable signals
* (time, data): [(0, 0), (10, 0), (20, 0), (30, 0), (40, 0), (50, 0), (60, 0), (70, 0), (80, 0), (90, 0), (100, 0), (110, 0), (120, 0), (130, 0), (140, 0), (150, 0), (160, 0), (170, 0), (180, 0), (190, 0), (200, 0), (210, 0), (220, 0), (230, 0), (240, 0), (250, 0), (260, 0), (270, 0), (280, 0), (290, 0), (300, 0), (310, 0), (320, 0), (330, 0), (340, 0), (350, 0), (360, 0), (370, 0), (380, 0), (390, 0), (400, 0), (410, 0), (420, 0), (430, 0), (440, 0), (450, 0), (460, 0), (470, 0), (480, 0), (490, 0), (500, 0), (510, 0), (520, 0), (530, 0), (540, 0), (550, 0), (560, 0), (570, 0), (580, 0), (590, 0), (600, 0), (610, 0), (620, 0), (630, 0), (640, 0), (650, 0), (660, 0), (670, 0), (680, 0), (690, 0), (700, 0), (710, 0), (720, 0), (730, 0), (740, 0), (750, 0), (760, 0), (770, 0), (780, 0), (790, 0), (800, 0), (810, 0), (820, 0), (830, 0), (840, 0), (850, 0), (860, 0), (870, 0), (880, 0), (890, 0), (900, 0), (910, 0), (920, 0), (930, 0), (940, 0), (950, 0), (960, 0), (970, 0), (980, 0), (990, 0), (1000, 0), (1010, 0), (1020, 0), (1030, 0), (1040, 0), (1050, 0), (1060, 0), (1070, 0), (1080, 0), (1090, 0), (1100, 0), (1110, 0), (1120, 0), (1130, 0), (1140, 0), (1150, 0), (1160, 0), (1170, 0), (1180, 0), (1190, 0), (1200, 0), (1210, 0), (1220, 0), (1230, 0), (1240, 0), (1250, 0), (1260, 0), (1270, 0), (1280, 0), (1290, 0), (1300, 0), (1310, 0), (1320, 0), (1330, 0), (1340, 0), (1350, 0), (1360, 0), (1370, 0), (1380, 0), (1390, 0), (1400, 0), (1410, 0), (1420, 0), (1430, 0), (1440, 0), (1450, 0), (1460, 0), (1470, 0), (1480, 0), (1490, 0), (1500, 0), (1510, 0), (1520, 0), (1530, 0), (1540, 0), (1550, 0), (1560, 0), (1570, 0), (1580, 0), (1590, 0), (1600, 0), (1610, 0), (1620, 0), (1630, 0), (1640, 0), (1650, 0), (1660, 0), (1670, 0), (1680, 0), (1690, 0), (1700, 0), (1710, 0), (1720, 0), (1730, 0), (1740, 0), (1750, 0), (1760, 0), (1770, 0), (1780, 0), (1790, 0), (1800, 0), (1810, 0), (1820, 0), (1830, 0), (1840, 0), (1850, 0), (1860, 0), (1870, 0), (1880, 0), (1890, 0), (1900, 0), (1910, 0), (1920, 0), (1930, 0), (1940, 0), (1950, 0), (1960, 0), (1970, 0), (1980, 0), (1990, 0), (2000, 0), (2010, 0), (2020, 0), (2030, 0), (2040, 0), (2050, 0)]
VSPARE_WEN0_0  SPARE_WEN0_0  0 PWL (0n 0.0v 9.495n 0.0v 9.505n 0.0v 19.495n 0.0v 19.505n 0.0v 29.495n 0.0v 29.505n 0.0v 39.495n 0.0v 39.505n 0.0v 49.495n 0.0v 49.505n 0.0v 59.495n 0.0v 59.505n 0.0v 69.495n 0.0v 69.505n 0.0v 79.495n 0.0v 79.505n 0.0v 89.495n 0.0v 89.505n 0.0v 99.495n 0.0v 99.505n 0.0v 109.495n 0.0v 109.505n 0.0v 119.495n 0.0v 119.505n 0.0v 129.495n 0.0v 129.505n 0.0v 139.495n 0.0v 139.505n 0.0v 149.495n 0.0v 149.505n 0.0v 159.495n 0.0v 159.505n 0.0v 169.495n 0.0v 169.505n 0.0v 179.495n 0.0v 179.505n 0.0v 189.495n 0.0v 189.505n 0.0v 199.495n 0.0v 199.505n 0.0v 209.495n 0.0v 209.505n 0.0v 219.495n 0.0v 219.505n 0.0v 229.495n 0.0v 229.505n 0.0v 239.495n 0.0v 239.505n 0.0v 249.495n 0.0v 249.505n 0.0v 259.495n 0.0v 259.505n 0.0v 269.495n 0.0v 269.505n 0.0v 279.495n 0.0v 279.505n 0.0v 289.495n 0.0v 289.505n 0.0v 299.495n 0.0v 299.505n 0.0v 309.495n 0.0v 309.505n 0.0v 319.495n 0.0v 319.505n 0.0v 329.495n 0.0v 329.505n 0.0v 339.495n 0.0v 339.505n 0.0v 349.495n 0.0v 349.505n 0.0v 359.495n 0.0v 359.505n 0.0v 369.495n 0.0v 369.505n 0.0v 379.495n 0.0v 379.505n 0.0v 389.495n 0.0v 389.505n 0.0v 399.495n 0.0v 399.505n 0.0v 409.495n 0.0v 409.505n 0.0v 419.495n 0.0v 419.505n 0.0v 429.495n 0.0v 429.505n 0.0v 439.495n 0.0v 439.505n 0.0v 449.495n 0.0v 449.505n 0.0v 459.495n 0.0v 459.505n 0.0v 469.495n 0.0v 469.505n 0.0v 479.495n 0.0v 479.505n 0.0v 489.495n 0.0v 489.505n 0.0v 499.495n 0.0v 499.505n 0.0v 509.495n 0.0v 509.505n 0.0v 519.495n 0.0v 519.505n 0.0v 529.495n 0.0v 529.505n 0.0v 539.495n 0.0v 539.505n 0.0v 549.495n 0.0v 549.505n 0.0v 559.495n 0.0v 559.505n 0.0v 569.495n 0.0v 569.505n 0.0v 579.495n 0.0v 579.505n 0.0v 589.495n 0.0v 589.505n 0.0v 599.495n 0.0v 599.505n 0.0v 609.495n 0.0v 609.505n 0.0v 619.495n 0.0v 619.505n 0.0v 629.495n 0.0v 629.505n 0.0v 639.495n 0.0v 639.505n 0.0v 649.495n 0.0v 649.505n 0.0v 659.495n 0.0v 659.505n 0.0v 669.495n 0.0v 669.505n 0.0v 679.495n 0.0v 679.505n 0.0v 689.495n 0.0v 689.505n 0.0v 699.495n 0.0v 699.505n 0.0v 709.495n 0.0v 709.505n 0.0v 719.495n 0.0v 719.505n 0.0v 729.495n 0.0v 729.505n 0.0v 739.495n 0.0v 739.505n 0.0v 749.495n 0.0v 749.505n 0.0v 759.495n 0.0v 759.505n 0.0v 769.495n 0.0v 769.505n 0.0v 779.495n 0.0v 779.505n 0.0v 789.495n 0.0v 789.505n 0.0v 799.495n 0.0v 799.505n 0.0v 809.495n 0.0v 809.505n 0.0v 819.495n 0.0v 819.505n 0.0v 829.495n 0.0v 829.505n 0.0v 839.495n 0.0v 839.505n 0.0v 849.495n 0.0v 849.505n 0.0v 859.495n 0.0v 859.505n 0.0v 869.495n 0.0v 869.505n 0.0v 879.495n 0.0v 879.505n 0.0v 889.495n 0.0v 889.505n 0.0v 899.495n 0.0v 899.505n 0.0v 909.495n 0.0v 909.505n 0.0v 919.495n 0.0v 919.505n 0.0v 929.495n 0.0v 929.505n 0.0v 939.495n 0.0v 939.505n 0.0v 949.495n 0.0v 949.505n 0.0v 959.495n 0.0v 959.505n 0.0v 969.495n 0.0v 969.505n 0.0v 979.495n 0.0v 979.505n 0.0v 989.495n 0.0v 989.505n 0.0v 999.495n 0.0v 999.505n 0.0v 1009.495n 0.0v 1009.505n 0.0v 1019.495n 0.0v 1019.505n 0.0v 1029.495n 0.0v 1029.505n 0.0v 1039.495n 0.0v 1039.505n 0.0v 1049.495n 0.0v 1049.505n 0.0v 1059.495n 0.0v 1059.505n 0.0v 1069.495n 0.0v 1069.505n 0.0v 1079.495n 0.0v 1079.505n 0.0v 1089.495n 0.0v 1089.505n 0.0v 1099.495n 0.0v 1099.505n 0.0v 1109.495n 0.0v 1109.505n 0.0v 1119.495n 0.0v 1119.505n 0.0v 1129.495n 0.0v 1129.505n 0.0v 1139.495n 0.0v 1139.505n 0.0v 1149.495n 0.0v 1149.505n 0.0v 1159.495n 0.0v 1159.505n 0.0v 1169.495n 0.0v 1169.505n 0.0v 1179.495n 0.0v 1179.505n 0.0v 1189.495n 0.0v 1189.505n 0.0v 1199.495n 0.0v 1199.505n 0.0v 1209.495n 0.0v 1209.505n 0.0v 1219.495n 0.0v 1219.505n 0.0v 1229.495n 0.0v 1229.505n 0.0v 1239.495n 0.0v 1239.505n 0.0v 1249.495n 0.0v 1249.505n 0.0v 1259.495n 0.0v 1259.505n 0.0v 1269.495n 0.0v 1269.505n 0.0v 1279.495n 0.0v 1279.505n 0.0v 1289.495n 0.0v 1289.505n 0.0v 1299.495n 0.0v 1299.505n 0.0v 1309.495n 0.0v 1309.505n 0.0v 1319.495n 0.0v 1319.505n 0.0v 1329.495n 0.0v 1329.505n 0.0v 1339.495n 0.0v 1339.505n 0.0v 1349.495n 0.0v 1349.505n 0.0v 1359.495n 0.0v 1359.505n 0.0v 1369.495n 0.0v 1369.505n 0.0v 1379.495n 0.0v 1379.505n 0.0v 1389.495n 0.0v 1389.505n 0.0v 1399.495n 0.0v 1399.505n 0.0v 1409.495n 0.0v 1409.505n 0.0v 1419.495n 0.0v 1419.505n 0.0v 1429.495n 0.0v 1429.505n 0.0v 1439.495n 0.0v 1439.505n 0.0v 1449.495n 0.0v 1449.505n 0.0v 1459.495n 0.0v 1459.505n 0.0v 1469.495n 0.0v 1469.505n 0.0v 1479.495n 0.0v 1479.505n 0.0v 1489.495n 0.0v 1489.505n 0.0v 1499.495n 0.0v 1499.505n 0.0v 1509.495n 0.0v 1509.505n 0.0v 1519.495n 0.0v 1519.505n 0.0v 1529.495n 0.0v 1529.505n 0.0v 1539.495n 0.0v 1539.505n 0.0v 1549.495n 0.0v 1549.505n 0.0v 1559.495n 0.0v 1559.505n 0.0v 1569.495n 0.0v 1569.505n 0.0v 1579.495n 0.0v 1579.505n 0.0v 1589.495n 0.0v 1589.505n 0.0v 1599.495n 0.0v 1599.505n 0.0v 1609.495n 0.0v 1609.505n 0.0v 1619.495n 0.0v 1619.505n 0.0v 1629.495n 0.0v 1629.505n 0.0v 1639.495n 0.0v 1639.505n 0.0v 1649.495n 0.0v 1649.505n 0.0v 1659.495n 0.0v 1659.505n 0.0v 1669.495n 0.0v 1669.505n 0.0v 1679.495n 0.0v 1679.505n 0.0v 1689.495n 0.0v 1689.505n 0.0v 1699.495n 0.0v 1699.505n 0.0v 1709.495n 0.0v 1709.505n 0.0v 1719.495n 0.0v 1719.505n 0.0v 1729.495n 0.0v 1729.505n 0.0v 1739.495n 0.0v 1739.505n 0.0v 1749.495n 0.0v 1749.505n 0.0v 1759.495n 0.0v 1759.505n 0.0v 1769.495n 0.0v 1769.505n 0.0v 1779.495n 0.0v 1779.505n 0.0v 1789.495n 0.0v 1789.505n 0.0v 1799.495n 0.0v 1799.505n 0.0v 1809.495n 0.0v 1809.505n 0.0v 1819.495n 0.0v 1819.505n 0.0v 1829.495n 0.0v 1829.505n 0.0v 1839.495n 0.0v 1839.505n 0.0v 1849.495n 0.0v 1849.505n 0.0v 1859.495n 0.0v 1859.505n 0.0v 1869.495n 0.0v 1869.505n 0.0v 1879.495n 0.0v 1879.505n 0.0v 1889.495n 0.0v 1889.505n 0.0v 1899.495n 0.0v 1899.505n 0.0v 1909.495n 0.0v 1909.505n 0.0v 1919.495n 0.0v 1919.505n 0.0v 1929.495n 0.0v 1929.505n 0.0v 1939.495n 0.0v 1939.505n 0.0v 1949.495n 0.0v 1949.505n 0.0v 1959.495n 0.0v 1959.505n 0.0v 1969.495n 0.0v 1969.505n 0.0v 1979.495n 0.0v 1979.505n 0.0v 1989.495n 0.0v 1989.505n 0.0v 1999.495n 0.0v 1999.505n 0.0v 2009.495n 0.0v 2009.505n 0.0v 2019.495n 0.0v 2019.505n 0.0v 2029.495n 0.0v 2029.505n 0.0v 2039.495n 0.0v 2039.505n 0.0v 2049.495n 0.0v 2049.505n 0.0v )
* PULSE: period=10
Vclk0 clk0 0 PULSE (0 1.8 9.995n 0.01n 0.01n 4.99n 10n)

 * Generation of dout measurements
* CHECK dout0_0 vdout0_0ck4 = 1.8 time = 50
* CHECK dout0_1 vdout0_1ck4 = 0 time = 50
* CHECK dout0_2 vdout0_2ck4 = 1.8 time = 50
* CHECK dout0_3 vdout0_3ck4 = 1.8 time = 50
* CHECK dout0_4 vdout0_4ck4 = 0 time = 50
* CHECK dout0_5 vdout0_5ck4 = 0 time = 50
* CHECK dout0_6 vdout0_6ck4 = 0 time = 50
* CHECK dout0_7 vdout0_7ck4 = 0 time = 50
* CHECK dout0_8 vdout0_8ck4 = 1.8 time = 50
* CHECK dout0_9 vdout0_9ck4 = 0 time = 50
* CHECK dout0_10 vdout0_10ck4 = 1.8 time = 50
* CHECK dout0_11 vdout0_11ck4 = 1.8 time = 50
* CHECK dout0_12 vdout0_12ck4 = 1.8 time = 50
* CHECK dout0_13 vdout0_13ck4 = 0 time = 50
* CHECK dout0_14 vdout0_14ck4 = 1.8 time = 50
* CHECK dout0_15 vdout0_15ck4 = 1.8 time = 50
* CHECK dout0_16 vdout0_16ck4 = 1.8 time = 50
* CHECK dout0_17 vdout0_17ck4 = 0 time = 50
* CHECK dout0_18 vdout0_18ck4 = 1.8 time = 50
* CHECK dout0_19 vdout0_19ck4 = 0 time = 50
* CHECK dout0_20 vdout0_20ck4 = 0 time = 50
* CHECK dout0_21 vdout0_21ck4 = 1.8 time = 50
* CHECK dout0_22 vdout0_22ck4 = 1.8 time = 50
* CHECK dout0_23 vdout0_23ck4 = 0 time = 50
* CHECK dout0_24 vdout0_24ck4 = 1.8 time = 50
* CHECK dout0_25 vdout0_25ck4 = 1.8 time = 50
* CHECK dout0_26 vdout0_26ck4 = 1.8 time = 50
* CHECK dout0_27 vdout0_27ck4 = 0 time = 50
* CHECK dout0_28 vdout0_28ck4 = 0 time = 50
* CHECK dout0_29 vdout0_29ck4 = 0 time = 50
* CHECK dout0_30 vdout0_30ck4 = 0 time = 50
* CHECK dout0_31 vdout0_31ck4 = 0 time = 50
* CHECK dout0_32 vdout0_32ck4 = 0 time = 50
* CHECK dout0_0 vdout0_0ck5 = 1.8 time = 60
* CHECK dout0_1 vdout0_1ck5 = 0 time = 60
* CHECK dout0_2 vdout0_2ck5 = 1.8 time = 60
* CHECK dout0_3 vdout0_3ck5 = 1.8 time = 60
* CHECK dout0_4 vdout0_4ck5 = 0 time = 60
* CHECK dout0_5 vdout0_5ck5 = 0 time = 60
* CHECK dout0_6 vdout0_6ck5 = 0 time = 60
* CHECK dout0_7 vdout0_7ck5 = 0 time = 60
* CHECK dout0_8 vdout0_8ck5 = 1.8 time = 60
* CHECK dout0_9 vdout0_9ck5 = 0 time = 60
* CHECK dout0_10 vdout0_10ck5 = 1.8 time = 60
* CHECK dout0_11 vdout0_11ck5 = 1.8 time = 60
* CHECK dout0_12 vdout0_12ck5 = 1.8 time = 60
* CHECK dout0_13 vdout0_13ck5 = 0 time = 60
* CHECK dout0_14 vdout0_14ck5 = 1.8 time = 60
* CHECK dout0_15 vdout0_15ck5 = 1.8 time = 60
* CHECK dout0_16 vdout0_16ck5 = 1.8 time = 60
* CHECK dout0_17 vdout0_17ck5 = 0 time = 60
* CHECK dout0_18 vdout0_18ck5 = 1.8 time = 60
* CHECK dout0_19 vdout0_19ck5 = 0 time = 60
* CHECK dout0_20 vdout0_20ck5 = 0 time = 60
* CHECK dout0_21 vdout0_21ck5 = 1.8 time = 60
* CHECK dout0_22 vdout0_22ck5 = 1.8 time = 60
* CHECK dout0_23 vdout0_23ck5 = 0 time = 60
* CHECK dout0_24 vdout0_24ck5 = 1.8 time = 60
* CHECK dout0_25 vdout0_25ck5 = 1.8 time = 60
* CHECK dout0_26 vdout0_26ck5 = 1.8 time = 60
* CHECK dout0_27 vdout0_27ck5 = 0 time = 60
* CHECK dout0_28 vdout0_28ck5 = 0 time = 60
* CHECK dout0_29 vdout0_29ck5 = 0 time = 60
* CHECK dout0_30 vdout0_30ck5 = 0 time = 60
* CHECK dout0_31 vdout0_31ck5 = 0 time = 60
* CHECK dout0_32 vdout0_32ck5 = 0 time = 60
* CHECK dout0_0 vdout0_0ck7 = 1.8 time = 80
* CHECK dout0_1 vdout0_1ck7 = 0 time = 80
* CHECK dout0_2 vdout0_2ck7 = 1.8 time = 80
* CHECK dout0_3 vdout0_3ck7 = 1.8 time = 80
* CHECK dout0_4 vdout0_4ck7 = 0 time = 80
* CHECK dout0_5 vdout0_5ck7 = 0 time = 80
* CHECK dout0_6 vdout0_6ck7 = 0 time = 80
* CHECK dout0_7 vdout0_7ck7 = 0 time = 80
* CHECK dout0_8 vdout0_8ck7 = 1.8 time = 80
* CHECK dout0_9 vdout0_9ck7 = 0 time = 80
* CHECK dout0_10 vdout0_10ck7 = 1.8 time = 80
* CHECK dout0_11 vdout0_11ck7 = 1.8 time = 80
* CHECK dout0_12 vdout0_12ck7 = 1.8 time = 80
* CHECK dout0_13 vdout0_13ck7 = 0 time = 80
* CHECK dout0_14 vdout0_14ck7 = 1.8 time = 80
* CHECK dout0_15 vdout0_15ck7 = 1.8 time = 80
* CHECK dout0_16 vdout0_16ck7 = 1.8 time = 80
* CHECK dout0_17 vdout0_17ck7 = 0 time = 80
* CHECK dout0_18 vdout0_18ck7 = 1.8 time = 80
* CHECK dout0_19 vdout0_19ck7 = 0 time = 80
* CHECK dout0_20 vdout0_20ck7 = 0 time = 80
* CHECK dout0_21 vdout0_21ck7 = 1.8 time = 80
* CHECK dout0_22 vdout0_22ck7 = 1.8 time = 80
* CHECK dout0_23 vdout0_23ck7 = 0 time = 80
* CHECK dout0_24 vdout0_24ck7 = 1.8 time = 80
* CHECK dout0_25 vdout0_25ck7 = 1.8 time = 80
* CHECK dout0_26 vdout0_26ck7 = 1.8 time = 80
* CHECK dout0_27 vdout0_27ck7 = 0 time = 80
* CHECK dout0_28 vdout0_28ck7 = 0 time = 80
* CHECK dout0_29 vdout0_29ck7 = 0 time = 80
* CHECK dout0_30 vdout0_30ck7 = 0 time = 80
* CHECK dout0_31 vdout0_31ck7 = 0 time = 80
* CHECK dout0_32 vdout0_32ck7 = 0 time = 80
* CHECK dout0_0 vdout0_0ck9 = 1.8 time = 100
* CHECK dout0_1 vdout0_1ck9 = 0 time = 100
* CHECK dout0_2 vdout0_2ck9 = 1.8 time = 100
* CHECK dout0_3 vdout0_3ck9 = 1.8 time = 100
* CHECK dout0_4 vdout0_4ck9 = 0 time = 100
* CHECK dout0_5 vdout0_5ck9 = 0 time = 100
* CHECK dout0_6 vdout0_6ck9 = 0 time = 100
* CHECK dout0_7 vdout0_7ck9 = 0 time = 100
* CHECK dout0_8 vdout0_8ck9 = 1.8 time = 100
* CHECK dout0_9 vdout0_9ck9 = 0 time = 100
* CHECK dout0_10 vdout0_10ck9 = 1.8 time = 100
* CHECK dout0_11 vdout0_11ck9 = 1.8 time = 100
* CHECK dout0_12 vdout0_12ck9 = 1.8 time = 100
* CHECK dout0_13 vdout0_13ck9 = 0 time = 100
* CHECK dout0_14 vdout0_14ck9 = 1.8 time = 100
* CHECK dout0_15 vdout0_15ck9 = 1.8 time = 100
* CHECK dout0_16 vdout0_16ck9 = 1.8 time = 100
* CHECK dout0_17 vdout0_17ck9 = 0 time = 100
* CHECK dout0_18 vdout0_18ck9 = 1.8 time = 100
* CHECK dout0_19 vdout0_19ck9 = 0 time = 100
* CHECK dout0_20 vdout0_20ck9 = 0 time = 100
* CHECK dout0_21 vdout0_21ck9 = 1.8 time = 100
* CHECK dout0_22 vdout0_22ck9 = 1.8 time = 100
* CHECK dout0_23 vdout0_23ck9 = 0 time = 100
* CHECK dout0_24 vdout0_24ck9 = 1.8 time = 100
* CHECK dout0_25 vdout0_25ck9 = 1.8 time = 100
* CHECK dout0_26 vdout0_26ck9 = 1.8 time = 100
* CHECK dout0_27 vdout0_27ck9 = 0 time = 100
* CHECK dout0_28 vdout0_28ck9 = 0 time = 100
* CHECK dout0_29 vdout0_29ck9 = 0 time = 100
* CHECK dout0_30 vdout0_30ck9 = 0 time = 100
* CHECK dout0_31 vdout0_31ck9 = 0 time = 100
* CHECK dout0_32 vdout0_32ck9 = 0 time = 100
* CHECK dout0_0 vdout0_0ck13 = 0 time = 140
* CHECK dout0_1 vdout0_1ck13 = 1.8 time = 140
* CHECK dout0_2 vdout0_2ck13 = 0 time = 140
* CHECK dout0_3 vdout0_3ck13 = 1.8 time = 140
* CHECK dout0_4 vdout0_4ck13 = 0 time = 140
* CHECK dout0_5 vdout0_5ck13 = 0 time = 140
* CHECK dout0_6 vdout0_6ck13 = 0 time = 140
* CHECK dout0_7 vdout0_7ck13 = 0 time = 140
* CHECK dout0_8 vdout0_8ck13 = 1.8 time = 140
* CHECK dout0_9 vdout0_9ck13 = 1.8 time = 140
* CHECK dout0_10 vdout0_10ck13 = 1.8 time = 140
* CHECK dout0_11 vdout0_11ck13 = 0 time = 140
* CHECK dout0_12 vdout0_12ck13 = 1.8 time = 140
* CHECK dout0_13 vdout0_13ck13 = 1.8 time = 140
* CHECK dout0_14 vdout0_14ck13 = 0 time = 140
* CHECK dout0_15 vdout0_15ck13 = 1.8 time = 140
* CHECK dout0_16 vdout0_16ck13 = 1.8 time = 140
* CHECK dout0_17 vdout0_17ck13 = 1.8 time = 140
* CHECK dout0_18 vdout0_18ck13 = 1.8 time = 140
* CHECK dout0_19 vdout0_19ck13 = 0 time = 140
* CHECK dout0_20 vdout0_20ck13 = 0 time = 140
* CHECK dout0_21 vdout0_21ck13 = 0 time = 140
* CHECK dout0_22 vdout0_22ck13 = 0 time = 140
* CHECK dout0_23 vdout0_23ck13 = 1.8 time = 140
* CHECK dout0_24 vdout0_24ck13 = 0 time = 140
* CHECK dout0_25 vdout0_25ck13 = 1.8 time = 140
* CHECK dout0_26 vdout0_26ck13 = 0 time = 140
* CHECK dout0_27 vdout0_27ck13 = 1.8 time = 140
* CHECK dout0_28 vdout0_28ck13 = 1.8 time = 140
* CHECK dout0_29 vdout0_29ck13 = 1.8 time = 140
* CHECK dout0_30 vdout0_30ck13 = 0 time = 140
* CHECK dout0_31 vdout0_31ck13 = 0 time = 140
* CHECK dout0_32 vdout0_32ck13 = 0 time = 140
* CHECK dout0_0 vdout0_0ck14 = 0 time = 150
* CHECK dout0_1 vdout0_1ck14 = 1.8 time = 150
* CHECK dout0_2 vdout0_2ck14 = 0 time = 150
* CHECK dout0_3 vdout0_3ck14 = 1.8 time = 150
* CHECK dout0_4 vdout0_4ck14 = 0 time = 150
* CHECK dout0_5 vdout0_5ck14 = 0 time = 150
* CHECK dout0_6 vdout0_6ck14 = 0 time = 150
* CHECK dout0_7 vdout0_7ck14 = 0 time = 150
* CHECK dout0_8 vdout0_8ck14 = 1.8 time = 150
* CHECK dout0_9 vdout0_9ck14 = 1.8 time = 150
* CHECK dout0_10 vdout0_10ck14 = 1.8 time = 150
* CHECK dout0_11 vdout0_11ck14 = 0 time = 150
* CHECK dout0_12 vdout0_12ck14 = 1.8 time = 150
* CHECK dout0_13 vdout0_13ck14 = 1.8 time = 150
* CHECK dout0_14 vdout0_14ck14 = 0 time = 150
* CHECK dout0_15 vdout0_15ck14 = 1.8 time = 150
* CHECK dout0_16 vdout0_16ck14 = 1.8 time = 150
* CHECK dout0_17 vdout0_17ck14 = 1.8 time = 150
* CHECK dout0_18 vdout0_18ck14 = 1.8 time = 150
* CHECK dout0_19 vdout0_19ck14 = 0 time = 150
* CHECK dout0_20 vdout0_20ck14 = 0 time = 150
* CHECK dout0_21 vdout0_21ck14 = 0 time = 150
* CHECK dout0_22 vdout0_22ck14 = 0 time = 150
* CHECK dout0_23 vdout0_23ck14 = 1.8 time = 150
* CHECK dout0_24 vdout0_24ck14 = 0 time = 150
* CHECK dout0_25 vdout0_25ck14 = 1.8 time = 150
* CHECK dout0_26 vdout0_26ck14 = 0 time = 150
* CHECK dout0_27 vdout0_27ck14 = 1.8 time = 150
* CHECK dout0_28 vdout0_28ck14 = 1.8 time = 150
* CHECK dout0_29 vdout0_29ck14 = 1.8 time = 150
* CHECK dout0_30 vdout0_30ck14 = 0 time = 150
* CHECK dout0_31 vdout0_31ck14 = 0 time = 150
* CHECK dout0_32 vdout0_32ck14 = 0 time = 150
* CHECK dout0_0 vdout0_0ck15 = 1.8 time = 160
* CHECK dout0_1 vdout0_1ck15 = 0 time = 160
* CHECK dout0_2 vdout0_2ck15 = 0 time = 160
* CHECK dout0_3 vdout0_3ck15 = 1.8 time = 160
* CHECK dout0_4 vdout0_4ck15 = 1.8 time = 160
* CHECK dout0_5 vdout0_5ck15 = 0 time = 160
* CHECK dout0_6 vdout0_6ck15 = 0 time = 160
* CHECK dout0_7 vdout0_7ck15 = 0 time = 160
* CHECK dout0_8 vdout0_8ck15 = 0 time = 160
* CHECK dout0_9 vdout0_9ck15 = 1.8 time = 160
* CHECK dout0_10 vdout0_10ck15 = 0 time = 160
* CHECK dout0_11 vdout0_11ck15 = 1.8 time = 160
* CHECK dout0_12 vdout0_12ck15 = 1.8 time = 160
* CHECK dout0_13 vdout0_13ck15 = 1.8 time = 160
* CHECK dout0_14 vdout0_14ck15 = 0 time = 160
* CHECK dout0_15 vdout0_15ck15 = 1.8 time = 160
* CHECK dout0_16 vdout0_16ck15 = 1.8 time = 160
* CHECK dout0_17 vdout0_17ck15 = 1.8 time = 160
* CHECK dout0_18 vdout0_18ck15 = 0 time = 160
* CHECK dout0_19 vdout0_19ck15 = 1.8 time = 160
* CHECK dout0_20 vdout0_20ck15 = 0 time = 160
* CHECK dout0_21 vdout0_21ck15 = 0 time = 160
* CHECK dout0_22 vdout0_22ck15 = 0 time = 160
* CHECK dout0_23 vdout0_23ck15 = 1.8 time = 160
* CHECK dout0_24 vdout0_24ck15 = 0 time = 160
* CHECK dout0_25 vdout0_25ck15 = 1.8 time = 160
* CHECK dout0_26 vdout0_26ck15 = 1.8 time = 160
* CHECK dout0_27 vdout0_27ck15 = 0 time = 160
* CHECK dout0_28 vdout0_28ck15 = 0 time = 160
* CHECK dout0_29 vdout0_29ck15 = 0 time = 160
* CHECK dout0_30 vdout0_30ck15 = 1.8 time = 160
* CHECK dout0_31 vdout0_31ck15 = 0 time = 160
* CHECK dout0_32 vdout0_32ck15 = 0 time = 160
* CHECK dout0_0 vdout0_0ck16 = 0 time = 170
* CHECK dout0_1 vdout0_1ck16 = 1.8 time = 170
* CHECK dout0_2 vdout0_2ck16 = 0 time = 170
* CHECK dout0_3 vdout0_3ck16 = 1.8 time = 170
* CHECK dout0_4 vdout0_4ck16 = 0 time = 170
* CHECK dout0_5 vdout0_5ck16 = 0 time = 170
* CHECK dout0_6 vdout0_6ck16 = 0 time = 170
* CHECK dout0_7 vdout0_7ck16 = 0 time = 170
* CHECK dout0_8 vdout0_8ck16 = 1.8 time = 170
* CHECK dout0_9 vdout0_9ck16 = 1.8 time = 170
* CHECK dout0_10 vdout0_10ck16 = 1.8 time = 170
* CHECK dout0_11 vdout0_11ck16 = 0 time = 170
* CHECK dout0_12 vdout0_12ck16 = 1.8 time = 170
* CHECK dout0_13 vdout0_13ck16 = 1.8 time = 170
* CHECK dout0_14 vdout0_14ck16 = 0 time = 170
* CHECK dout0_15 vdout0_15ck16 = 1.8 time = 170
* CHECK dout0_16 vdout0_16ck16 = 1.8 time = 170
* CHECK dout0_17 vdout0_17ck16 = 1.8 time = 170
* CHECK dout0_18 vdout0_18ck16 = 1.8 time = 170
* CHECK dout0_19 vdout0_19ck16 = 0 time = 170
* CHECK dout0_20 vdout0_20ck16 = 0 time = 170
* CHECK dout0_21 vdout0_21ck16 = 0 time = 170
* CHECK dout0_22 vdout0_22ck16 = 0 time = 170
* CHECK dout0_23 vdout0_23ck16 = 1.8 time = 170
* CHECK dout0_24 vdout0_24ck16 = 0 time = 170
* CHECK dout0_25 vdout0_25ck16 = 1.8 time = 170
* CHECK dout0_26 vdout0_26ck16 = 0 time = 170
* CHECK dout0_27 vdout0_27ck16 = 1.8 time = 170
* CHECK dout0_28 vdout0_28ck16 = 1.8 time = 170
* CHECK dout0_29 vdout0_29ck16 = 1.8 time = 170
* CHECK dout0_30 vdout0_30ck16 = 0 time = 170
* CHECK dout0_31 vdout0_31ck16 = 0 time = 170
* CHECK dout0_32 vdout0_32ck16 = 0 time = 170
* CHECK dout0_0 vdout0_0ck17 = 1.8 time = 180
* CHECK dout0_1 vdout0_1ck17 = 0 time = 180
* CHECK dout0_2 vdout0_2ck17 = 0 time = 180
* CHECK dout0_3 vdout0_3ck17 = 1.8 time = 180
* CHECK dout0_4 vdout0_4ck17 = 1.8 time = 180
* CHECK dout0_5 vdout0_5ck17 = 0 time = 180
* CHECK dout0_6 vdout0_6ck17 = 0 time = 180
* CHECK dout0_7 vdout0_7ck17 = 0 time = 180
* CHECK dout0_8 vdout0_8ck17 = 0 time = 180
* CHECK dout0_9 vdout0_9ck17 = 1.8 time = 180
* CHECK dout0_10 vdout0_10ck17 = 0 time = 180
* CHECK dout0_11 vdout0_11ck17 = 1.8 time = 180
* CHECK dout0_12 vdout0_12ck17 = 1.8 time = 180
* CHECK dout0_13 vdout0_13ck17 = 1.8 time = 180
* CHECK dout0_14 vdout0_14ck17 = 0 time = 180
* CHECK dout0_15 vdout0_15ck17 = 1.8 time = 180
* CHECK dout0_16 vdout0_16ck17 = 1.8 time = 180
* CHECK dout0_17 vdout0_17ck17 = 1.8 time = 180
* CHECK dout0_18 vdout0_18ck17 = 0 time = 180
* CHECK dout0_19 vdout0_19ck17 = 1.8 time = 180
* CHECK dout0_20 vdout0_20ck17 = 0 time = 180
* CHECK dout0_21 vdout0_21ck17 = 0 time = 180
* CHECK dout0_22 vdout0_22ck17 = 0 time = 180
* CHECK dout0_23 vdout0_23ck17 = 1.8 time = 180
* CHECK dout0_24 vdout0_24ck17 = 0 time = 180
* CHECK dout0_25 vdout0_25ck17 = 1.8 time = 180
* CHECK dout0_26 vdout0_26ck17 = 1.8 time = 180
* CHECK dout0_27 vdout0_27ck17 = 0 time = 180
* CHECK dout0_28 vdout0_28ck17 = 0 time = 180
* CHECK dout0_29 vdout0_29ck17 = 0 time = 180
* CHECK dout0_30 vdout0_30ck17 = 1.8 time = 180
* CHECK dout0_31 vdout0_31ck17 = 0 time = 180
* CHECK dout0_32 vdout0_32ck17 = 0 time = 180
* CHECK dout0_0 vdout0_0ck18 = 1.8 time = 190
* CHECK dout0_1 vdout0_1ck18 = 0 time = 190
* CHECK dout0_2 vdout0_2ck18 = 0 time = 190
* CHECK dout0_3 vdout0_3ck18 = 1.8 time = 190
* CHECK dout0_4 vdout0_4ck18 = 1.8 time = 190
* CHECK dout0_5 vdout0_5ck18 = 0 time = 190
* CHECK dout0_6 vdout0_6ck18 = 0 time = 190
* CHECK dout0_7 vdout0_7ck18 = 0 time = 190
* CHECK dout0_8 vdout0_8ck18 = 0 time = 190
* CHECK dout0_9 vdout0_9ck18 = 1.8 time = 190
* CHECK dout0_10 vdout0_10ck18 = 0 time = 190
* CHECK dout0_11 vdout0_11ck18 = 1.8 time = 190
* CHECK dout0_12 vdout0_12ck18 = 1.8 time = 190
* CHECK dout0_13 vdout0_13ck18 = 1.8 time = 190
* CHECK dout0_14 vdout0_14ck18 = 0 time = 190
* CHECK dout0_15 vdout0_15ck18 = 1.8 time = 190
* CHECK dout0_16 vdout0_16ck18 = 1.8 time = 190
* CHECK dout0_17 vdout0_17ck18 = 1.8 time = 190
* CHECK dout0_18 vdout0_18ck18 = 0 time = 190
* CHECK dout0_19 vdout0_19ck18 = 1.8 time = 190
* CHECK dout0_20 vdout0_20ck18 = 0 time = 190
* CHECK dout0_21 vdout0_21ck18 = 0 time = 190
* CHECK dout0_22 vdout0_22ck18 = 0 time = 190
* CHECK dout0_23 vdout0_23ck18 = 1.8 time = 190
* CHECK dout0_24 vdout0_24ck18 = 0 time = 190
* CHECK dout0_25 vdout0_25ck18 = 1.8 time = 190
* CHECK dout0_26 vdout0_26ck18 = 1.8 time = 190
* CHECK dout0_27 vdout0_27ck18 = 0 time = 190
* CHECK dout0_28 vdout0_28ck18 = 0 time = 190
* CHECK dout0_29 vdout0_29ck18 = 0 time = 190
* CHECK dout0_30 vdout0_30ck18 = 1.8 time = 190
* CHECK dout0_31 vdout0_31ck18 = 0 time = 190
* CHECK dout0_32 vdout0_32ck18 = 0 time = 190
* CHECK dout0_0 vdout0_0ck22 = 0 time = 230
* CHECK dout0_1 vdout0_1ck22 = 1.8 time = 230
* CHECK dout0_2 vdout0_2ck22 = 0 time = 230
* CHECK dout0_3 vdout0_3ck22 = 1.8 time = 230
* CHECK dout0_4 vdout0_4ck22 = 0 time = 230
* CHECK dout0_5 vdout0_5ck22 = 0 time = 230
* CHECK dout0_6 vdout0_6ck22 = 0 time = 230
* CHECK dout0_7 vdout0_7ck22 = 0 time = 230
* CHECK dout0_8 vdout0_8ck22 = 1.8 time = 230
* CHECK dout0_9 vdout0_9ck22 = 1.8 time = 230
* CHECK dout0_10 vdout0_10ck22 = 1.8 time = 230
* CHECK dout0_11 vdout0_11ck22 = 0 time = 230
* CHECK dout0_12 vdout0_12ck22 = 1.8 time = 230
* CHECK dout0_13 vdout0_13ck22 = 1.8 time = 230
* CHECK dout0_14 vdout0_14ck22 = 0 time = 230
* CHECK dout0_15 vdout0_15ck22 = 1.8 time = 230
* CHECK dout0_16 vdout0_16ck22 = 1.8 time = 230
* CHECK dout0_17 vdout0_17ck22 = 1.8 time = 230
* CHECK dout0_18 vdout0_18ck22 = 1.8 time = 230
* CHECK dout0_19 vdout0_19ck22 = 0 time = 230
* CHECK dout0_20 vdout0_20ck22 = 0 time = 230
* CHECK dout0_21 vdout0_21ck22 = 0 time = 230
* CHECK dout0_22 vdout0_22ck22 = 0 time = 230
* CHECK dout0_23 vdout0_23ck22 = 1.8 time = 230
* CHECK dout0_24 vdout0_24ck22 = 0 time = 230
* CHECK dout0_25 vdout0_25ck22 = 1.8 time = 230
* CHECK dout0_26 vdout0_26ck22 = 0 time = 230
* CHECK dout0_27 vdout0_27ck22 = 1.8 time = 230
* CHECK dout0_28 vdout0_28ck22 = 1.8 time = 230
* CHECK dout0_29 vdout0_29ck22 = 1.8 time = 230
* CHECK dout0_30 vdout0_30ck22 = 0 time = 230
* CHECK dout0_31 vdout0_31ck22 = 0 time = 230
* CHECK dout0_32 vdout0_32ck22 = 0 time = 230
* CHECK dout0_0 vdout0_0ck23 = 0 time = 240
* CHECK dout0_1 vdout0_1ck23 = 1.8 time = 240
* CHECK dout0_2 vdout0_2ck23 = 0 time = 240
* CHECK dout0_3 vdout0_3ck23 = 1.8 time = 240
* CHECK dout0_4 vdout0_4ck23 = 0 time = 240
* CHECK dout0_5 vdout0_5ck23 = 0 time = 240
* CHECK dout0_6 vdout0_6ck23 = 0 time = 240
* CHECK dout0_7 vdout0_7ck23 = 0 time = 240
* CHECK dout0_8 vdout0_8ck23 = 1.8 time = 240
* CHECK dout0_9 vdout0_9ck23 = 1.8 time = 240
* CHECK dout0_10 vdout0_10ck23 = 1.8 time = 240
* CHECK dout0_11 vdout0_11ck23 = 0 time = 240
* CHECK dout0_12 vdout0_12ck23 = 1.8 time = 240
* CHECK dout0_13 vdout0_13ck23 = 1.8 time = 240
* CHECK dout0_14 vdout0_14ck23 = 0 time = 240
* CHECK dout0_15 vdout0_15ck23 = 1.8 time = 240
* CHECK dout0_16 vdout0_16ck23 = 1.8 time = 240
* CHECK dout0_17 vdout0_17ck23 = 1.8 time = 240
* CHECK dout0_18 vdout0_18ck23 = 1.8 time = 240
* CHECK dout0_19 vdout0_19ck23 = 0 time = 240
* CHECK dout0_20 vdout0_20ck23 = 0 time = 240
* CHECK dout0_21 vdout0_21ck23 = 0 time = 240
* CHECK dout0_22 vdout0_22ck23 = 0 time = 240
* CHECK dout0_23 vdout0_23ck23 = 1.8 time = 240
* CHECK dout0_24 vdout0_24ck23 = 0 time = 240
* CHECK dout0_25 vdout0_25ck23 = 1.8 time = 240
* CHECK dout0_26 vdout0_26ck23 = 0 time = 240
* CHECK dout0_27 vdout0_27ck23 = 1.8 time = 240
* CHECK dout0_28 vdout0_28ck23 = 1.8 time = 240
* CHECK dout0_29 vdout0_29ck23 = 1.8 time = 240
* CHECK dout0_30 vdout0_30ck23 = 0 time = 240
* CHECK dout0_31 vdout0_31ck23 = 0 time = 240
* CHECK dout0_32 vdout0_32ck23 = 0 time = 240
* CHECK dout0_0 vdout0_0ck24 = 1.8 time = 250
* CHECK dout0_1 vdout0_1ck24 = 0 time = 250
* CHECK dout0_2 vdout0_2ck24 = 0 time = 250
* CHECK dout0_3 vdout0_3ck24 = 1.8 time = 250
* CHECK dout0_4 vdout0_4ck24 = 1.8 time = 250
* CHECK dout0_5 vdout0_5ck24 = 0 time = 250
* CHECK dout0_6 vdout0_6ck24 = 0 time = 250
* CHECK dout0_7 vdout0_7ck24 = 0 time = 250
* CHECK dout0_8 vdout0_8ck24 = 0 time = 250
* CHECK dout0_9 vdout0_9ck24 = 1.8 time = 250
* CHECK dout0_10 vdout0_10ck24 = 0 time = 250
* CHECK dout0_11 vdout0_11ck24 = 1.8 time = 250
* CHECK dout0_12 vdout0_12ck24 = 1.8 time = 250
* CHECK dout0_13 vdout0_13ck24 = 1.8 time = 250
* CHECK dout0_14 vdout0_14ck24 = 0 time = 250
* CHECK dout0_15 vdout0_15ck24 = 1.8 time = 250
* CHECK dout0_16 vdout0_16ck24 = 1.8 time = 250
* CHECK dout0_17 vdout0_17ck24 = 1.8 time = 250
* CHECK dout0_18 vdout0_18ck24 = 0 time = 250
* CHECK dout0_19 vdout0_19ck24 = 1.8 time = 250
* CHECK dout0_20 vdout0_20ck24 = 0 time = 250
* CHECK dout0_21 vdout0_21ck24 = 0 time = 250
* CHECK dout0_22 vdout0_22ck24 = 0 time = 250
* CHECK dout0_23 vdout0_23ck24 = 1.8 time = 250
* CHECK dout0_24 vdout0_24ck24 = 0 time = 250
* CHECK dout0_25 vdout0_25ck24 = 1.8 time = 250
* CHECK dout0_26 vdout0_26ck24 = 1.8 time = 250
* CHECK dout0_27 vdout0_27ck24 = 0 time = 250
* CHECK dout0_28 vdout0_28ck24 = 0 time = 250
* CHECK dout0_29 vdout0_29ck24 = 0 time = 250
* CHECK dout0_30 vdout0_30ck24 = 1.8 time = 250
* CHECK dout0_31 vdout0_31ck24 = 0 time = 250
* CHECK dout0_32 vdout0_32ck24 = 0 time = 250
* CHECK dout0_0 vdout0_0ck25 = 0 time = 260
* CHECK dout0_1 vdout0_1ck25 = 1.8 time = 260
* CHECK dout0_2 vdout0_2ck25 = 0 time = 260
* CHECK dout0_3 vdout0_3ck25 = 1.8 time = 260
* CHECK dout0_4 vdout0_4ck25 = 0 time = 260
* CHECK dout0_5 vdout0_5ck25 = 0 time = 260
* CHECK dout0_6 vdout0_6ck25 = 0 time = 260
* CHECK dout0_7 vdout0_7ck25 = 0 time = 260
* CHECK dout0_8 vdout0_8ck25 = 1.8 time = 260
* CHECK dout0_9 vdout0_9ck25 = 1.8 time = 260
* CHECK dout0_10 vdout0_10ck25 = 1.8 time = 260
* CHECK dout0_11 vdout0_11ck25 = 0 time = 260
* CHECK dout0_12 vdout0_12ck25 = 1.8 time = 260
* CHECK dout0_13 vdout0_13ck25 = 1.8 time = 260
* CHECK dout0_14 vdout0_14ck25 = 0 time = 260
* CHECK dout0_15 vdout0_15ck25 = 1.8 time = 260
* CHECK dout0_16 vdout0_16ck25 = 1.8 time = 260
* CHECK dout0_17 vdout0_17ck25 = 1.8 time = 260
* CHECK dout0_18 vdout0_18ck25 = 1.8 time = 260
* CHECK dout0_19 vdout0_19ck25 = 0 time = 260
* CHECK dout0_20 vdout0_20ck25 = 0 time = 260
* CHECK dout0_21 vdout0_21ck25 = 0 time = 260
* CHECK dout0_22 vdout0_22ck25 = 0 time = 260
* CHECK dout0_23 vdout0_23ck25 = 1.8 time = 260
* CHECK dout0_24 vdout0_24ck25 = 0 time = 260
* CHECK dout0_25 vdout0_25ck25 = 1.8 time = 260
* CHECK dout0_26 vdout0_26ck25 = 0 time = 260
* CHECK dout0_27 vdout0_27ck25 = 1.8 time = 260
* CHECK dout0_28 vdout0_28ck25 = 1.8 time = 260
* CHECK dout0_29 vdout0_29ck25 = 1.8 time = 260
* CHECK dout0_30 vdout0_30ck25 = 0 time = 260
* CHECK dout0_31 vdout0_31ck25 = 0 time = 260
* CHECK dout0_32 vdout0_32ck25 = 0 time = 260
* CHECK dout0_0 vdout0_0ck27 = 0 time = 280
* CHECK dout0_1 vdout0_1ck27 = 0 time = 280
* CHECK dout0_2 vdout0_2ck27 = 1.8 time = 280
* CHECK dout0_3 vdout0_3ck27 = 0 time = 280
* CHECK dout0_4 vdout0_4ck27 = 1.8 time = 280
* CHECK dout0_5 vdout0_5ck27 = 0 time = 280
* CHECK dout0_6 vdout0_6ck27 = 0 time = 280
* CHECK dout0_7 vdout0_7ck27 = 1.8 time = 280
* CHECK dout0_8 vdout0_8ck27 = 1.8 time = 280
* CHECK dout0_9 vdout0_9ck27 = 1.8 time = 280
* CHECK dout0_10 vdout0_10ck27 = 1.8 time = 280
* CHECK dout0_11 vdout0_11ck27 = 0 time = 280
* CHECK dout0_12 vdout0_12ck27 = 1.8 time = 280
* CHECK dout0_13 vdout0_13ck27 = 1.8 time = 280
* CHECK dout0_14 vdout0_14ck27 = 0 time = 280
* CHECK dout0_15 vdout0_15ck27 = 0 time = 280
* CHECK dout0_16 vdout0_16ck27 = 1.8 time = 280
* CHECK dout0_17 vdout0_17ck27 = 0 time = 280
* CHECK dout0_18 vdout0_18ck27 = 1.8 time = 280
* CHECK dout0_19 vdout0_19ck27 = 0 time = 280
* CHECK dout0_20 vdout0_20ck27 = 0 time = 280
* CHECK dout0_21 vdout0_21ck27 = 1.8 time = 280
* CHECK dout0_22 vdout0_22ck27 = 1.8 time = 280
* CHECK dout0_23 vdout0_23ck27 = 0 time = 280
* CHECK dout0_24 vdout0_24ck27 = 1.8 time = 280
* CHECK dout0_25 vdout0_25ck27 = 0 time = 280
* CHECK dout0_26 vdout0_26ck27 = 0 time = 280
* CHECK dout0_27 vdout0_27ck27 = 1.8 time = 280
* CHECK dout0_28 vdout0_28ck27 = 0 time = 280
* CHECK dout0_29 vdout0_29ck27 = 1.8 time = 280
* CHECK dout0_30 vdout0_30ck27 = 1.8 time = 280
* CHECK dout0_31 vdout0_31ck27 = 0 time = 280
* CHECK dout0_32 vdout0_32ck27 = 0 time = 280
* CHECK dout0_0 vdout0_0ck29 = 1.8 time = 300
* CHECK dout0_1 vdout0_1ck29 = 0 time = 300
* CHECK dout0_2 vdout0_2ck29 = 0 time = 300
* CHECK dout0_3 vdout0_3ck29 = 1.8 time = 300
* CHECK dout0_4 vdout0_4ck29 = 1.8 time = 300
* CHECK dout0_5 vdout0_5ck29 = 0 time = 300
* CHECK dout0_6 vdout0_6ck29 = 0 time = 300
* CHECK dout0_7 vdout0_7ck29 = 0 time = 300
* CHECK dout0_8 vdout0_8ck29 = 0 time = 300
* CHECK dout0_9 vdout0_9ck29 = 1.8 time = 300
* CHECK dout0_10 vdout0_10ck29 = 0 time = 300
* CHECK dout0_11 vdout0_11ck29 = 1.8 time = 300
* CHECK dout0_12 vdout0_12ck29 = 1.8 time = 300
* CHECK dout0_13 vdout0_13ck29 = 1.8 time = 300
* CHECK dout0_14 vdout0_14ck29 = 0 time = 300
* CHECK dout0_15 vdout0_15ck29 = 1.8 time = 300
* CHECK dout0_16 vdout0_16ck29 = 1.8 time = 300
* CHECK dout0_17 vdout0_17ck29 = 1.8 time = 300
* CHECK dout0_18 vdout0_18ck29 = 0 time = 300
* CHECK dout0_19 vdout0_19ck29 = 1.8 time = 300
* CHECK dout0_20 vdout0_20ck29 = 0 time = 300
* CHECK dout0_21 vdout0_21ck29 = 0 time = 300
* CHECK dout0_22 vdout0_22ck29 = 0 time = 300
* CHECK dout0_23 vdout0_23ck29 = 1.8 time = 300
* CHECK dout0_24 vdout0_24ck29 = 0 time = 300
* CHECK dout0_25 vdout0_25ck29 = 1.8 time = 300
* CHECK dout0_26 vdout0_26ck29 = 1.8 time = 300
* CHECK dout0_27 vdout0_27ck29 = 0 time = 300
* CHECK dout0_28 vdout0_28ck29 = 0 time = 300
* CHECK dout0_29 vdout0_29ck29 = 0 time = 300
* CHECK dout0_30 vdout0_30ck29 = 1.8 time = 300
* CHECK dout0_31 vdout0_31ck29 = 0 time = 300
* CHECK dout0_32 vdout0_32ck29 = 0 time = 300
* CHECK dout0_0 vdout0_0ck31 = 0 time = 320
* CHECK dout0_1 vdout0_1ck31 = 0 time = 320
* CHECK dout0_2 vdout0_2ck31 = 1.8 time = 320
* CHECK dout0_3 vdout0_3ck31 = 1.8 time = 320
* CHECK dout0_4 vdout0_4ck31 = 0 time = 320
* CHECK dout0_5 vdout0_5ck31 = 0 time = 320
* CHECK dout0_6 vdout0_6ck31 = 1.8 time = 320
* CHECK dout0_7 vdout0_7ck31 = 0 time = 320
* CHECK dout0_8 vdout0_8ck31 = 1.8 time = 320
* CHECK dout0_9 vdout0_9ck31 = 0 time = 320
* CHECK dout0_10 vdout0_10ck31 = 1.8 time = 320
* CHECK dout0_11 vdout0_11ck31 = 0 time = 320
* CHECK dout0_12 vdout0_12ck31 = 1.8 time = 320
* CHECK dout0_13 vdout0_13ck31 = 0 time = 320
* CHECK dout0_14 vdout0_14ck31 = 0 time = 320
* CHECK dout0_15 vdout0_15ck31 = 0 time = 320
* CHECK dout0_16 vdout0_16ck31 = 1.8 time = 320
* CHECK dout0_17 vdout0_17ck31 = 0 time = 320
* CHECK dout0_18 vdout0_18ck31 = 1.8 time = 320
* CHECK dout0_19 vdout0_19ck31 = 0 time = 320
* CHECK dout0_20 vdout0_20ck31 = 1.8 time = 320
* CHECK dout0_21 vdout0_21ck31 = 1.8 time = 320
* CHECK dout0_22 vdout0_22ck31 = 1.8 time = 320
* CHECK dout0_23 vdout0_23ck31 = 1.8 time = 320
* CHECK dout0_24 vdout0_24ck31 = 0 time = 320
* CHECK dout0_25 vdout0_25ck31 = 0 time = 320
* CHECK dout0_26 vdout0_26ck31 = 1.8 time = 320
* CHECK dout0_27 vdout0_27ck31 = 1.8 time = 320
* CHECK dout0_28 vdout0_28ck31 = 1.8 time = 320
* CHECK dout0_29 vdout0_29ck31 = 1.8 time = 320
* CHECK dout0_30 vdout0_30ck31 = 1.8 time = 320
* CHECK dout0_31 vdout0_31ck31 = 1.8 time = 320
* CHECK dout0_32 vdout0_32ck31 = 0 time = 320
* CHECK dout0_0 vdout0_0ck32 = 1.8 time = 330
* CHECK dout0_1 vdout0_1ck32 = 0 time = 330
* CHECK dout0_2 vdout0_2ck32 = 0 time = 330
* CHECK dout0_3 vdout0_3ck32 = 1.8 time = 330
* CHECK dout0_4 vdout0_4ck32 = 1.8 time = 330
* CHECK dout0_5 vdout0_5ck32 = 0 time = 330
* CHECK dout0_6 vdout0_6ck32 = 0 time = 330
* CHECK dout0_7 vdout0_7ck32 = 0 time = 330
* CHECK dout0_8 vdout0_8ck32 = 0 time = 330
* CHECK dout0_9 vdout0_9ck32 = 1.8 time = 330
* CHECK dout0_10 vdout0_10ck32 = 0 time = 330
* CHECK dout0_11 vdout0_11ck32 = 1.8 time = 330
* CHECK dout0_12 vdout0_12ck32 = 1.8 time = 330
* CHECK dout0_13 vdout0_13ck32 = 1.8 time = 330
* CHECK dout0_14 vdout0_14ck32 = 0 time = 330
* CHECK dout0_15 vdout0_15ck32 = 1.8 time = 330
* CHECK dout0_16 vdout0_16ck32 = 1.8 time = 330
* CHECK dout0_17 vdout0_17ck32 = 1.8 time = 330
* CHECK dout0_18 vdout0_18ck32 = 0 time = 330
* CHECK dout0_19 vdout0_19ck32 = 1.8 time = 330
* CHECK dout0_20 vdout0_20ck32 = 0 time = 330
* CHECK dout0_21 vdout0_21ck32 = 0 time = 330
* CHECK dout0_22 vdout0_22ck32 = 0 time = 330
* CHECK dout0_23 vdout0_23ck32 = 1.8 time = 330
* CHECK dout0_24 vdout0_24ck32 = 0 time = 330
* CHECK dout0_25 vdout0_25ck32 = 1.8 time = 330
* CHECK dout0_26 vdout0_26ck32 = 1.8 time = 330
* CHECK dout0_27 vdout0_27ck32 = 0 time = 330
* CHECK dout0_28 vdout0_28ck32 = 0 time = 330
* CHECK dout0_29 vdout0_29ck32 = 0 time = 330
* CHECK dout0_30 vdout0_30ck32 = 1.8 time = 330
* CHECK dout0_31 vdout0_31ck32 = 0 time = 330
* CHECK dout0_32 vdout0_32ck32 = 0 time = 330
* CHECK dout0_0 vdout0_0ck34 = 0 time = 350
* CHECK dout0_1 vdout0_1ck34 = 0 time = 350
* CHECK dout0_2 vdout0_2ck34 = 1.8 time = 350
* CHECK dout0_3 vdout0_3ck34 = 1.8 time = 350
* CHECK dout0_4 vdout0_4ck34 = 0 time = 350
* CHECK dout0_5 vdout0_5ck34 = 0 time = 350
* CHECK dout0_6 vdout0_6ck34 = 1.8 time = 350
* CHECK dout0_7 vdout0_7ck34 = 0 time = 350
* CHECK dout0_8 vdout0_8ck34 = 1.8 time = 350
* CHECK dout0_9 vdout0_9ck34 = 0 time = 350
* CHECK dout0_10 vdout0_10ck34 = 1.8 time = 350
* CHECK dout0_11 vdout0_11ck34 = 0 time = 350
* CHECK dout0_12 vdout0_12ck34 = 1.8 time = 350
* CHECK dout0_13 vdout0_13ck34 = 0 time = 350
* CHECK dout0_14 vdout0_14ck34 = 0 time = 350
* CHECK dout0_15 vdout0_15ck34 = 0 time = 350
* CHECK dout0_16 vdout0_16ck34 = 1.8 time = 350
* CHECK dout0_17 vdout0_17ck34 = 0 time = 350
* CHECK dout0_18 vdout0_18ck34 = 1.8 time = 350
* CHECK dout0_19 vdout0_19ck34 = 0 time = 350
* CHECK dout0_20 vdout0_20ck34 = 1.8 time = 350
* CHECK dout0_21 vdout0_21ck34 = 1.8 time = 350
* CHECK dout0_22 vdout0_22ck34 = 1.8 time = 350
* CHECK dout0_23 vdout0_23ck34 = 1.8 time = 350
* CHECK dout0_24 vdout0_24ck34 = 0 time = 350
* CHECK dout0_25 vdout0_25ck34 = 0 time = 350
* CHECK dout0_26 vdout0_26ck34 = 1.8 time = 350
* CHECK dout0_27 vdout0_27ck34 = 1.8 time = 350
* CHECK dout0_28 vdout0_28ck34 = 1.8 time = 350
* CHECK dout0_29 vdout0_29ck34 = 1.8 time = 350
* CHECK dout0_30 vdout0_30ck34 = 1.8 time = 350
* CHECK dout0_31 vdout0_31ck34 = 1.8 time = 350
* CHECK dout0_32 vdout0_32ck34 = 0 time = 350
* CHECK dout0_0 vdout0_0ck35 = 1.8 time = 360
* CHECK dout0_1 vdout0_1ck35 = 0 time = 360
* CHECK dout0_2 vdout0_2ck35 = 0 time = 360
* CHECK dout0_3 vdout0_3ck35 = 1.8 time = 360
* CHECK dout0_4 vdout0_4ck35 = 1.8 time = 360
* CHECK dout0_5 vdout0_5ck35 = 0 time = 360
* CHECK dout0_6 vdout0_6ck35 = 0 time = 360
* CHECK dout0_7 vdout0_7ck35 = 0 time = 360
* CHECK dout0_8 vdout0_8ck35 = 0 time = 360
* CHECK dout0_9 vdout0_9ck35 = 1.8 time = 360
* CHECK dout0_10 vdout0_10ck35 = 0 time = 360
* CHECK dout0_11 vdout0_11ck35 = 1.8 time = 360
* CHECK dout0_12 vdout0_12ck35 = 1.8 time = 360
* CHECK dout0_13 vdout0_13ck35 = 1.8 time = 360
* CHECK dout0_14 vdout0_14ck35 = 0 time = 360
* CHECK dout0_15 vdout0_15ck35 = 1.8 time = 360
* CHECK dout0_16 vdout0_16ck35 = 1.8 time = 360
* CHECK dout0_17 vdout0_17ck35 = 1.8 time = 360
* CHECK dout0_18 vdout0_18ck35 = 0 time = 360
* CHECK dout0_19 vdout0_19ck35 = 1.8 time = 360
* CHECK dout0_20 vdout0_20ck35 = 0 time = 360
* CHECK dout0_21 vdout0_21ck35 = 0 time = 360
* CHECK dout0_22 vdout0_22ck35 = 0 time = 360
* CHECK dout0_23 vdout0_23ck35 = 1.8 time = 360
* CHECK dout0_24 vdout0_24ck35 = 0 time = 360
* CHECK dout0_25 vdout0_25ck35 = 1.8 time = 360
* CHECK dout0_26 vdout0_26ck35 = 1.8 time = 360
* CHECK dout0_27 vdout0_27ck35 = 0 time = 360
* CHECK dout0_28 vdout0_28ck35 = 0 time = 360
* CHECK dout0_29 vdout0_29ck35 = 0 time = 360
* CHECK dout0_30 vdout0_30ck35 = 1.8 time = 360
* CHECK dout0_31 vdout0_31ck35 = 0 time = 360
* CHECK dout0_32 vdout0_32ck35 = 0 time = 360
* CHECK dout0_0 vdout0_0ck36 = 0 time = 370
* CHECK dout0_1 vdout0_1ck36 = 0 time = 370
* CHECK dout0_2 vdout0_2ck36 = 1.8 time = 370
* CHECK dout0_3 vdout0_3ck36 = 1.8 time = 370
* CHECK dout0_4 vdout0_4ck36 = 0 time = 370
* CHECK dout0_5 vdout0_5ck36 = 0 time = 370
* CHECK dout0_6 vdout0_6ck36 = 1.8 time = 370
* CHECK dout0_7 vdout0_7ck36 = 0 time = 370
* CHECK dout0_8 vdout0_8ck36 = 1.8 time = 370
* CHECK dout0_9 vdout0_9ck36 = 0 time = 370
* CHECK dout0_10 vdout0_10ck36 = 1.8 time = 370
* CHECK dout0_11 vdout0_11ck36 = 0 time = 370
* CHECK dout0_12 vdout0_12ck36 = 1.8 time = 370
* CHECK dout0_13 vdout0_13ck36 = 0 time = 370
* CHECK dout0_14 vdout0_14ck36 = 0 time = 370
* CHECK dout0_15 vdout0_15ck36 = 0 time = 370
* CHECK dout0_16 vdout0_16ck36 = 1.8 time = 370
* CHECK dout0_17 vdout0_17ck36 = 0 time = 370
* CHECK dout0_18 vdout0_18ck36 = 1.8 time = 370
* CHECK dout0_19 vdout0_19ck36 = 0 time = 370
* CHECK dout0_20 vdout0_20ck36 = 1.8 time = 370
* CHECK dout0_21 vdout0_21ck36 = 1.8 time = 370
* CHECK dout0_22 vdout0_22ck36 = 1.8 time = 370
* CHECK dout0_23 vdout0_23ck36 = 1.8 time = 370
* CHECK dout0_24 vdout0_24ck36 = 0 time = 370
* CHECK dout0_25 vdout0_25ck36 = 0 time = 370
* CHECK dout0_26 vdout0_26ck36 = 1.8 time = 370
* CHECK dout0_27 vdout0_27ck36 = 1.8 time = 370
* CHECK dout0_28 vdout0_28ck36 = 1.8 time = 370
* CHECK dout0_29 vdout0_29ck36 = 1.8 time = 370
* CHECK dout0_30 vdout0_30ck36 = 1.8 time = 370
* CHECK dout0_31 vdout0_31ck36 = 1.8 time = 370
* CHECK dout0_32 vdout0_32ck36 = 0 time = 370
* CHECK dout0_0 vdout0_0ck37 = 1.8 time = 380
* CHECK dout0_1 vdout0_1ck37 = 0 time = 380
* CHECK dout0_2 vdout0_2ck37 = 0 time = 380
* CHECK dout0_3 vdout0_3ck37 = 1.8 time = 380
* CHECK dout0_4 vdout0_4ck37 = 1.8 time = 380
* CHECK dout0_5 vdout0_5ck37 = 0 time = 380
* CHECK dout0_6 vdout0_6ck37 = 0 time = 380
* CHECK dout0_7 vdout0_7ck37 = 0 time = 380
* CHECK dout0_8 vdout0_8ck37 = 0 time = 380
* CHECK dout0_9 vdout0_9ck37 = 1.8 time = 380
* CHECK dout0_10 vdout0_10ck37 = 0 time = 380
* CHECK dout0_11 vdout0_11ck37 = 1.8 time = 380
* CHECK dout0_12 vdout0_12ck37 = 1.8 time = 380
* CHECK dout0_13 vdout0_13ck37 = 1.8 time = 380
* CHECK dout0_14 vdout0_14ck37 = 0 time = 380
* CHECK dout0_15 vdout0_15ck37 = 1.8 time = 380
* CHECK dout0_16 vdout0_16ck37 = 1.8 time = 380
* CHECK dout0_17 vdout0_17ck37 = 1.8 time = 380
* CHECK dout0_18 vdout0_18ck37 = 0 time = 380
* CHECK dout0_19 vdout0_19ck37 = 1.8 time = 380
* CHECK dout0_20 vdout0_20ck37 = 0 time = 380
* CHECK dout0_21 vdout0_21ck37 = 0 time = 380
* CHECK dout0_22 vdout0_22ck37 = 0 time = 380
* CHECK dout0_23 vdout0_23ck37 = 1.8 time = 380
* CHECK dout0_24 vdout0_24ck37 = 0 time = 380
* CHECK dout0_25 vdout0_25ck37 = 1.8 time = 380
* CHECK dout0_26 vdout0_26ck37 = 1.8 time = 380
* CHECK dout0_27 vdout0_27ck37 = 0 time = 380
* CHECK dout0_28 vdout0_28ck37 = 0 time = 380
* CHECK dout0_29 vdout0_29ck37 = 0 time = 380
* CHECK dout0_30 vdout0_30ck37 = 1.8 time = 380
* CHECK dout0_31 vdout0_31ck37 = 0 time = 380
* CHECK dout0_32 vdout0_32ck37 = 0 time = 380
* CHECK dout0_0 vdout0_0ck38 = 1.8 time = 390
* CHECK dout0_1 vdout0_1ck38 = 0 time = 390
* CHECK dout0_2 vdout0_2ck38 = 0 time = 390
* CHECK dout0_3 vdout0_3ck38 = 1.8 time = 390
* CHECK dout0_4 vdout0_4ck38 = 1.8 time = 390
* CHECK dout0_5 vdout0_5ck38 = 0 time = 390
* CHECK dout0_6 vdout0_6ck38 = 0 time = 390
* CHECK dout0_7 vdout0_7ck38 = 0 time = 390
* CHECK dout0_8 vdout0_8ck38 = 0 time = 390
* CHECK dout0_9 vdout0_9ck38 = 1.8 time = 390
* CHECK dout0_10 vdout0_10ck38 = 0 time = 390
* CHECK dout0_11 vdout0_11ck38 = 1.8 time = 390
* CHECK dout0_12 vdout0_12ck38 = 1.8 time = 390
* CHECK dout0_13 vdout0_13ck38 = 1.8 time = 390
* CHECK dout0_14 vdout0_14ck38 = 0 time = 390
* CHECK dout0_15 vdout0_15ck38 = 1.8 time = 390
* CHECK dout0_16 vdout0_16ck38 = 1.8 time = 390
* CHECK dout0_17 vdout0_17ck38 = 1.8 time = 390
* CHECK dout0_18 vdout0_18ck38 = 0 time = 390
* CHECK dout0_19 vdout0_19ck38 = 1.8 time = 390
* CHECK dout0_20 vdout0_20ck38 = 0 time = 390
* CHECK dout0_21 vdout0_21ck38 = 0 time = 390
* CHECK dout0_22 vdout0_22ck38 = 0 time = 390
* CHECK dout0_23 vdout0_23ck38 = 1.8 time = 390
* CHECK dout0_24 vdout0_24ck38 = 0 time = 390
* CHECK dout0_25 vdout0_25ck38 = 1.8 time = 390
* CHECK dout0_26 vdout0_26ck38 = 1.8 time = 390
* CHECK dout0_27 vdout0_27ck38 = 0 time = 390
* CHECK dout0_28 vdout0_28ck38 = 0 time = 390
* CHECK dout0_29 vdout0_29ck38 = 0 time = 390
* CHECK dout0_30 vdout0_30ck38 = 1.8 time = 390
* CHECK dout0_31 vdout0_31ck38 = 0 time = 390
* CHECK dout0_32 vdout0_32ck38 = 0 time = 390
* CHECK dout0_0 vdout0_0ck41 = 1.8 time = 420
* CHECK dout0_1 vdout0_1ck41 = 0 time = 420
* CHECK dout0_2 vdout0_2ck41 = 0 time = 420
* CHECK dout0_3 vdout0_3ck41 = 1.8 time = 420
* CHECK dout0_4 vdout0_4ck41 = 1.8 time = 420
* CHECK dout0_5 vdout0_5ck41 = 0 time = 420
* CHECK dout0_6 vdout0_6ck41 = 0 time = 420
* CHECK dout0_7 vdout0_7ck41 = 0 time = 420
* CHECK dout0_8 vdout0_8ck41 = 0 time = 420
* CHECK dout0_9 vdout0_9ck41 = 1.8 time = 420
* CHECK dout0_10 vdout0_10ck41 = 0 time = 420
* CHECK dout0_11 vdout0_11ck41 = 1.8 time = 420
* CHECK dout0_12 vdout0_12ck41 = 1.8 time = 420
* CHECK dout0_13 vdout0_13ck41 = 1.8 time = 420
* CHECK dout0_14 vdout0_14ck41 = 0 time = 420
* CHECK dout0_15 vdout0_15ck41 = 1.8 time = 420
* CHECK dout0_16 vdout0_16ck41 = 1.8 time = 420
* CHECK dout0_17 vdout0_17ck41 = 1.8 time = 420
* CHECK dout0_18 vdout0_18ck41 = 0 time = 420
* CHECK dout0_19 vdout0_19ck41 = 1.8 time = 420
* CHECK dout0_20 vdout0_20ck41 = 0 time = 420
* CHECK dout0_21 vdout0_21ck41 = 0 time = 420
* CHECK dout0_22 vdout0_22ck41 = 0 time = 420
* CHECK dout0_23 vdout0_23ck41 = 1.8 time = 420
* CHECK dout0_24 vdout0_24ck41 = 0 time = 420
* CHECK dout0_25 vdout0_25ck41 = 1.8 time = 420
* CHECK dout0_26 vdout0_26ck41 = 1.8 time = 420
* CHECK dout0_27 vdout0_27ck41 = 0 time = 420
* CHECK dout0_28 vdout0_28ck41 = 0 time = 420
* CHECK dout0_29 vdout0_29ck41 = 0 time = 420
* CHECK dout0_30 vdout0_30ck41 = 1.8 time = 420
* CHECK dout0_31 vdout0_31ck41 = 0 time = 420
* CHECK dout0_32 vdout0_32ck41 = 0 time = 420
* CHECK dout0_0 vdout0_0ck43 = 1.8 time = 440
* CHECK dout0_1 vdout0_1ck43 = 0 time = 440
* CHECK dout0_2 vdout0_2ck43 = 0 time = 440
* CHECK dout0_3 vdout0_3ck43 = 1.8 time = 440
* CHECK dout0_4 vdout0_4ck43 = 1.8 time = 440
* CHECK dout0_5 vdout0_5ck43 = 0 time = 440
* CHECK dout0_6 vdout0_6ck43 = 0 time = 440
* CHECK dout0_7 vdout0_7ck43 = 0 time = 440
* CHECK dout0_8 vdout0_8ck43 = 0 time = 440
* CHECK dout0_9 vdout0_9ck43 = 1.8 time = 440
* CHECK dout0_10 vdout0_10ck43 = 0 time = 440
* CHECK dout0_11 vdout0_11ck43 = 1.8 time = 440
* CHECK dout0_12 vdout0_12ck43 = 1.8 time = 440
* CHECK dout0_13 vdout0_13ck43 = 1.8 time = 440
* CHECK dout0_14 vdout0_14ck43 = 0 time = 440
* CHECK dout0_15 vdout0_15ck43 = 1.8 time = 440
* CHECK dout0_16 vdout0_16ck43 = 1.8 time = 440
* CHECK dout0_17 vdout0_17ck43 = 1.8 time = 440
* CHECK dout0_18 vdout0_18ck43 = 0 time = 440
* CHECK dout0_19 vdout0_19ck43 = 1.8 time = 440
* CHECK dout0_20 vdout0_20ck43 = 0 time = 440
* CHECK dout0_21 vdout0_21ck43 = 0 time = 440
* CHECK dout0_22 vdout0_22ck43 = 0 time = 440
* CHECK dout0_23 vdout0_23ck43 = 1.8 time = 440
* CHECK dout0_24 vdout0_24ck43 = 0 time = 440
* CHECK dout0_25 vdout0_25ck43 = 1.8 time = 440
* CHECK dout0_26 vdout0_26ck43 = 1.8 time = 440
* CHECK dout0_27 vdout0_27ck43 = 0 time = 440
* CHECK dout0_28 vdout0_28ck43 = 0 time = 440
* CHECK dout0_29 vdout0_29ck43 = 0 time = 440
* CHECK dout0_30 vdout0_30ck43 = 1.8 time = 440
* CHECK dout0_31 vdout0_31ck43 = 0 time = 440
* CHECK dout0_32 vdout0_32ck43 = 0 time = 440
* CHECK dout0_0 vdout0_0ck44 = 1.8 time = 450
* CHECK dout0_1 vdout0_1ck44 = 0 time = 450
* CHECK dout0_2 vdout0_2ck44 = 0 time = 450
* CHECK dout0_3 vdout0_3ck44 = 1.8 time = 450
* CHECK dout0_4 vdout0_4ck44 = 1.8 time = 450
* CHECK dout0_5 vdout0_5ck44 = 0 time = 450
* CHECK dout0_6 vdout0_6ck44 = 0 time = 450
* CHECK dout0_7 vdout0_7ck44 = 0 time = 450
* CHECK dout0_8 vdout0_8ck44 = 0 time = 450
* CHECK dout0_9 vdout0_9ck44 = 1.8 time = 450
* CHECK dout0_10 vdout0_10ck44 = 0 time = 450
* CHECK dout0_11 vdout0_11ck44 = 1.8 time = 450
* CHECK dout0_12 vdout0_12ck44 = 1.8 time = 450
* CHECK dout0_13 vdout0_13ck44 = 1.8 time = 450
* CHECK dout0_14 vdout0_14ck44 = 0 time = 450
* CHECK dout0_15 vdout0_15ck44 = 1.8 time = 450
* CHECK dout0_16 vdout0_16ck44 = 1.8 time = 450
* CHECK dout0_17 vdout0_17ck44 = 1.8 time = 450
* CHECK dout0_18 vdout0_18ck44 = 0 time = 450
* CHECK dout0_19 vdout0_19ck44 = 1.8 time = 450
* CHECK dout0_20 vdout0_20ck44 = 0 time = 450
* CHECK dout0_21 vdout0_21ck44 = 0 time = 450
* CHECK dout0_22 vdout0_22ck44 = 0 time = 450
* CHECK dout0_23 vdout0_23ck44 = 1.8 time = 450
* CHECK dout0_24 vdout0_24ck44 = 0 time = 450
* CHECK dout0_25 vdout0_25ck44 = 1.8 time = 450
* CHECK dout0_26 vdout0_26ck44 = 1.8 time = 450
* CHECK dout0_27 vdout0_27ck44 = 0 time = 450
* CHECK dout0_28 vdout0_28ck44 = 0 time = 450
* CHECK dout0_29 vdout0_29ck44 = 0 time = 450
* CHECK dout0_30 vdout0_30ck44 = 1.8 time = 450
* CHECK dout0_31 vdout0_31ck44 = 0 time = 450
* CHECK dout0_32 vdout0_32ck44 = 0 time = 450
* CHECK dout0_0 vdout0_0ck48 = 0 time = 490
* CHECK dout0_1 vdout0_1ck48 = 1.8 time = 490
* CHECK dout0_2 vdout0_2ck48 = 0 time = 490
* CHECK dout0_3 vdout0_3ck48 = 1.8 time = 490
* CHECK dout0_4 vdout0_4ck48 = 0 time = 490
* CHECK dout0_5 vdout0_5ck48 = 1.8 time = 490
* CHECK dout0_6 vdout0_6ck48 = 0 time = 490
* CHECK dout0_7 vdout0_7ck48 = 1.8 time = 490
* CHECK dout0_8 vdout0_8ck48 = 0 time = 490
* CHECK dout0_9 vdout0_9ck48 = 0 time = 490
* CHECK dout0_10 vdout0_10ck48 = 1.8 time = 490
* CHECK dout0_11 vdout0_11ck48 = 0 time = 490
* CHECK dout0_12 vdout0_12ck48 = 0 time = 490
* CHECK dout0_13 vdout0_13ck48 = 1.8 time = 490
* CHECK dout0_14 vdout0_14ck48 = 1.8 time = 490
* CHECK dout0_15 vdout0_15ck48 = 0 time = 490
* CHECK dout0_16 vdout0_16ck48 = 0 time = 490
* CHECK dout0_17 vdout0_17ck48 = 0 time = 490
* CHECK dout0_18 vdout0_18ck48 = 0 time = 490
* CHECK dout0_19 vdout0_19ck48 = 1.8 time = 490
* CHECK dout0_20 vdout0_20ck48 = 0 time = 490
* CHECK dout0_21 vdout0_21ck48 = 0 time = 490
* CHECK dout0_22 vdout0_22ck48 = 0 time = 490
* CHECK dout0_23 vdout0_23ck48 = 1.8 time = 490
* CHECK dout0_24 vdout0_24ck48 = 1.8 time = 490
* CHECK dout0_25 vdout0_25ck48 = 0 time = 490
* CHECK dout0_26 vdout0_26ck48 = 1.8 time = 490
* CHECK dout0_27 vdout0_27ck48 = 0 time = 490
* CHECK dout0_28 vdout0_28ck48 = 0 time = 490
* CHECK dout0_29 vdout0_29ck48 = 1.8 time = 490
* CHECK dout0_30 vdout0_30ck48 = 0 time = 490
* CHECK dout0_31 vdout0_31ck48 = 1.8 time = 490
* CHECK dout0_32 vdout0_32ck48 = 0 time = 490
* CHECK dout0_0 vdout0_0ck49 = 0 time = 500
* CHECK dout0_1 vdout0_1ck49 = 0 time = 500
* CHECK dout0_2 vdout0_2ck49 = 1.8 time = 500
* CHECK dout0_3 vdout0_3ck49 = 0 time = 500
* CHECK dout0_4 vdout0_4ck49 = 1.8 time = 500
* CHECK dout0_5 vdout0_5ck49 = 0 time = 500
* CHECK dout0_6 vdout0_6ck49 = 0 time = 500
* CHECK dout0_7 vdout0_7ck49 = 1.8 time = 500
* CHECK dout0_8 vdout0_8ck49 = 1.8 time = 500
* CHECK dout0_9 vdout0_9ck49 = 1.8 time = 500
* CHECK dout0_10 vdout0_10ck49 = 1.8 time = 500
* CHECK dout0_11 vdout0_11ck49 = 0 time = 500
* CHECK dout0_12 vdout0_12ck49 = 0 time = 500
* CHECK dout0_13 vdout0_13ck49 = 1.8 time = 500
* CHECK dout0_14 vdout0_14ck49 = 1.8 time = 500
* CHECK dout0_15 vdout0_15ck49 = 1.8 time = 500
* CHECK dout0_16 vdout0_16ck49 = 1.8 time = 500
* CHECK dout0_17 vdout0_17ck49 = 0 time = 500
* CHECK dout0_18 vdout0_18ck49 = 1.8 time = 500
* CHECK dout0_19 vdout0_19ck49 = 0 time = 500
* CHECK dout0_20 vdout0_20ck49 = 0 time = 500
* CHECK dout0_21 vdout0_21ck49 = 0 time = 500
* CHECK dout0_22 vdout0_22ck49 = 0 time = 500
* CHECK dout0_23 vdout0_23ck49 = 1.8 time = 500
* CHECK dout0_24 vdout0_24ck49 = 0 time = 500
* CHECK dout0_25 vdout0_25ck49 = 1.8 time = 500
* CHECK dout0_26 vdout0_26ck49 = 1.8 time = 500
* CHECK dout0_27 vdout0_27ck49 = 0 time = 500
* CHECK dout0_28 vdout0_28ck49 = 1.8 time = 500
* CHECK dout0_29 vdout0_29ck49 = 0 time = 500
* CHECK dout0_30 vdout0_30ck49 = 0 time = 500
* CHECK dout0_31 vdout0_31ck49 = 1.8 time = 500
* CHECK dout0_32 vdout0_32ck49 = 0 time = 500
* CHECK dout0_0 vdout0_0ck51 = 0 time = 520
* CHECK dout0_1 vdout0_1ck51 = 1.8 time = 520
* CHECK dout0_2 vdout0_2ck51 = 0 time = 520
* CHECK dout0_3 vdout0_3ck51 = 1.8 time = 520
* CHECK dout0_4 vdout0_4ck51 = 0 time = 520
* CHECK dout0_5 vdout0_5ck51 = 1.8 time = 520
* CHECK dout0_6 vdout0_6ck51 = 0 time = 520
* CHECK dout0_7 vdout0_7ck51 = 1.8 time = 520
* CHECK dout0_8 vdout0_8ck51 = 0 time = 520
* CHECK dout0_9 vdout0_9ck51 = 0 time = 520
* CHECK dout0_10 vdout0_10ck51 = 1.8 time = 520
* CHECK dout0_11 vdout0_11ck51 = 0 time = 520
* CHECK dout0_12 vdout0_12ck51 = 0 time = 520
* CHECK dout0_13 vdout0_13ck51 = 1.8 time = 520
* CHECK dout0_14 vdout0_14ck51 = 1.8 time = 520
* CHECK dout0_15 vdout0_15ck51 = 0 time = 520
* CHECK dout0_16 vdout0_16ck51 = 0 time = 520
* CHECK dout0_17 vdout0_17ck51 = 0 time = 520
* CHECK dout0_18 vdout0_18ck51 = 0 time = 520
* CHECK dout0_19 vdout0_19ck51 = 1.8 time = 520
* CHECK dout0_20 vdout0_20ck51 = 0 time = 520
* CHECK dout0_21 vdout0_21ck51 = 0 time = 520
* CHECK dout0_22 vdout0_22ck51 = 0 time = 520
* CHECK dout0_23 vdout0_23ck51 = 1.8 time = 520
* CHECK dout0_24 vdout0_24ck51 = 1.8 time = 520
* CHECK dout0_25 vdout0_25ck51 = 0 time = 520
* CHECK dout0_26 vdout0_26ck51 = 1.8 time = 520
* CHECK dout0_27 vdout0_27ck51 = 0 time = 520
* CHECK dout0_28 vdout0_28ck51 = 0 time = 520
* CHECK dout0_29 vdout0_29ck51 = 1.8 time = 520
* CHECK dout0_30 vdout0_30ck51 = 0 time = 520
* CHECK dout0_31 vdout0_31ck51 = 1.8 time = 520
* CHECK dout0_32 vdout0_32ck51 = 0 time = 520
* CHECK dout0_0 vdout0_0ck52 = 0 time = 530
* CHECK dout0_1 vdout0_1ck52 = 0 time = 530
* CHECK dout0_2 vdout0_2ck52 = 1.8 time = 530
* CHECK dout0_3 vdout0_3ck52 = 0 time = 530
* CHECK dout0_4 vdout0_4ck52 = 1.8 time = 530
* CHECK dout0_5 vdout0_5ck52 = 0 time = 530
* CHECK dout0_6 vdout0_6ck52 = 0 time = 530
* CHECK dout0_7 vdout0_7ck52 = 1.8 time = 530
* CHECK dout0_8 vdout0_8ck52 = 1.8 time = 530
* CHECK dout0_9 vdout0_9ck52 = 1.8 time = 530
* CHECK dout0_10 vdout0_10ck52 = 1.8 time = 530
* CHECK dout0_11 vdout0_11ck52 = 0 time = 530
* CHECK dout0_12 vdout0_12ck52 = 0 time = 530
* CHECK dout0_13 vdout0_13ck52 = 1.8 time = 530
* CHECK dout0_14 vdout0_14ck52 = 1.8 time = 530
* CHECK dout0_15 vdout0_15ck52 = 1.8 time = 530
* CHECK dout0_16 vdout0_16ck52 = 1.8 time = 530
* CHECK dout0_17 vdout0_17ck52 = 0 time = 530
* CHECK dout0_18 vdout0_18ck52 = 1.8 time = 530
* CHECK dout0_19 vdout0_19ck52 = 0 time = 530
* CHECK dout0_20 vdout0_20ck52 = 0 time = 530
* CHECK dout0_21 vdout0_21ck52 = 0 time = 530
* CHECK dout0_22 vdout0_22ck52 = 0 time = 530
* CHECK dout0_23 vdout0_23ck52 = 1.8 time = 530
* CHECK dout0_24 vdout0_24ck52 = 0 time = 530
* CHECK dout0_25 vdout0_25ck52 = 1.8 time = 530
* CHECK dout0_26 vdout0_26ck52 = 1.8 time = 530
* CHECK dout0_27 vdout0_27ck52 = 0 time = 530
* CHECK dout0_28 vdout0_28ck52 = 1.8 time = 530
* CHECK dout0_29 vdout0_29ck52 = 0 time = 530
* CHECK dout0_30 vdout0_30ck52 = 0 time = 530
* CHECK dout0_31 vdout0_31ck52 = 1.8 time = 530
* CHECK dout0_32 vdout0_32ck52 = 0 time = 530
* CHECK dout0_0 vdout0_0ck53 = 0 time = 540
* CHECK dout0_1 vdout0_1ck53 = 1.8 time = 540
* CHECK dout0_2 vdout0_2ck53 = 0 time = 540
* CHECK dout0_3 vdout0_3ck53 = 1.8 time = 540
* CHECK dout0_4 vdout0_4ck53 = 0 time = 540
* CHECK dout0_5 vdout0_5ck53 = 1.8 time = 540
* CHECK dout0_6 vdout0_6ck53 = 0 time = 540
* CHECK dout0_7 vdout0_7ck53 = 1.8 time = 540
* CHECK dout0_8 vdout0_8ck53 = 0 time = 540
* CHECK dout0_9 vdout0_9ck53 = 0 time = 540
* CHECK dout0_10 vdout0_10ck53 = 1.8 time = 540
* CHECK dout0_11 vdout0_11ck53 = 0 time = 540
* CHECK dout0_12 vdout0_12ck53 = 0 time = 540
* CHECK dout0_13 vdout0_13ck53 = 1.8 time = 540
* CHECK dout0_14 vdout0_14ck53 = 1.8 time = 540
* CHECK dout0_15 vdout0_15ck53 = 0 time = 540
* CHECK dout0_16 vdout0_16ck53 = 0 time = 540
* CHECK dout0_17 vdout0_17ck53 = 0 time = 540
* CHECK dout0_18 vdout0_18ck53 = 0 time = 540
* CHECK dout0_19 vdout0_19ck53 = 1.8 time = 540
* CHECK dout0_20 vdout0_20ck53 = 0 time = 540
* CHECK dout0_21 vdout0_21ck53 = 0 time = 540
* CHECK dout0_22 vdout0_22ck53 = 0 time = 540
* CHECK dout0_23 vdout0_23ck53 = 1.8 time = 540
* CHECK dout0_24 vdout0_24ck53 = 1.8 time = 540
* CHECK dout0_25 vdout0_25ck53 = 0 time = 540
* CHECK dout0_26 vdout0_26ck53 = 1.8 time = 540
* CHECK dout0_27 vdout0_27ck53 = 0 time = 540
* CHECK dout0_28 vdout0_28ck53 = 0 time = 540
* CHECK dout0_29 vdout0_29ck53 = 1.8 time = 540
* CHECK dout0_30 vdout0_30ck53 = 0 time = 540
* CHECK dout0_31 vdout0_31ck53 = 1.8 time = 540
* CHECK dout0_32 vdout0_32ck53 = 0 time = 540
* CHECK dout0_0 vdout0_0ck55 = 0 time = 560
* CHECK dout0_1 vdout0_1ck55 = 0 time = 560
* CHECK dout0_2 vdout0_2ck55 = 1.8 time = 560
* CHECK dout0_3 vdout0_3ck55 = 0 time = 560
* CHECK dout0_4 vdout0_4ck55 = 1.8 time = 560
* CHECK dout0_5 vdout0_5ck55 = 0 time = 560
* CHECK dout0_6 vdout0_6ck55 = 0 time = 560
* CHECK dout0_7 vdout0_7ck55 = 0 time = 560
* CHECK dout0_8 vdout0_8ck55 = 1.8 time = 560
* CHECK dout0_9 vdout0_9ck55 = 1.8 time = 560
* CHECK dout0_10 vdout0_10ck55 = 1.8 time = 560
* CHECK dout0_11 vdout0_11ck55 = 0 time = 560
* CHECK dout0_12 vdout0_12ck55 = 0 time = 560
* CHECK dout0_13 vdout0_13ck55 = 1.8 time = 560
* CHECK dout0_14 vdout0_14ck55 = 0 time = 560
* CHECK dout0_15 vdout0_15ck55 = 0 time = 560
* CHECK dout0_16 vdout0_16ck55 = 0 time = 560
* CHECK dout0_17 vdout0_17ck55 = 1.8 time = 560
* CHECK dout0_18 vdout0_18ck55 = 1.8 time = 560
* CHECK dout0_19 vdout0_19ck55 = 1.8 time = 560
* CHECK dout0_20 vdout0_20ck55 = 1.8 time = 560
* CHECK dout0_21 vdout0_21ck55 = 1.8 time = 560
* CHECK dout0_22 vdout0_22ck55 = 1.8 time = 560
* CHECK dout0_23 vdout0_23ck55 = 0 time = 560
* CHECK dout0_24 vdout0_24ck55 = 1.8 time = 560
* CHECK dout0_25 vdout0_25ck55 = 0 time = 560
* CHECK dout0_26 vdout0_26ck55 = 1.8 time = 560
* CHECK dout0_27 vdout0_27ck55 = 0 time = 560
* CHECK dout0_28 vdout0_28ck55 = 1.8 time = 560
* CHECK dout0_29 vdout0_29ck55 = 1.8 time = 560
* CHECK dout0_30 vdout0_30ck55 = 1.8 time = 560
* CHECK dout0_31 vdout0_31ck55 = 0 time = 560
* CHECK dout0_32 vdout0_32ck55 = 0 time = 560
* CHECK dout0_0 vdout0_0ck58 = 0 time = 590
* CHECK dout0_1 vdout0_1ck58 = 1.8 time = 590
* CHECK dout0_2 vdout0_2ck58 = 0 time = 590
* CHECK dout0_3 vdout0_3ck58 = 1.8 time = 590
* CHECK dout0_4 vdout0_4ck58 = 0 time = 590
* CHECK dout0_5 vdout0_5ck58 = 1.8 time = 590
* CHECK dout0_6 vdout0_6ck58 = 0 time = 590
* CHECK dout0_7 vdout0_7ck58 = 1.8 time = 590
* CHECK dout0_8 vdout0_8ck58 = 0 time = 590
* CHECK dout0_9 vdout0_9ck58 = 0 time = 590
* CHECK dout0_10 vdout0_10ck58 = 1.8 time = 590
* CHECK dout0_11 vdout0_11ck58 = 0 time = 590
* CHECK dout0_12 vdout0_12ck58 = 0 time = 590
* CHECK dout0_13 vdout0_13ck58 = 1.8 time = 590
* CHECK dout0_14 vdout0_14ck58 = 1.8 time = 590
* CHECK dout0_15 vdout0_15ck58 = 0 time = 590
* CHECK dout0_16 vdout0_16ck58 = 0 time = 590
* CHECK dout0_17 vdout0_17ck58 = 0 time = 590
* CHECK dout0_18 vdout0_18ck58 = 0 time = 590
* CHECK dout0_19 vdout0_19ck58 = 1.8 time = 590
* CHECK dout0_20 vdout0_20ck58 = 0 time = 590
* CHECK dout0_21 vdout0_21ck58 = 0 time = 590
* CHECK dout0_22 vdout0_22ck58 = 0 time = 590
* CHECK dout0_23 vdout0_23ck58 = 1.8 time = 590
* CHECK dout0_24 vdout0_24ck58 = 1.8 time = 590
* CHECK dout0_25 vdout0_25ck58 = 0 time = 590
* CHECK dout0_26 vdout0_26ck58 = 1.8 time = 590
* CHECK dout0_27 vdout0_27ck58 = 0 time = 590
* CHECK dout0_28 vdout0_28ck58 = 0 time = 590
* CHECK dout0_29 vdout0_29ck58 = 1.8 time = 590
* CHECK dout0_30 vdout0_30ck58 = 0 time = 590
* CHECK dout0_31 vdout0_31ck58 = 1.8 time = 590
* CHECK dout0_32 vdout0_32ck58 = 0 time = 590
* CHECK dout0_0 vdout0_0ck61 = 0 time = 620
* CHECK dout0_1 vdout0_1ck61 = 1.8 time = 620
* CHECK dout0_2 vdout0_2ck61 = 0 time = 620
* CHECK dout0_3 vdout0_3ck61 = 1.8 time = 620
* CHECK dout0_4 vdout0_4ck61 = 0 time = 620
* CHECK dout0_5 vdout0_5ck61 = 1.8 time = 620
* CHECK dout0_6 vdout0_6ck61 = 0 time = 620
* CHECK dout0_7 vdout0_7ck61 = 1.8 time = 620
* CHECK dout0_8 vdout0_8ck61 = 0 time = 620
* CHECK dout0_9 vdout0_9ck61 = 0 time = 620
* CHECK dout0_10 vdout0_10ck61 = 1.8 time = 620
* CHECK dout0_11 vdout0_11ck61 = 0 time = 620
* CHECK dout0_12 vdout0_12ck61 = 0 time = 620
* CHECK dout0_13 vdout0_13ck61 = 1.8 time = 620
* CHECK dout0_14 vdout0_14ck61 = 1.8 time = 620
* CHECK dout0_15 vdout0_15ck61 = 0 time = 620
* CHECK dout0_16 vdout0_16ck61 = 0 time = 620
* CHECK dout0_17 vdout0_17ck61 = 0 time = 620
* CHECK dout0_18 vdout0_18ck61 = 0 time = 620
* CHECK dout0_19 vdout0_19ck61 = 1.8 time = 620
* CHECK dout0_20 vdout0_20ck61 = 0 time = 620
* CHECK dout0_21 vdout0_21ck61 = 0 time = 620
* CHECK dout0_22 vdout0_22ck61 = 0 time = 620
* CHECK dout0_23 vdout0_23ck61 = 1.8 time = 620
* CHECK dout0_24 vdout0_24ck61 = 1.8 time = 620
* CHECK dout0_25 vdout0_25ck61 = 0 time = 620
* CHECK dout0_26 vdout0_26ck61 = 1.8 time = 620
* CHECK dout0_27 vdout0_27ck61 = 0 time = 620
* CHECK dout0_28 vdout0_28ck61 = 0 time = 620
* CHECK dout0_29 vdout0_29ck61 = 1.8 time = 620
* CHECK dout0_30 vdout0_30ck61 = 0 time = 620
* CHECK dout0_31 vdout0_31ck61 = 1.8 time = 620
* CHECK dout0_32 vdout0_32ck61 = 0 time = 620
* CHECK dout0_0 vdout0_0ck65 = 1.8 time = 660
* CHECK dout0_1 vdout0_1ck65 = 1.8 time = 660
* CHECK dout0_2 vdout0_2ck65 = 1.8 time = 660
* CHECK dout0_3 vdout0_3ck65 = 1.8 time = 660
* CHECK dout0_4 vdout0_4ck65 = 1.8 time = 660
* CHECK dout0_5 vdout0_5ck65 = 1.8 time = 660
* CHECK dout0_6 vdout0_6ck65 = 0 time = 660
* CHECK dout0_7 vdout0_7ck65 = 0 time = 660
* CHECK dout0_8 vdout0_8ck65 = 1.8 time = 660
* CHECK dout0_9 vdout0_9ck65 = 0 time = 660
* CHECK dout0_10 vdout0_10ck65 = 0 time = 660
* CHECK dout0_11 vdout0_11ck65 = 1.8 time = 660
* CHECK dout0_12 vdout0_12ck65 = 0 time = 660
* CHECK dout0_13 vdout0_13ck65 = 1.8 time = 660
* CHECK dout0_14 vdout0_14ck65 = 0 time = 660
* CHECK dout0_15 vdout0_15ck65 = 0 time = 660
* CHECK dout0_16 vdout0_16ck65 = 1.8 time = 660
* CHECK dout0_17 vdout0_17ck65 = 0 time = 660
* CHECK dout0_18 vdout0_18ck65 = 1.8 time = 660
* CHECK dout0_19 vdout0_19ck65 = 0 time = 660
* CHECK dout0_20 vdout0_20ck65 = 1.8 time = 660
* CHECK dout0_21 vdout0_21ck65 = 1.8 time = 660
* CHECK dout0_22 vdout0_22ck65 = 0 time = 660
* CHECK dout0_23 vdout0_23ck65 = 0 time = 660
* CHECK dout0_24 vdout0_24ck65 = 1.8 time = 660
* CHECK dout0_25 vdout0_25ck65 = 1.8 time = 660
* CHECK dout0_26 vdout0_26ck65 = 0 time = 660
* CHECK dout0_27 vdout0_27ck65 = 0 time = 660
* CHECK dout0_28 vdout0_28ck65 = 0 time = 660
* CHECK dout0_29 vdout0_29ck65 = 0 time = 660
* CHECK dout0_30 vdout0_30ck65 = 1.8 time = 660
* CHECK dout0_31 vdout0_31ck65 = 0 time = 660
* CHECK dout0_32 vdout0_32ck65 = 0 time = 660
* CHECK dout0_0 vdout0_0ck68 = 0 time = 690
* CHECK dout0_1 vdout0_1ck68 = 1.8 time = 690
* CHECK dout0_2 vdout0_2ck68 = 0 time = 690
* CHECK dout0_3 vdout0_3ck68 = 1.8 time = 690
* CHECK dout0_4 vdout0_4ck68 = 0 time = 690
* CHECK dout0_5 vdout0_5ck68 = 1.8 time = 690
* CHECK dout0_6 vdout0_6ck68 = 0 time = 690
* CHECK dout0_7 vdout0_7ck68 = 1.8 time = 690
* CHECK dout0_8 vdout0_8ck68 = 0 time = 690
* CHECK dout0_9 vdout0_9ck68 = 0 time = 690
* CHECK dout0_10 vdout0_10ck68 = 1.8 time = 690
* CHECK dout0_11 vdout0_11ck68 = 0 time = 690
* CHECK dout0_12 vdout0_12ck68 = 0 time = 690
* CHECK dout0_13 vdout0_13ck68 = 1.8 time = 690
* CHECK dout0_14 vdout0_14ck68 = 1.8 time = 690
* CHECK dout0_15 vdout0_15ck68 = 0 time = 690
* CHECK dout0_16 vdout0_16ck68 = 0 time = 690
* CHECK dout0_17 vdout0_17ck68 = 0 time = 690
* CHECK dout0_18 vdout0_18ck68 = 0 time = 690
* CHECK dout0_19 vdout0_19ck68 = 1.8 time = 690
* CHECK dout0_20 vdout0_20ck68 = 0 time = 690
* CHECK dout0_21 vdout0_21ck68 = 0 time = 690
* CHECK dout0_22 vdout0_22ck68 = 0 time = 690
* CHECK dout0_23 vdout0_23ck68 = 1.8 time = 690
* CHECK dout0_24 vdout0_24ck68 = 1.8 time = 690
* CHECK dout0_25 vdout0_25ck68 = 0 time = 690
* CHECK dout0_26 vdout0_26ck68 = 1.8 time = 690
* CHECK dout0_27 vdout0_27ck68 = 0 time = 690
* CHECK dout0_28 vdout0_28ck68 = 0 time = 690
* CHECK dout0_29 vdout0_29ck68 = 1.8 time = 690
* CHECK dout0_30 vdout0_30ck68 = 0 time = 690
* CHECK dout0_31 vdout0_31ck68 = 1.8 time = 690
* CHECK dout0_32 vdout0_32ck68 = 0 time = 690
* CHECK dout0_0 vdout0_0ck71 = 0 time = 720
* CHECK dout0_1 vdout0_1ck71 = 0 time = 720
* CHECK dout0_2 vdout0_2ck71 = 0 time = 720
* CHECK dout0_3 vdout0_3ck71 = 1.8 time = 720
* CHECK dout0_4 vdout0_4ck71 = 1.8 time = 720
* CHECK dout0_5 vdout0_5ck71 = 1.8 time = 720
* CHECK dout0_6 vdout0_6ck71 = 0 time = 720
* CHECK dout0_7 vdout0_7ck71 = 1.8 time = 720
* CHECK dout0_8 vdout0_8ck71 = 0 time = 720
* CHECK dout0_9 vdout0_9ck71 = 1.8 time = 720
* CHECK dout0_10 vdout0_10ck71 = 0 time = 720
* CHECK dout0_11 vdout0_11ck71 = 0 time = 720
* CHECK dout0_12 vdout0_12ck71 = 0 time = 720
* CHECK dout0_13 vdout0_13ck71 = 1.8 time = 720
* CHECK dout0_14 vdout0_14ck71 = 0 time = 720
* CHECK dout0_15 vdout0_15ck71 = 1.8 time = 720
* CHECK dout0_16 vdout0_16ck71 = 0 time = 720
* CHECK dout0_17 vdout0_17ck71 = 1.8 time = 720
* CHECK dout0_18 vdout0_18ck71 = 0 time = 720
* CHECK dout0_19 vdout0_19ck71 = 1.8 time = 720
* CHECK dout0_20 vdout0_20ck71 = 1.8 time = 720
* CHECK dout0_21 vdout0_21ck71 = 1.8 time = 720
* CHECK dout0_22 vdout0_22ck71 = 0 time = 720
* CHECK dout0_23 vdout0_23ck71 = 0 time = 720
* CHECK dout0_24 vdout0_24ck71 = 0 time = 720
* CHECK dout0_25 vdout0_25ck71 = 0 time = 720
* CHECK dout0_26 vdout0_26ck71 = 0 time = 720
* CHECK dout0_27 vdout0_27ck71 = 1.8 time = 720
* CHECK dout0_28 vdout0_28ck71 = 1.8 time = 720
* CHECK dout0_29 vdout0_29ck71 = 1.8 time = 720
* CHECK dout0_30 vdout0_30ck71 = 1.8 time = 720
* CHECK dout0_31 vdout0_31ck71 = 0 time = 720
* CHECK dout0_32 vdout0_32ck71 = 0 time = 720
* CHECK dout0_0 vdout0_0ck72 = 0 time = 730
* CHECK dout0_1 vdout0_1ck72 = 0 time = 730
* CHECK dout0_2 vdout0_2ck72 = 0 time = 730
* CHECK dout0_3 vdout0_3ck72 = 0 time = 730
* CHECK dout0_4 vdout0_4ck72 = 1.8 time = 730
* CHECK dout0_5 vdout0_5ck72 = 1.8 time = 730
* CHECK dout0_6 vdout0_6ck72 = 1.8 time = 730
* CHECK dout0_7 vdout0_7ck72 = 0 time = 730
* CHECK dout0_8 vdout0_8ck72 = 1.8 time = 730
* CHECK dout0_9 vdout0_9ck72 = 1.8 time = 730
* CHECK dout0_10 vdout0_10ck72 = 0 time = 730
* CHECK dout0_11 vdout0_11ck72 = 0 time = 730
* CHECK dout0_12 vdout0_12ck72 = 1.8 time = 730
* CHECK dout0_13 vdout0_13ck72 = 1.8 time = 730
* CHECK dout0_14 vdout0_14ck72 = 0 time = 730
* CHECK dout0_15 vdout0_15ck72 = 1.8 time = 730
* CHECK dout0_16 vdout0_16ck72 = 0 time = 730
* CHECK dout0_17 vdout0_17ck72 = 0 time = 730
* CHECK dout0_18 vdout0_18ck72 = 0 time = 730
* CHECK dout0_19 vdout0_19ck72 = 1.8 time = 730
* CHECK dout0_20 vdout0_20ck72 = 0 time = 730
* CHECK dout0_21 vdout0_21ck72 = 1.8 time = 730
* CHECK dout0_22 vdout0_22ck72 = 1.8 time = 730
* CHECK dout0_23 vdout0_23ck72 = 1.8 time = 730
* CHECK dout0_24 vdout0_24ck72 = 0 time = 730
* CHECK dout0_25 vdout0_25ck72 = 0 time = 730
* CHECK dout0_26 vdout0_26ck72 = 1.8 time = 730
* CHECK dout0_27 vdout0_27ck72 = 1.8 time = 730
* CHECK dout0_28 vdout0_28ck72 = 1.8 time = 730
* CHECK dout0_29 vdout0_29ck72 = 0 time = 730
* CHECK dout0_30 vdout0_30ck72 = 0 time = 730
* CHECK dout0_31 vdout0_31ck72 = 0 time = 730
* CHECK dout0_32 vdout0_32ck72 = 0 time = 730
* CHECK dout0_0 vdout0_0ck73 = 0 time = 740
* CHECK dout0_1 vdout0_1ck73 = 0 time = 740
* CHECK dout0_2 vdout0_2ck73 = 0 time = 740
* CHECK dout0_3 vdout0_3ck73 = 0 time = 740
* CHECK dout0_4 vdout0_4ck73 = 1.8 time = 740
* CHECK dout0_5 vdout0_5ck73 = 1.8 time = 740
* CHECK dout0_6 vdout0_6ck73 = 1.8 time = 740
* CHECK dout0_7 vdout0_7ck73 = 0 time = 740
* CHECK dout0_8 vdout0_8ck73 = 1.8 time = 740
* CHECK dout0_9 vdout0_9ck73 = 1.8 time = 740
* CHECK dout0_10 vdout0_10ck73 = 0 time = 740
* CHECK dout0_11 vdout0_11ck73 = 0 time = 740
* CHECK dout0_12 vdout0_12ck73 = 1.8 time = 740
* CHECK dout0_13 vdout0_13ck73 = 1.8 time = 740
* CHECK dout0_14 vdout0_14ck73 = 0 time = 740
* CHECK dout0_15 vdout0_15ck73 = 1.8 time = 740
* CHECK dout0_16 vdout0_16ck73 = 0 time = 740
* CHECK dout0_17 vdout0_17ck73 = 0 time = 740
* CHECK dout0_18 vdout0_18ck73 = 0 time = 740
* CHECK dout0_19 vdout0_19ck73 = 1.8 time = 740
* CHECK dout0_20 vdout0_20ck73 = 0 time = 740
* CHECK dout0_21 vdout0_21ck73 = 1.8 time = 740
* CHECK dout0_22 vdout0_22ck73 = 1.8 time = 740
* CHECK dout0_23 vdout0_23ck73 = 1.8 time = 740
* CHECK dout0_24 vdout0_24ck73 = 0 time = 740
* CHECK dout0_25 vdout0_25ck73 = 0 time = 740
* CHECK dout0_26 vdout0_26ck73 = 1.8 time = 740
* CHECK dout0_27 vdout0_27ck73 = 1.8 time = 740
* CHECK dout0_28 vdout0_28ck73 = 1.8 time = 740
* CHECK dout0_29 vdout0_29ck73 = 0 time = 740
* CHECK dout0_30 vdout0_30ck73 = 0 time = 740
* CHECK dout0_31 vdout0_31ck73 = 0 time = 740
* CHECK dout0_32 vdout0_32ck73 = 0 time = 740
* CHECK dout0_0 vdout0_0ck76 = 0 time = 770
* CHECK dout0_1 vdout0_1ck76 = 0 time = 770
* CHECK dout0_2 vdout0_2ck76 = 0 time = 770
* CHECK dout0_3 vdout0_3ck76 = 0 time = 770
* CHECK dout0_4 vdout0_4ck76 = 1.8 time = 770
* CHECK dout0_5 vdout0_5ck76 = 1.8 time = 770
* CHECK dout0_6 vdout0_6ck76 = 1.8 time = 770
* CHECK dout0_7 vdout0_7ck76 = 0 time = 770
* CHECK dout0_8 vdout0_8ck76 = 1.8 time = 770
* CHECK dout0_9 vdout0_9ck76 = 1.8 time = 770
* CHECK dout0_10 vdout0_10ck76 = 0 time = 770
* CHECK dout0_11 vdout0_11ck76 = 0 time = 770
* CHECK dout0_12 vdout0_12ck76 = 1.8 time = 770
* CHECK dout0_13 vdout0_13ck76 = 1.8 time = 770
* CHECK dout0_14 vdout0_14ck76 = 0 time = 770
* CHECK dout0_15 vdout0_15ck76 = 1.8 time = 770
* CHECK dout0_16 vdout0_16ck76 = 0 time = 770
* CHECK dout0_17 vdout0_17ck76 = 0 time = 770
* CHECK dout0_18 vdout0_18ck76 = 0 time = 770
* CHECK dout0_19 vdout0_19ck76 = 1.8 time = 770
* CHECK dout0_20 vdout0_20ck76 = 0 time = 770
* CHECK dout0_21 vdout0_21ck76 = 1.8 time = 770
* CHECK dout0_22 vdout0_22ck76 = 1.8 time = 770
* CHECK dout0_23 vdout0_23ck76 = 1.8 time = 770
* CHECK dout0_24 vdout0_24ck76 = 0 time = 770
* CHECK dout0_25 vdout0_25ck76 = 0 time = 770
* CHECK dout0_26 vdout0_26ck76 = 1.8 time = 770
* CHECK dout0_27 vdout0_27ck76 = 1.8 time = 770
* CHECK dout0_28 vdout0_28ck76 = 1.8 time = 770
* CHECK dout0_29 vdout0_29ck76 = 0 time = 770
* CHECK dout0_30 vdout0_30ck76 = 0 time = 770
* CHECK dout0_31 vdout0_31ck76 = 0 time = 770
* CHECK dout0_32 vdout0_32ck76 = 0 time = 770
* CHECK dout0_0 vdout0_0ck79 = 0 time = 800
* CHECK dout0_1 vdout0_1ck79 = 0 time = 800
* CHECK dout0_2 vdout0_2ck79 = 0 time = 800
* CHECK dout0_3 vdout0_3ck79 = 0 time = 800
* CHECK dout0_4 vdout0_4ck79 = 1.8 time = 800
* CHECK dout0_5 vdout0_5ck79 = 1.8 time = 800
* CHECK dout0_6 vdout0_6ck79 = 1.8 time = 800
* CHECK dout0_7 vdout0_7ck79 = 0 time = 800
* CHECK dout0_8 vdout0_8ck79 = 1.8 time = 800
* CHECK dout0_9 vdout0_9ck79 = 1.8 time = 800
* CHECK dout0_10 vdout0_10ck79 = 0 time = 800
* CHECK dout0_11 vdout0_11ck79 = 0 time = 800
* CHECK dout0_12 vdout0_12ck79 = 1.8 time = 800
* CHECK dout0_13 vdout0_13ck79 = 1.8 time = 800
* CHECK dout0_14 vdout0_14ck79 = 0 time = 800
* CHECK dout0_15 vdout0_15ck79 = 1.8 time = 800
* CHECK dout0_16 vdout0_16ck79 = 0 time = 800
* CHECK dout0_17 vdout0_17ck79 = 0 time = 800
* CHECK dout0_18 vdout0_18ck79 = 0 time = 800
* CHECK dout0_19 vdout0_19ck79 = 1.8 time = 800
* CHECK dout0_20 vdout0_20ck79 = 0 time = 800
* CHECK dout0_21 vdout0_21ck79 = 1.8 time = 800
* CHECK dout0_22 vdout0_22ck79 = 1.8 time = 800
* CHECK dout0_23 vdout0_23ck79 = 1.8 time = 800
* CHECK dout0_24 vdout0_24ck79 = 0 time = 800
* CHECK dout0_25 vdout0_25ck79 = 0 time = 800
* CHECK dout0_26 vdout0_26ck79 = 1.8 time = 800
* CHECK dout0_27 vdout0_27ck79 = 1.8 time = 800
* CHECK dout0_28 vdout0_28ck79 = 1.8 time = 800
* CHECK dout0_29 vdout0_29ck79 = 0 time = 800
* CHECK dout0_30 vdout0_30ck79 = 0 time = 800
* CHECK dout0_31 vdout0_31ck79 = 0 time = 800
* CHECK dout0_32 vdout0_32ck79 = 0 time = 800
* CHECK dout0_0 vdout0_0ck80 = 0 time = 810
* CHECK dout0_1 vdout0_1ck80 = 0 time = 810
* CHECK dout0_2 vdout0_2ck80 = 0 time = 810
* CHECK dout0_3 vdout0_3ck80 = 0 time = 810
* CHECK dout0_4 vdout0_4ck80 = 1.8 time = 810
* CHECK dout0_5 vdout0_5ck80 = 1.8 time = 810
* CHECK dout0_6 vdout0_6ck80 = 1.8 time = 810
* CHECK dout0_7 vdout0_7ck80 = 0 time = 810
* CHECK dout0_8 vdout0_8ck80 = 1.8 time = 810
* CHECK dout0_9 vdout0_9ck80 = 1.8 time = 810
* CHECK dout0_10 vdout0_10ck80 = 0 time = 810
* CHECK dout0_11 vdout0_11ck80 = 0 time = 810
* CHECK dout0_12 vdout0_12ck80 = 1.8 time = 810
* CHECK dout0_13 vdout0_13ck80 = 1.8 time = 810
* CHECK dout0_14 vdout0_14ck80 = 0 time = 810
* CHECK dout0_15 vdout0_15ck80 = 1.8 time = 810
* CHECK dout0_16 vdout0_16ck80 = 0 time = 810
* CHECK dout0_17 vdout0_17ck80 = 0 time = 810
* CHECK dout0_18 vdout0_18ck80 = 0 time = 810
* CHECK dout0_19 vdout0_19ck80 = 1.8 time = 810
* CHECK dout0_20 vdout0_20ck80 = 0 time = 810
* CHECK dout0_21 vdout0_21ck80 = 1.8 time = 810
* CHECK dout0_22 vdout0_22ck80 = 1.8 time = 810
* CHECK dout0_23 vdout0_23ck80 = 1.8 time = 810
* CHECK dout0_24 vdout0_24ck80 = 0 time = 810
* CHECK dout0_25 vdout0_25ck80 = 0 time = 810
* CHECK dout0_26 vdout0_26ck80 = 1.8 time = 810
* CHECK dout0_27 vdout0_27ck80 = 1.8 time = 810
* CHECK dout0_28 vdout0_28ck80 = 1.8 time = 810
* CHECK dout0_29 vdout0_29ck80 = 0 time = 810
* CHECK dout0_30 vdout0_30ck80 = 0 time = 810
* CHECK dout0_31 vdout0_31ck80 = 0 time = 810
* CHECK dout0_32 vdout0_32ck80 = 0 time = 810
* CHECK dout0_0 vdout0_0ck81 = 0 time = 820
* CHECK dout0_1 vdout0_1ck81 = 0 time = 820
* CHECK dout0_2 vdout0_2ck81 = 0 time = 820
* CHECK dout0_3 vdout0_3ck81 = 0 time = 820
* CHECK dout0_4 vdout0_4ck81 = 1.8 time = 820
* CHECK dout0_5 vdout0_5ck81 = 1.8 time = 820
* CHECK dout0_6 vdout0_6ck81 = 1.8 time = 820
* CHECK dout0_7 vdout0_7ck81 = 0 time = 820
* CHECK dout0_8 vdout0_8ck81 = 1.8 time = 820
* CHECK dout0_9 vdout0_9ck81 = 1.8 time = 820
* CHECK dout0_10 vdout0_10ck81 = 0 time = 820
* CHECK dout0_11 vdout0_11ck81 = 0 time = 820
* CHECK dout0_12 vdout0_12ck81 = 1.8 time = 820
* CHECK dout0_13 vdout0_13ck81 = 1.8 time = 820
* CHECK dout0_14 vdout0_14ck81 = 0 time = 820
* CHECK dout0_15 vdout0_15ck81 = 1.8 time = 820
* CHECK dout0_16 vdout0_16ck81 = 0 time = 820
* CHECK dout0_17 vdout0_17ck81 = 0 time = 820
* CHECK dout0_18 vdout0_18ck81 = 0 time = 820
* CHECK dout0_19 vdout0_19ck81 = 1.8 time = 820
* CHECK dout0_20 vdout0_20ck81 = 0 time = 820
* CHECK dout0_21 vdout0_21ck81 = 1.8 time = 820
* CHECK dout0_22 vdout0_22ck81 = 1.8 time = 820
* CHECK dout0_23 vdout0_23ck81 = 1.8 time = 820
* CHECK dout0_24 vdout0_24ck81 = 0 time = 820
* CHECK dout0_25 vdout0_25ck81 = 0 time = 820
* CHECK dout0_26 vdout0_26ck81 = 1.8 time = 820
* CHECK dout0_27 vdout0_27ck81 = 1.8 time = 820
* CHECK dout0_28 vdout0_28ck81 = 1.8 time = 820
* CHECK dout0_29 vdout0_29ck81 = 0 time = 820
* CHECK dout0_30 vdout0_30ck81 = 0 time = 820
* CHECK dout0_31 vdout0_31ck81 = 0 time = 820
* CHECK dout0_32 vdout0_32ck81 = 0 time = 820
* CHECK dout0_0 vdout0_0ck84 = 1.8 time = 850
* CHECK dout0_1 vdout0_1ck84 = 0 time = 850
* CHECK dout0_2 vdout0_2ck84 = 1.8 time = 850
* CHECK dout0_3 vdout0_3ck84 = 1.8 time = 850
* CHECK dout0_4 vdout0_4ck84 = 1.8 time = 850
* CHECK dout0_5 vdout0_5ck84 = 1.8 time = 850
* CHECK dout0_6 vdout0_6ck84 = 0 time = 850
* CHECK dout0_7 vdout0_7ck84 = 1.8 time = 850
* CHECK dout0_8 vdout0_8ck84 = 1.8 time = 850
* CHECK dout0_9 vdout0_9ck84 = 0 time = 850
* CHECK dout0_10 vdout0_10ck84 = 1.8 time = 850
* CHECK dout0_11 vdout0_11ck84 = 1.8 time = 850
* CHECK dout0_12 vdout0_12ck84 = 1.8 time = 850
* CHECK dout0_13 vdout0_13ck84 = 1.8 time = 850
* CHECK dout0_14 vdout0_14ck84 = 1.8 time = 850
* CHECK dout0_15 vdout0_15ck84 = 1.8 time = 850
* CHECK dout0_16 vdout0_16ck84 = 0 time = 850
* CHECK dout0_17 vdout0_17ck84 = 1.8 time = 850
* CHECK dout0_18 vdout0_18ck84 = 1.8 time = 850
* CHECK dout0_19 vdout0_19ck84 = 0 time = 850
* CHECK dout0_20 vdout0_20ck84 = 0 time = 850
* CHECK dout0_21 vdout0_21ck84 = 1.8 time = 850
* CHECK dout0_22 vdout0_22ck84 = 0 time = 850
* CHECK dout0_23 vdout0_23ck84 = 0 time = 850
* CHECK dout0_24 vdout0_24ck84 = 0 time = 850
* CHECK dout0_25 vdout0_25ck84 = 0 time = 850
* CHECK dout0_26 vdout0_26ck84 = 1.8 time = 850
* CHECK dout0_27 vdout0_27ck84 = 1.8 time = 850
* CHECK dout0_28 vdout0_28ck84 = 0 time = 850
* CHECK dout0_29 vdout0_29ck84 = 0 time = 850
* CHECK dout0_30 vdout0_30ck84 = 0 time = 850
* CHECK dout0_31 vdout0_31ck84 = 0 time = 850
* CHECK dout0_32 vdout0_32ck84 = 0 time = 850
* CHECK dout0_0 vdout0_0ck86 = 1.8 time = 870
* CHECK dout0_1 vdout0_1ck86 = 0 time = 870
* CHECK dout0_2 vdout0_2ck86 = 1.8 time = 870
* CHECK dout0_3 vdout0_3ck86 = 1.8 time = 870
* CHECK dout0_4 vdout0_4ck86 = 1.8 time = 870
* CHECK dout0_5 vdout0_5ck86 = 1.8 time = 870
* CHECK dout0_6 vdout0_6ck86 = 0 time = 870
* CHECK dout0_7 vdout0_7ck86 = 1.8 time = 870
* CHECK dout0_8 vdout0_8ck86 = 1.8 time = 870
* CHECK dout0_9 vdout0_9ck86 = 0 time = 870
* CHECK dout0_10 vdout0_10ck86 = 1.8 time = 870
* CHECK dout0_11 vdout0_11ck86 = 1.8 time = 870
* CHECK dout0_12 vdout0_12ck86 = 1.8 time = 870
* CHECK dout0_13 vdout0_13ck86 = 1.8 time = 870
* CHECK dout0_14 vdout0_14ck86 = 1.8 time = 870
* CHECK dout0_15 vdout0_15ck86 = 1.8 time = 870
* CHECK dout0_16 vdout0_16ck86 = 0 time = 870
* CHECK dout0_17 vdout0_17ck86 = 1.8 time = 870
* CHECK dout0_18 vdout0_18ck86 = 1.8 time = 870
* CHECK dout0_19 vdout0_19ck86 = 0 time = 870
* CHECK dout0_20 vdout0_20ck86 = 0 time = 870
* CHECK dout0_21 vdout0_21ck86 = 1.8 time = 870
* CHECK dout0_22 vdout0_22ck86 = 0 time = 870
* CHECK dout0_23 vdout0_23ck86 = 0 time = 870
* CHECK dout0_24 vdout0_24ck86 = 0 time = 870
* CHECK dout0_25 vdout0_25ck86 = 0 time = 870
* CHECK dout0_26 vdout0_26ck86 = 1.8 time = 870
* CHECK dout0_27 vdout0_27ck86 = 1.8 time = 870
* CHECK dout0_28 vdout0_28ck86 = 0 time = 870
* CHECK dout0_29 vdout0_29ck86 = 0 time = 870
* CHECK dout0_30 vdout0_30ck86 = 0 time = 870
* CHECK dout0_31 vdout0_31ck86 = 0 time = 870
* CHECK dout0_32 vdout0_32ck86 = 0 time = 870
* CHECK dout0_0 vdout0_0ck87 = 1.8 time = 880
* CHECK dout0_1 vdout0_1ck87 = 0 time = 880
* CHECK dout0_2 vdout0_2ck87 = 1.8 time = 880
* CHECK dout0_3 vdout0_3ck87 = 1.8 time = 880
* CHECK dout0_4 vdout0_4ck87 = 1.8 time = 880
* CHECK dout0_5 vdout0_5ck87 = 1.8 time = 880
* CHECK dout0_6 vdout0_6ck87 = 0 time = 880
* CHECK dout0_7 vdout0_7ck87 = 1.8 time = 880
* CHECK dout0_8 vdout0_8ck87 = 1.8 time = 880
* CHECK dout0_9 vdout0_9ck87 = 0 time = 880
* CHECK dout0_10 vdout0_10ck87 = 1.8 time = 880
* CHECK dout0_11 vdout0_11ck87 = 1.8 time = 880
* CHECK dout0_12 vdout0_12ck87 = 1.8 time = 880
* CHECK dout0_13 vdout0_13ck87 = 1.8 time = 880
* CHECK dout0_14 vdout0_14ck87 = 1.8 time = 880
* CHECK dout0_15 vdout0_15ck87 = 1.8 time = 880
* CHECK dout0_16 vdout0_16ck87 = 0 time = 880
* CHECK dout0_17 vdout0_17ck87 = 1.8 time = 880
* CHECK dout0_18 vdout0_18ck87 = 1.8 time = 880
* CHECK dout0_19 vdout0_19ck87 = 0 time = 880
* CHECK dout0_20 vdout0_20ck87 = 0 time = 880
* CHECK dout0_21 vdout0_21ck87 = 1.8 time = 880
* CHECK dout0_22 vdout0_22ck87 = 0 time = 880
* CHECK dout0_23 vdout0_23ck87 = 0 time = 880
* CHECK dout0_24 vdout0_24ck87 = 0 time = 880
* CHECK dout0_25 vdout0_25ck87 = 0 time = 880
* CHECK dout0_26 vdout0_26ck87 = 1.8 time = 880
* CHECK dout0_27 vdout0_27ck87 = 1.8 time = 880
* CHECK dout0_28 vdout0_28ck87 = 0 time = 880
* CHECK dout0_29 vdout0_29ck87 = 0 time = 880
* CHECK dout0_30 vdout0_30ck87 = 0 time = 880
* CHECK dout0_31 vdout0_31ck87 = 0 time = 880
* CHECK dout0_32 vdout0_32ck87 = 0 time = 880
* CHECK dout0_0 vdout0_0ck92 = 1.8 time = 930
* CHECK dout0_1 vdout0_1ck92 = 0 time = 930
* CHECK dout0_2 vdout0_2ck92 = 0 time = 930
* CHECK dout0_3 vdout0_3ck92 = 1.8 time = 930
* CHECK dout0_4 vdout0_4ck92 = 0 time = 930
* CHECK dout0_5 vdout0_5ck92 = 0 time = 930
* CHECK dout0_6 vdout0_6ck92 = 0 time = 930
* CHECK dout0_7 vdout0_7ck92 = 0 time = 930
* CHECK dout0_8 vdout0_8ck92 = 0 time = 930
* CHECK dout0_9 vdout0_9ck92 = 0 time = 930
* CHECK dout0_10 vdout0_10ck92 = 1.8 time = 930
* CHECK dout0_11 vdout0_11ck92 = 1.8 time = 930
* CHECK dout0_12 vdout0_12ck92 = 1.8 time = 930
* CHECK dout0_13 vdout0_13ck92 = 1.8 time = 930
* CHECK dout0_14 vdout0_14ck92 = 0 time = 930
* CHECK dout0_15 vdout0_15ck92 = 0 time = 930
* CHECK dout0_16 vdout0_16ck92 = 0 time = 930
* CHECK dout0_17 vdout0_17ck92 = 1.8 time = 930
* CHECK dout0_18 vdout0_18ck92 = 1.8 time = 930
* CHECK dout0_19 vdout0_19ck92 = 0 time = 930
* CHECK dout0_20 vdout0_20ck92 = 0 time = 930
* CHECK dout0_21 vdout0_21ck92 = 0 time = 930
* CHECK dout0_22 vdout0_22ck92 = 1.8 time = 930
* CHECK dout0_23 vdout0_23ck92 = 1.8 time = 930
* CHECK dout0_24 vdout0_24ck92 = 1.8 time = 930
* CHECK dout0_25 vdout0_25ck92 = 0 time = 930
* CHECK dout0_26 vdout0_26ck92 = 1.8 time = 930
* CHECK dout0_27 vdout0_27ck92 = 0 time = 930
* CHECK dout0_28 vdout0_28ck92 = 0 time = 930
* CHECK dout0_29 vdout0_29ck92 = 1.8 time = 930
* CHECK dout0_30 vdout0_30ck92 = 1.8 time = 930
* CHECK dout0_31 vdout0_31ck92 = 1.8 time = 930
* CHECK dout0_32 vdout0_32ck92 = 0 time = 930
* CHECK dout0_0 vdout0_0ck93 = 1.8 time = 940
* CHECK dout0_1 vdout0_1ck93 = 0 time = 940
* CHECK dout0_2 vdout0_2ck93 = 0 time = 940
* CHECK dout0_3 vdout0_3ck93 = 1.8 time = 940
* CHECK dout0_4 vdout0_4ck93 = 0 time = 940
* CHECK dout0_5 vdout0_5ck93 = 0 time = 940
* CHECK dout0_6 vdout0_6ck93 = 0 time = 940
* CHECK dout0_7 vdout0_7ck93 = 0 time = 940
* CHECK dout0_8 vdout0_8ck93 = 0 time = 940
* CHECK dout0_9 vdout0_9ck93 = 0 time = 940
* CHECK dout0_10 vdout0_10ck93 = 1.8 time = 940
* CHECK dout0_11 vdout0_11ck93 = 1.8 time = 940
* CHECK dout0_12 vdout0_12ck93 = 1.8 time = 940
* CHECK dout0_13 vdout0_13ck93 = 1.8 time = 940
* CHECK dout0_14 vdout0_14ck93 = 0 time = 940
* CHECK dout0_15 vdout0_15ck93 = 0 time = 940
* CHECK dout0_16 vdout0_16ck93 = 0 time = 940
* CHECK dout0_17 vdout0_17ck93 = 1.8 time = 940
* CHECK dout0_18 vdout0_18ck93 = 1.8 time = 940
* CHECK dout0_19 vdout0_19ck93 = 0 time = 940
* CHECK dout0_20 vdout0_20ck93 = 0 time = 940
* CHECK dout0_21 vdout0_21ck93 = 0 time = 940
* CHECK dout0_22 vdout0_22ck93 = 1.8 time = 940
* CHECK dout0_23 vdout0_23ck93 = 1.8 time = 940
* CHECK dout0_24 vdout0_24ck93 = 1.8 time = 940
* CHECK dout0_25 vdout0_25ck93 = 0 time = 940
* CHECK dout0_26 vdout0_26ck93 = 1.8 time = 940
* CHECK dout0_27 vdout0_27ck93 = 0 time = 940
* CHECK dout0_28 vdout0_28ck93 = 0 time = 940
* CHECK dout0_29 vdout0_29ck93 = 1.8 time = 940
* CHECK dout0_30 vdout0_30ck93 = 1.8 time = 940
* CHECK dout0_31 vdout0_31ck93 = 1.8 time = 940
* CHECK dout0_32 vdout0_32ck93 = 0 time = 940
* CHECK dout0_0 vdout0_0ck95 = 0 time = 960
* CHECK dout0_1 vdout0_1ck95 = 0 time = 960
* CHECK dout0_2 vdout0_2ck95 = 1.8 time = 960
* CHECK dout0_3 vdout0_3ck95 = 1.8 time = 960
* CHECK dout0_4 vdout0_4ck95 = 0 time = 960
* CHECK dout0_5 vdout0_5ck95 = 1.8 time = 960
* CHECK dout0_6 vdout0_6ck95 = 1.8 time = 960
* CHECK dout0_7 vdout0_7ck95 = 0 time = 960
* CHECK dout0_8 vdout0_8ck95 = 0 time = 960
* CHECK dout0_9 vdout0_9ck95 = 1.8 time = 960
* CHECK dout0_10 vdout0_10ck95 = 0 time = 960
* CHECK dout0_11 vdout0_11ck95 = 0 time = 960
* CHECK dout0_12 vdout0_12ck95 = 1.8 time = 960
* CHECK dout0_13 vdout0_13ck95 = 0 time = 960
* CHECK dout0_14 vdout0_14ck95 = 1.8 time = 960
* CHECK dout0_15 vdout0_15ck95 = 1.8 time = 960
* CHECK dout0_16 vdout0_16ck95 = 0 time = 960
* CHECK dout0_17 vdout0_17ck95 = 1.8 time = 960
* CHECK dout0_18 vdout0_18ck95 = 0 time = 960
* CHECK dout0_19 vdout0_19ck95 = 0 time = 960
* CHECK dout0_20 vdout0_20ck95 = 1.8 time = 960
* CHECK dout0_21 vdout0_21ck95 = 0 time = 960
* CHECK dout0_22 vdout0_22ck95 = 1.8 time = 960
* CHECK dout0_23 vdout0_23ck95 = 0 time = 960
* CHECK dout0_24 vdout0_24ck95 = 0 time = 960
* CHECK dout0_25 vdout0_25ck95 = 1.8 time = 960
* CHECK dout0_26 vdout0_26ck95 = 1.8 time = 960
* CHECK dout0_27 vdout0_27ck95 = 1.8 time = 960
* CHECK dout0_28 vdout0_28ck95 = 1.8 time = 960
* CHECK dout0_29 vdout0_29ck95 = 0 time = 960
* CHECK dout0_30 vdout0_30ck95 = 0 time = 960
* CHECK dout0_31 vdout0_31ck95 = 1.8 time = 960
* CHECK dout0_32 vdout0_32ck95 = 0 time = 960
* CHECK dout0_0 vdout0_0ck96 = 0 time = 970
* CHECK dout0_1 vdout0_1ck96 = 0 time = 970
* CHECK dout0_2 vdout0_2ck96 = 1.8 time = 970
* CHECK dout0_3 vdout0_3ck96 = 1.8 time = 970
* CHECK dout0_4 vdout0_4ck96 = 0 time = 970
* CHECK dout0_5 vdout0_5ck96 = 1.8 time = 970
* CHECK dout0_6 vdout0_6ck96 = 1.8 time = 970
* CHECK dout0_7 vdout0_7ck96 = 0 time = 970
* CHECK dout0_8 vdout0_8ck96 = 0 time = 970
* CHECK dout0_9 vdout0_9ck96 = 1.8 time = 970
* CHECK dout0_10 vdout0_10ck96 = 0 time = 970
* CHECK dout0_11 vdout0_11ck96 = 0 time = 970
* CHECK dout0_12 vdout0_12ck96 = 1.8 time = 970
* CHECK dout0_13 vdout0_13ck96 = 0 time = 970
* CHECK dout0_14 vdout0_14ck96 = 1.8 time = 970
* CHECK dout0_15 vdout0_15ck96 = 1.8 time = 970
* CHECK dout0_16 vdout0_16ck96 = 0 time = 970
* CHECK dout0_17 vdout0_17ck96 = 1.8 time = 970
* CHECK dout0_18 vdout0_18ck96 = 0 time = 970
* CHECK dout0_19 vdout0_19ck96 = 0 time = 970
* CHECK dout0_20 vdout0_20ck96 = 1.8 time = 970
* CHECK dout0_21 vdout0_21ck96 = 0 time = 970
* CHECK dout0_22 vdout0_22ck96 = 1.8 time = 970
* CHECK dout0_23 vdout0_23ck96 = 0 time = 970
* CHECK dout0_24 vdout0_24ck96 = 0 time = 970
* CHECK dout0_25 vdout0_25ck96 = 1.8 time = 970
* CHECK dout0_26 vdout0_26ck96 = 1.8 time = 970
* CHECK dout0_27 vdout0_27ck96 = 1.8 time = 970
* CHECK dout0_28 vdout0_28ck96 = 1.8 time = 970
* CHECK dout0_29 vdout0_29ck96 = 0 time = 970
* CHECK dout0_30 vdout0_30ck96 = 0 time = 970
* CHECK dout0_31 vdout0_31ck96 = 1.8 time = 970
* CHECK dout0_32 vdout0_32ck96 = 0 time = 970
* CHECK dout0_0 vdout0_0ck98 = 0 time = 990
* CHECK dout0_1 vdout0_1ck98 = 0 time = 990
* CHECK dout0_2 vdout0_2ck98 = 1.8 time = 990
* CHECK dout0_3 vdout0_3ck98 = 1.8 time = 990
* CHECK dout0_4 vdout0_4ck98 = 0 time = 990
* CHECK dout0_5 vdout0_5ck98 = 1.8 time = 990
* CHECK dout0_6 vdout0_6ck98 = 1.8 time = 990
* CHECK dout0_7 vdout0_7ck98 = 0 time = 990
* CHECK dout0_8 vdout0_8ck98 = 0 time = 990
* CHECK dout0_9 vdout0_9ck98 = 1.8 time = 990
* CHECK dout0_10 vdout0_10ck98 = 0 time = 990
* CHECK dout0_11 vdout0_11ck98 = 0 time = 990
* CHECK dout0_12 vdout0_12ck98 = 1.8 time = 990
* CHECK dout0_13 vdout0_13ck98 = 0 time = 990
* CHECK dout0_14 vdout0_14ck98 = 1.8 time = 990
* CHECK dout0_15 vdout0_15ck98 = 1.8 time = 990
* CHECK dout0_16 vdout0_16ck98 = 0 time = 990
* CHECK dout0_17 vdout0_17ck98 = 1.8 time = 990
* CHECK dout0_18 vdout0_18ck98 = 0 time = 990
* CHECK dout0_19 vdout0_19ck98 = 0 time = 990
* CHECK dout0_20 vdout0_20ck98 = 1.8 time = 990
* CHECK dout0_21 vdout0_21ck98 = 0 time = 990
* CHECK dout0_22 vdout0_22ck98 = 1.8 time = 990
* CHECK dout0_23 vdout0_23ck98 = 0 time = 990
* CHECK dout0_24 vdout0_24ck98 = 0 time = 990
* CHECK dout0_25 vdout0_25ck98 = 1.8 time = 990
* CHECK dout0_26 vdout0_26ck98 = 1.8 time = 990
* CHECK dout0_27 vdout0_27ck98 = 1.8 time = 990
* CHECK dout0_28 vdout0_28ck98 = 1.8 time = 990
* CHECK dout0_29 vdout0_29ck98 = 0 time = 990
* CHECK dout0_30 vdout0_30ck98 = 0 time = 990
* CHECK dout0_31 vdout0_31ck98 = 1.8 time = 990
* CHECK dout0_32 vdout0_32ck98 = 0 time = 990
* CHECK dout0_0 vdout0_0ck99 = 0 time = 1000
* CHECK dout0_1 vdout0_1ck99 = 0 time = 1000
* CHECK dout0_2 vdout0_2ck99 = 1.8 time = 1000
* CHECK dout0_3 vdout0_3ck99 = 1.8 time = 1000
* CHECK dout0_4 vdout0_4ck99 = 0 time = 1000
* CHECK dout0_5 vdout0_5ck99 = 1.8 time = 1000
* CHECK dout0_6 vdout0_6ck99 = 1.8 time = 1000
* CHECK dout0_7 vdout0_7ck99 = 0 time = 1000
* CHECK dout0_8 vdout0_8ck99 = 0 time = 1000
* CHECK dout0_9 vdout0_9ck99 = 1.8 time = 1000
* CHECK dout0_10 vdout0_10ck99 = 0 time = 1000
* CHECK dout0_11 vdout0_11ck99 = 0 time = 1000
* CHECK dout0_12 vdout0_12ck99 = 1.8 time = 1000
* CHECK dout0_13 vdout0_13ck99 = 0 time = 1000
* CHECK dout0_14 vdout0_14ck99 = 1.8 time = 1000
* CHECK dout0_15 vdout0_15ck99 = 1.8 time = 1000
* CHECK dout0_16 vdout0_16ck99 = 0 time = 1000
* CHECK dout0_17 vdout0_17ck99 = 1.8 time = 1000
* CHECK dout0_18 vdout0_18ck99 = 0 time = 1000
* CHECK dout0_19 vdout0_19ck99 = 0 time = 1000
* CHECK dout0_20 vdout0_20ck99 = 1.8 time = 1000
* CHECK dout0_21 vdout0_21ck99 = 0 time = 1000
* CHECK dout0_22 vdout0_22ck99 = 1.8 time = 1000
* CHECK dout0_23 vdout0_23ck99 = 0 time = 1000
* CHECK dout0_24 vdout0_24ck99 = 0 time = 1000
* CHECK dout0_25 vdout0_25ck99 = 1.8 time = 1000
* CHECK dout0_26 vdout0_26ck99 = 1.8 time = 1000
* CHECK dout0_27 vdout0_27ck99 = 1.8 time = 1000
* CHECK dout0_28 vdout0_28ck99 = 1.8 time = 1000
* CHECK dout0_29 vdout0_29ck99 = 0 time = 1000
* CHECK dout0_30 vdout0_30ck99 = 0 time = 1000
* CHECK dout0_31 vdout0_31ck99 = 1.8 time = 1000
* CHECK dout0_32 vdout0_32ck99 = 0 time = 1000
* CHECK dout0_0 vdout0_0ck101 = 1.8 time = 1020
* CHECK dout0_1 vdout0_1ck101 = 1.8 time = 1020
* CHECK dout0_2 vdout0_2ck101 = 1.8 time = 1020
* CHECK dout0_3 vdout0_3ck101 = 1.8 time = 1020
* CHECK dout0_4 vdout0_4ck101 = 1.8 time = 1020
* CHECK dout0_5 vdout0_5ck101 = 0 time = 1020
* CHECK dout0_6 vdout0_6ck101 = 1.8 time = 1020
* CHECK dout0_7 vdout0_7ck101 = 0 time = 1020
* CHECK dout0_8 vdout0_8ck101 = 1.8 time = 1020
* CHECK dout0_9 vdout0_9ck101 = 1.8 time = 1020
* CHECK dout0_10 vdout0_10ck101 = 1.8 time = 1020
* CHECK dout0_11 vdout0_11ck101 = 1.8 time = 1020
* CHECK dout0_12 vdout0_12ck101 = 0 time = 1020
* CHECK dout0_13 vdout0_13ck101 = 0 time = 1020
* CHECK dout0_14 vdout0_14ck101 = 0 time = 1020
* CHECK dout0_15 vdout0_15ck101 = 1.8 time = 1020
* CHECK dout0_16 vdout0_16ck101 = 1.8 time = 1020
* CHECK dout0_17 vdout0_17ck101 = 0 time = 1020
* CHECK dout0_18 vdout0_18ck101 = 1.8 time = 1020
* CHECK dout0_19 vdout0_19ck101 = 1.8 time = 1020
* CHECK dout0_20 vdout0_20ck101 = 1.8 time = 1020
* CHECK dout0_21 vdout0_21ck101 = 1.8 time = 1020
* CHECK dout0_22 vdout0_22ck101 = 1.8 time = 1020
* CHECK dout0_23 vdout0_23ck101 = 0 time = 1020
* CHECK dout0_24 vdout0_24ck101 = 0 time = 1020
* CHECK dout0_25 vdout0_25ck101 = 0 time = 1020
* CHECK dout0_26 vdout0_26ck101 = 1.8 time = 1020
* CHECK dout0_27 vdout0_27ck101 = 0 time = 1020
* CHECK dout0_28 vdout0_28ck101 = 0 time = 1020
* CHECK dout0_29 vdout0_29ck101 = 0 time = 1020
* CHECK dout0_30 vdout0_30ck101 = 1.8 time = 1020
* CHECK dout0_31 vdout0_31ck101 = 1.8 time = 1020
* CHECK dout0_32 vdout0_32ck101 = 0 time = 1020
* CHECK dout0_0 vdout0_0ck104 = 0 time = 1050
* CHECK dout0_1 vdout0_1ck104 = 1.8 time = 1050
* CHECK dout0_2 vdout0_2ck104 = 1.8 time = 1050
* CHECK dout0_3 vdout0_3ck104 = 1.8 time = 1050
* CHECK dout0_4 vdout0_4ck104 = 1.8 time = 1050
* CHECK dout0_5 vdout0_5ck104 = 0 time = 1050
* CHECK dout0_6 vdout0_6ck104 = 0 time = 1050
* CHECK dout0_7 vdout0_7ck104 = 0 time = 1050
* CHECK dout0_8 vdout0_8ck104 = 1.8 time = 1050
* CHECK dout0_9 vdout0_9ck104 = 1.8 time = 1050
* CHECK dout0_10 vdout0_10ck104 = 1.8 time = 1050
* CHECK dout0_11 vdout0_11ck104 = 0 time = 1050
* CHECK dout0_12 vdout0_12ck104 = 1.8 time = 1050
* CHECK dout0_13 vdout0_13ck104 = 1.8 time = 1050
* CHECK dout0_14 vdout0_14ck104 = 1.8 time = 1050
* CHECK dout0_15 vdout0_15ck104 = 0 time = 1050
* CHECK dout0_16 vdout0_16ck104 = 1.8 time = 1050
* CHECK dout0_17 vdout0_17ck104 = 0 time = 1050
* CHECK dout0_18 vdout0_18ck104 = 1.8 time = 1050
* CHECK dout0_19 vdout0_19ck104 = 0 time = 1050
* CHECK dout0_20 vdout0_20ck104 = 0 time = 1050
* CHECK dout0_21 vdout0_21ck104 = 0 time = 1050
* CHECK dout0_22 vdout0_22ck104 = 1.8 time = 1050
* CHECK dout0_23 vdout0_23ck104 = 1.8 time = 1050
* CHECK dout0_24 vdout0_24ck104 = 1.8 time = 1050
* CHECK dout0_25 vdout0_25ck104 = 0 time = 1050
* CHECK dout0_26 vdout0_26ck104 = 1.8 time = 1050
* CHECK dout0_27 vdout0_27ck104 = 1.8 time = 1050
* CHECK dout0_28 vdout0_28ck104 = 0 time = 1050
* CHECK dout0_29 vdout0_29ck104 = 0 time = 1050
* CHECK dout0_30 vdout0_30ck104 = 1.8 time = 1050
* CHECK dout0_31 vdout0_31ck104 = 1.8 time = 1050
* CHECK dout0_32 vdout0_32ck104 = 0 time = 1050
* CHECK dout0_0 vdout0_0ck105 = 0 time = 1060
* CHECK dout0_1 vdout0_1ck105 = 0 time = 1060
* CHECK dout0_2 vdout0_2ck105 = 1.8 time = 1060
* CHECK dout0_3 vdout0_3ck105 = 1.8 time = 1060
* CHECK dout0_4 vdout0_4ck105 = 0 time = 1060
* CHECK dout0_5 vdout0_5ck105 = 1.8 time = 1060
* CHECK dout0_6 vdout0_6ck105 = 1.8 time = 1060
* CHECK dout0_7 vdout0_7ck105 = 0 time = 1060
* CHECK dout0_8 vdout0_8ck105 = 0 time = 1060
* CHECK dout0_9 vdout0_9ck105 = 1.8 time = 1060
* CHECK dout0_10 vdout0_10ck105 = 0 time = 1060
* CHECK dout0_11 vdout0_11ck105 = 0 time = 1060
* CHECK dout0_12 vdout0_12ck105 = 1.8 time = 1060
* CHECK dout0_13 vdout0_13ck105 = 0 time = 1060
* CHECK dout0_14 vdout0_14ck105 = 1.8 time = 1060
* CHECK dout0_15 vdout0_15ck105 = 1.8 time = 1060
* CHECK dout0_16 vdout0_16ck105 = 0 time = 1060
* CHECK dout0_17 vdout0_17ck105 = 1.8 time = 1060
* CHECK dout0_18 vdout0_18ck105 = 0 time = 1060
* CHECK dout0_19 vdout0_19ck105 = 0 time = 1060
* CHECK dout0_20 vdout0_20ck105 = 1.8 time = 1060
* CHECK dout0_21 vdout0_21ck105 = 0 time = 1060
* CHECK dout0_22 vdout0_22ck105 = 1.8 time = 1060
* CHECK dout0_23 vdout0_23ck105 = 0 time = 1060
* CHECK dout0_24 vdout0_24ck105 = 0 time = 1060
* CHECK dout0_25 vdout0_25ck105 = 1.8 time = 1060
* CHECK dout0_26 vdout0_26ck105 = 1.8 time = 1060
* CHECK dout0_27 vdout0_27ck105 = 1.8 time = 1060
* CHECK dout0_28 vdout0_28ck105 = 1.8 time = 1060
* CHECK dout0_29 vdout0_29ck105 = 0 time = 1060
* CHECK dout0_30 vdout0_30ck105 = 0 time = 1060
* CHECK dout0_31 vdout0_31ck105 = 1.8 time = 1060
* CHECK dout0_32 vdout0_32ck105 = 0 time = 1060
* CHECK dout0_0 vdout0_0ck106 = 0 time = 1070
* CHECK dout0_1 vdout0_1ck106 = 1.8 time = 1070
* CHECK dout0_2 vdout0_2ck106 = 1.8 time = 1070
* CHECK dout0_3 vdout0_3ck106 = 1.8 time = 1070
* CHECK dout0_4 vdout0_4ck106 = 1.8 time = 1070
* CHECK dout0_5 vdout0_5ck106 = 0 time = 1070
* CHECK dout0_6 vdout0_6ck106 = 0 time = 1070
* CHECK dout0_7 vdout0_7ck106 = 0 time = 1070
* CHECK dout0_8 vdout0_8ck106 = 1.8 time = 1070
* CHECK dout0_9 vdout0_9ck106 = 1.8 time = 1070
* CHECK dout0_10 vdout0_10ck106 = 1.8 time = 1070
* CHECK dout0_11 vdout0_11ck106 = 0 time = 1070
* CHECK dout0_12 vdout0_12ck106 = 1.8 time = 1070
* CHECK dout0_13 vdout0_13ck106 = 1.8 time = 1070
* CHECK dout0_14 vdout0_14ck106 = 1.8 time = 1070
* CHECK dout0_15 vdout0_15ck106 = 0 time = 1070
* CHECK dout0_16 vdout0_16ck106 = 1.8 time = 1070
* CHECK dout0_17 vdout0_17ck106 = 0 time = 1070
* CHECK dout0_18 vdout0_18ck106 = 1.8 time = 1070
* CHECK dout0_19 vdout0_19ck106 = 0 time = 1070
* CHECK dout0_20 vdout0_20ck106 = 0 time = 1070
* CHECK dout0_21 vdout0_21ck106 = 0 time = 1070
* CHECK dout0_22 vdout0_22ck106 = 1.8 time = 1070
* CHECK dout0_23 vdout0_23ck106 = 1.8 time = 1070
* CHECK dout0_24 vdout0_24ck106 = 1.8 time = 1070
* CHECK dout0_25 vdout0_25ck106 = 0 time = 1070
* CHECK dout0_26 vdout0_26ck106 = 1.8 time = 1070
* CHECK dout0_27 vdout0_27ck106 = 1.8 time = 1070
* CHECK dout0_28 vdout0_28ck106 = 0 time = 1070
* CHECK dout0_29 vdout0_29ck106 = 0 time = 1070
* CHECK dout0_30 vdout0_30ck106 = 1.8 time = 1070
* CHECK dout0_31 vdout0_31ck106 = 1.8 time = 1070
* CHECK dout0_32 vdout0_32ck106 = 0 time = 1070
* CHECK dout0_0 vdout0_0ck110 = 1.8 time = 1110
* CHECK dout0_1 vdout0_1ck110 = 0 time = 1110
* CHECK dout0_2 vdout0_2ck110 = 0 time = 1110
* CHECK dout0_3 vdout0_3ck110 = 1.8 time = 1110
* CHECK dout0_4 vdout0_4ck110 = 1.8 time = 1110
* CHECK dout0_5 vdout0_5ck110 = 1.8 time = 1110
* CHECK dout0_6 vdout0_6ck110 = 1.8 time = 1110
* CHECK dout0_7 vdout0_7ck110 = 1.8 time = 1110
* CHECK dout0_8 vdout0_8ck110 = 0 time = 1110
* CHECK dout0_9 vdout0_9ck110 = 1.8 time = 1110
* CHECK dout0_10 vdout0_10ck110 = 1.8 time = 1110
* CHECK dout0_11 vdout0_11ck110 = 1.8 time = 1110
* CHECK dout0_12 vdout0_12ck110 = 1.8 time = 1110
* CHECK dout0_13 vdout0_13ck110 = 1.8 time = 1110
* CHECK dout0_14 vdout0_14ck110 = 1.8 time = 1110
* CHECK dout0_15 vdout0_15ck110 = 1.8 time = 1110
* CHECK dout0_16 vdout0_16ck110 = 0 time = 1110
* CHECK dout0_17 vdout0_17ck110 = 0 time = 1110
* CHECK dout0_18 vdout0_18ck110 = 0 time = 1110
* CHECK dout0_19 vdout0_19ck110 = 0 time = 1110
* CHECK dout0_20 vdout0_20ck110 = 1.8 time = 1110
* CHECK dout0_21 vdout0_21ck110 = 0 time = 1110
* CHECK dout0_22 vdout0_22ck110 = 1.8 time = 1110
* CHECK dout0_23 vdout0_23ck110 = 0 time = 1110
* CHECK dout0_24 vdout0_24ck110 = 1.8 time = 1110
* CHECK dout0_25 vdout0_25ck110 = 1.8 time = 1110
* CHECK dout0_26 vdout0_26ck110 = 1.8 time = 1110
* CHECK dout0_27 vdout0_27ck110 = 1.8 time = 1110
* CHECK dout0_28 vdout0_28ck110 = 1.8 time = 1110
* CHECK dout0_29 vdout0_29ck110 = 0 time = 1110
* CHECK dout0_30 vdout0_30ck110 = 0 time = 1110
* CHECK dout0_31 vdout0_31ck110 = 0 time = 1110
* CHECK dout0_32 vdout0_32ck110 = 0 time = 1110
* CHECK dout0_0 vdout0_0ck115 = 0 time = 1160
* CHECK dout0_1 vdout0_1ck115 = 1.8 time = 1160
* CHECK dout0_2 vdout0_2ck115 = 0 time = 1160
* CHECK dout0_3 vdout0_3ck115 = 1.8 time = 1160
* CHECK dout0_4 vdout0_4ck115 = 1.8 time = 1160
* CHECK dout0_5 vdout0_5ck115 = 0 time = 1160
* CHECK dout0_6 vdout0_6ck115 = 0 time = 1160
* CHECK dout0_7 vdout0_7ck115 = 0 time = 1160
* CHECK dout0_8 vdout0_8ck115 = 0 time = 1160
* CHECK dout0_9 vdout0_9ck115 = 1.8 time = 1160
* CHECK dout0_10 vdout0_10ck115 = 0 time = 1160
* CHECK dout0_11 vdout0_11ck115 = 1.8 time = 1160
* CHECK dout0_12 vdout0_12ck115 = 0 time = 1160
* CHECK dout0_13 vdout0_13ck115 = 0 time = 1160
* CHECK dout0_14 vdout0_14ck115 = 0 time = 1160
* CHECK dout0_15 vdout0_15ck115 = 1.8 time = 1160
* CHECK dout0_16 vdout0_16ck115 = 1.8 time = 1160
* CHECK dout0_17 vdout0_17ck115 = 0 time = 1160
* CHECK dout0_18 vdout0_18ck115 = 0 time = 1160
* CHECK dout0_19 vdout0_19ck115 = 1.8 time = 1160
* CHECK dout0_20 vdout0_20ck115 = 1.8 time = 1160
* CHECK dout0_21 vdout0_21ck115 = 1.8 time = 1160
* CHECK dout0_22 vdout0_22ck115 = 0 time = 1160
* CHECK dout0_23 vdout0_23ck115 = 0 time = 1160
* CHECK dout0_24 vdout0_24ck115 = 1.8 time = 1160
* CHECK dout0_25 vdout0_25ck115 = 1.8 time = 1160
* CHECK dout0_26 vdout0_26ck115 = 1.8 time = 1160
* CHECK dout0_27 vdout0_27ck115 = 1.8 time = 1160
* CHECK dout0_28 vdout0_28ck115 = 1.8 time = 1160
* CHECK dout0_29 vdout0_29ck115 = 0 time = 1160
* CHECK dout0_30 vdout0_30ck115 = 1.8 time = 1160
* CHECK dout0_31 vdout0_31ck115 = 0 time = 1160
* CHECK dout0_32 vdout0_32ck115 = 0 time = 1160
* CHECK dout0_0 vdout0_0ck116 = 0 time = 1170
* CHECK dout0_1 vdout0_1ck116 = 1.8 time = 1170
* CHECK dout0_2 vdout0_2ck116 = 0 time = 1170
* CHECK dout0_3 vdout0_3ck116 = 1.8 time = 1170
* CHECK dout0_4 vdout0_4ck116 = 1.8 time = 1170
* CHECK dout0_5 vdout0_5ck116 = 0 time = 1170
* CHECK dout0_6 vdout0_6ck116 = 0 time = 1170
* CHECK dout0_7 vdout0_7ck116 = 0 time = 1170
* CHECK dout0_8 vdout0_8ck116 = 0 time = 1170
* CHECK dout0_9 vdout0_9ck116 = 1.8 time = 1170
* CHECK dout0_10 vdout0_10ck116 = 0 time = 1170
* CHECK dout0_11 vdout0_11ck116 = 1.8 time = 1170
* CHECK dout0_12 vdout0_12ck116 = 0 time = 1170
* CHECK dout0_13 vdout0_13ck116 = 0 time = 1170
* CHECK dout0_14 vdout0_14ck116 = 0 time = 1170
* CHECK dout0_15 vdout0_15ck116 = 1.8 time = 1170
* CHECK dout0_16 vdout0_16ck116 = 1.8 time = 1170
* CHECK dout0_17 vdout0_17ck116 = 0 time = 1170
* CHECK dout0_18 vdout0_18ck116 = 0 time = 1170
* CHECK dout0_19 vdout0_19ck116 = 1.8 time = 1170
* CHECK dout0_20 vdout0_20ck116 = 1.8 time = 1170
* CHECK dout0_21 vdout0_21ck116 = 1.8 time = 1170
* CHECK dout0_22 vdout0_22ck116 = 0 time = 1170
* CHECK dout0_23 vdout0_23ck116 = 0 time = 1170
* CHECK dout0_24 vdout0_24ck116 = 1.8 time = 1170
* CHECK dout0_25 vdout0_25ck116 = 1.8 time = 1170
* CHECK dout0_26 vdout0_26ck116 = 1.8 time = 1170
* CHECK dout0_27 vdout0_27ck116 = 1.8 time = 1170
* CHECK dout0_28 vdout0_28ck116 = 1.8 time = 1170
* CHECK dout0_29 vdout0_29ck116 = 0 time = 1170
* CHECK dout0_30 vdout0_30ck116 = 1.8 time = 1170
* CHECK dout0_31 vdout0_31ck116 = 0 time = 1170
* CHECK dout0_32 vdout0_32ck116 = 0 time = 1170
* CHECK dout0_0 vdout0_0ck118 = 0 time = 1190
* CHECK dout0_1 vdout0_1ck118 = 1.8 time = 1190
* CHECK dout0_2 vdout0_2ck118 = 0 time = 1190
* CHECK dout0_3 vdout0_3ck118 = 1.8 time = 1190
* CHECK dout0_4 vdout0_4ck118 = 1.8 time = 1190
* CHECK dout0_5 vdout0_5ck118 = 0 time = 1190
* CHECK dout0_6 vdout0_6ck118 = 0 time = 1190
* CHECK dout0_7 vdout0_7ck118 = 0 time = 1190
* CHECK dout0_8 vdout0_8ck118 = 0 time = 1190
* CHECK dout0_9 vdout0_9ck118 = 1.8 time = 1190
* CHECK dout0_10 vdout0_10ck118 = 0 time = 1190
* CHECK dout0_11 vdout0_11ck118 = 1.8 time = 1190
* CHECK dout0_12 vdout0_12ck118 = 0 time = 1190
* CHECK dout0_13 vdout0_13ck118 = 0 time = 1190
* CHECK dout0_14 vdout0_14ck118 = 0 time = 1190
* CHECK dout0_15 vdout0_15ck118 = 1.8 time = 1190
* CHECK dout0_16 vdout0_16ck118 = 1.8 time = 1190
* CHECK dout0_17 vdout0_17ck118 = 0 time = 1190
* CHECK dout0_18 vdout0_18ck118 = 0 time = 1190
* CHECK dout0_19 vdout0_19ck118 = 1.8 time = 1190
* CHECK dout0_20 vdout0_20ck118 = 1.8 time = 1190
* CHECK dout0_21 vdout0_21ck118 = 1.8 time = 1190
* CHECK dout0_22 vdout0_22ck118 = 0 time = 1190
* CHECK dout0_23 vdout0_23ck118 = 0 time = 1190
* CHECK dout0_24 vdout0_24ck118 = 1.8 time = 1190
* CHECK dout0_25 vdout0_25ck118 = 1.8 time = 1190
* CHECK dout0_26 vdout0_26ck118 = 1.8 time = 1190
* CHECK dout0_27 vdout0_27ck118 = 1.8 time = 1190
* CHECK dout0_28 vdout0_28ck118 = 1.8 time = 1190
* CHECK dout0_29 vdout0_29ck118 = 0 time = 1190
* CHECK dout0_30 vdout0_30ck118 = 1.8 time = 1190
* CHECK dout0_31 vdout0_31ck118 = 0 time = 1190
* CHECK dout0_32 vdout0_32ck118 = 0 time = 1190
* CHECK dout0_0 vdout0_0ck119 = 0 time = 1200
* CHECK dout0_1 vdout0_1ck119 = 0 time = 1200
* CHECK dout0_2 vdout0_2ck119 = 1.8 time = 1200
* CHECK dout0_3 vdout0_3ck119 = 0 time = 1200
* CHECK dout0_4 vdout0_4ck119 = 0 time = 1200
* CHECK dout0_5 vdout0_5ck119 = 1.8 time = 1200
* CHECK dout0_6 vdout0_6ck119 = 0 time = 1200
* CHECK dout0_7 vdout0_7ck119 = 0 time = 1200
* CHECK dout0_8 vdout0_8ck119 = 0 time = 1200
* CHECK dout0_9 vdout0_9ck119 = 1.8 time = 1200
* CHECK dout0_10 vdout0_10ck119 = 1.8 time = 1200
* CHECK dout0_11 vdout0_11ck119 = 1.8 time = 1200
* CHECK dout0_12 vdout0_12ck119 = 1.8 time = 1200
* CHECK dout0_13 vdout0_13ck119 = 0 time = 1200
* CHECK dout0_14 vdout0_14ck119 = 0 time = 1200
* CHECK dout0_15 vdout0_15ck119 = 1.8 time = 1200
* CHECK dout0_16 vdout0_16ck119 = 0 time = 1200
* CHECK dout0_17 vdout0_17ck119 = 1.8 time = 1200
* CHECK dout0_18 vdout0_18ck119 = 0 time = 1200
* CHECK dout0_19 vdout0_19ck119 = 1.8 time = 1200
* CHECK dout0_20 vdout0_20ck119 = 1.8 time = 1200
* CHECK dout0_21 vdout0_21ck119 = 0 time = 1200
* CHECK dout0_22 vdout0_22ck119 = 0 time = 1200
* CHECK dout0_23 vdout0_23ck119 = 1.8 time = 1200
* CHECK dout0_24 vdout0_24ck119 = 1.8 time = 1200
* CHECK dout0_25 vdout0_25ck119 = 0 time = 1200
* CHECK dout0_26 vdout0_26ck119 = 0 time = 1200
* CHECK dout0_27 vdout0_27ck119 = 1.8 time = 1200
* CHECK dout0_28 vdout0_28ck119 = 0 time = 1200
* CHECK dout0_29 vdout0_29ck119 = 0 time = 1200
* CHECK dout0_30 vdout0_30ck119 = 0 time = 1200
* CHECK dout0_31 vdout0_31ck119 = 1.8 time = 1200
* CHECK dout0_32 vdout0_32ck119 = 0 time = 1200
* CHECK dout0_0 vdout0_0ck120 = 0 time = 1210
* CHECK dout0_1 vdout0_1ck120 = 1.8 time = 1210
* CHECK dout0_2 vdout0_2ck120 = 0 time = 1210
* CHECK dout0_3 vdout0_3ck120 = 1.8 time = 1210
* CHECK dout0_4 vdout0_4ck120 = 1.8 time = 1210
* CHECK dout0_5 vdout0_5ck120 = 0 time = 1210
* CHECK dout0_6 vdout0_6ck120 = 0 time = 1210
* CHECK dout0_7 vdout0_7ck120 = 0 time = 1210
* CHECK dout0_8 vdout0_8ck120 = 0 time = 1210
* CHECK dout0_9 vdout0_9ck120 = 1.8 time = 1210
* CHECK dout0_10 vdout0_10ck120 = 0 time = 1210
* CHECK dout0_11 vdout0_11ck120 = 1.8 time = 1210
* CHECK dout0_12 vdout0_12ck120 = 0 time = 1210
* CHECK dout0_13 vdout0_13ck120 = 0 time = 1210
* CHECK dout0_14 vdout0_14ck120 = 0 time = 1210
* CHECK dout0_15 vdout0_15ck120 = 1.8 time = 1210
* CHECK dout0_16 vdout0_16ck120 = 1.8 time = 1210
* CHECK dout0_17 vdout0_17ck120 = 0 time = 1210
* CHECK dout0_18 vdout0_18ck120 = 0 time = 1210
* CHECK dout0_19 vdout0_19ck120 = 1.8 time = 1210
* CHECK dout0_20 vdout0_20ck120 = 1.8 time = 1210
* CHECK dout0_21 vdout0_21ck120 = 1.8 time = 1210
* CHECK dout0_22 vdout0_22ck120 = 0 time = 1210
* CHECK dout0_23 vdout0_23ck120 = 0 time = 1210
* CHECK dout0_24 vdout0_24ck120 = 1.8 time = 1210
* CHECK dout0_25 vdout0_25ck120 = 1.8 time = 1210
* CHECK dout0_26 vdout0_26ck120 = 1.8 time = 1210
* CHECK dout0_27 vdout0_27ck120 = 1.8 time = 1210
* CHECK dout0_28 vdout0_28ck120 = 1.8 time = 1210
* CHECK dout0_29 vdout0_29ck120 = 0 time = 1210
* CHECK dout0_30 vdout0_30ck120 = 1.8 time = 1210
* CHECK dout0_31 vdout0_31ck120 = 0 time = 1210
* CHECK dout0_32 vdout0_32ck120 = 0 time = 1210
* CHECK dout0_0 vdout0_0ck122 = 0 time = 1230
* CHECK dout0_1 vdout0_1ck122 = 0 time = 1230
* CHECK dout0_2 vdout0_2ck122 = 1.8 time = 1230
* CHECK dout0_3 vdout0_3ck122 = 0 time = 1230
* CHECK dout0_4 vdout0_4ck122 = 0 time = 1230
* CHECK dout0_5 vdout0_5ck122 = 1.8 time = 1230
* CHECK dout0_6 vdout0_6ck122 = 0 time = 1230
* CHECK dout0_7 vdout0_7ck122 = 0 time = 1230
* CHECK dout0_8 vdout0_8ck122 = 0 time = 1230
* CHECK dout0_9 vdout0_9ck122 = 1.8 time = 1230
* CHECK dout0_10 vdout0_10ck122 = 1.8 time = 1230
* CHECK dout0_11 vdout0_11ck122 = 1.8 time = 1230
* CHECK dout0_12 vdout0_12ck122 = 1.8 time = 1230
* CHECK dout0_13 vdout0_13ck122 = 0 time = 1230
* CHECK dout0_14 vdout0_14ck122 = 0 time = 1230
* CHECK dout0_15 vdout0_15ck122 = 1.8 time = 1230
* CHECK dout0_16 vdout0_16ck122 = 0 time = 1230
* CHECK dout0_17 vdout0_17ck122 = 1.8 time = 1230
* CHECK dout0_18 vdout0_18ck122 = 0 time = 1230
* CHECK dout0_19 vdout0_19ck122 = 1.8 time = 1230
* CHECK dout0_20 vdout0_20ck122 = 1.8 time = 1230
* CHECK dout0_21 vdout0_21ck122 = 0 time = 1230
* CHECK dout0_22 vdout0_22ck122 = 0 time = 1230
* CHECK dout0_23 vdout0_23ck122 = 1.8 time = 1230
* CHECK dout0_24 vdout0_24ck122 = 1.8 time = 1230
* CHECK dout0_25 vdout0_25ck122 = 0 time = 1230
* CHECK dout0_26 vdout0_26ck122 = 0 time = 1230
* CHECK dout0_27 vdout0_27ck122 = 1.8 time = 1230
* CHECK dout0_28 vdout0_28ck122 = 0 time = 1230
* CHECK dout0_29 vdout0_29ck122 = 0 time = 1230
* CHECK dout0_30 vdout0_30ck122 = 0 time = 1230
* CHECK dout0_31 vdout0_31ck122 = 1.8 time = 1230
* CHECK dout0_32 vdout0_32ck122 = 0 time = 1230
* CHECK dout0_0 vdout0_0ck125 = 0 time = 1260
* CHECK dout0_1 vdout0_1ck125 = 0 time = 1260
* CHECK dout0_2 vdout0_2ck125 = 1.8 time = 1260
* CHECK dout0_3 vdout0_3ck125 = 0 time = 1260
* CHECK dout0_4 vdout0_4ck125 = 0 time = 1260
* CHECK dout0_5 vdout0_5ck125 = 1.8 time = 1260
* CHECK dout0_6 vdout0_6ck125 = 0 time = 1260
* CHECK dout0_7 vdout0_7ck125 = 0 time = 1260
* CHECK dout0_8 vdout0_8ck125 = 0 time = 1260
* CHECK dout0_9 vdout0_9ck125 = 1.8 time = 1260
* CHECK dout0_10 vdout0_10ck125 = 1.8 time = 1260
* CHECK dout0_11 vdout0_11ck125 = 1.8 time = 1260
* CHECK dout0_12 vdout0_12ck125 = 1.8 time = 1260
* CHECK dout0_13 vdout0_13ck125 = 0 time = 1260
* CHECK dout0_14 vdout0_14ck125 = 0 time = 1260
* CHECK dout0_15 vdout0_15ck125 = 1.8 time = 1260
* CHECK dout0_16 vdout0_16ck125 = 0 time = 1260
* CHECK dout0_17 vdout0_17ck125 = 1.8 time = 1260
* CHECK dout0_18 vdout0_18ck125 = 0 time = 1260
* CHECK dout0_19 vdout0_19ck125 = 1.8 time = 1260
* CHECK dout0_20 vdout0_20ck125 = 1.8 time = 1260
* CHECK dout0_21 vdout0_21ck125 = 0 time = 1260
* CHECK dout0_22 vdout0_22ck125 = 0 time = 1260
* CHECK dout0_23 vdout0_23ck125 = 1.8 time = 1260
* CHECK dout0_24 vdout0_24ck125 = 1.8 time = 1260
* CHECK dout0_25 vdout0_25ck125 = 0 time = 1260
* CHECK dout0_26 vdout0_26ck125 = 0 time = 1260
* CHECK dout0_27 vdout0_27ck125 = 1.8 time = 1260
* CHECK dout0_28 vdout0_28ck125 = 0 time = 1260
* CHECK dout0_29 vdout0_29ck125 = 0 time = 1260
* CHECK dout0_30 vdout0_30ck125 = 0 time = 1260
* CHECK dout0_31 vdout0_31ck125 = 1.8 time = 1260
* CHECK dout0_32 vdout0_32ck125 = 0 time = 1260
* CHECK dout0_0 vdout0_0ck127 = 0 time = 1280
* CHECK dout0_1 vdout0_1ck127 = 1.8 time = 1280
* CHECK dout0_2 vdout0_2ck127 = 0 time = 1280
* CHECK dout0_3 vdout0_3ck127 = 0 time = 1280
* CHECK dout0_4 vdout0_4ck127 = 1.8 time = 1280
* CHECK dout0_5 vdout0_5ck127 = 1.8 time = 1280
* CHECK dout0_6 vdout0_6ck127 = 0 time = 1280
* CHECK dout0_7 vdout0_7ck127 = 1.8 time = 1280
* CHECK dout0_8 vdout0_8ck127 = 1.8 time = 1280
* CHECK dout0_9 vdout0_9ck127 = 1.8 time = 1280
* CHECK dout0_10 vdout0_10ck127 = 0 time = 1280
* CHECK dout0_11 vdout0_11ck127 = 0 time = 1280
* CHECK dout0_12 vdout0_12ck127 = 1.8 time = 1280
* CHECK dout0_13 vdout0_13ck127 = 0 time = 1280
* CHECK dout0_14 vdout0_14ck127 = 0 time = 1280
* CHECK dout0_15 vdout0_15ck127 = 1.8 time = 1280
* CHECK dout0_16 vdout0_16ck127 = 0 time = 1280
* CHECK dout0_17 vdout0_17ck127 = 1.8 time = 1280
* CHECK dout0_18 vdout0_18ck127 = 1.8 time = 1280
* CHECK dout0_19 vdout0_19ck127 = 1.8 time = 1280
* CHECK dout0_20 vdout0_20ck127 = 0 time = 1280
* CHECK dout0_21 vdout0_21ck127 = 0 time = 1280
* CHECK dout0_22 vdout0_22ck127 = 0 time = 1280
* CHECK dout0_23 vdout0_23ck127 = 1.8 time = 1280
* CHECK dout0_24 vdout0_24ck127 = 1.8 time = 1280
* CHECK dout0_25 vdout0_25ck127 = 0 time = 1280
* CHECK dout0_26 vdout0_26ck127 = 0 time = 1280
* CHECK dout0_27 vdout0_27ck127 = 1.8 time = 1280
* CHECK dout0_28 vdout0_28ck127 = 0 time = 1280
* CHECK dout0_29 vdout0_29ck127 = 0 time = 1280
* CHECK dout0_30 vdout0_30ck127 = 1.8 time = 1280
* CHECK dout0_31 vdout0_31ck127 = 0 time = 1280
* CHECK dout0_32 vdout0_32ck127 = 0 time = 1280
* CHECK dout0_0 vdout0_0ck132 = 0 time = 1330
* CHECK dout0_1 vdout0_1ck132 = 0 time = 1330
* CHECK dout0_2 vdout0_2ck132 = 1.8 time = 1330
* CHECK dout0_3 vdout0_3ck132 = 1.8 time = 1330
* CHECK dout0_4 vdout0_4ck132 = 1.8 time = 1330
* CHECK dout0_5 vdout0_5ck132 = 0 time = 1330
* CHECK dout0_6 vdout0_6ck132 = 0 time = 1330
* CHECK dout0_7 vdout0_7ck132 = 0 time = 1330
* CHECK dout0_8 vdout0_8ck132 = 1.8 time = 1330
* CHECK dout0_9 vdout0_9ck132 = 0 time = 1330
* CHECK dout0_10 vdout0_10ck132 = 1.8 time = 1330
* CHECK dout0_11 vdout0_11ck132 = 0 time = 1330
* CHECK dout0_12 vdout0_12ck132 = 1.8 time = 1330
* CHECK dout0_13 vdout0_13ck132 = 1.8 time = 1330
* CHECK dout0_14 vdout0_14ck132 = 1.8 time = 1330
* CHECK dout0_15 vdout0_15ck132 = 1.8 time = 1330
* CHECK dout0_16 vdout0_16ck132 = 1.8 time = 1330
* CHECK dout0_17 vdout0_17ck132 = 1.8 time = 1330
* CHECK dout0_18 vdout0_18ck132 = 0 time = 1330
* CHECK dout0_19 vdout0_19ck132 = 0 time = 1330
* CHECK dout0_20 vdout0_20ck132 = 0 time = 1330
* CHECK dout0_21 vdout0_21ck132 = 1.8 time = 1330
* CHECK dout0_22 vdout0_22ck132 = 0 time = 1330
* CHECK dout0_23 vdout0_23ck132 = 0 time = 1330
* CHECK dout0_24 vdout0_24ck132 = 1.8 time = 1330
* CHECK dout0_25 vdout0_25ck132 = 0 time = 1330
* CHECK dout0_26 vdout0_26ck132 = 1.8 time = 1330
* CHECK dout0_27 vdout0_27ck132 = 0 time = 1330
* CHECK dout0_28 vdout0_28ck132 = 0 time = 1330
* CHECK dout0_29 vdout0_29ck132 = 0 time = 1330
* CHECK dout0_30 vdout0_30ck132 = 1.8 time = 1330
* CHECK dout0_31 vdout0_31ck132 = 1.8 time = 1330
* CHECK dout0_32 vdout0_32ck132 = 0 time = 1330
* CHECK dout0_0 vdout0_0ck133 = 0 time = 1340
* CHECK dout0_1 vdout0_1ck133 = 1.8 time = 1340
* CHECK dout0_2 vdout0_2ck133 = 0 time = 1340
* CHECK dout0_3 vdout0_3ck133 = 1.8 time = 1340
* CHECK dout0_4 vdout0_4ck133 = 0 time = 1340
* CHECK dout0_5 vdout0_5ck133 = 1.8 time = 1340
* CHECK dout0_6 vdout0_6ck133 = 1.8 time = 1340
* CHECK dout0_7 vdout0_7ck133 = 1.8 time = 1340
* CHECK dout0_8 vdout0_8ck133 = 0 time = 1340
* CHECK dout0_9 vdout0_9ck133 = 0 time = 1340
* CHECK dout0_10 vdout0_10ck133 = 1.8 time = 1340
* CHECK dout0_11 vdout0_11ck133 = 1.8 time = 1340
* CHECK dout0_12 vdout0_12ck133 = 0 time = 1340
* CHECK dout0_13 vdout0_13ck133 = 0 time = 1340
* CHECK dout0_14 vdout0_14ck133 = 0 time = 1340
* CHECK dout0_15 vdout0_15ck133 = 1.8 time = 1340
* CHECK dout0_16 vdout0_16ck133 = 0 time = 1340
* CHECK dout0_17 vdout0_17ck133 = 0 time = 1340
* CHECK dout0_18 vdout0_18ck133 = 1.8 time = 1340
* CHECK dout0_19 vdout0_19ck133 = 0 time = 1340
* CHECK dout0_20 vdout0_20ck133 = 0 time = 1340
* CHECK dout0_21 vdout0_21ck133 = 1.8 time = 1340
* CHECK dout0_22 vdout0_22ck133 = 0 time = 1340
* CHECK dout0_23 vdout0_23ck133 = 1.8 time = 1340
* CHECK dout0_24 vdout0_24ck133 = 1.8 time = 1340
* CHECK dout0_25 vdout0_25ck133 = 1.8 time = 1340
* CHECK dout0_26 vdout0_26ck133 = 1.8 time = 1340
* CHECK dout0_27 vdout0_27ck133 = 0 time = 1340
* CHECK dout0_28 vdout0_28ck133 = 1.8 time = 1340
* CHECK dout0_29 vdout0_29ck133 = 1.8 time = 1340
* CHECK dout0_30 vdout0_30ck133 = 0 time = 1340
* CHECK dout0_31 vdout0_31ck133 = 0 time = 1340
* CHECK dout0_32 vdout0_32ck133 = 0 time = 1340
* CHECK dout0_0 vdout0_0ck135 = 0 time = 1360
* CHECK dout0_1 vdout0_1ck135 = 0 time = 1360
* CHECK dout0_2 vdout0_2ck135 = 1.8 time = 1360
* CHECK dout0_3 vdout0_3ck135 = 1.8 time = 1360
* CHECK dout0_4 vdout0_4ck135 = 1.8 time = 1360
* CHECK dout0_5 vdout0_5ck135 = 0 time = 1360
* CHECK dout0_6 vdout0_6ck135 = 0 time = 1360
* CHECK dout0_7 vdout0_7ck135 = 0 time = 1360
* CHECK dout0_8 vdout0_8ck135 = 1.8 time = 1360
* CHECK dout0_9 vdout0_9ck135 = 0 time = 1360
* CHECK dout0_10 vdout0_10ck135 = 1.8 time = 1360
* CHECK dout0_11 vdout0_11ck135 = 0 time = 1360
* CHECK dout0_12 vdout0_12ck135 = 1.8 time = 1360
* CHECK dout0_13 vdout0_13ck135 = 1.8 time = 1360
* CHECK dout0_14 vdout0_14ck135 = 1.8 time = 1360
* CHECK dout0_15 vdout0_15ck135 = 1.8 time = 1360
* CHECK dout0_16 vdout0_16ck135 = 1.8 time = 1360
* CHECK dout0_17 vdout0_17ck135 = 1.8 time = 1360
* CHECK dout0_18 vdout0_18ck135 = 0 time = 1360
* CHECK dout0_19 vdout0_19ck135 = 0 time = 1360
* CHECK dout0_20 vdout0_20ck135 = 0 time = 1360
* CHECK dout0_21 vdout0_21ck135 = 1.8 time = 1360
* CHECK dout0_22 vdout0_22ck135 = 0 time = 1360
* CHECK dout0_23 vdout0_23ck135 = 0 time = 1360
* CHECK dout0_24 vdout0_24ck135 = 1.8 time = 1360
* CHECK dout0_25 vdout0_25ck135 = 0 time = 1360
* CHECK dout0_26 vdout0_26ck135 = 1.8 time = 1360
* CHECK dout0_27 vdout0_27ck135 = 0 time = 1360
* CHECK dout0_28 vdout0_28ck135 = 0 time = 1360
* CHECK dout0_29 vdout0_29ck135 = 0 time = 1360
* CHECK dout0_30 vdout0_30ck135 = 1.8 time = 1360
* CHECK dout0_31 vdout0_31ck135 = 1.8 time = 1360
* CHECK dout0_32 vdout0_32ck135 = 0 time = 1360
* CHECK dout0_0 vdout0_0ck138 = 0 time = 1390
* CHECK dout0_1 vdout0_1ck138 = 1.8 time = 1390
* CHECK dout0_2 vdout0_2ck138 = 0 time = 1390
* CHECK dout0_3 vdout0_3ck138 = 1.8 time = 1390
* CHECK dout0_4 vdout0_4ck138 = 0 time = 1390
* CHECK dout0_5 vdout0_5ck138 = 1.8 time = 1390
* CHECK dout0_6 vdout0_6ck138 = 1.8 time = 1390
* CHECK dout0_7 vdout0_7ck138 = 1.8 time = 1390
* CHECK dout0_8 vdout0_8ck138 = 0 time = 1390
* CHECK dout0_9 vdout0_9ck138 = 0 time = 1390
* CHECK dout0_10 vdout0_10ck138 = 1.8 time = 1390
* CHECK dout0_11 vdout0_11ck138 = 1.8 time = 1390
* CHECK dout0_12 vdout0_12ck138 = 0 time = 1390
* CHECK dout0_13 vdout0_13ck138 = 0 time = 1390
* CHECK dout0_14 vdout0_14ck138 = 0 time = 1390
* CHECK dout0_15 vdout0_15ck138 = 1.8 time = 1390
* CHECK dout0_16 vdout0_16ck138 = 0 time = 1390
* CHECK dout0_17 vdout0_17ck138 = 0 time = 1390
* CHECK dout0_18 vdout0_18ck138 = 1.8 time = 1390
* CHECK dout0_19 vdout0_19ck138 = 0 time = 1390
* CHECK dout0_20 vdout0_20ck138 = 0 time = 1390
* CHECK dout0_21 vdout0_21ck138 = 1.8 time = 1390
* CHECK dout0_22 vdout0_22ck138 = 0 time = 1390
* CHECK dout0_23 vdout0_23ck138 = 1.8 time = 1390
* CHECK dout0_24 vdout0_24ck138 = 1.8 time = 1390
* CHECK dout0_25 vdout0_25ck138 = 1.8 time = 1390
* CHECK dout0_26 vdout0_26ck138 = 1.8 time = 1390
* CHECK dout0_27 vdout0_27ck138 = 0 time = 1390
* CHECK dout0_28 vdout0_28ck138 = 1.8 time = 1390
* CHECK dout0_29 vdout0_29ck138 = 1.8 time = 1390
* CHECK dout0_30 vdout0_30ck138 = 0 time = 1390
* CHECK dout0_31 vdout0_31ck138 = 0 time = 1390
* CHECK dout0_32 vdout0_32ck138 = 0 time = 1390
* CHECK dout0_0 vdout0_0ck139 = 1.8 time = 1400
* CHECK dout0_1 vdout0_1ck139 = 0 time = 1400
* CHECK dout0_2 vdout0_2ck139 = 1.8 time = 1400
* CHECK dout0_3 vdout0_3ck139 = 0 time = 1400
* CHECK dout0_4 vdout0_4ck139 = 1.8 time = 1400
* CHECK dout0_5 vdout0_5ck139 = 0 time = 1400
* CHECK dout0_6 vdout0_6ck139 = 1.8 time = 1400
* CHECK dout0_7 vdout0_7ck139 = 1.8 time = 1400
* CHECK dout0_8 vdout0_8ck139 = 0 time = 1400
* CHECK dout0_9 vdout0_9ck139 = 1.8 time = 1400
* CHECK dout0_10 vdout0_10ck139 = 1.8 time = 1400
* CHECK dout0_11 vdout0_11ck139 = 0 time = 1400
* CHECK dout0_12 vdout0_12ck139 = 0 time = 1400
* CHECK dout0_13 vdout0_13ck139 = 1.8 time = 1400
* CHECK dout0_14 vdout0_14ck139 = 1.8 time = 1400
* CHECK dout0_15 vdout0_15ck139 = 1.8 time = 1400
* CHECK dout0_16 vdout0_16ck139 = 1.8 time = 1400
* CHECK dout0_17 vdout0_17ck139 = 0 time = 1400
* CHECK dout0_18 vdout0_18ck139 = 0 time = 1400
* CHECK dout0_19 vdout0_19ck139 = 1.8 time = 1400
* CHECK dout0_20 vdout0_20ck139 = 1.8 time = 1400
* CHECK dout0_21 vdout0_21ck139 = 0 time = 1400
* CHECK dout0_22 vdout0_22ck139 = 1.8 time = 1400
* CHECK dout0_23 vdout0_23ck139 = 0 time = 1400
* CHECK dout0_24 vdout0_24ck139 = 1.8 time = 1400
* CHECK dout0_25 vdout0_25ck139 = 0 time = 1400
* CHECK dout0_26 vdout0_26ck139 = 1.8 time = 1400
* CHECK dout0_27 vdout0_27ck139 = 0 time = 1400
* CHECK dout0_28 vdout0_28ck139 = 1.8 time = 1400
* CHECK dout0_29 vdout0_29ck139 = 0 time = 1400
* CHECK dout0_30 vdout0_30ck139 = 0 time = 1400
* CHECK dout0_31 vdout0_31ck139 = 0 time = 1400
* CHECK dout0_32 vdout0_32ck139 = 0 time = 1400
* CHECK dout0_0 vdout0_0ck142 = 1.8 time = 1430
* CHECK dout0_1 vdout0_1ck142 = 0 time = 1430
* CHECK dout0_2 vdout0_2ck142 = 0 time = 1430
* CHECK dout0_3 vdout0_3ck142 = 0 time = 1430
* CHECK dout0_4 vdout0_4ck142 = 0 time = 1430
* CHECK dout0_5 vdout0_5ck142 = 0 time = 1430
* CHECK dout0_6 vdout0_6ck142 = 0 time = 1430
* CHECK dout0_7 vdout0_7ck142 = 0 time = 1430
* CHECK dout0_8 vdout0_8ck142 = 0 time = 1430
* CHECK dout0_9 vdout0_9ck142 = 1.8 time = 1430
* CHECK dout0_10 vdout0_10ck142 = 1.8 time = 1430
* CHECK dout0_11 vdout0_11ck142 = 0 time = 1430
* CHECK dout0_12 vdout0_12ck142 = 1.8 time = 1430
* CHECK dout0_13 vdout0_13ck142 = 1.8 time = 1430
* CHECK dout0_14 vdout0_14ck142 = 0 time = 1430
* CHECK dout0_15 vdout0_15ck142 = 1.8 time = 1430
* CHECK dout0_16 vdout0_16ck142 = 1.8 time = 1430
* CHECK dout0_17 vdout0_17ck142 = 1.8 time = 1430
* CHECK dout0_18 vdout0_18ck142 = 1.8 time = 1430
* CHECK dout0_19 vdout0_19ck142 = 0 time = 1430
* CHECK dout0_20 vdout0_20ck142 = 0 time = 1430
* CHECK dout0_21 vdout0_21ck142 = 1.8 time = 1430
* CHECK dout0_22 vdout0_22ck142 = 0 time = 1430
* CHECK dout0_23 vdout0_23ck142 = 1.8 time = 1430
* CHECK dout0_24 vdout0_24ck142 = 0 time = 1430
* CHECK dout0_25 vdout0_25ck142 = 0 time = 1430
* CHECK dout0_26 vdout0_26ck142 = 1.8 time = 1430
* CHECK dout0_27 vdout0_27ck142 = 1.8 time = 1430
* CHECK dout0_28 vdout0_28ck142 = 0 time = 1430
* CHECK dout0_29 vdout0_29ck142 = 1.8 time = 1430
* CHECK dout0_30 vdout0_30ck142 = 0 time = 1430
* CHECK dout0_31 vdout0_31ck142 = 0 time = 1430
* CHECK dout0_32 vdout0_32ck142 = 0 time = 1430
* CHECK dout0_0 vdout0_0ck145 = 0 time = 1460
* CHECK dout0_1 vdout0_1ck145 = 1.8 time = 1460
* CHECK dout0_2 vdout0_2ck145 = 0 time = 1460
* CHECK dout0_3 vdout0_3ck145 = 0 time = 1460
* CHECK dout0_4 vdout0_4ck145 = 0 time = 1460
* CHECK dout0_5 vdout0_5ck145 = 1.8 time = 1460
* CHECK dout0_6 vdout0_6ck145 = 0 time = 1460
* CHECK dout0_7 vdout0_7ck145 = 1.8 time = 1460
* CHECK dout0_8 vdout0_8ck145 = 1.8 time = 1460
* CHECK dout0_9 vdout0_9ck145 = 0 time = 1460
* CHECK dout0_10 vdout0_10ck145 = 0 time = 1460
* CHECK dout0_11 vdout0_11ck145 = 0 time = 1460
* CHECK dout0_12 vdout0_12ck145 = 1.8 time = 1460
* CHECK dout0_13 vdout0_13ck145 = 1.8 time = 1460
* CHECK dout0_14 vdout0_14ck145 = 1.8 time = 1460
* CHECK dout0_15 vdout0_15ck145 = 0 time = 1460
* CHECK dout0_16 vdout0_16ck145 = 1.8 time = 1460
* CHECK dout0_17 vdout0_17ck145 = 0 time = 1460
* CHECK dout0_18 vdout0_18ck145 = 0 time = 1460
* CHECK dout0_19 vdout0_19ck145 = 1.8 time = 1460
* CHECK dout0_20 vdout0_20ck145 = 1.8 time = 1460
* CHECK dout0_21 vdout0_21ck145 = 1.8 time = 1460
* CHECK dout0_22 vdout0_22ck145 = 1.8 time = 1460
* CHECK dout0_23 vdout0_23ck145 = 1.8 time = 1460
* CHECK dout0_24 vdout0_24ck145 = 0 time = 1460
* CHECK dout0_25 vdout0_25ck145 = 1.8 time = 1460
* CHECK dout0_26 vdout0_26ck145 = 0 time = 1460
* CHECK dout0_27 vdout0_27ck145 = 0 time = 1460
* CHECK dout0_28 vdout0_28ck145 = 1.8 time = 1460
* CHECK dout0_29 vdout0_29ck145 = 1.8 time = 1460
* CHECK dout0_30 vdout0_30ck145 = 1.8 time = 1460
* CHECK dout0_31 vdout0_31ck145 = 1.8 time = 1460
* CHECK dout0_32 vdout0_32ck145 = 0 time = 1460
* CHECK dout0_0 vdout0_0ck150 = 1.8 time = 1510
* CHECK dout0_1 vdout0_1ck150 = 0 time = 1510
* CHECK dout0_2 vdout0_2ck150 = 1.8 time = 1510
* CHECK dout0_3 vdout0_3ck150 = 1.8 time = 1510
* CHECK dout0_4 vdout0_4ck150 = 0 time = 1510
* CHECK dout0_5 vdout0_5ck150 = 1.8 time = 1510
* CHECK dout0_6 vdout0_6ck150 = 0 time = 1510
* CHECK dout0_7 vdout0_7ck150 = 1.8 time = 1510
* CHECK dout0_8 vdout0_8ck150 = 1.8 time = 1510
* CHECK dout0_9 vdout0_9ck150 = 1.8 time = 1510
* CHECK dout0_10 vdout0_10ck150 = 0 time = 1510
* CHECK dout0_11 vdout0_11ck150 = 0 time = 1510
* CHECK dout0_12 vdout0_12ck150 = 0 time = 1510
* CHECK dout0_13 vdout0_13ck150 = 0 time = 1510
* CHECK dout0_14 vdout0_14ck150 = 0 time = 1510
* CHECK dout0_15 vdout0_15ck150 = 0 time = 1510
* CHECK dout0_16 vdout0_16ck150 = 1.8 time = 1510
* CHECK dout0_17 vdout0_17ck150 = 1.8 time = 1510
* CHECK dout0_18 vdout0_18ck150 = 0 time = 1510
* CHECK dout0_19 vdout0_19ck150 = 0 time = 1510
* CHECK dout0_20 vdout0_20ck150 = 1.8 time = 1510
* CHECK dout0_21 vdout0_21ck150 = 1.8 time = 1510
* CHECK dout0_22 vdout0_22ck150 = 0 time = 1510
* CHECK dout0_23 vdout0_23ck150 = 1.8 time = 1510
* CHECK dout0_24 vdout0_24ck150 = 0 time = 1510
* CHECK dout0_25 vdout0_25ck150 = 0 time = 1510
* CHECK dout0_26 vdout0_26ck150 = 1.8 time = 1510
* CHECK dout0_27 vdout0_27ck150 = 0 time = 1510
* CHECK dout0_28 vdout0_28ck150 = 0 time = 1510
* CHECK dout0_29 vdout0_29ck150 = 1.8 time = 1510
* CHECK dout0_30 vdout0_30ck150 = 1.8 time = 1510
* CHECK dout0_31 vdout0_31ck150 = 1.8 time = 1510
* CHECK dout0_32 vdout0_32ck150 = 0 time = 1510
* CHECK dout0_0 vdout0_0ck151 = 0 time = 1520
* CHECK dout0_1 vdout0_1ck151 = 1.8 time = 1520
* CHECK dout0_2 vdout0_2ck151 = 1.8 time = 1520
* CHECK dout0_3 vdout0_3ck151 = 1.8 time = 1520
* CHECK dout0_4 vdout0_4ck151 = 1.8 time = 1520
* CHECK dout0_5 vdout0_5ck151 = 0 time = 1520
* CHECK dout0_6 vdout0_6ck151 = 1.8 time = 1520
* CHECK dout0_7 vdout0_7ck151 = 1.8 time = 1520
* CHECK dout0_8 vdout0_8ck151 = 1.8 time = 1520
* CHECK dout0_9 vdout0_9ck151 = 0 time = 1520
* CHECK dout0_10 vdout0_10ck151 = 1.8 time = 1520
* CHECK dout0_11 vdout0_11ck151 = 1.8 time = 1520
* CHECK dout0_12 vdout0_12ck151 = 1.8 time = 1520
* CHECK dout0_13 vdout0_13ck151 = 0 time = 1520
* CHECK dout0_14 vdout0_14ck151 = 1.8 time = 1520
* CHECK dout0_15 vdout0_15ck151 = 1.8 time = 1520
* CHECK dout0_16 vdout0_16ck151 = 0 time = 1520
* CHECK dout0_17 vdout0_17ck151 = 0 time = 1520
* CHECK dout0_18 vdout0_18ck151 = 0 time = 1520
* CHECK dout0_19 vdout0_19ck151 = 0 time = 1520
* CHECK dout0_20 vdout0_20ck151 = 0 time = 1520
* CHECK dout0_21 vdout0_21ck151 = 0 time = 1520
* CHECK dout0_22 vdout0_22ck151 = 0 time = 1520
* CHECK dout0_23 vdout0_23ck151 = 0 time = 1520
* CHECK dout0_24 vdout0_24ck151 = 0 time = 1520
* CHECK dout0_25 vdout0_25ck151 = 1.8 time = 1520
* CHECK dout0_26 vdout0_26ck151 = 0 time = 1520
* CHECK dout0_27 vdout0_27ck151 = 1.8 time = 1520
* CHECK dout0_28 vdout0_28ck151 = 1.8 time = 1520
* CHECK dout0_29 vdout0_29ck151 = 1.8 time = 1520
* CHECK dout0_30 vdout0_30ck151 = 1.8 time = 1520
* CHECK dout0_31 vdout0_31ck151 = 1.8 time = 1520
* CHECK dout0_32 vdout0_32ck151 = 0 time = 1520
* CHECK dout0_0 vdout0_0ck153 = 1.8 time = 1540
* CHECK dout0_1 vdout0_1ck153 = 0 time = 1540
* CHECK dout0_2 vdout0_2ck153 = 1.8 time = 1540
* CHECK dout0_3 vdout0_3ck153 = 1.8 time = 1540
* CHECK dout0_4 vdout0_4ck153 = 0 time = 1540
* CHECK dout0_5 vdout0_5ck153 = 1.8 time = 1540
* CHECK dout0_6 vdout0_6ck153 = 0 time = 1540
* CHECK dout0_7 vdout0_7ck153 = 1.8 time = 1540
* CHECK dout0_8 vdout0_8ck153 = 1.8 time = 1540
* CHECK dout0_9 vdout0_9ck153 = 1.8 time = 1540
* CHECK dout0_10 vdout0_10ck153 = 0 time = 1540
* CHECK dout0_11 vdout0_11ck153 = 0 time = 1540
* CHECK dout0_12 vdout0_12ck153 = 0 time = 1540
* CHECK dout0_13 vdout0_13ck153 = 0 time = 1540
* CHECK dout0_14 vdout0_14ck153 = 0 time = 1540
* CHECK dout0_15 vdout0_15ck153 = 0 time = 1540
* CHECK dout0_16 vdout0_16ck153 = 1.8 time = 1540
* CHECK dout0_17 vdout0_17ck153 = 1.8 time = 1540
* CHECK dout0_18 vdout0_18ck153 = 0 time = 1540
* CHECK dout0_19 vdout0_19ck153 = 0 time = 1540
* CHECK dout0_20 vdout0_20ck153 = 1.8 time = 1540
* CHECK dout0_21 vdout0_21ck153 = 1.8 time = 1540
* CHECK dout0_22 vdout0_22ck153 = 0 time = 1540
* CHECK dout0_23 vdout0_23ck153 = 1.8 time = 1540
* CHECK dout0_24 vdout0_24ck153 = 0 time = 1540
* CHECK dout0_25 vdout0_25ck153 = 0 time = 1540
* CHECK dout0_26 vdout0_26ck153 = 1.8 time = 1540
* CHECK dout0_27 vdout0_27ck153 = 0 time = 1540
* CHECK dout0_28 vdout0_28ck153 = 0 time = 1540
* CHECK dout0_29 vdout0_29ck153 = 1.8 time = 1540
* CHECK dout0_30 vdout0_30ck153 = 1.8 time = 1540
* CHECK dout0_31 vdout0_31ck153 = 1.8 time = 1540
* CHECK dout0_32 vdout0_32ck153 = 0 time = 1540
* CHECK dout0_0 vdout0_0ck154 = 1.8 time = 1550
* CHECK dout0_1 vdout0_1ck154 = 0 time = 1550
* CHECK dout0_2 vdout0_2ck154 = 1.8 time = 1550
* CHECK dout0_3 vdout0_3ck154 = 1.8 time = 1550
* CHECK dout0_4 vdout0_4ck154 = 0 time = 1550
* CHECK dout0_5 vdout0_5ck154 = 1.8 time = 1550
* CHECK dout0_6 vdout0_6ck154 = 0 time = 1550
* CHECK dout0_7 vdout0_7ck154 = 1.8 time = 1550
* CHECK dout0_8 vdout0_8ck154 = 1.8 time = 1550
* CHECK dout0_9 vdout0_9ck154 = 1.8 time = 1550
* CHECK dout0_10 vdout0_10ck154 = 0 time = 1550
* CHECK dout0_11 vdout0_11ck154 = 0 time = 1550
* CHECK dout0_12 vdout0_12ck154 = 0 time = 1550
* CHECK dout0_13 vdout0_13ck154 = 0 time = 1550
* CHECK dout0_14 vdout0_14ck154 = 0 time = 1550
* CHECK dout0_15 vdout0_15ck154 = 0 time = 1550
* CHECK dout0_16 vdout0_16ck154 = 1.8 time = 1550
* CHECK dout0_17 vdout0_17ck154 = 1.8 time = 1550
* CHECK dout0_18 vdout0_18ck154 = 0 time = 1550
* CHECK dout0_19 vdout0_19ck154 = 0 time = 1550
* CHECK dout0_20 vdout0_20ck154 = 1.8 time = 1550
* CHECK dout0_21 vdout0_21ck154 = 1.8 time = 1550
* CHECK dout0_22 vdout0_22ck154 = 0 time = 1550
* CHECK dout0_23 vdout0_23ck154 = 1.8 time = 1550
* CHECK dout0_24 vdout0_24ck154 = 0 time = 1550
* CHECK dout0_25 vdout0_25ck154 = 0 time = 1550
* CHECK dout0_26 vdout0_26ck154 = 1.8 time = 1550
* CHECK dout0_27 vdout0_27ck154 = 0 time = 1550
* CHECK dout0_28 vdout0_28ck154 = 0 time = 1550
* CHECK dout0_29 vdout0_29ck154 = 1.8 time = 1550
* CHECK dout0_30 vdout0_30ck154 = 1.8 time = 1550
* CHECK dout0_31 vdout0_31ck154 = 1.8 time = 1550
* CHECK dout0_32 vdout0_32ck154 = 0 time = 1550
* CHECK dout0_0 vdout0_0ck156 = 1.8 time = 1570
* CHECK dout0_1 vdout0_1ck156 = 1.8 time = 1570
* CHECK dout0_2 vdout0_2ck156 = 1.8 time = 1570
* CHECK dout0_3 vdout0_3ck156 = 1.8 time = 1570
* CHECK dout0_4 vdout0_4ck156 = 1.8 time = 1570
* CHECK dout0_5 vdout0_5ck156 = 1.8 time = 1570
* CHECK dout0_6 vdout0_6ck156 = 1.8 time = 1570
* CHECK dout0_7 vdout0_7ck156 = 1.8 time = 1570
* CHECK dout0_8 vdout0_8ck156 = 0 time = 1570
* CHECK dout0_9 vdout0_9ck156 = 1.8 time = 1570
* CHECK dout0_10 vdout0_10ck156 = 0 time = 1570
* CHECK dout0_11 vdout0_11ck156 = 0 time = 1570
* CHECK dout0_12 vdout0_12ck156 = 1.8 time = 1570
* CHECK dout0_13 vdout0_13ck156 = 0 time = 1570
* CHECK dout0_14 vdout0_14ck156 = 1.8 time = 1570
* CHECK dout0_15 vdout0_15ck156 = 0 time = 1570
* CHECK dout0_16 vdout0_16ck156 = 0 time = 1570
* CHECK dout0_17 vdout0_17ck156 = 0 time = 1570
* CHECK dout0_18 vdout0_18ck156 = 0 time = 1570
* CHECK dout0_19 vdout0_19ck156 = 0 time = 1570
* CHECK dout0_20 vdout0_20ck156 = 1.8 time = 1570
* CHECK dout0_21 vdout0_21ck156 = 0 time = 1570
* CHECK dout0_22 vdout0_22ck156 = 1.8 time = 1570
* CHECK dout0_23 vdout0_23ck156 = 0 time = 1570
* CHECK dout0_24 vdout0_24ck156 = 0 time = 1570
* CHECK dout0_25 vdout0_25ck156 = 1.8 time = 1570
* CHECK dout0_26 vdout0_26ck156 = 1.8 time = 1570
* CHECK dout0_27 vdout0_27ck156 = 1.8 time = 1570
* CHECK dout0_28 vdout0_28ck156 = 0 time = 1570
* CHECK dout0_29 vdout0_29ck156 = 0 time = 1570
* CHECK dout0_30 vdout0_30ck156 = 1.8 time = 1570
* CHECK dout0_31 vdout0_31ck156 = 0 time = 1570
* CHECK dout0_32 vdout0_32ck156 = 0 time = 1570
* CHECK dout0_0 vdout0_0ck157 = 1.8 time = 1580
* CHECK dout0_1 vdout0_1ck157 = 1.8 time = 1580
* CHECK dout0_2 vdout0_2ck157 = 1.8 time = 1580
* CHECK dout0_3 vdout0_3ck157 = 1.8 time = 1580
* CHECK dout0_4 vdout0_4ck157 = 1.8 time = 1580
* CHECK dout0_5 vdout0_5ck157 = 1.8 time = 1580
* CHECK dout0_6 vdout0_6ck157 = 1.8 time = 1580
* CHECK dout0_7 vdout0_7ck157 = 1.8 time = 1580
* CHECK dout0_8 vdout0_8ck157 = 0 time = 1580
* CHECK dout0_9 vdout0_9ck157 = 1.8 time = 1580
* CHECK dout0_10 vdout0_10ck157 = 0 time = 1580
* CHECK dout0_11 vdout0_11ck157 = 0 time = 1580
* CHECK dout0_12 vdout0_12ck157 = 1.8 time = 1580
* CHECK dout0_13 vdout0_13ck157 = 0 time = 1580
* CHECK dout0_14 vdout0_14ck157 = 1.8 time = 1580
* CHECK dout0_15 vdout0_15ck157 = 0 time = 1580
* CHECK dout0_16 vdout0_16ck157 = 0 time = 1580
* CHECK dout0_17 vdout0_17ck157 = 0 time = 1580
* CHECK dout0_18 vdout0_18ck157 = 0 time = 1580
* CHECK dout0_19 vdout0_19ck157 = 0 time = 1580
* CHECK dout0_20 vdout0_20ck157 = 1.8 time = 1580
* CHECK dout0_21 vdout0_21ck157 = 0 time = 1580
* CHECK dout0_22 vdout0_22ck157 = 1.8 time = 1580
* CHECK dout0_23 vdout0_23ck157 = 0 time = 1580
* CHECK dout0_24 vdout0_24ck157 = 0 time = 1580
* CHECK dout0_25 vdout0_25ck157 = 1.8 time = 1580
* CHECK dout0_26 vdout0_26ck157 = 1.8 time = 1580
* CHECK dout0_27 vdout0_27ck157 = 1.8 time = 1580
* CHECK dout0_28 vdout0_28ck157 = 0 time = 1580
* CHECK dout0_29 vdout0_29ck157 = 0 time = 1580
* CHECK dout0_30 vdout0_30ck157 = 1.8 time = 1580
* CHECK dout0_31 vdout0_31ck157 = 0 time = 1580
* CHECK dout0_32 vdout0_32ck157 = 0 time = 1580
* CHECK dout0_0 vdout0_0ck160 = 0 time = 1610
* CHECK dout0_1 vdout0_1ck160 = 1.8 time = 1610
* CHECK dout0_2 vdout0_2ck160 = 0 time = 1610
* CHECK dout0_3 vdout0_3ck160 = 1.8 time = 1610
* CHECK dout0_4 vdout0_4ck160 = 0 time = 1610
* CHECK dout0_5 vdout0_5ck160 = 0 time = 1610
* CHECK dout0_6 vdout0_6ck160 = 0 time = 1610
* CHECK dout0_7 vdout0_7ck160 = 1.8 time = 1610
* CHECK dout0_8 vdout0_8ck160 = 1.8 time = 1610
* CHECK dout0_9 vdout0_9ck160 = 0 time = 1610
* CHECK dout0_10 vdout0_10ck160 = 1.8 time = 1610
* CHECK dout0_11 vdout0_11ck160 = 1.8 time = 1610
* CHECK dout0_12 vdout0_12ck160 = 1.8 time = 1610
* CHECK dout0_13 vdout0_13ck160 = 1.8 time = 1610
* CHECK dout0_14 vdout0_14ck160 = 1.8 time = 1610
* CHECK dout0_15 vdout0_15ck160 = 0 time = 1610
* CHECK dout0_16 vdout0_16ck160 = 0 time = 1610
* CHECK dout0_17 vdout0_17ck160 = 0 time = 1610
* CHECK dout0_18 vdout0_18ck160 = 0 time = 1610
* CHECK dout0_19 vdout0_19ck160 = 0 time = 1610
* CHECK dout0_20 vdout0_20ck160 = 1.8 time = 1610
* CHECK dout0_21 vdout0_21ck160 = 0 time = 1610
* CHECK dout0_22 vdout0_22ck160 = 1.8 time = 1610
* CHECK dout0_23 vdout0_23ck160 = 1.8 time = 1610
* CHECK dout0_24 vdout0_24ck160 = 1.8 time = 1610
* CHECK dout0_25 vdout0_25ck160 = 1.8 time = 1610
* CHECK dout0_26 vdout0_26ck160 = 1.8 time = 1610
* CHECK dout0_27 vdout0_27ck160 = 1.8 time = 1610
* CHECK dout0_28 vdout0_28ck160 = 1.8 time = 1610
* CHECK dout0_29 vdout0_29ck160 = 1.8 time = 1610
* CHECK dout0_30 vdout0_30ck160 = 0 time = 1610
* CHECK dout0_31 vdout0_31ck160 = 1.8 time = 1610
* CHECK dout0_32 vdout0_32ck160 = 0 time = 1610
* CHECK dout0_0 vdout0_0ck161 = 0 time = 1620
* CHECK dout0_1 vdout0_1ck161 = 1.8 time = 1620
* CHECK dout0_2 vdout0_2ck161 = 0 time = 1620
* CHECK dout0_3 vdout0_3ck161 = 1.8 time = 1620
* CHECK dout0_4 vdout0_4ck161 = 1.8 time = 1620
* CHECK dout0_5 vdout0_5ck161 = 1.8 time = 1620
* CHECK dout0_6 vdout0_6ck161 = 0 time = 1620
* CHECK dout0_7 vdout0_7ck161 = 0 time = 1620
* CHECK dout0_8 vdout0_8ck161 = 1.8 time = 1620
* CHECK dout0_9 vdout0_9ck161 = 1.8 time = 1620
* CHECK dout0_10 vdout0_10ck161 = 1.8 time = 1620
* CHECK dout0_11 vdout0_11ck161 = 0 time = 1620
* CHECK dout0_12 vdout0_12ck161 = 1.8 time = 1620
* CHECK dout0_13 vdout0_13ck161 = 0 time = 1620
* CHECK dout0_14 vdout0_14ck161 = 1.8 time = 1620
* CHECK dout0_15 vdout0_15ck161 = 0 time = 1620
* CHECK dout0_16 vdout0_16ck161 = 0 time = 1620
* CHECK dout0_17 vdout0_17ck161 = 1.8 time = 1620
* CHECK dout0_18 vdout0_18ck161 = 0 time = 1620
* CHECK dout0_19 vdout0_19ck161 = 1.8 time = 1620
* CHECK dout0_20 vdout0_20ck161 = 0 time = 1620
* CHECK dout0_21 vdout0_21ck161 = 1.8 time = 1620
* CHECK dout0_22 vdout0_22ck161 = 1.8 time = 1620
* CHECK dout0_23 vdout0_23ck161 = 1.8 time = 1620
* CHECK dout0_24 vdout0_24ck161 = 1.8 time = 1620
* CHECK dout0_25 vdout0_25ck161 = 1.8 time = 1620
* CHECK dout0_26 vdout0_26ck161 = 0 time = 1620
* CHECK dout0_27 vdout0_27ck161 = 0 time = 1620
* CHECK dout0_28 vdout0_28ck161 = 1.8 time = 1620
* CHECK dout0_29 vdout0_29ck161 = 1.8 time = 1620
* CHECK dout0_30 vdout0_30ck161 = 0 time = 1620
* CHECK dout0_31 vdout0_31ck161 = 0 time = 1620
* CHECK dout0_32 vdout0_32ck161 = 0 time = 1620
* CHECK dout0_0 vdout0_0ck165 = 0 time = 1660
* CHECK dout0_1 vdout0_1ck165 = 1.8 time = 1660
* CHECK dout0_2 vdout0_2ck165 = 0 time = 1660
* CHECK dout0_3 vdout0_3ck165 = 1.8 time = 1660
* CHECK dout0_4 vdout0_4ck165 = 1.8 time = 1660
* CHECK dout0_5 vdout0_5ck165 = 1.8 time = 1660
* CHECK dout0_6 vdout0_6ck165 = 0 time = 1660
* CHECK dout0_7 vdout0_7ck165 = 0 time = 1660
* CHECK dout0_8 vdout0_8ck165 = 1.8 time = 1660
* CHECK dout0_9 vdout0_9ck165 = 1.8 time = 1660
* CHECK dout0_10 vdout0_10ck165 = 1.8 time = 1660
* CHECK dout0_11 vdout0_11ck165 = 0 time = 1660
* CHECK dout0_12 vdout0_12ck165 = 1.8 time = 1660
* CHECK dout0_13 vdout0_13ck165 = 0 time = 1660
* CHECK dout0_14 vdout0_14ck165 = 1.8 time = 1660
* CHECK dout0_15 vdout0_15ck165 = 0 time = 1660
* CHECK dout0_16 vdout0_16ck165 = 0 time = 1660
* CHECK dout0_17 vdout0_17ck165 = 1.8 time = 1660
* CHECK dout0_18 vdout0_18ck165 = 0 time = 1660
* CHECK dout0_19 vdout0_19ck165 = 1.8 time = 1660
* CHECK dout0_20 vdout0_20ck165 = 0 time = 1660
* CHECK dout0_21 vdout0_21ck165 = 1.8 time = 1660
* CHECK dout0_22 vdout0_22ck165 = 1.8 time = 1660
* CHECK dout0_23 vdout0_23ck165 = 1.8 time = 1660
* CHECK dout0_24 vdout0_24ck165 = 1.8 time = 1660
* CHECK dout0_25 vdout0_25ck165 = 1.8 time = 1660
* CHECK dout0_26 vdout0_26ck165 = 0 time = 1660
* CHECK dout0_27 vdout0_27ck165 = 0 time = 1660
* CHECK dout0_28 vdout0_28ck165 = 1.8 time = 1660
* CHECK dout0_29 vdout0_29ck165 = 1.8 time = 1660
* CHECK dout0_30 vdout0_30ck165 = 0 time = 1660
* CHECK dout0_31 vdout0_31ck165 = 0 time = 1660
* CHECK dout0_32 vdout0_32ck165 = 0 time = 1660
* CHECK dout0_0 vdout0_0ck167 = 0 time = 1680
* CHECK dout0_1 vdout0_1ck167 = 1.8 time = 1680
* CHECK dout0_2 vdout0_2ck167 = 0 time = 1680
* CHECK dout0_3 vdout0_3ck167 = 1.8 time = 1680
* CHECK dout0_4 vdout0_4ck167 = 1.8 time = 1680
* CHECK dout0_5 vdout0_5ck167 = 1.8 time = 1680
* CHECK dout0_6 vdout0_6ck167 = 0 time = 1680
* CHECK dout0_7 vdout0_7ck167 = 0 time = 1680
* CHECK dout0_8 vdout0_8ck167 = 1.8 time = 1680
* CHECK dout0_9 vdout0_9ck167 = 1.8 time = 1680
* CHECK dout0_10 vdout0_10ck167 = 1.8 time = 1680
* CHECK dout0_11 vdout0_11ck167 = 0 time = 1680
* CHECK dout0_12 vdout0_12ck167 = 1.8 time = 1680
* CHECK dout0_13 vdout0_13ck167 = 0 time = 1680
* CHECK dout0_14 vdout0_14ck167 = 1.8 time = 1680
* CHECK dout0_15 vdout0_15ck167 = 0 time = 1680
* CHECK dout0_16 vdout0_16ck167 = 0 time = 1680
* CHECK dout0_17 vdout0_17ck167 = 1.8 time = 1680
* CHECK dout0_18 vdout0_18ck167 = 0 time = 1680
* CHECK dout0_19 vdout0_19ck167 = 1.8 time = 1680
* CHECK dout0_20 vdout0_20ck167 = 0 time = 1680
* CHECK dout0_21 vdout0_21ck167 = 1.8 time = 1680
* CHECK dout0_22 vdout0_22ck167 = 1.8 time = 1680
* CHECK dout0_23 vdout0_23ck167 = 1.8 time = 1680
* CHECK dout0_24 vdout0_24ck167 = 1.8 time = 1680
* CHECK dout0_25 vdout0_25ck167 = 1.8 time = 1680
* CHECK dout0_26 vdout0_26ck167 = 0 time = 1680
* CHECK dout0_27 vdout0_27ck167 = 0 time = 1680
* CHECK dout0_28 vdout0_28ck167 = 1.8 time = 1680
* CHECK dout0_29 vdout0_29ck167 = 1.8 time = 1680
* CHECK dout0_30 vdout0_30ck167 = 0 time = 1680
* CHECK dout0_31 vdout0_31ck167 = 0 time = 1680
* CHECK dout0_32 vdout0_32ck167 = 0 time = 1680
* CHECK dout0_0 vdout0_0ck174 = 1.8 time = 1750
* CHECK dout0_1 vdout0_1ck174 = 0 time = 1750
* CHECK dout0_2 vdout0_2ck174 = 0 time = 1750
* CHECK dout0_3 vdout0_3ck174 = 1.8 time = 1750
* CHECK dout0_4 vdout0_4ck174 = 1.8 time = 1750
* CHECK dout0_5 vdout0_5ck174 = 1.8 time = 1750
* CHECK dout0_6 vdout0_6ck174 = 1.8 time = 1750
* CHECK dout0_7 vdout0_7ck174 = 1.8 time = 1750
* CHECK dout0_8 vdout0_8ck174 = 1.8 time = 1750
* CHECK dout0_9 vdout0_9ck174 = 0 time = 1750
* CHECK dout0_10 vdout0_10ck174 = 1.8 time = 1750
* CHECK dout0_11 vdout0_11ck174 = 1.8 time = 1750
* CHECK dout0_12 vdout0_12ck174 = 1.8 time = 1750
* CHECK dout0_13 vdout0_13ck174 = 1.8 time = 1750
* CHECK dout0_14 vdout0_14ck174 = 0 time = 1750
* CHECK dout0_15 vdout0_15ck174 = 1.8 time = 1750
* CHECK dout0_16 vdout0_16ck174 = 1.8 time = 1750
* CHECK dout0_17 vdout0_17ck174 = 1.8 time = 1750
* CHECK dout0_18 vdout0_18ck174 = 1.8 time = 1750
* CHECK dout0_19 vdout0_19ck174 = 0 time = 1750
* CHECK dout0_20 vdout0_20ck174 = 0 time = 1750
* CHECK dout0_21 vdout0_21ck174 = 0 time = 1750
* CHECK dout0_22 vdout0_22ck174 = 1.8 time = 1750
* CHECK dout0_23 vdout0_23ck174 = 0 time = 1750
* CHECK dout0_24 vdout0_24ck174 = 1.8 time = 1750
* CHECK dout0_25 vdout0_25ck174 = 0 time = 1750
* CHECK dout0_26 vdout0_26ck174 = 1.8 time = 1750
* CHECK dout0_27 vdout0_27ck174 = 1.8 time = 1750
* CHECK dout0_28 vdout0_28ck174 = 1.8 time = 1750
* CHECK dout0_29 vdout0_29ck174 = 0 time = 1750
* CHECK dout0_30 vdout0_30ck174 = 0 time = 1750
* CHECK dout0_31 vdout0_31ck174 = 1.8 time = 1750
* CHECK dout0_32 vdout0_32ck174 = 0 time = 1750
* CHECK dout0_0 vdout0_0ck175 = 1.8 time = 1760
* CHECK dout0_1 vdout0_1ck175 = 0 time = 1760
* CHECK dout0_2 vdout0_2ck175 = 0 time = 1760
* CHECK dout0_3 vdout0_3ck175 = 1.8 time = 1760
* CHECK dout0_4 vdout0_4ck175 = 1.8 time = 1760
* CHECK dout0_5 vdout0_5ck175 = 1.8 time = 1760
* CHECK dout0_6 vdout0_6ck175 = 1.8 time = 1760
* CHECK dout0_7 vdout0_7ck175 = 1.8 time = 1760
* CHECK dout0_8 vdout0_8ck175 = 1.8 time = 1760
* CHECK dout0_9 vdout0_9ck175 = 0 time = 1760
* CHECK dout0_10 vdout0_10ck175 = 1.8 time = 1760
* CHECK dout0_11 vdout0_11ck175 = 1.8 time = 1760
* CHECK dout0_12 vdout0_12ck175 = 1.8 time = 1760
* CHECK dout0_13 vdout0_13ck175 = 1.8 time = 1760
* CHECK dout0_14 vdout0_14ck175 = 0 time = 1760
* CHECK dout0_15 vdout0_15ck175 = 1.8 time = 1760
* CHECK dout0_16 vdout0_16ck175 = 1.8 time = 1760
* CHECK dout0_17 vdout0_17ck175 = 1.8 time = 1760
* CHECK dout0_18 vdout0_18ck175 = 1.8 time = 1760
* CHECK dout0_19 vdout0_19ck175 = 0 time = 1760
* CHECK dout0_20 vdout0_20ck175 = 0 time = 1760
* CHECK dout0_21 vdout0_21ck175 = 0 time = 1760
* CHECK dout0_22 vdout0_22ck175 = 1.8 time = 1760
* CHECK dout0_23 vdout0_23ck175 = 0 time = 1760
* CHECK dout0_24 vdout0_24ck175 = 1.8 time = 1760
* CHECK dout0_25 vdout0_25ck175 = 0 time = 1760
* CHECK dout0_26 vdout0_26ck175 = 1.8 time = 1760
* CHECK dout0_27 vdout0_27ck175 = 1.8 time = 1760
* CHECK dout0_28 vdout0_28ck175 = 1.8 time = 1760
* CHECK dout0_29 vdout0_29ck175 = 0 time = 1760
* CHECK dout0_30 vdout0_30ck175 = 0 time = 1760
* CHECK dout0_31 vdout0_31ck175 = 1.8 time = 1760
* CHECK dout0_32 vdout0_32ck175 = 0 time = 1760
* CHECK dout0_0 vdout0_0ck176 = 1.8 time = 1770
* CHECK dout0_1 vdout0_1ck176 = 0 time = 1770
* CHECK dout0_2 vdout0_2ck176 = 0 time = 1770
* CHECK dout0_3 vdout0_3ck176 = 1.8 time = 1770
* CHECK dout0_4 vdout0_4ck176 = 1.8 time = 1770
* CHECK dout0_5 vdout0_5ck176 = 1.8 time = 1770
* CHECK dout0_6 vdout0_6ck176 = 0 time = 1770
* CHECK dout0_7 vdout0_7ck176 = 1.8 time = 1770
* CHECK dout0_8 vdout0_8ck176 = 1.8 time = 1770
* CHECK dout0_9 vdout0_9ck176 = 1.8 time = 1770
* CHECK dout0_10 vdout0_10ck176 = 1.8 time = 1770
* CHECK dout0_11 vdout0_11ck176 = 1.8 time = 1770
* CHECK dout0_12 vdout0_12ck176 = 0 time = 1770
* CHECK dout0_13 vdout0_13ck176 = 0 time = 1770
* CHECK dout0_14 vdout0_14ck176 = 0 time = 1770
* CHECK dout0_15 vdout0_15ck176 = 1.8 time = 1770
* CHECK dout0_16 vdout0_16ck176 = 1.8 time = 1770
* CHECK dout0_17 vdout0_17ck176 = 1.8 time = 1770
* CHECK dout0_18 vdout0_18ck176 = 1.8 time = 1770
* CHECK dout0_19 vdout0_19ck176 = 0 time = 1770
* CHECK dout0_20 vdout0_20ck176 = 1.8 time = 1770
* CHECK dout0_21 vdout0_21ck176 = 0 time = 1770
* CHECK dout0_22 vdout0_22ck176 = 0 time = 1770
* CHECK dout0_23 vdout0_23ck176 = 0 time = 1770
* CHECK dout0_24 vdout0_24ck176 = 0 time = 1770
* CHECK dout0_25 vdout0_25ck176 = 1.8 time = 1770
* CHECK dout0_26 vdout0_26ck176 = 0 time = 1770
* CHECK dout0_27 vdout0_27ck176 = 0 time = 1770
* CHECK dout0_28 vdout0_28ck176 = 1.8 time = 1770
* CHECK dout0_29 vdout0_29ck176 = 0 time = 1770
* CHECK dout0_30 vdout0_30ck176 = 1.8 time = 1770
* CHECK dout0_31 vdout0_31ck176 = 1.8 time = 1770
* CHECK dout0_32 vdout0_32ck176 = 0 time = 1770
* CHECK dout0_0 vdout0_0ck177 = 1.8 time = 1780
* CHECK dout0_1 vdout0_1ck177 = 0 time = 1780
* CHECK dout0_2 vdout0_2ck177 = 0 time = 1780
* CHECK dout0_3 vdout0_3ck177 = 1.8 time = 1780
* CHECK dout0_4 vdout0_4ck177 = 1.8 time = 1780
* CHECK dout0_5 vdout0_5ck177 = 1.8 time = 1780
* CHECK dout0_6 vdout0_6ck177 = 1.8 time = 1780
* CHECK dout0_7 vdout0_7ck177 = 1.8 time = 1780
* CHECK dout0_8 vdout0_8ck177 = 1.8 time = 1780
* CHECK dout0_9 vdout0_9ck177 = 0 time = 1780
* CHECK dout0_10 vdout0_10ck177 = 1.8 time = 1780
* CHECK dout0_11 vdout0_11ck177 = 1.8 time = 1780
* CHECK dout0_12 vdout0_12ck177 = 1.8 time = 1780
* CHECK dout0_13 vdout0_13ck177 = 1.8 time = 1780
* CHECK dout0_14 vdout0_14ck177 = 0 time = 1780
* CHECK dout0_15 vdout0_15ck177 = 1.8 time = 1780
* CHECK dout0_16 vdout0_16ck177 = 1.8 time = 1780
* CHECK dout0_17 vdout0_17ck177 = 1.8 time = 1780
* CHECK dout0_18 vdout0_18ck177 = 1.8 time = 1780
* CHECK dout0_19 vdout0_19ck177 = 0 time = 1780
* CHECK dout0_20 vdout0_20ck177 = 0 time = 1780
* CHECK dout0_21 vdout0_21ck177 = 0 time = 1780
* CHECK dout0_22 vdout0_22ck177 = 1.8 time = 1780
* CHECK dout0_23 vdout0_23ck177 = 0 time = 1780
* CHECK dout0_24 vdout0_24ck177 = 1.8 time = 1780
* CHECK dout0_25 vdout0_25ck177 = 0 time = 1780
* CHECK dout0_26 vdout0_26ck177 = 1.8 time = 1780
* CHECK dout0_27 vdout0_27ck177 = 1.8 time = 1780
* CHECK dout0_28 vdout0_28ck177 = 1.8 time = 1780
* CHECK dout0_29 vdout0_29ck177 = 0 time = 1780
* CHECK dout0_30 vdout0_30ck177 = 0 time = 1780
* CHECK dout0_31 vdout0_31ck177 = 1.8 time = 1780
* CHECK dout0_32 vdout0_32ck177 = 0 time = 1780
* CHECK dout0_0 vdout0_0ck179 = 1.8 time = 1800
* CHECK dout0_1 vdout0_1ck179 = 0 time = 1800
* CHECK dout0_2 vdout0_2ck179 = 0 time = 1800
* CHECK dout0_3 vdout0_3ck179 = 1.8 time = 1800
* CHECK dout0_4 vdout0_4ck179 = 1.8 time = 1800
* CHECK dout0_5 vdout0_5ck179 = 1.8 time = 1800
* CHECK dout0_6 vdout0_6ck179 = 0 time = 1800
* CHECK dout0_7 vdout0_7ck179 = 1.8 time = 1800
* CHECK dout0_8 vdout0_8ck179 = 1.8 time = 1800
* CHECK dout0_9 vdout0_9ck179 = 1.8 time = 1800
* CHECK dout0_10 vdout0_10ck179 = 1.8 time = 1800
* CHECK dout0_11 vdout0_11ck179 = 1.8 time = 1800
* CHECK dout0_12 vdout0_12ck179 = 0 time = 1800
* CHECK dout0_13 vdout0_13ck179 = 0 time = 1800
* CHECK dout0_14 vdout0_14ck179 = 0 time = 1800
* CHECK dout0_15 vdout0_15ck179 = 1.8 time = 1800
* CHECK dout0_16 vdout0_16ck179 = 1.8 time = 1800
* CHECK dout0_17 vdout0_17ck179 = 1.8 time = 1800
* CHECK dout0_18 vdout0_18ck179 = 1.8 time = 1800
* CHECK dout0_19 vdout0_19ck179 = 0 time = 1800
* CHECK dout0_20 vdout0_20ck179 = 1.8 time = 1800
* CHECK dout0_21 vdout0_21ck179 = 0 time = 1800
* CHECK dout0_22 vdout0_22ck179 = 0 time = 1800
* CHECK dout0_23 vdout0_23ck179 = 0 time = 1800
* CHECK dout0_24 vdout0_24ck179 = 0 time = 1800
* CHECK dout0_25 vdout0_25ck179 = 1.8 time = 1800
* CHECK dout0_26 vdout0_26ck179 = 0 time = 1800
* CHECK dout0_27 vdout0_27ck179 = 0 time = 1800
* CHECK dout0_28 vdout0_28ck179 = 1.8 time = 1800
* CHECK dout0_29 vdout0_29ck179 = 0 time = 1800
* CHECK dout0_30 vdout0_30ck179 = 1.8 time = 1800
* CHECK dout0_31 vdout0_31ck179 = 1.8 time = 1800
* CHECK dout0_32 vdout0_32ck179 = 0 time = 1800
* CHECK dout0_0 vdout0_0ck181 = 1.8 time = 1820
* CHECK dout0_1 vdout0_1ck181 = 0 time = 1820
* CHECK dout0_2 vdout0_2ck181 = 0 time = 1820
* CHECK dout0_3 vdout0_3ck181 = 1.8 time = 1820
* CHECK dout0_4 vdout0_4ck181 = 1.8 time = 1820
* CHECK dout0_5 vdout0_5ck181 = 1.8 time = 1820
* CHECK dout0_6 vdout0_6ck181 = 1.8 time = 1820
* CHECK dout0_7 vdout0_7ck181 = 1.8 time = 1820
* CHECK dout0_8 vdout0_8ck181 = 1.8 time = 1820
* CHECK dout0_9 vdout0_9ck181 = 0 time = 1820
* CHECK dout0_10 vdout0_10ck181 = 1.8 time = 1820
* CHECK dout0_11 vdout0_11ck181 = 1.8 time = 1820
* CHECK dout0_12 vdout0_12ck181 = 1.8 time = 1820
* CHECK dout0_13 vdout0_13ck181 = 1.8 time = 1820
* CHECK dout0_14 vdout0_14ck181 = 0 time = 1820
* CHECK dout0_15 vdout0_15ck181 = 1.8 time = 1820
* CHECK dout0_16 vdout0_16ck181 = 1.8 time = 1820
* CHECK dout0_17 vdout0_17ck181 = 1.8 time = 1820
* CHECK dout0_18 vdout0_18ck181 = 1.8 time = 1820
* CHECK dout0_19 vdout0_19ck181 = 0 time = 1820
* CHECK dout0_20 vdout0_20ck181 = 0 time = 1820
* CHECK dout0_21 vdout0_21ck181 = 0 time = 1820
* CHECK dout0_22 vdout0_22ck181 = 1.8 time = 1820
* CHECK dout0_23 vdout0_23ck181 = 0 time = 1820
* CHECK dout0_24 vdout0_24ck181 = 1.8 time = 1820
* CHECK dout0_25 vdout0_25ck181 = 0 time = 1820
* CHECK dout0_26 vdout0_26ck181 = 1.8 time = 1820
* CHECK dout0_27 vdout0_27ck181 = 1.8 time = 1820
* CHECK dout0_28 vdout0_28ck181 = 1.8 time = 1820
* CHECK dout0_29 vdout0_29ck181 = 0 time = 1820
* CHECK dout0_30 vdout0_30ck181 = 0 time = 1820
* CHECK dout0_31 vdout0_31ck181 = 1.8 time = 1820
* CHECK dout0_32 vdout0_32ck181 = 0 time = 1820
* CHECK dout0_0 vdout0_0ck182 = 1.8 time = 1830
* CHECK dout0_1 vdout0_1ck182 = 0 time = 1830
* CHECK dout0_2 vdout0_2ck182 = 0 time = 1830
* CHECK dout0_3 vdout0_3ck182 = 1.8 time = 1830
* CHECK dout0_4 vdout0_4ck182 = 1.8 time = 1830
* CHECK dout0_5 vdout0_5ck182 = 1.8 time = 1830
* CHECK dout0_6 vdout0_6ck182 = 1.8 time = 1830
* CHECK dout0_7 vdout0_7ck182 = 1.8 time = 1830
* CHECK dout0_8 vdout0_8ck182 = 1.8 time = 1830
* CHECK dout0_9 vdout0_9ck182 = 0 time = 1830
* CHECK dout0_10 vdout0_10ck182 = 1.8 time = 1830
* CHECK dout0_11 vdout0_11ck182 = 1.8 time = 1830
* CHECK dout0_12 vdout0_12ck182 = 1.8 time = 1830
* CHECK dout0_13 vdout0_13ck182 = 1.8 time = 1830
* CHECK dout0_14 vdout0_14ck182 = 0 time = 1830
* CHECK dout0_15 vdout0_15ck182 = 1.8 time = 1830
* CHECK dout0_16 vdout0_16ck182 = 1.8 time = 1830
* CHECK dout0_17 vdout0_17ck182 = 1.8 time = 1830
* CHECK dout0_18 vdout0_18ck182 = 1.8 time = 1830
* CHECK dout0_19 vdout0_19ck182 = 0 time = 1830
* CHECK dout0_20 vdout0_20ck182 = 0 time = 1830
* CHECK dout0_21 vdout0_21ck182 = 0 time = 1830
* CHECK dout0_22 vdout0_22ck182 = 1.8 time = 1830
* CHECK dout0_23 vdout0_23ck182 = 0 time = 1830
* CHECK dout0_24 vdout0_24ck182 = 1.8 time = 1830
* CHECK dout0_25 vdout0_25ck182 = 0 time = 1830
* CHECK dout0_26 vdout0_26ck182 = 1.8 time = 1830
* CHECK dout0_27 vdout0_27ck182 = 1.8 time = 1830
* CHECK dout0_28 vdout0_28ck182 = 1.8 time = 1830
* CHECK dout0_29 vdout0_29ck182 = 0 time = 1830
* CHECK dout0_30 vdout0_30ck182 = 0 time = 1830
* CHECK dout0_31 vdout0_31ck182 = 1.8 time = 1830
* CHECK dout0_32 vdout0_32ck182 = 0 time = 1830
* CHECK dout0_0 vdout0_0ck183 = 1.8 time = 1840
* CHECK dout0_1 vdout0_1ck183 = 0 time = 1840
* CHECK dout0_2 vdout0_2ck183 = 0 time = 1840
* CHECK dout0_3 vdout0_3ck183 = 1.8 time = 1840
* CHECK dout0_4 vdout0_4ck183 = 1.8 time = 1840
* CHECK dout0_5 vdout0_5ck183 = 1.8 time = 1840
* CHECK dout0_6 vdout0_6ck183 = 1.8 time = 1840
* CHECK dout0_7 vdout0_7ck183 = 1.8 time = 1840
* CHECK dout0_8 vdout0_8ck183 = 1.8 time = 1840
* CHECK dout0_9 vdout0_9ck183 = 0 time = 1840
* CHECK dout0_10 vdout0_10ck183 = 1.8 time = 1840
* CHECK dout0_11 vdout0_11ck183 = 1.8 time = 1840
* CHECK dout0_12 vdout0_12ck183 = 1.8 time = 1840
* CHECK dout0_13 vdout0_13ck183 = 1.8 time = 1840
* CHECK dout0_14 vdout0_14ck183 = 0 time = 1840
* CHECK dout0_15 vdout0_15ck183 = 1.8 time = 1840
* CHECK dout0_16 vdout0_16ck183 = 1.8 time = 1840
* CHECK dout0_17 vdout0_17ck183 = 1.8 time = 1840
* CHECK dout0_18 vdout0_18ck183 = 1.8 time = 1840
* CHECK dout0_19 vdout0_19ck183 = 0 time = 1840
* CHECK dout0_20 vdout0_20ck183 = 0 time = 1840
* CHECK dout0_21 vdout0_21ck183 = 0 time = 1840
* CHECK dout0_22 vdout0_22ck183 = 1.8 time = 1840
* CHECK dout0_23 vdout0_23ck183 = 0 time = 1840
* CHECK dout0_24 vdout0_24ck183 = 1.8 time = 1840
* CHECK dout0_25 vdout0_25ck183 = 0 time = 1840
* CHECK dout0_26 vdout0_26ck183 = 1.8 time = 1840
* CHECK dout0_27 vdout0_27ck183 = 1.8 time = 1840
* CHECK dout0_28 vdout0_28ck183 = 1.8 time = 1840
* CHECK dout0_29 vdout0_29ck183 = 0 time = 1840
* CHECK dout0_30 vdout0_30ck183 = 0 time = 1840
* CHECK dout0_31 vdout0_31ck183 = 1.8 time = 1840
* CHECK dout0_32 vdout0_32ck183 = 0 time = 1840
* CHECK dout0_0 vdout0_0ck185 = 1.8 time = 1860
* CHECK dout0_1 vdout0_1ck185 = 1.8 time = 1860
* CHECK dout0_2 vdout0_2ck185 = 0 time = 1860
* CHECK dout0_3 vdout0_3ck185 = 1.8 time = 1860
* CHECK dout0_4 vdout0_4ck185 = 1.8 time = 1860
* CHECK dout0_5 vdout0_5ck185 = 0 time = 1860
* CHECK dout0_6 vdout0_6ck185 = 0 time = 1860
* CHECK dout0_7 vdout0_7ck185 = 0 time = 1860
* CHECK dout0_8 vdout0_8ck185 = 0 time = 1860
* CHECK dout0_9 vdout0_9ck185 = 1.8 time = 1860
* CHECK dout0_10 vdout0_10ck185 = 1.8 time = 1860
* CHECK dout0_11 vdout0_11ck185 = 0 time = 1860
* CHECK dout0_12 vdout0_12ck185 = 1.8 time = 1860
* CHECK dout0_13 vdout0_13ck185 = 1.8 time = 1860
* CHECK dout0_14 vdout0_14ck185 = 1.8 time = 1860
* CHECK dout0_15 vdout0_15ck185 = 0 time = 1860
* CHECK dout0_16 vdout0_16ck185 = 1.8 time = 1860
* CHECK dout0_17 vdout0_17ck185 = 1.8 time = 1860
* CHECK dout0_18 vdout0_18ck185 = 0 time = 1860
* CHECK dout0_19 vdout0_19ck185 = 1.8 time = 1860
* CHECK dout0_20 vdout0_20ck185 = 0 time = 1860
* CHECK dout0_21 vdout0_21ck185 = 1.8 time = 1860
* CHECK dout0_22 vdout0_22ck185 = 1.8 time = 1860
* CHECK dout0_23 vdout0_23ck185 = 0 time = 1860
* CHECK dout0_24 vdout0_24ck185 = 1.8 time = 1860
* CHECK dout0_25 vdout0_25ck185 = 0 time = 1860
* CHECK dout0_26 vdout0_26ck185 = 0 time = 1860
* CHECK dout0_27 vdout0_27ck185 = 1.8 time = 1860
* CHECK dout0_28 vdout0_28ck185 = 0 time = 1860
* CHECK dout0_29 vdout0_29ck185 = 0 time = 1860
* CHECK dout0_30 vdout0_30ck185 = 0 time = 1860
* CHECK dout0_31 vdout0_31ck185 = 0 time = 1860
* CHECK dout0_32 vdout0_32ck185 = 0 time = 1860
* CHECK dout0_0 vdout0_0ck187 = 0 time = 1880
* CHECK dout0_1 vdout0_1ck187 = 1.8 time = 1880
* CHECK dout0_2 vdout0_2ck187 = 1.8 time = 1880
* CHECK dout0_3 vdout0_3ck187 = 0 time = 1880
* CHECK dout0_4 vdout0_4ck187 = 1.8 time = 1880
* CHECK dout0_5 vdout0_5ck187 = 1.8 time = 1880
* CHECK dout0_6 vdout0_6ck187 = 1.8 time = 1880
* CHECK dout0_7 vdout0_7ck187 = 1.8 time = 1880
* CHECK dout0_8 vdout0_8ck187 = 0 time = 1880
* CHECK dout0_9 vdout0_9ck187 = 0 time = 1880
* CHECK dout0_10 vdout0_10ck187 = 1.8 time = 1880
* CHECK dout0_11 vdout0_11ck187 = 0 time = 1880
* CHECK dout0_12 vdout0_12ck187 = 0 time = 1880
* CHECK dout0_13 vdout0_13ck187 = 1.8 time = 1880
* CHECK dout0_14 vdout0_14ck187 = 1.8 time = 1880
* CHECK dout0_15 vdout0_15ck187 = 1.8 time = 1880
* CHECK dout0_16 vdout0_16ck187 = 0 time = 1880
* CHECK dout0_17 vdout0_17ck187 = 0 time = 1880
* CHECK dout0_18 vdout0_18ck187 = 0 time = 1880
* CHECK dout0_19 vdout0_19ck187 = 1.8 time = 1880
* CHECK dout0_20 vdout0_20ck187 = 0 time = 1880
* CHECK dout0_21 vdout0_21ck187 = 1.8 time = 1880
* CHECK dout0_22 vdout0_22ck187 = 0 time = 1880
* CHECK dout0_23 vdout0_23ck187 = 1.8 time = 1880
* CHECK dout0_24 vdout0_24ck187 = 1.8 time = 1880
* CHECK dout0_25 vdout0_25ck187 = 1.8 time = 1880
* CHECK dout0_26 vdout0_26ck187 = 1.8 time = 1880
* CHECK dout0_27 vdout0_27ck187 = 1.8 time = 1880
* CHECK dout0_28 vdout0_28ck187 = 0 time = 1880
* CHECK dout0_29 vdout0_29ck187 = 0 time = 1880
* CHECK dout0_30 vdout0_30ck187 = 1.8 time = 1880
* CHECK dout0_31 vdout0_31ck187 = 1.8 time = 1880
* CHECK dout0_32 vdout0_32ck187 = 0 time = 1880
* CHECK dout0_0 vdout0_0ck188 = 1.8 time = 1890
* CHECK dout0_1 vdout0_1ck188 = 1.8 time = 1890
* CHECK dout0_2 vdout0_2ck188 = 0 time = 1890
* CHECK dout0_3 vdout0_3ck188 = 1.8 time = 1890
* CHECK dout0_4 vdout0_4ck188 = 1.8 time = 1890
* CHECK dout0_5 vdout0_5ck188 = 0 time = 1890
* CHECK dout0_6 vdout0_6ck188 = 0 time = 1890
* CHECK dout0_7 vdout0_7ck188 = 0 time = 1890
* CHECK dout0_8 vdout0_8ck188 = 0 time = 1890
* CHECK dout0_9 vdout0_9ck188 = 1.8 time = 1890
* CHECK dout0_10 vdout0_10ck188 = 1.8 time = 1890
* CHECK dout0_11 vdout0_11ck188 = 0 time = 1890
* CHECK dout0_12 vdout0_12ck188 = 1.8 time = 1890
* CHECK dout0_13 vdout0_13ck188 = 1.8 time = 1890
* CHECK dout0_14 vdout0_14ck188 = 1.8 time = 1890
* CHECK dout0_15 vdout0_15ck188 = 0 time = 1890
* CHECK dout0_16 vdout0_16ck188 = 1.8 time = 1890
* CHECK dout0_17 vdout0_17ck188 = 1.8 time = 1890
* CHECK dout0_18 vdout0_18ck188 = 0 time = 1890
* CHECK dout0_19 vdout0_19ck188 = 1.8 time = 1890
* CHECK dout0_20 vdout0_20ck188 = 0 time = 1890
* CHECK dout0_21 vdout0_21ck188 = 1.8 time = 1890
* CHECK dout0_22 vdout0_22ck188 = 1.8 time = 1890
* CHECK dout0_23 vdout0_23ck188 = 0 time = 1890
* CHECK dout0_24 vdout0_24ck188 = 1.8 time = 1890
* CHECK dout0_25 vdout0_25ck188 = 0 time = 1890
* CHECK dout0_26 vdout0_26ck188 = 0 time = 1890
* CHECK dout0_27 vdout0_27ck188 = 1.8 time = 1890
* CHECK dout0_28 vdout0_28ck188 = 0 time = 1890
* CHECK dout0_29 vdout0_29ck188 = 0 time = 1890
* CHECK dout0_30 vdout0_30ck188 = 0 time = 1890
* CHECK dout0_31 vdout0_31ck188 = 0 time = 1890
* CHECK dout0_32 vdout0_32ck188 = 0 time = 1890
* CHECK dout0_0 vdout0_0ck192 = 0 time = 1930
* CHECK dout0_1 vdout0_1ck192 = 1.8 time = 1930
* CHECK dout0_2 vdout0_2ck192 = 0 time = 1930
* CHECK dout0_3 vdout0_3ck192 = 0 time = 1930
* CHECK dout0_4 vdout0_4ck192 = 0 time = 1930
* CHECK dout0_5 vdout0_5ck192 = 0 time = 1930
* CHECK dout0_6 vdout0_6ck192 = 1.8 time = 1930
* CHECK dout0_7 vdout0_7ck192 = 0 time = 1930
* CHECK dout0_8 vdout0_8ck192 = 0 time = 1930
* CHECK dout0_9 vdout0_9ck192 = 0 time = 1930
* CHECK dout0_10 vdout0_10ck192 = 0 time = 1930
* CHECK dout0_11 vdout0_11ck192 = 0 time = 1930
* CHECK dout0_12 vdout0_12ck192 = 1.8 time = 1930
* CHECK dout0_13 vdout0_13ck192 = 1.8 time = 1930
* CHECK dout0_14 vdout0_14ck192 = 0 time = 1930
* CHECK dout0_15 vdout0_15ck192 = 0 time = 1930
* CHECK dout0_16 vdout0_16ck192 = 1.8 time = 1930
* CHECK dout0_17 vdout0_17ck192 = 0 time = 1930
* CHECK dout0_18 vdout0_18ck192 = 0 time = 1930
* CHECK dout0_19 vdout0_19ck192 = 1.8 time = 1930
* CHECK dout0_20 vdout0_20ck192 = 0 time = 1930
* CHECK dout0_21 vdout0_21ck192 = 0 time = 1930
* CHECK dout0_22 vdout0_22ck192 = 1.8 time = 1930
* CHECK dout0_23 vdout0_23ck192 = 0 time = 1930
* CHECK dout0_24 vdout0_24ck192 = 1.8 time = 1930
* CHECK dout0_25 vdout0_25ck192 = 0 time = 1930
* CHECK dout0_26 vdout0_26ck192 = 0 time = 1930
* CHECK dout0_27 vdout0_27ck192 = 1.8 time = 1930
* CHECK dout0_28 vdout0_28ck192 = 1.8 time = 1930
* CHECK dout0_29 vdout0_29ck192 = 1.8 time = 1930
* CHECK dout0_30 vdout0_30ck192 = 0 time = 1930
* CHECK dout0_31 vdout0_31ck192 = 1.8 time = 1930
* CHECK dout0_32 vdout0_32ck192 = 0 time = 1930
* CHECK dout0_0 vdout0_0ck193 = 1.8 time = 1940
* CHECK dout0_1 vdout0_1ck193 = 1.8 time = 1940
* CHECK dout0_2 vdout0_2ck193 = 0 time = 1940
* CHECK dout0_3 vdout0_3ck193 = 1.8 time = 1940
* CHECK dout0_4 vdout0_4ck193 = 1.8 time = 1940
* CHECK dout0_5 vdout0_5ck193 = 0 time = 1940
* CHECK dout0_6 vdout0_6ck193 = 0 time = 1940
* CHECK dout0_7 vdout0_7ck193 = 0 time = 1940
* CHECK dout0_8 vdout0_8ck193 = 0 time = 1940
* CHECK dout0_9 vdout0_9ck193 = 1.8 time = 1940
* CHECK dout0_10 vdout0_10ck193 = 1.8 time = 1940
* CHECK dout0_11 vdout0_11ck193 = 0 time = 1940
* CHECK dout0_12 vdout0_12ck193 = 1.8 time = 1940
* CHECK dout0_13 vdout0_13ck193 = 1.8 time = 1940
* CHECK dout0_14 vdout0_14ck193 = 1.8 time = 1940
* CHECK dout0_15 vdout0_15ck193 = 0 time = 1940
* CHECK dout0_16 vdout0_16ck193 = 1.8 time = 1940
* CHECK dout0_17 vdout0_17ck193 = 1.8 time = 1940
* CHECK dout0_18 vdout0_18ck193 = 0 time = 1940
* CHECK dout0_19 vdout0_19ck193 = 1.8 time = 1940
* CHECK dout0_20 vdout0_20ck193 = 0 time = 1940
* CHECK dout0_21 vdout0_21ck193 = 1.8 time = 1940
* CHECK dout0_22 vdout0_22ck193 = 1.8 time = 1940
* CHECK dout0_23 vdout0_23ck193 = 0 time = 1940
* CHECK dout0_24 vdout0_24ck193 = 1.8 time = 1940
* CHECK dout0_25 vdout0_25ck193 = 0 time = 1940
* CHECK dout0_26 vdout0_26ck193 = 0 time = 1940
* CHECK dout0_27 vdout0_27ck193 = 1.8 time = 1940
* CHECK dout0_28 vdout0_28ck193 = 0 time = 1940
* CHECK dout0_29 vdout0_29ck193 = 0 time = 1940
* CHECK dout0_30 vdout0_30ck193 = 0 time = 1940
* CHECK dout0_31 vdout0_31ck193 = 0 time = 1940
* CHECK dout0_32 vdout0_32ck193 = 0 time = 1940
* CHECK dout0_0 vdout0_0ck194 = 0 time = 1950
* CHECK dout0_1 vdout0_1ck194 = 1.8 time = 1950
* CHECK dout0_2 vdout0_2ck194 = 0 time = 1950
* CHECK dout0_3 vdout0_3ck194 = 0 time = 1950
* CHECK dout0_4 vdout0_4ck194 = 0 time = 1950
* CHECK dout0_5 vdout0_5ck194 = 0 time = 1950
* CHECK dout0_6 vdout0_6ck194 = 1.8 time = 1950
* CHECK dout0_7 vdout0_7ck194 = 0 time = 1950
* CHECK dout0_8 vdout0_8ck194 = 0 time = 1950
* CHECK dout0_9 vdout0_9ck194 = 0 time = 1950
* CHECK dout0_10 vdout0_10ck194 = 0 time = 1950
* CHECK dout0_11 vdout0_11ck194 = 0 time = 1950
* CHECK dout0_12 vdout0_12ck194 = 1.8 time = 1950
* CHECK dout0_13 vdout0_13ck194 = 1.8 time = 1950
* CHECK dout0_14 vdout0_14ck194 = 0 time = 1950
* CHECK dout0_15 vdout0_15ck194 = 0 time = 1950
* CHECK dout0_16 vdout0_16ck194 = 1.8 time = 1950
* CHECK dout0_17 vdout0_17ck194 = 0 time = 1950
* CHECK dout0_18 vdout0_18ck194 = 0 time = 1950
* CHECK dout0_19 vdout0_19ck194 = 1.8 time = 1950
* CHECK dout0_20 vdout0_20ck194 = 0 time = 1950
* CHECK dout0_21 vdout0_21ck194 = 0 time = 1950
* CHECK dout0_22 vdout0_22ck194 = 1.8 time = 1950
* CHECK dout0_23 vdout0_23ck194 = 0 time = 1950
* CHECK dout0_24 vdout0_24ck194 = 1.8 time = 1950
* CHECK dout0_25 vdout0_25ck194 = 0 time = 1950
* CHECK dout0_26 vdout0_26ck194 = 0 time = 1950
* CHECK dout0_27 vdout0_27ck194 = 1.8 time = 1950
* CHECK dout0_28 vdout0_28ck194 = 1.8 time = 1950
* CHECK dout0_29 vdout0_29ck194 = 1.8 time = 1950
* CHECK dout0_30 vdout0_30ck194 = 0 time = 1950
* CHECK dout0_31 vdout0_31ck194 = 1.8 time = 1950
* CHECK dout0_32 vdout0_32ck194 = 0 time = 1950
* CHECK dout0_0 vdout0_0ck195 = 0 time = 1960
* CHECK dout0_1 vdout0_1ck195 = 1.8 time = 1960
* CHECK dout0_2 vdout0_2ck195 = 0 time = 1960
* CHECK dout0_3 vdout0_3ck195 = 0 time = 1960
* CHECK dout0_4 vdout0_4ck195 = 0 time = 1960
* CHECK dout0_5 vdout0_5ck195 = 0 time = 1960
* CHECK dout0_6 vdout0_6ck195 = 1.8 time = 1960
* CHECK dout0_7 vdout0_7ck195 = 0 time = 1960
* CHECK dout0_8 vdout0_8ck195 = 0 time = 1960
* CHECK dout0_9 vdout0_9ck195 = 0 time = 1960
* CHECK dout0_10 vdout0_10ck195 = 0 time = 1960
* CHECK dout0_11 vdout0_11ck195 = 0 time = 1960
* CHECK dout0_12 vdout0_12ck195 = 1.8 time = 1960
* CHECK dout0_13 vdout0_13ck195 = 1.8 time = 1960
* CHECK dout0_14 vdout0_14ck195 = 0 time = 1960
* CHECK dout0_15 vdout0_15ck195 = 0 time = 1960
* CHECK dout0_16 vdout0_16ck195 = 1.8 time = 1960
* CHECK dout0_17 vdout0_17ck195 = 0 time = 1960
* CHECK dout0_18 vdout0_18ck195 = 0 time = 1960
* CHECK dout0_19 vdout0_19ck195 = 1.8 time = 1960
* CHECK dout0_20 vdout0_20ck195 = 0 time = 1960
* CHECK dout0_21 vdout0_21ck195 = 0 time = 1960
* CHECK dout0_22 vdout0_22ck195 = 1.8 time = 1960
* CHECK dout0_23 vdout0_23ck195 = 0 time = 1960
* CHECK dout0_24 vdout0_24ck195 = 1.8 time = 1960
* CHECK dout0_25 vdout0_25ck195 = 0 time = 1960
* CHECK dout0_26 vdout0_26ck195 = 0 time = 1960
* CHECK dout0_27 vdout0_27ck195 = 1.8 time = 1960
* CHECK dout0_28 vdout0_28ck195 = 1.8 time = 1960
* CHECK dout0_29 vdout0_29ck195 = 1.8 time = 1960
* CHECK dout0_30 vdout0_30ck195 = 0 time = 1960
* CHECK dout0_31 vdout0_31ck195 = 1.8 time = 1960
* CHECK dout0_32 vdout0_32ck195 = 0 time = 1960
* CHECK dout0_0 vdout0_0ck198 = 0 time = 1990
* CHECK dout0_1 vdout0_1ck198 = 1.8 time = 1990
* CHECK dout0_2 vdout0_2ck198 = 0 time = 1990
* CHECK dout0_3 vdout0_3ck198 = 0 time = 1990
* CHECK dout0_4 vdout0_4ck198 = 0 time = 1990
* CHECK dout0_5 vdout0_5ck198 = 0 time = 1990
* CHECK dout0_6 vdout0_6ck198 = 1.8 time = 1990
* CHECK dout0_7 vdout0_7ck198 = 0 time = 1990
* CHECK dout0_8 vdout0_8ck198 = 0 time = 1990
* CHECK dout0_9 vdout0_9ck198 = 0 time = 1990
* CHECK dout0_10 vdout0_10ck198 = 0 time = 1990
* CHECK dout0_11 vdout0_11ck198 = 0 time = 1990
* CHECK dout0_12 vdout0_12ck198 = 1.8 time = 1990
* CHECK dout0_13 vdout0_13ck198 = 1.8 time = 1990
* CHECK dout0_14 vdout0_14ck198 = 0 time = 1990
* CHECK dout0_15 vdout0_15ck198 = 0 time = 1990
* CHECK dout0_16 vdout0_16ck198 = 1.8 time = 1990
* CHECK dout0_17 vdout0_17ck198 = 0 time = 1990
* CHECK dout0_18 vdout0_18ck198 = 0 time = 1990
* CHECK dout0_19 vdout0_19ck198 = 1.8 time = 1990
* CHECK dout0_20 vdout0_20ck198 = 0 time = 1990
* CHECK dout0_21 vdout0_21ck198 = 0 time = 1990
* CHECK dout0_22 vdout0_22ck198 = 1.8 time = 1990
* CHECK dout0_23 vdout0_23ck198 = 0 time = 1990
* CHECK dout0_24 vdout0_24ck198 = 1.8 time = 1990
* CHECK dout0_25 vdout0_25ck198 = 0 time = 1990
* CHECK dout0_26 vdout0_26ck198 = 0 time = 1990
* CHECK dout0_27 vdout0_27ck198 = 1.8 time = 1990
* CHECK dout0_28 vdout0_28ck198 = 1.8 time = 1990
* CHECK dout0_29 vdout0_29ck198 = 1.8 time = 1990
* CHECK dout0_30 vdout0_30ck198 = 0 time = 1990
* CHECK dout0_31 vdout0_31ck198 = 1.8 time = 1990
* CHECK dout0_32 vdout0_32ck198 = 0 time = 1990
* CHECK dout0_0 vdout0_0ck201 = 0 time = 2020
* CHECK dout0_1 vdout0_1ck201 = 0 time = 2020
* CHECK dout0_2 vdout0_2ck201 = 0 time = 2020
* CHECK dout0_3 vdout0_3ck201 = 1.8 time = 2020
* CHECK dout0_4 vdout0_4ck201 = 1.8 time = 2020
* CHECK dout0_5 vdout0_5ck201 = 0 time = 2020
* CHECK dout0_6 vdout0_6ck201 = 0 time = 2020
* CHECK dout0_7 vdout0_7ck201 = 1.8 time = 2020
* CHECK dout0_8 vdout0_8ck201 = 1.8 time = 2020
* CHECK dout0_9 vdout0_9ck201 = 1.8 time = 2020
* CHECK dout0_10 vdout0_10ck201 = 0 time = 2020
* CHECK dout0_11 vdout0_11ck201 = 1.8 time = 2020
* CHECK dout0_12 vdout0_12ck201 = 0 time = 2020
* CHECK dout0_13 vdout0_13ck201 = 1.8 time = 2020
* CHECK dout0_14 vdout0_14ck201 = 0 time = 2020
* CHECK dout0_15 vdout0_15ck201 = 1.8 time = 2020
* CHECK dout0_16 vdout0_16ck201 = 1.8 time = 2020
* CHECK dout0_17 vdout0_17ck201 = 1.8 time = 2020
* CHECK dout0_18 vdout0_18ck201 = 0 time = 2020
* CHECK dout0_19 vdout0_19ck201 = 0 time = 2020
* CHECK dout0_20 vdout0_20ck201 = 0 time = 2020
* CHECK dout0_21 vdout0_21ck201 = 0 time = 2020
* CHECK dout0_22 vdout0_22ck201 = 1.8 time = 2020
* CHECK dout0_23 vdout0_23ck201 = 1.8 time = 2020
* CHECK dout0_24 vdout0_24ck201 = 0 time = 2020
* CHECK dout0_25 vdout0_25ck201 = 1.8 time = 2020
* CHECK dout0_26 vdout0_26ck201 = 0 time = 2020
* CHECK dout0_27 vdout0_27ck201 = 1.8 time = 2020
* CHECK dout0_28 vdout0_28ck201 = 0 time = 2020
* CHECK dout0_29 vdout0_29ck201 = 0 time = 2020
* CHECK dout0_30 vdout0_30ck201 = 0 time = 2020
* CHECK dout0_31 vdout0_31ck201 = 1.8 time = 2020
* CHECK dout0_32 vdout0_32ck201 = 0 time = 2020
.include /home/lukas/Projects/neorv32-openram-sky130/openram/spiral_min/out/sram_1rw_32x16/functional_meas.sp
* probe is used for hspice/xa, while plot is used in ngspice
.plot V(*)
.end
