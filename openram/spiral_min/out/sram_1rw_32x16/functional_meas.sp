.meas tran vdout0_0ck40 FIND v(dout0_0) AT=50.05n

.meas tran vdout0_1ck40 FIND v(dout0_1) AT=50.05n

.meas tran vdout0_2ck40 FIND v(dout0_2) AT=50.05n

.meas tran vdout0_3ck40 FIND v(dout0_3) AT=50.05n

.meas tran vdout0_4ck40 FIND v(dout0_4) AT=50.05n

.meas tran vdout0_5ck40 FIND v(dout0_5) AT=50.05n

.meas tran vdout0_6ck40 FIND v(dout0_6) AT=50.05n

.meas tran vdout0_7ck40 FIND v(dout0_7) AT=50.05n

.meas tran vdout0_8ck40 FIND v(dout0_8) AT=50.05n

.meas tran vdout0_9ck40 FIND v(dout0_9) AT=50.05n

.meas tran vdout0_10ck40 FIND v(dout0_10) AT=50.05n

.meas tran vdout0_11ck40 FIND v(dout0_11) AT=50.05n

.meas tran vdout0_12ck40 FIND v(dout0_12) AT=50.05n

.meas tran vdout0_13ck40 FIND v(dout0_13) AT=50.05n

.meas tran vdout0_14ck40 FIND v(dout0_14) AT=50.05n

.meas tran vdout0_15ck40 FIND v(dout0_15) AT=50.05n

.meas tran vdout0_16ck40 FIND v(dout0_16) AT=50.05n

.meas tran vdout0_17ck40 FIND v(dout0_17) AT=50.05n

.meas tran vdout0_18ck40 FIND v(dout0_18) AT=50.05n

.meas tran vdout0_19ck40 FIND v(dout0_19) AT=50.05n

.meas tran vdout0_20ck40 FIND v(dout0_20) AT=50.05n

.meas tran vdout0_21ck40 FIND v(dout0_21) AT=50.05n

.meas tran vdout0_22ck40 FIND v(dout0_22) AT=50.05n

.meas tran vdout0_23ck40 FIND v(dout0_23) AT=50.05n

.meas tran vdout0_24ck40 FIND v(dout0_24) AT=50.05n

.meas tran vdout0_25ck40 FIND v(dout0_25) AT=50.05n

.meas tran vdout0_26ck40 FIND v(dout0_26) AT=50.05n

.meas tran vdout0_27ck40 FIND v(dout0_27) AT=50.05n

.meas tran vdout0_28ck40 FIND v(dout0_28) AT=50.05n

.meas tran vdout0_29ck40 FIND v(dout0_29) AT=50.05n

.meas tran vdout0_30ck40 FIND v(dout0_30) AT=50.05n

.meas tran vdout0_31ck40 FIND v(dout0_31) AT=50.05n

.meas tran vdout0_32ck40 FIND v(dout0_32) AT=50.05n

.meas tran vdout0_0ck50 FIND v(dout0_0) AT=60.05n

.meas tran vdout0_1ck50 FIND v(dout0_1) AT=60.05n

.meas tran vdout0_2ck50 FIND v(dout0_2) AT=60.05n

.meas tran vdout0_3ck50 FIND v(dout0_3) AT=60.05n

.meas tran vdout0_4ck50 FIND v(dout0_4) AT=60.05n

.meas tran vdout0_5ck50 FIND v(dout0_5) AT=60.05n

.meas tran vdout0_6ck50 FIND v(dout0_6) AT=60.05n

.meas tran vdout0_7ck50 FIND v(dout0_7) AT=60.05n

.meas tran vdout0_8ck50 FIND v(dout0_8) AT=60.05n

.meas tran vdout0_9ck50 FIND v(dout0_9) AT=60.05n

.meas tran vdout0_10ck50 FIND v(dout0_10) AT=60.05n

.meas tran vdout0_11ck50 FIND v(dout0_11) AT=60.05n

.meas tran vdout0_12ck50 FIND v(dout0_12) AT=60.05n

.meas tran vdout0_13ck50 FIND v(dout0_13) AT=60.05n

.meas tran vdout0_14ck50 FIND v(dout0_14) AT=60.05n

.meas tran vdout0_15ck50 FIND v(dout0_15) AT=60.05n

.meas tran vdout0_16ck50 FIND v(dout0_16) AT=60.05n

.meas tran vdout0_17ck50 FIND v(dout0_17) AT=60.05n

.meas tran vdout0_18ck50 FIND v(dout0_18) AT=60.05n

.meas tran vdout0_19ck50 FIND v(dout0_19) AT=60.05n

.meas tran vdout0_20ck50 FIND v(dout0_20) AT=60.05n

.meas tran vdout0_21ck50 FIND v(dout0_21) AT=60.05n

.meas tran vdout0_22ck50 FIND v(dout0_22) AT=60.05n

.meas tran vdout0_23ck50 FIND v(dout0_23) AT=60.05n

.meas tran vdout0_24ck50 FIND v(dout0_24) AT=60.05n

.meas tran vdout0_25ck50 FIND v(dout0_25) AT=60.05n

.meas tran vdout0_26ck50 FIND v(dout0_26) AT=60.05n

.meas tran vdout0_27ck50 FIND v(dout0_27) AT=60.05n

.meas tran vdout0_28ck50 FIND v(dout0_28) AT=60.05n

.meas tran vdout0_29ck50 FIND v(dout0_29) AT=60.05n

.meas tran vdout0_30ck50 FIND v(dout0_30) AT=60.05n

.meas tran vdout0_31ck50 FIND v(dout0_31) AT=60.05n

.meas tran vdout0_32ck50 FIND v(dout0_32) AT=60.05n

.meas tran vdout0_0ck70 FIND v(dout0_0) AT=80.05n

.meas tran vdout0_1ck70 FIND v(dout0_1) AT=80.05n

.meas tran vdout0_2ck70 FIND v(dout0_2) AT=80.05n

.meas tran vdout0_3ck70 FIND v(dout0_3) AT=80.05n

.meas tran vdout0_4ck70 FIND v(dout0_4) AT=80.05n

.meas tran vdout0_5ck70 FIND v(dout0_5) AT=80.05n

.meas tran vdout0_6ck70 FIND v(dout0_6) AT=80.05n

.meas tran vdout0_7ck70 FIND v(dout0_7) AT=80.05n

.meas tran vdout0_8ck70 FIND v(dout0_8) AT=80.05n

.meas tran vdout0_9ck70 FIND v(dout0_9) AT=80.05n

.meas tran vdout0_10ck70 FIND v(dout0_10) AT=80.05n

.meas tran vdout0_11ck70 FIND v(dout0_11) AT=80.05n

.meas tran vdout0_12ck70 FIND v(dout0_12) AT=80.05n

.meas tran vdout0_13ck70 FIND v(dout0_13) AT=80.05n

.meas tran vdout0_14ck70 FIND v(dout0_14) AT=80.05n

.meas tran vdout0_15ck70 FIND v(dout0_15) AT=80.05n

.meas tran vdout0_16ck70 FIND v(dout0_16) AT=80.05n

.meas tran vdout0_17ck70 FIND v(dout0_17) AT=80.05n

.meas tran vdout0_18ck70 FIND v(dout0_18) AT=80.05n

.meas tran vdout0_19ck70 FIND v(dout0_19) AT=80.05n

.meas tran vdout0_20ck70 FIND v(dout0_20) AT=80.05n

.meas tran vdout0_21ck70 FIND v(dout0_21) AT=80.05n

.meas tran vdout0_22ck70 FIND v(dout0_22) AT=80.05n

.meas tran vdout0_23ck70 FIND v(dout0_23) AT=80.05n

.meas tran vdout0_24ck70 FIND v(dout0_24) AT=80.05n

.meas tran vdout0_25ck70 FIND v(dout0_25) AT=80.05n

.meas tran vdout0_26ck70 FIND v(dout0_26) AT=80.05n

.meas tran vdout0_27ck70 FIND v(dout0_27) AT=80.05n

.meas tran vdout0_28ck70 FIND v(dout0_28) AT=80.05n

.meas tran vdout0_29ck70 FIND v(dout0_29) AT=80.05n

.meas tran vdout0_30ck70 FIND v(dout0_30) AT=80.05n

.meas tran vdout0_31ck70 FIND v(dout0_31) AT=80.05n

.meas tran vdout0_32ck70 FIND v(dout0_32) AT=80.05n

.meas tran vdout0_0ck90 FIND v(dout0_0) AT=100.05n

.meas tran vdout0_1ck90 FIND v(dout0_1) AT=100.05n

.meas tran vdout0_2ck90 FIND v(dout0_2) AT=100.05n

.meas tran vdout0_3ck90 FIND v(dout0_3) AT=100.05n

.meas tran vdout0_4ck90 FIND v(dout0_4) AT=100.05n

.meas tran vdout0_5ck90 FIND v(dout0_5) AT=100.05n

.meas tran vdout0_6ck90 FIND v(dout0_6) AT=100.05n

.meas tran vdout0_7ck90 FIND v(dout0_7) AT=100.05n

.meas tran vdout0_8ck90 FIND v(dout0_8) AT=100.05n

.meas tran vdout0_9ck90 FIND v(dout0_9) AT=100.05n

.meas tran vdout0_10ck90 FIND v(dout0_10) AT=100.05n

.meas tran vdout0_11ck90 FIND v(dout0_11) AT=100.05n

.meas tran vdout0_12ck90 FIND v(dout0_12) AT=100.05n

.meas tran vdout0_13ck90 FIND v(dout0_13) AT=100.05n

.meas tran vdout0_14ck90 FIND v(dout0_14) AT=100.05n

.meas tran vdout0_15ck90 FIND v(dout0_15) AT=100.05n

.meas tran vdout0_16ck90 FIND v(dout0_16) AT=100.05n

.meas tran vdout0_17ck90 FIND v(dout0_17) AT=100.05n

.meas tran vdout0_18ck90 FIND v(dout0_18) AT=100.05n

.meas tran vdout0_19ck90 FIND v(dout0_19) AT=100.05n

.meas tran vdout0_20ck90 FIND v(dout0_20) AT=100.05n

.meas tran vdout0_21ck90 FIND v(dout0_21) AT=100.05n

.meas tran vdout0_22ck90 FIND v(dout0_22) AT=100.05n

.meas tran vdout0_23ck90 FIND v(dout0_23) AT=100.05n

.meas tran vdout0_24ck90 FIND v(dout0_24) AT=100.05n

.meas tran vdout0_25ck90 FIND v(dout0_25) AT=100.05n

.meas tran vdout0_26ck90 FIND v(dout0_26) AT=100.05n

.meas tran vdout0_27ck90 FIND v(dout0_27) AT=100.05n

.meas tran vdout0_28ck90 FIND v(dout0_28) AT=100.05n

.meas tran vdout0_29ck90 FIND v(dout0_29) AT=100.05n

.meas tran vdout0_30ck90 FIND v(dout0_30) AT=100.05n

.meas tran vdout0_31ck90 FIND v(dout0_31) AT=100.05n

.meas tran vdout0_32ck90 FIND v(dout0_32) AT=100.05n

.meas tran vdout0_0ck130 FIND v(dout0_0) AT=140.05n

.meas tran vdout0_1ck130 FIND v(dout0_1) AT=140.05n

.meas tran vdout0_2ck130 FIND v(dout0_2) AT=140.05n

.meas tran vdout0_3ck130 FIND v(dout0_3) AT=140.05n

.meas tran vdout0_4ck130 FIND v(dout0_4) AT=140.05n

.meas tran vdout0_5ck130 FIND v(dout0_5) AT=140.05n

.meas tran vdout0_6ck130 FIND v(dout0_6) AT=140.05n

.meas tran vdout0_7ck130 FIND v(dout0_7) AT=140.05n

.meas tran vdout0_8ck130 FIND v(dout0_8) AT=140.05n

.meas tran vdout0_9ck130 FIND v(dout0_9) AT=140.05n

.meas tran vdout0_10ck130 FIND v(dout0_10) AT=140.05n

.meas tran vdout0_11ck130 FIND v(dout0_11) AT=140.05n

.meas tran vdout0_12ck130 FIND v(dout0_12) AT=140.05n

.meas tran vdout0_13ck130 FIND v(dout0_13) AT=140.05n

.meas tran vdout0_14ck130 FIND v(dout0_14) AT=140.05n

.meas tran vdout0_15ck130 FIND v(dout0_15) AT=140.05n

.meas tran vdout0_16ck130 FIND v(dout0_16) AT=140.05n

.meas tran vdout0_17ck130 FIND v(dout0_17) AT=140.05n

.meas tran vdout0_18ck130 FIND v(dout0_18) AT=140.05n

.meas tran vdout0_19ck130 FIND v(dout0_19) AT=140.05n

.meas tran vdout0_20ck130 FIND v(dout0_20) AT=140.05n

.meas tran vdout0_21ck130 FIND v(dout0_21) AT=140.05n

.meas tran vdout0_22ck130 FIND v(dout0_22) AT=140.05n

.meas tran vdout0_23ck130 FIND v(dout0_23) AT=140.05n

.meas tran vdout0_24ck130 FIND v(dout0_24) AT=140.05n

.meas tran vdout0_25ck130 FIND v(dout0_25) AT=140.05n

.meas tran vdout0_26ck130 FIND v(dout0_26) AT=140.05n

.meas tran vdout0_27ck130 FIND v(dout0_27) AT=140.05n

.meas tran vdout0_28ck130 FIND v(dout0_28) AT=140.05n

.meas tran vdout0_29ck130 FIND v(dout0_29) AT=140.05n

.meas tran vdout0_30ck130 FIND v(dout0_30) AT=140.05n

.meas tran vdout0_31ck130 FIND v(dout0_31) AT=140.05n

.meas tran vdout0_32ck130 FIND v(dout0_32) AT=140.05n

.meas tran vdout0_0ck140 FIND v(dout0_0) AT=150.05n

.meas tran vdout0_1ck140 FIND v(dout0_1) AT=150.05n

.meas tran vdout0_2ck140 FIND v(dout0_2) AT=150.05n

.meas tran vdout0_3ck140 FIND v(dout0_3) AT=150.05n

.meas tran vdout0_4ck140 FIND v(dout0_4) AT=150.05n

.meas tran vdout0_5ck140 FIND v(dout0_5) AT=150.05n

.meas tran vdout0_6ck140 FIND v(dout0_6) AT=150.05n

.meas tran vdout0_7ck140 FIND v(dout0_7) AT=150.05n

.meas tran vdout0_8ck140 FIND v(dout0_8) AT=150.05n

.meas tran vdout0_9ck140 FIND v(dout0_9) AT=150.05n

.meas tran vdout0_10ck140 FIND v(dout0_10) AT=150.05n

.meas tran vdout0_11ck140 FIND v(dout0_11) AT=150.05n

.meas tran vdout0_12ck140 FIND v(dout0_12) AT=150.05n

.meas tran vdout0_13ck140 FIND v(dout0_13) AT=150.05n

.meas tran vdout0_14ck140 FIND v(dout0_14) AT=150.05n

.meas tran vdout0_15ck140 FIND v(dout0_15) AT=150.05n

.meas tran vdout0_16ck140 FIND v(dout0_16) AT=150.05n

.meas tran vdout0_17ck140 FIND v(dout0_17) AT=150.05n

.meas tran vdout0_18ck140 FIND v(dout0_18) AT=150.05n

.meas tran vdout0_19ck140 FIND v(dout0_19) AT=150.05n

.meas tran vdout0_20ck140 FIND v(dout0_20) AT=150.05n

.meas tran vdout0_21ck140 FIND v(dout0_21) AT=150.05n

.meas tran vdout0_22ck140 FIND v(dout0_22) AT=150.05n

.meas tran vdout0_23ck140 FIND v(dout0_23) AT=150.05n

.meas tran vdout0_24ck140 FIND v(dout0_24) AT=150.05n

.meas tran vdout0_25ck140 FIND v(dout0_25) AT=150.05n

.meas tran vdout0_26ck140 FIND v(dout0_26) AT=150.05n

.meas tran vdout0_27ck140 FIND v(dout0_27) AT=150.05n

.meas tran vdout0_28ck140 FIND v(dout0_28) AT=150.05n

.meas tran vdout0_29ck140 FIND v(dout0_29) AT=150.05n

.meas tran vdout0_30ck140 FIND v(dout0_30) AT=150.05n

.meas tran vdout0_31ck140 FIND v(dout0_31) AT=150.05n

.meas tran vdout0_32ck140 FIND v(dout0_32) AT=150.05n

.meas tran vdout0_0ck150 FIND v(dout0_0) AT=160.05n

.meas tran vdout0_1ck150 FIND v(dout0_1) AT=160.05n

.meas tran vdout0_2ck150 FIND v(dout0_2) AT=160.05n

.meas tran vdout0_3ck150 FIND v(dout0_3) AT=160.05n

.meas tran vdout0_4ck150 FIND v(dout0_4) AT=160.05n

.meas tran vdout0_5ck150 FIND v(dout0_5) AT=160.05n

.meas tran vdout0_6ck150 FIND v(dout0_6) AT=160.05n

.meas tran vdout0_7ck150 FIND v(dout0_7) AT=160.05n

.meas tran vdout0_8ck150 FIND v(dout0_8) AT=160.05n

.meas tran vdout0_9ck150 FIND v(dout0_9) AT=160.05n

.meas tran vdout0_10ck150 FIND v(dout0_10) AT=160.05n

.meas tran vdout0_11ck150 FIND v(dout0_11) AT=160.05n

.meas tran vdout0_12ck150 FIND v(dout0_12) AT=160.05n

.meas tran vdout0_13ck150 FIND v(dout0_13) AT=160.05n

.meas tran vdout0_14ck150 FIND v(dout0_14) AT=160.05n

.meas tran vdout0_15ck150 FIND v(dout0_15) AT=160.05n

.meas tran vdout0_16ck150 FIND v(dout0_16) AT=160.05n

.meas tran vdout0_17ck150 FIND v(dout0_17) AT=160.05n

.meas tran vdout0_18ck150 FIND v(dout0_18) AT=160.05n

.meas tran vdout0_19ck150 FIND v(dout0_19) AT=160.05n

.meas tran vdout0_20ck150 FIND v(dout0_20) AT=160.05n

.meas tran vdout0_21ck150 FIND v(dout0_21) AT=160.05n

.meas tran vdout0_22ck150 FIND v(dout0_22) AT=160.05n

.meas tran vdout0_23ck150 FIND v(dout0_23) AT=160.05n

.meas tran vdout0_24ck150 FIND v(dout0_24) AT=160.05n

.meas tran vdout0_25ck150 FIND v(dout0_25) AT=160.05n

.meas tran vdout0_26ck150 FIND v(dout0_26) AT=160.05n

.meas tran vdout0_27ck150 FIND v(dout0_27) AT=160.05n

.meas tran vdout0_28ck150 FIND v(dout0_28) AT=160.05n

.meas tran vdout0_29ck150 FIND v(dout0_29) AT=160.05n

.meas tran vdout0_30ck150 FIND v(dout0_30) AT=160.05n

.meas tran vdout0_31ck150 FIND v(dout0_31) AT=160.05n

.meas tran vdout0_32ck150 FIND v(dout0_32) AT=160.05n

.meas tran vdout0_0ck160 FIND v(dout0_0) AT=170.05n

.meas tran vdout0_1ck160 FIND v(dout0_1) AT=170.05n

.meas tran vdout0_2ck160 FIND v(dout0_2) AT=170.05n

.meas tran vdout0_3ck160 FIND v(dout0_3) AT=170.05n

.meas tran vdout0_4ck160 FIND v(dout0_4) AT=170.05n

.meas tran vdout0_5ck160 FIND v(dout0_5) AT=170.05n

.meas tran vdout0_6ck160 FIND v(dout0_6) AT=170.05n

.meas tran vdout0_7ck160 FIND v(dout0_7) AT=170.05n

.meas tran vdout0_8ck160 FIND v(dout0_8) AT=170.05n

.meas tran vdout0_9ck160 FIND v(dout0_9) AT=170.05n

.meas tran vdout0_10ck160 FIND v(dout0_10) AT=170.05n

.meas tran vdout0_11ck160 FIND v(dout0_11) AT=170.05n

.meas tran vdout0_12ck160 FIND v(dout0_12) AT=170.05n

.meas tran vdout0_13ck160 FIND v(dout0_13) AT=170.05n

.meas tran vdout0_14ck160 FIND v(dout0_14) AT=170.05n

.meas tran vdout0_15ck160 FIND v(dout0_15) AT=170.05n

.meas tran vdout0_16ck160 FIND v(dout0_16) AT=170.05n

.meas tran vdout0_17ck160 FIND v(dout0_17) AT=170.05n

.meas tran vdout0_18ck160 FIND v(dout0_18) AT=170.05n

.meas tran vdout0_19ck160 FIND v(dout0_19) AT=170.05n

.meas tran vdout0_20ck160 FIND v(dout0_20) AT=170.05n

.meas tran vdout0_21ck160 FIND v(dout0_21) AT=170.05n

.meas tran vdout0_22ck160 FIND v(dout0_22) AT=170.05n

.meas tran vdout0_23ck160 FIND v(dout0_23) AT=170.05n

.meas tran vdout0_24ck160 FIND v(dout0_24) AT=170.05n

.meas tran vdout0_25ck160 FIND v(dout0_25) AT=170.05n

.meas tran vdout0_26ck160 FIND v(dout0_26) AT=170.05n

.meas tran vdout0_27ck160 FIND v(dout0_27) AT=170.05n

.meas tran vdout0_28ck160 FIND v(dout0_28) AT=170.05n

.meas tran vdout0_29ck160 FIND v(dout0_29) AT=170.05n

.meas tran vdout0_30ck160 FIND v(dout0_30) AT=170.05n

.meas tran vdout0_31ck160 FIND v(dout0_31) AT=170.05n

.meas tran vdout0_32ck160 FIND v(dout0_32) AT=170.05n

.meas tran vdout0_0ck170 FIND v(dout0_0) AT=180.05n

.meas tran vdout0_1ck170 FIND v(dout0_1) AT=180.05n

.meas tran vdout0_2ck170 FIND v(dout0_2) AT=180.05n

.meas tran vdout0_3ck170 FIND v(dout0_3) AT=180.05n

.meas tran vdout0_4ck170 FIND v(dout0_4) AT=180.05n

.meas tran vdout0_5ck170 FIND v(dout0_5) AT=180.05n

.meas tran vdout0_6ck170 FIND v(dout0_6) AT=180.05n

.meas tran vdout0_7ck170 FIND v(dout0_7) AT=180.05n

.meas tran vdout0_8ck170 FIND v(dout0_8) AT=180.05n

.meas tran vdout0_9ck170 FIND v(dout0_9) AT=180.05n

.meas tran vdout0_10ck170 FIND v(dout0_10) AT=180.05n

.meas tran vdout0_11ck170 FIND v(dout0_11) AT=180.05n

.meas tran vdout0_12ck170 FIND v(dout0_12) AT=180.05n

.meas tran vdout0_13ck170 FIND v(dout0_13) AT=180.05n

.meas tran vdout0_14ck170 FIND v(dout0_14) AT=180.05n

.meas tran vdout0_15ck170 FIND v(dout0_15) AT=180.05n

.meas tran vdout0_16ck170 FIND v(dout0_16) AT=180.05n

.meas tran vdout0_17ck170 FIND v(dout0_17) AT=180.05n

.meas tran vdout0_18ck170 FIND v(dout0_18) AT=180.05n

.meas tran vdout0_19ck170 FIND v(dout0_19) AT=180.05n

.meas tran vdout0_20ck170 FIND v(dout0_20) AT=180.05n

.meas tran vdout0_21ck170 FIND v(dout0_21) AT=180.05n

.meas tran vdout0_22ck170 FIND v(dout0_22) AT=180.05n

.meas tran vdout0_23ck170 FIND v(dout0_23) AT=180.05n

.meas tran vdout0_24ck170 FIND v(dout0_24) AT=180.05n

.meas tran vdout0_25ck170 FIND v(dout0_25) AT=180.05n

.meas tran vdout0_26ck170 FIND v(dout0_26) AT=180.05n

.meas tran vdout0_27ck170 FIND v(dout0_27) AT=180.05n

.meas tran vdout0_28ck170 FIND v(dout0_28) AT=180.05n

.meas tran vdout0_29ck170 FIND v(dout0_29) AT=180.05n

.meas tran vdout0_30ck170 FIND v(dout0_30) AT=180.05n

.meas tran vdout0_31ck170 FIND v(dout0_31) AT=180.05n

.meas tran vdout0_32ck170 FIND v(dout0_32) AT=180.05n

.meas tran vdout0_0ck180 FIND v(dout0_0) AT=190.05n

.meas tran vdout0_1ck180 FIND v(dout0_1) AT=190.05n

.meas tran vdout0_2ck180 FIND v(dout0_2) AT=190.05n

.meas tran vdout0_3ck180 FIND v(dout0_3) AT=190.05n

.meas tran vdout0_4ck180 FIND v(dout0_4) AT=190.05n

.meas tran vdout0_5ck180 FIND v(dout0_5) AT=190.05n

.meas tran vdout0_6ck180 FIND v(dout0_6) AT=190.05n

.meas tran vdout0_7ck180 FIND v(dout0_7) AT=190.05n

.meas tran vdout0_8ck180 FIND v(dout0_8) AT=190.05n

.meas tran vdout0_9ck180 FIND v(dout0_9) AT=190.05n

.meas tran vdout0_10ck180 FIND v(dout0_10) AT=190.05n

.meas tran vdout0_11ck180 FIND v(dout0_11) AT=190.05n

.meas tran vdout0_12ck180 FIND v(dout0_12) AT=190.05n

.meas tran vdout0_13ck180 FIND v(dout0_13) AT=190.05n

.meas tran vdout0_14ck180 FIND v(dout0_14) AT=190.05n

.meas tran vdout0_15ck180 FIND v(dout0_15) AT=190.05n

.meas tran vdout0_16ck180 FIND v(dout0_16) AT=190.05n

.meas tran vdout0_17ck180 FIND v(dout0_17) AT=190.05n

.meas tran vdout0_18ck180 FIND v(dout0_18) AT=190.05n

.meas tran vdout0_19ck180 FIND v(dout0_19) AT=190.05n

.meas tran vdout0_20ck180 FIND v(dout0_20) AT=190.05n

.meas tran vdout0_21ck180 FIND v(dout0_21) AT=190.05n

.meas tran vdout0_22ck180 FIND v(dout0_22) AT=190.05n

.meas tran vdout0_23ck180 FIND v(dout0_23) AT=190.05n

.meas tran vdout0_24ck180 FIND v(dout0_24) AT=190.05n

.meas tran vdout0_25ck180 FIND v(dout0_25) AT=190.05n

.meas tran vdout0_26ck180 FIND v(dout0_26) AT=190.05n

.meas tran vdout0_27ck180 FIND v(dout0_27) AT=190.05n

.meas tran vdout0_28ck180 FIND v(dout0_28) AT=190.05n

.meas tran vdout0_29ck180 FIND v(dout0_29) AT=190.05n

.meas tran vdout0_30ck180 FIND v(dout0_30) AT=190.05n

.meas tran vdout0_31ck180 FIND v(dout0_31) AT=190.05n

.meas tran vdout0_32ck180 FIND v(dout0_32) AT=190.05n

.meas tran vdout0_0ck220 FIND v(dout0_0) AT=230.05n

.meas tran vdout0_1ck220 FIND v(dout0_1) AT=230.05n

.meas tran vdout0_2ck220 FIND v(dout0_2) AT=230.05n

.meas tran vdout0_3ck220 FIND v(dout0_3) AT=230.05n

.meas tran vdout0_4ck220 FIND v(dout0_4) AT=230.05n

.meas tran vdout0_5ck220 FIND v(dout0_5) AT=230.05n

.meas tran vdout0_6ck220 FIND v(dout0_6) AT=230.05n

.meas tran vdout0_7ck220 FIND v(dout0_7) AT=230.05n

.meas tran vdout0_8ck220 FIND v(dout0_8) AT=230.05n

.meas tran vdout0_9ck220 FIND v(dout0_9) AT=230.05n

.meas tran vdout0_10ck220 FIND v(dout0_10) AT=230.05n

.meas tran vdout0_11ck220 FIND v(dout0_11) AT=230.05n

.meas tran vdout0_12ck220 FIND v(dout0_12) AT=230.05n

.meas tran vdout0_13ck220 FIND v(dout0_13) AT=230.05n

.meas tran vdout0_14ck220 FIND v(dout0_14) AT=230.05n

.meas tran vdout0_15ck220 FIND v(dout0_15) AT=230.05n

.meas tran vdout0_16ck220 FIND v(dout0_16) AT=230.05n

.meas tran vdout0_17ck220 FIND v(dout0_17) AT=230.05n

.meas tran vdout0_18ck220 FIND v(dout0_18) AT=230.05n

.meas tran vdout0_19ck220 FIND v(dout0_19) AT=230.05n

.meas tran vdout0_20ck220 FIND v(dout0_20) AT=230.05n

.meas tran vdout0_21ck220 FIND v(dout0_21) AT=230.05n

.meas tran vdout0_22ck220 FIND v(dout0_22) AT=230.05n

.meas tran vdout0_23ck220 FIND v(dout0_23) AT=230.05n

.meas tran vdout0_24ck220 FIND v(dout0_24) AT=230.05n

.meas tran vdout0_25ck220 FIND v(dout0_25) AT=230.05n

.meas tran vdout0_26ck220 FIND v(dout0_26) AT=230.05n

.meas tran vdout0_27ck220 FIND v(dout0_27) AT=230.05n

.meas tran vdout0_28ck220 FIND v(dout0_28) AT=230.05n

.meas tran vdout0_29ck220 FIND v(dout0_29) AT=230.05n

.meas tran vdout0_30ck220 FIND v(dout0_30) AT=230.05n

.meas tran vdout0_31ck220 FIND v(dout0_31) AT=230.05n

.meas tran vdout0_32ck220 FIND v(dout0_32) AT=230.05n

.meas tran vdout0_0ck230 FIND v(dout0_0) AT=240.05n

.meas tran vdout0_1ck230 FIND v(dout0_1) AT=240.05n

.meas tran vdout0_2ck230 FIND v(dout0_2) AT=240.05n

.meas tran vdout0_3ck230 FIND v(dout0_3) AT=240.05n

.meas tran vdout0_4ck230 FIND v(dout0_4) AT=240.05n

.meas tran vdout0_5ck230 FIND v(dout0_5) AT=240.05n

.meas tran vdout0_6ck230 FIND v(dout0_6) AT=240.05n

.meas tran vdout0_7ck230 FIND v(dout0_7) AT=240.05n

.meas tran vdout0_8ck230 FIND v(dout0_8) AT=240.05n

.meas tran vdout0_9ck230 FIND v(dout0_9) AT=240.05n

.meas tran vdout0_10ck230 FIND v(dout0_10) AT=240.05n

.meas tran vdout0_11ck230 FIND v(dout0_11) AT=240.05n

.meas tran vdout0_12ck230 FIND v(dout0_12) AT=240.05n

.meas tran vdout0_13ck230 FIND v(dout0_13) AT=240.05n

.meas tran vdout0_14ck230 FIND v(dout0_14) AT=240.05n

.meas tran vdout0_15ck230 FIND v(dout0_15) AT=240.05n

.meas tran vdout0_16ck230 FIND v(dout0_16) AT=240.05n

.meas tran vdout0_17ck230 FIND v(dout0_17) AT=240.05n

.meas tran vdout0_18ck230 FIND v(dout0_18) AT=240.05n

.meas tran vdout0_19ck230 FIND v(dout0_19) AT=240.05n

.meas tran vdout0_20ck230 FIND v(dout0_20) AT=240.05n

.meas tran vdout0_21ck230 FIND v(dout0_21) AT=240.05n

.meas tran vdout0_22ck230 FIND v(dout0_22) AT=240.05n

.meas tran vdout0_23ck230 FIND v(dout0_23) AT=240.05n

.meas tran vdout0_24ck230 FIND v(dout0_24) AT=240.05n

.meas tran vdout0_25ck230 FIND v(dout0_25) AT=240.05n

.meas tran vdout0_26ck230 FIND v(dout0_26) AT=240.05n

.meas tran vdout0_27ck230 FIND v(dout0_27) AT=240.05n

.meas tran vdout0_28ck230 FIND v(dout0_28) AT=240.05n

.meas tran vdout0_29ck230 FIND v(dout0_29) AT=240.05n

.meas tran vdout0_30ck230 FIND v(dout0_30) AT=240.05n

.meas tran vdout0_31ck230 FIND v(dout0_31) AT=240.05n

.meas tran vdout0_32ck230 FIND v(dout0_32) AT=240.05n

.meas tran vdout0_0ck240 FIND v(dout0_0) AT=250.05n

.meas tran vdout0_1ck240 FIND v(dout0_1) AT=250.05n

.meas tran vdout0_2ck240 FIND v(dout0_2) AT=250.05n

.meas tran vdout0_3ck240 FIND v(dout0_3) AT=250.05n

.meas tran vdout0_4ck240 FIND v(dout0_4) AT=250.05n

.meas tran vdout0_5ck240 FIND v(dout0_5) AT=250.05n

.meas tran vdout0_6ck240 FIND v(dout0_6) AT=250.05n

.meas tran vdout0_7ck240 FIND v(dout0_7) AT=250.05n

.meas tran vdout0_8ck240 FIND v(dout0_8) AT=250.05n

.meas tran vdout0_9ck240 FIND v(dout0_9) AT=250.05n

.meas tran vdout0_10ck240 FIND v(dout0_10) AT=250.05n

.meas tran vdout0_11ck240 FIND v(dout0_11) AT=250.05n

.meas tran vdout0_12ck240 FIND v(dout0_12) AT=250.05n

.meas tran vdout0_13ck240 FIND v(dout0_13) AT=250.05n

.meas tran vdout0_14ck240 FIND v(dout0_14) AT=250.05n

.meas tran vdout0_15ck240 FIND v(dout0_15) AT=250.05n

.meas tran vdout0_16ck240 FIND v(dout0_16) AT=250.05n

.meas tran vdout0_17ck240 FIND v(dout0_17) AT=250.05n

.meas tran vdout0_18ck240 FIND v(dout0_18) AT=250.05n

.meas tran vdout0_19ck240 FIND v(dout0_19) AT=250.05n

.meas tran vdout0_20ck240 FIND v(dout0_20) AT=250.05n

.meas tran vdout0_21ck240 FIND v(dout0_21) AT=250.05n

.meas tran vdout0_22ck240 FIND v(dout0_22) AT=250.05n

.meas tran vdout0_23ck240 FIND v(dout0_23) AT=250.05n

.meas tran vdout0_24ck240 FIND v(dout0_24) AT=250.05n

.meas tran vdout0_25ck240 FIND v(dout0_25) AT=250.05n

.meas tran vdout0_26ck240 FIND v(dout0_26) AT=250.05n

.meas tran vdout0_27ck240 FIND v(dout0_27) AT=250.05n

.meas tran vdout0_28ck240 FIND v(dout0_28) AT=250.05n

.meas tran vdout0_29ck240 FIND v(dout0_29) AT=250.05n

.meas tran vdout0_30ck240 FIND v(dout0_30) AT=250.05n

.meas tran vdout0_31ck240 FIND v(dout0_31) AT=250.05n

.meas tran vdout0_32ck240 FIND v(dout0_32) AT=250.05n

.meas tran vdout0_0ck250 FIND v(dout0_0) AT=260.05n

.meas tran vdout0_1ck250 FIND v(dout0_1) AT=260.05n

.meas tran vdout0_2ck250 FIND v(dout0_2) AT=260.05n

.meas tran vdout0_3ck250 FIND v(dout0_3) AT=260.05n

.meas tran vdout0_4ck250 FIND v(dout0_4) AT=260.05n

.meas tran vdout0_5ck250 FIND v(dout0_5) AT=260.05n

.meas tran vdout0_6ck250 FIND v(dout0_6) AT=260.05n

.meas tran vdout0_7ck250 FIND v(dout0_7) AT=260.05n

.meas tran vdout0_8ck250 FIND v(dout0_8) AT=260.05n

.meas tran vdout0_9ck250 FIND v(dout0_9) AT=260.05n

.meas tran vdout0_10ck250 FIND v(dout0_10) AT=260.05n

.meas tran vdout0_11ck250 FIND v(dout0_11) AT=260.05n

.meas tran vdout0_12ck250 FIND v(dout0_12) AT=260.05n

.meas tran vdout0_13ck250 FIND v(dout0_13) AT=260.05n

.meas tran vdout0_14ck250 FIND v(dout0_14) AT=260.05n

.meas tran vdout0_15ck250 FIND v(dout0_15) AT=260.05n

.meas tran vdout0_16ck250 FIND v(dout0_16) AT=260.05n

.meas tran vdout0_17ck250 FIND v(dout0_17) AT=260.05n

.meas tran vdout0_18ck250 FIND v(dout0_18) AT=260.05n

.meas tran vdout0_19ck250 FIND v(dout0_19) AT=260.05n

.meas tran vdout0_20ck250 FIND v(dout0_20) AT=260.05n

.meas tran vdout0_21ck250 FIND v(dout0_21) AT=260.05n

.meas tran vdout0_22ck250 FIND v(dout0_22) AT=260.05n

.meas tran vdout0_23ck250 FIND v(dout0_23) AT=260.05n

.meas tran vdout0_24ck250 FIND v(dout0_24) AT=260.05n

.meas tran vdout0_25ck250 FIND v(dout0_25) AT=260.05n

.meas tran vdout0_26ck250 FIND v(dout0_26) AT=260.05n

.meas tran vdout0_27ck250 FIND v(dout0_27) AT=260.05n

.meas tran vdout0_28ck250 FIND v(dout0_28) AT=260.05n

.meas tran vdout0_29ck250 FIND v(dout0_29) AT=260.05n

.meas tran vdout0_30ck250 FIND v(dout0_30) AT=260.05n

.meas tran vdout0_31ck250 FIND v(dout0_31) AT=260.05n

.meas tran vdout0_32ck250 FIND v(dout0_32) AT=260.05n

.meas tran vdout0_0ck270 FIND v(dout0_0) AT=280.05n

.meas tran vdout0_1ck270 FIND v(dout0_1) AT=280.05n

.meas tran vdout0_2ck270 FIND v(dout0_2) AT=280.05n

.meas tran vdout0_3ck270 FIND v(dout0_3) AT=280.05n

.meas tran vdout0_4ck270 FIND v(dout0_4) AT=280.05n

.meas tran vdout0_5ck270 FIND v(dout0_5) AT=280.05n

.meas tran vdout0_6ck270 FIND v(dout0_6) AT=280.05n

.meas tran vdout0_7ck270 FIND v(dout0_7) AT=280.05n

.meas tran vdout0_8ck270 FIND v(dout0_8) AT=280.05n

.meas tran vdout0_9ck270 FIND v(dout0_9) AT=280.05n

.meas tran vdout0_10ck270 FIND v(dout0_10) AT=280.05n

.meas tran vdout0_11ck270 FIND v(dout0_11) AT=280.05n

.meas tran vdout0_12ck270 FIND v(dout0_12) AT=280.05n

.meas tran vdout0_13ck270 FIND v(dout0_13) AT=280.05n

.meas tran vdout0_14ck270 FIND v(dout0_14) AT=280.05n

.meas tran vdout0_15ck270 FIND v(dout0_15) AT=280.05n

.meas tran vdout0_16ck270 FIND v(dout0_16) AT=280.05n

.meas tran vdout0_17ck270 FIND v(dout0_17) AT=280.05n

.meas tran vdout0_18ck270 FIND v(dout0_18) AT=280.05n

.meas tran vdout0_19ck270 FIND v(dout0_19) AT=280.05n

.meas tran vdout0_20ck270 FIND v(dout0_20) AT=280.05n

.meas tran vdout0_21ck270 FIND v(dout0_21) AT=280.05n

.meas tran vdout0_22ck270 FIND v(dout0_22) AT=280.05n

.meas tran vdout0_23ck270 FIND v(dout0_23) AT=280.05n

.meas tran vdout0_24ck270 FIND v(dout0_24) AT=280.05n

.meas tran vdout0_25ck270 FIND v(dout0_25) AT=280.05n

.meas tran vdout0_26ck270 FIND v(dout0_26) AT=280.05n

.meas tran vdout0_27ck270 FIND v(dout0_27) AT=280.05n

.meas tran vdout0_28ck270 FIND v(dout0_28) AT=280.05n

.meas tran vdout0_29ck270 FIND v(dout0_29) AT=280.05n

.meas tran vdout0_30ck270 FIND v(dout0_30) AT=280.05n

.meas tran vdout0_31ck270 FIND v(dout0_31) AT=280.05n

.meas tran vdout0_32ck270 FIND v(dout0_32) AT=280.05n

.meas tran vdout0_0ck290 FIND v(dout0_0) AT=300.05n

.meas tran vdout0_1ck290 FIND v(dout0_1) AT=300.05n

.meas tran vdout0_2ck290 FIND v(dout0_2) AT=300.05n

.meas tran vdout0_3ck290 FIND v(dout0_3) AT=300.05n

.meas tran vdout0_4ck290 FIND v(dout0_4) AT=300.05n

.meas tran vdout0_5ck290 FIND v(dout0_5) AT=300.05n

.meas tran vdout0_6ck290 FIND v(dout0_6) AT=300.05n

.meas tran vdout0_7ck290 FIND v(dout0_7) AT=300.05n

.meas tran vdout0_8ck290 FIND v(dout0_8) AT=300.05n

.meas tran vdout0_9ck290 FIND v(dout0_9) AT=300.05n

.meas tran vdout0_10ck290 FIND v(dout0_10) AT=300.05n

.meas tran vdout0_11ck290 FIND v(dout0_11) AT=300.05n

.meas tran vdout0_12ck290 FIND v(dout0_12) AT=300.05n

.meas tran vdout0_13ck290 FIND v(dout0_13) AT=300.05n

.meas tran vdout0_14ck290 FIND v(dout0_14) AT=300.05n

.meas tran vdout0_15ck290 FIND v(dout0_15) AT=300.05n

.meas tran vdout0_16ck290 FIND v(dout0_16) AT=300.05n

.meas tran vdout0_17ck290 FIND v(dout0_17) AT=300.05n

.meas tran vdout0_18ck290 FIND v(dout0_18) AT=300.05n

.meas tran vdout0_19ck290 FIND v(dout0_19) AT=300.05n

.meas tran vdout0_20ck290 FIND v(dout0_20) AT=300.05n

.meas tran vdout0_21ck290 FIND v(dout0_21) AT=300.05n

.meas tran vdout0_22ck290 FIND v(dout0_22) AT=300.05n

.meas tran vdout0_23ck290 FIND v(dout0_23) AT=300.05n

.meas tran vdout0_24ck290 FIND v(dout0_24) AT=300.05n

.meas tran vdout0_25ck290 FIND v(dout0_25) AT=300.05n

.meas tran vdout0_26ck290 FIND v(dout0_26) AT=300.05n

.meas tran vdout0_27ck290 FIND v(dout0_27) AT=300.05n

.meas tran vdout0_28ck290 FIND v(dout0_28) AT=300.05n

.meas tran vdout0_29ck290 FIND v(dout0_29) AT=300.05n

.meas tran vdout0_30ck290 FIND v(dout0_30) AT=300.05n

.meas tran vdout0_31ck290 FIND v(dout0_31) AT=300.05n

.meas tran vdout0_32ck290 FIND v(dout0_32) AT=300.05n

.meas tran vdout0_0ck310 FIND v(dout0_0) AT=320.05n

.meas tran vdout0_1ck310 FIND v(dout0_1) AT=320.05n

.meas tran vdout0_2ck310 FIND v(dout0_2) AT=320.05n

.meas tran vdout0_3ck310 FIND v(dout0_3) AT=320.05n

.meas tran vdout0_4ck310 FIND v(dout0_4) AT=320.05n

.meas tran vdout0_5ck310 FIND v(dout0_5) AT=320.05n

.meas tran vdout0_6ck310 FIND v(dout0_6) AT=320.05n

.meas tran vdout0_7ck310 FIND v(dout0_7) AT=320.05n

.meas tran vdout0_8ck310 FIND v(dout0_8) AT=320.05n

.meas tran vdout0_9ck310 FIND v(dout0_9) AT=320.05n

.meas tran vdout0_10ck310 FIND v(dout0_10) AT=320.05n

.meas tran vdout0_11ck310 FIND v(dout0_11) AT=320.05n

.meas tran vdout0_12ck310 FIND v(dout0_12) AT=320.05n

.meas tran vdout0_13ck310 FIND v(dout0_13) AT=320.05n

.meas tran vdout0_14ck310 FIND v(dout0_14) AT=320.05n

.meas tran vdout0_15ck310 FIND v(dout0_15) AT=320.05n

.meas tran vdout0_16ck310 FIND v(dout0_16) AT=320.05n

.meas tran vdout0_17ck310 FIND v(dout0_17) AT=320.05n

.meas tran vdout0_18ck310 FIND v(dout0_18) AT=320.05n

.meas tran vdout0_19ck310 FIND v(dout0_19) AT=320.05n

.meas tran vdout0_20ck310 FIND v(dout0_20) AT=320.05n

.meas tran vdout0_21ck310 FIND v(dout0_21) AT=320.05n

.meas tran vdout0_22ck310 FIND v(dout0_22) AT=320.05n

.meas tran vdout0_23ck310 FIND v(dout0_23) AT=320.05n

.meas tran vdout0_24ck310 FIND v(dout0_24) AT=320.05n

.meas tran vdout0_25ck310 FIND v(dout0_25) AT=320.05n

.meas tran vdout0_26ck310 FIND v(dout0_26) AT=320.05n

.meas tran vdout0_27ck310 FIND v(dout0_27) AT=320.05n

.meas tran vdout0_28ck310 FIND v(dout0_28) AT=320.05n

.meas tran vdout0_29ck310 FIND v(dout0_29) AT=320.05n

.meas tran vdout0_30ck310 FIND v(dout0_30) AT=320.05n

.meas tran vdout0_31ck310 FIND v(dout0_31) AT=320.05n

.meas tran vdout0_32ck310 FIND v(dout0_32) AT=320.05n

.meas tran vdout0_0ck320 FIND v(dout0_0) AT=330.05n

.meas tran vdout0_1ck320 FIND v(dout0_1) AT=330.05n

.meas tran vdout0_2ck320 FIND v(dout0_2) AT=330.05n

.meas tran vdout0_3ck320 FIND v(dout0_3) AT=330.05n

.meas tran vdout0_4ck320 FIND v(dout0_4) AT=330.05n

.meas tran vdout0_5ck320 FIND v(dout0_5) AT=330.05n

.meas tran vdout0_6ck320 FIND v(dout0_6) AT=330.05n

.meas tran vdout0_7ck320 FIND v(dout0_7) AT=330.05n

.meas tran vdout0_8ck320 FIND v(dout0_8) AT=330.05n

.meas tran vdout0_9ck320 FIND v(dout0_9) AT=330.05n

.meas tran vdout0_10ck320 FIND v(dout0_10) AT=330.05n

.meas tran vdout0_11ck320 FIND v(dout0_11) AT=330.05n

.meas tran vdout0_12ck320 FIND v(dout0_12) AT=330.05n

.meas tran vdout0_13ck320 FIND v(dout0_13) AT=330.05n

.meas tran vdout0_14ck320 FIND v(dout0_14) AT=330.05n

.meas tran vdout0_15ck320 FIND v(dout0_15) AT=330.05n

.meas tran vdout0_16ck320 FIND v(dout0_16) AT=330.05n

.meas tran vdout0_17ck320 FIND v(dout0_17) AT=330.05n

.meas tran vdout0_18ck320 FIND v(dout0_18) AT=330.05n

.meas tran vdout0_19ck320 FIND v(dout0_19) AT=330.05n

.meas tran vdout0_20ck320 FIND v(dout0_20) AT=330.05n

.meas tran vdout0_21ck320 FIND v(dout0_21) AT=330.05n

.meas tran vdout0_22ck320 FIND v(dout0_22) AT=330.05n

.meas tran vdout0_23ck320 FIND v(dout0_23) AT=330.05n

.meas tran vdout0_24ck320 FIND v(dout0_24) AT=330.05n

.meas tran vdout0_25ck320 FIND v(dout0_25) AT=330.05n

.meas tran vdout0_26ck320 FIND v(dout0_26) AT=330.05n

.meas tran vdout0_27ck320 FIND v(dout0_27) AT=330.05n

.meas tran vdout0_28ck320 FIND v(dout0_28) AT=330.05n

.meas tran vdout0_29ck320 FIND v(dout0_29) AT=330.05n

.meas tran vdout0_30ck320 FIND v(dout0_30) AT=330.05n

.meas tran vdout0_31ck320 FIND v(dout0_31) AT=330.05n

.meas tran vdout0_32ck320 FIND v(dout0_32) AT=330.05n

.meas tran vdout0_0ck340 FIND v(dout0_0) AT=350.05n

.meas tran vdout0_1ck340 FIND v(dout0_1) AT=350.05n

.meas tran vdout0_2ck340 FIND v(dout0_2) AT=350.05n

.meas tran vdout0_3ck340 FIND v(dout0_3) AT=350.05n

.meas tran vdout0_4ck340 FIND v(dout0_4) AT=350.05n

.meas tran vdout0_5ck340 FIND v(dout0_5) AT=350.05n

.meas tran vdout0_6ck340 FIND v(dout0_6) AT=350.05n

.meas tran vdout0_7ck340 FIND v(dout0_7) AT=350.05n

.meas tran vdout0_8ck340 FIND v(dout0_8) AT=350.05n

.meas tran vdout0_9ck340 FIND v(dout0_9) AT=350.05n

.meas tran vdout0_10ck340 FIND v(dout0_10) AT=350.05n

.meas tran vdout0_11ck340 FIND v(dout0_11) AT=350.05n

.meas tran vdout0_12ck340 FIND v(dout0_12) AT=350.05n

.meas tran vdout0_13ck340 FIND v(dout0_13) AT=350.05n

.meas tran vdout0_14ck340 FIND v(dout0_14) AT=350.05n

.meas tran vdout0_15ck340 FIND v(dout0_15) AT=350.05n

.meas tran vdout0_16ck340 FIND v(dout0_16) AT=350.05n

.meas tran vdout0_17ck340 FIND v(dout0_17) AT=350.05n

.meas tran vdout0_18ck340 FIND v(dout0_18) AT=350.05n

.meas tran vdout0_19ck340 FIND v(dout0_19) AT=350.05n

.meas tran vdout0_20ck340 FIND v(dout0_20) AT=350.05n

.meas tran vdout0_21ck340 FIND v(dout0_21) AT=350.05n

.meas tran vdout0_22ck340 FIND v(dout0_22) AT=350.05n

.meas tran vdout0_23ck340 FIND v(dout0_23) AT=350.05n

.meas tran vdout0_24ck340 FIND v(dout0_24) AT=350.05n

.meas tran vdout0_25ck340 FIND v(dout0_25) AT=350.05n

.meas tran vdout0_26ck340 FIND v(dout0_26) AT=350.05n

.meas tran vdout0_27ck340 FIND v(dout0_27) AT=350.05n

.meas tran vdout0_28ck340 FIND v(dout0_28) AT=350.05n

.meas tran vdout0_29ck340 FIND v(dout0_29) AT=350.05n

.meas tran vdout0_30ck340 FIND v(dout0_30) AT=350.05n

.meas tran vdout0_31ck340 FIND v(dout0_31) AT=350.05n

.meas tran vdout0_32ck340 FIND v(dout0_32) AT=350.05n

.meas tran vdout0_0ck350 FIND v(dout0_0) AT=360.05n

.meas tran vdout0_1ck350 FIND v(dout0_1) AT=360.05n

.meas tran vdout0_2ck350 FIND v(dout0_2) AT=360.05n

.meas tran vdout0_3ck350 FIND v(dout0_3) AT=360.05n

.meas tran vdout0_4ck350 FIND v(dout0_4) AT=360.05n

.meas tran vdout0_5ck350 FIND v(dout0_5) AT=360.05n

.meas tran vdout0_6ck350 FIND v(dout0_6) AT=360.05n

.meas tran vdout0_7ck350 FIND v(dout0_7) AT=360.05n

.meas tran vdout0_8ck350 FIND v(dout0_8) AT=360.05n

.meas tran vdout0_9ck350 FIND v(dout0_9) AT=360.05n

.meas tran vdout0_10ck350 FIND v(dout0_10) AT=360.05n

.meas tran vdout0_11ck350 FIND v(dout0_11) AT=360.05n

.meas tran vdout0_12ck350 FIND v(dout0_12) AT=360.05n

.meas tran vdout0_13ck350 FIND v(dout0_13) AT=360.05n

.meas tran vdout0_14ck350 FIND v(dout0_14) AT=360.05n

.meas tran vdout0_15ck350 FIND v(dout0_15) AT=360.05n

.meas tran vdout0_16ck350 FIND v(dout0_16) AT=360.05n

.meas tran vdout0_17ck350 FIND v(dout0_17) AT=360.05n

.meas tran vdout0_18ck350 FIND v(dout0_18) AT=360.05n

.meas tran vdout0_19ck350 FIND v(dout0_19) AT=360.05n

.meas tran vdout0_20ck350 FIND v(dout0_20) AT=360.05n

.meas tran vdout0_21ck350 FIND v(dout0_21) AT=360.05n

.meas tran vdout0_22ck350 FIND v(dout0_22) AT=360.05n

.meas tran vdout0_23ck350 FIND v(dout0_23) AT=360.05n

.meas tran vdout0_24ck350 FIND v(dout0_24) AT=360.05n

.meas tran vdout0_25ck350 FIND v(dout0_25) AT=360.05n

.meas tran vdout0_26ck350 FIND v(dout0_26) AT=360.05n

.meas tran vdout0_27ck350 FIND v(dout0_27) AT=360.05n

.meas tran vdout0_28ck350 FIND v(dout0_28) AT=360.05n

.meas tran vdout0_29ck350 FIND v(dout0_29) AT=360.05n

.meas tran vdout0_30ck350 FIND v(dout0_30) AT=360.05n

.meas tran vdout0_31ck350 FIND v(dout0_31) AT=360.05n

.meas tran vdout0_32ck350 FIND v(dout0_32) AT=360.05n

.meas tran vdout0_0ck360 FIND v(dout0_0) AT=370.05n

.meas tran vdout0_1ck360 FIND v(dout0_1) AT=370.05n

.meas tran vdout0_2ck360 FIND v(dout0_2) AT=370.05n

.meas tran vdout0_3ck360 FIND v(dout0_3) AT=370.05n

.meas tran vdout0_4ck360 FIND v(dout0_4) AT=370.05n

.meas tran vdout0_5ck360 FIND v(dout0_5) AT=370.05n

.meas tran vdout0_6ck360 FIND v(dout0_6) AT=370.05n

.meas tran vdout0_7ck360 FIND v(dout0_7) AT=370.05n

.meas tran vdout0_8ck360 FIND v(dout0_8) AT=370.05n

.meas tran vdout0_9ck360 FIND v(dout0_9) AT=370.05n

.meas tran vdout0_10ck360 FIND v(dout0_10) AT=370.05n

.meas tran vdout0_11ck360 FIND v(dout0_11) AT=370.05n

.meas tran vdout0_12ck360 FIND v(dout0_12) AT=370.05n

.meas tran vdout0_13ck360 FIND v(dout0_13) AT=370.05n

.meas tran vdout0_14ck360 FIND v(dout0_14) AT=370.05n

.meas tran vdout0_15ck360 FIND v(dout0_15) AT=370.05n

.meas tran vdout0_16ck360 FIND v(dout0_16) AT=370.05n

.meas tran vdout0_17ck360 FIND v(dout0_17) AT=370.05n

.meas tran vdout0_18ck360 FIND v(dout0_18) AT=370.05n

.meas tran vdout0_19ck360 FIND v(dout0_19) AT=370.05n

.meas tran vdout0_20ck360 FIND v(dout0_20) AT=370.05n

.meas tran vdout0_21ck360 FIND v(dout0_21) AT=370.05n

.meas tran vdout0_22ck360 FIND v(dout0_22) AT=370.05n

.meas tran vdout0_23ck360 FIND v(dout0_23) AT=370.05n

.meas tran vdout0_24ck360 FIND v(dout0_24) AT=370.05n

.meas tran vdout0_25ck360 FIND v(dout0_25) AT=370.05n

.meas tran vdout0_26ck360 FIND v(dout0_26) AT=370.05n

.meas tran vdout0_27ck360 FIND v(dout0_27) AT=370.05n

.meas tran vdout0_28ck360 FIND v(dout0_28) AT=370.05n

.meas tran vdout0_29ck360 FIND v(dout0_29) AT=370.05n

.meas tran vdout0_30ck360 FIND v(dout0_30) AT=370.05n

.meas tran vdout0_31ck360 FIND v(dout0_31) AT=370.05n

.meas tran vdout0_32ck360 FIND v(dout0_32) AT=370.05n

.meas tran vdout0_0ck370 FIND v(dout0_0) AT=380.05n

.meas tran vdout0_1ck370 FIND v(dout0_1) AT=380.05n

.meas tran vdout0_2ck370 FIND v(dout0_2) AT=380.05n

.meas tran vdout0_3ck370 FIND v(dout0_3) AT=380.05n

.meas tran vdout0_4ck370 FIND v(dout0_4) AT=380.05n

.meas tran vdout0_5ck370 FIND v(dout0_5) AT=380.05n

.meas tran vdout0_6ck370 FIND v(dout0_6) AT=380.05n

.meas tran vdout0_7ck370 FIND v(dout0_7) AT=380.05n

.meas tran vdout0_8ck370 FIND v(dout0_8) AT=380.05n

.meas tran vdout0_9ck370 FIND v(dout0_9) AT=380.05n

.meas tran vdout0_10ck370 FIND v(dout0_10) AT=380.05n

.meas tran vdout0_11ck370 FIND v(dout0_11) AT=380.05n

.meas tran vdout0_12ck370 FIND v(dout0_12) AT=380.05n

.meas tran vdout0_13ck370 FIND v(dout0_13) AT=380.05n

.meas tran vdout0_14ck370 FIND v(dout0_14) AT=380.05n

.meas tran vdout0_15ck370 FIND v(dout0_15) AT=380.05n

.meas tran vdout0_16ck370 FIND v(dout0_16) AT=380.05n

.meas tran vdout0_17ck370 FIND v(dout0_17) AT=380.05n

.meas tran vdout0_18ck370 FIND v(dout0_18) AT=380.05n

.meas tran vdout0_19ck370 FIND v(dout0_19) AT=380.05n

.meas tran vdout0_20ck370 FIND v(dout0_20) AT=380.05n

.meas tran vdout0_21ck370 FIND v(dout0_21) AT=380.05n

.meas tran vdout0_22ck370 FIND v(dout0_22) AT=380.05n

.meas tran vdout0_23ck370 FIND v(dout0_23) AT=380.05n

.meas tran vdout0_24ck370 FIND v(dout0_24) AT=380.05n

.meas tran vdout0_25ck370 FIND v(dout0_25) AT=380.05n

.meas tran vdout0_26ck370 FIND v(dout0_26) AT=380.05n

.meas tran vdout0_27ck370 FIND v(dout0_27) AT=380.05n

.meas tran vdout0_28ck370 FIND v(dout0_28) AT=380.05n

.meas tran vdout0_29ck370 FIND v(dout0_29) AT=380.05n

.meas tran vdout0_30ck370 FIND v(dout0_30) AT=380.05n

.meas tran vdout0_31ck370 FIND v(dout0_31) AT=380.05n

.meas tran vdout0_32ck370 FIND v(dout0_32) AT=380.05n

.meas tran vdout0_0ck380 FIND v(dout0_0) AT=390.05n

.meas tran vdout0_1ck380 FIND v(dout0_1) AT=390.05n

.meas tran vdout0_2ck380 FIND v(dout0_2) AT=390.05n

.meas tran vdout0_3ck380 FIND v(dout0_3) AT=390.05n

.meas tran vdout0_4ck380 FIND v(dout0_4) AT=390.05n

.meas tran vdout0_5ck380 FIND v(dout0_5) AT=390.05n

.meas tran vdout0_6ck380 FIND v(dout0_6) AT=390.05n

.meas tran vdout0_7ck380 FIND v(dout0_7) AT=390.05n

.meas tran vdout0_8ck380 FIND v(dout0_8) AT=390.05n

.meas tran vdout0_9ck380 FIND v(dout0_9) AT=390.05n

.meas tran vdout0_10ck380 FIND v(dout0_10) AT=390.05n

.meas tran vdout0_11ck380 FIND v(dout0_11) AT=390.05n

.meas tran vdout0_12ck380 FIND v(dout0_12) AT=390.05n

.meas tran vdout0_13ck380 FIND v(dout0_13) AT=390.05n

.meas tran vdout0_14ck380 FIND v(dout0_14) AT=390.05n

.meas tran vdout0_15ck380 FIND v(dout0_15) AT=390.05n

.meas tran vdout0_16ck380 FIND v(dout0_16) AT=390.05n

.meas tran vdout0_17ck380 FIND v(dout0_17) AT=390.05n

.meas tran vdout0_18ck380 FIND v(dout0_18) AT=390.05n

.meas tran vdout0_19ck380 FIND v(dout0_19) AT=390.05n

.meas tran vdout0_20ck380 FIND v(dout0_20) AT=390.05n

.meas tran vdout0_21ck380 FIND v(dout0_21) AT=390.05n

.meas tran vdout0_22ck380 FIND v(dout0_22) AT=390.05n

.meas tran vdout0_23ck380 FIND v(dout0_23) AT=390.05n

.meas tran vdout0_24ck380 FIND v(dout0_24) AT=390.05n

.meas tran vdout0_25ck380 FIND v(dout0_25) AT=390.05n

.meas tran vdout0_26ck380 FIND v(dout0_26) AT=390.05n

.meas tran vdout0_27ck380 FIND v(dout0_27) AT=390.05n

.meas tran vdout0_28ck380 FIND v(dout0_28) AT=390.05n

.meas tran vdout0_29ck380 FIND v(dout0_29) AT=390.05n

.meas tran vdout0_30ck380 FIND v(dout0_30) AT=390.05n

.meas tran vdout0_31ck380 FIND v(dout0_31) AT=390.05n

.meas tran vdout0_32ck380 FIND v(dout0_32) AT=390.05n

.meas tran vdout0_0ck410 FIND v(dout0_0) AT=420.05n

.meas tran vdout0_1ck410 FIND v(dout0_1) AT=420.05n

.meas tran vdout0_2ck410 FIND v(dout0_2) AT=420.05n

.meas tran vdout0_3ck410 FIND v(dout0_3) AT=420.05n

.meas tran vdout0_4ck410 FIND v(dout0_4) AT=420.05n

.meas tran vdout0_5ck410 FIND v(dout0_5) AT=420.05n

.meas tran vdout0_6ck410 FIND v(dout0_6) AT=420.05n

.meas tran vdout0_7ck410 FIND v(dout0_7) AT=420.05n

.meas tran vdout0_8ck410 FIND v(dout0_8) AT=420.05n

.meas tran vdout0_9ck410 FIND v(dout0_9) AT=420.05n

.meas tran vdout0_10ck410 FIND v(dout0_10) AT=420.05n

.meas tran vdout0_11ck410 FIND v(dout0_11) AT=420.05n

.meas tran vdout0_12ck410 FIND v(dout0_12) AT=420.05n

.meas tran vdout0_13ck410 FIND v(dout0_13) AT=420.05n

.meas tran vdout0_14ck410 FIND v(dout0_14) AT=420.05n

.meas tran vdout0_15ck410 FIND v(dout0_15) AT=420.05n

.meas tran vdout0_16ck410 FIND v(dout0_16) AT=420.05n

.meas tran vdout0_17ck410 FIND v(dout0_17) AT=420.05n

.meas tran vdout0_18ck410 FIND v(dout0_18) AT=420.05n

.meas tran vdout0_19ck410 FIND v(dout0_19) AT=420.05n

.meas tran vdout0_20ck410 FIND v(dout0_20) AT=420.05n

.meas tran vdout0_21ck410 FIND v(dout0_21) AT=420.05n

.meas tran vdout0_22ck410 FIND v(dout0_22) AT=420.05n

.meas tran vdout0_23ck410 FIND v(dout0_23) AT=420.05n

.meas tran vdout0_24ck410 FIND v(dout0_24) AT=420.05n

.meas tran vdout0_25ck410 FIND v(dout0_25) AT=420.05n

.meas tran vdout0_26ck410 FIND v(dout0_26) AT=420.05n

.meas tran vdout0_27ck410 FIND v(dout0_27) AT=420.05n

.meas tran vdout0_28ck410 FIND v(dout0_28) AT=420.05n

.meas tran vdout0_29ck410 FIND v(dout0_29) AT=420.05n

.meas tran vdout0_30ck410 FIND v(dout0_30) AT=420.05n

.meas tran vdout0_31ck410 FIND v(dout0_31) AT=420.05n

.meas tran vdout0_32ck410 FIND v(dout0_32) AT=420.05n

.meas tran vdout0_0ck430 FIND v(dout0_0) AT=440.05n

.meas tran vdout0_1ck430 FIND v(dout0_1) AT=440.05n

.meas tran vdout0_2ck430 FIND v(dout0_2) AT=440.05n

.meas tran vdout0_3ck430 FIND v(dout0_3) AT=440.05n

.meas tran vdout0_4ck430 FIND v(dout0_4) AT=440.05n

.meas tran vdout0_5ck430 FIND v(dout0_5) AT=440.05n

.meas tran vdout0_6ck430 FIND v(dout0_6) AT=440.05n

.meas tran vdout0_7ck430 FIND v(dout0_7) AT=440.05n

.meas tran vdout0_8ck430 FIND v(dout0_8) AT=440.05n

.meas tran vdout0_9ck430 FIND v(dout0_9) AT=440.05n

.meas tran vdout0_10ck430 FIND v(dout0_10) AT=440.05n

.meas tran vdout0_11ck430 FIND v(dout0_11) AT=440.05n

.meas tran vdout0_12ck430 FIND v(dout0_12) AT=440.05n

.meas tran vdout0_13ck430 FIND v(dout0_13) AT=440.05n

.meas tran vdout0_14ck430 FIND v(dout0_14) AT=440.05n

.meas tran vdout0_15ck430 FIND v(dout0_15) AT=440.05n

.meas tran vdout0_16ck430 FIND v(dout0_16) AT=440.05n

.meas tran vdout0_17ck430 FIND v(dout0_17) AT=440.05n

.meas tran vdout0_18ck430 FIND v(dout0_18) AT=440.05n

.meas tran vdout0_19ck430 FIND v(dout0_19) AT=440.05n

.meas tran vdout0_20ck430 FIND v(dout0_20) AT=440.05n

.meas tran vdout0_21ck430 FIND v(dout0_21) AT=440.05n

.meas tran vdout0_22ck430 FIND v(dout0_22) AT=440.05n

.meas tran vdout0_23ck430 FIND v(dout0_23) AT=440.05n

.meas tran vdout0_24ck430 FIND v(dout0_24) AT=440.05n

.meas tran vdout0_25ck430 FIND v(dout0_25) AT=440.05n

.meas tran vdout0_26ck430 FIND v(dout0_26) AT=440.05n

.meas tran vdout0_27ck430 FIND v(dout0_27) AT=440.05n

.meas tran vdout0_28ck430 FIND v(dout0_28) AT=440.05n

.meas tran vdout0_29ck430 FIND v(dout0_29) AT=440.05n

.meas tran vdout0_30ck430 FIND v(dout0_30) AT=440.05n

.meas tran vdout0_31ck430 FIND v(dout0_31) AT=440.05n

.meas tran vdout0_32ck430 FIND v(dout0_32) AT=440.05n

.meas tran vdout0_0ck440 FIND v(dout0_0) AT=450.05n

.meas tran vdout0_1ck440 FIND v(dout0_1) AT=450.05n

.meas tran vdout0_2ck440 FIND v(dout0_2) AT=450.05n

.meas tran vdout0_3ck440 FIND v(dout0_3) AT=450.05n

.meas tran vdout0_4ck440 FIND v(dout0_4) AT=450.05n

.meas tran vdout0_5ck440 FIND v(dout0_5) AT=450.05n

.meas tran vdout0_6ck440 FIND v(dout0_6) AT=450.05n

.meas tran vdout0_7ck440 FIND v(dout0_7) AT=450.05n

.meas tran vdout0_8ck440 FIND v(dout0_8) AT=450.05n

.meas tran vdout0_9ck440 FIND v(dout0_9) AT=450.05n

.meas tran vdout0_10ck440 FIND v(dout0_10) AT=450.05n

.meas tran vdout0_11ck440 FIND v(dout0_11) AT=450.05n

.meas tran vdout0_12ck440 FIND v(dout0_12) AT=450.05n

.meas tran vdout0_13ck440 FIND v(dout0_13) AT=450.05n

.meas tran vdout0_14ck440 FIND v(dout0_14) AT=450.05n

.meas tran vdout0_15ck440 FIND v(dout0_15) AT=450.05n

.meas tran vdout0_16ck440 FIND v(dout0_16) AT=450.05n

.meas tran vdout0_17ck440 FIND v(dout0_17) AT=450.05n

.meas tran vdout0_18ck440 FIND v(dout0_18) AT=450.05n

.meas tran vdout0_19ck440 FIND v(dout0_19) AT=450.05n

.meas tran vdout0_20ck440 FIND v(dout0_20) AT=450.05n

.meas tran vdout0_21ck440 FIND v(dout0_21) AT=450.05n

.meas tran vdout0_22ck440 FIND v(dout0_22) AT=450.05n

.meas tran vdout0_23ck440 FIND v(dout0_23) AT=450.05n

.meas tran vdout0_24ck440 FIND v(dout0_24) AT=450.05n

.meas tran vdout0_25ck440 FIND v(dout0_25) AT=450.05n

.meas tran vdout0_26ck440 FIND v(dout0_26) AT=450.05n

.meas tran vdout0_27ck440 FIND v(dout0_27) AT=450.05n

.meas tran vdout0_28ck440 FIND v(dout0_28) AT=450.05n

.meas tran vdout0_29ck440 FIND v(dout0_29) AT=450.05n

.meas tran vdout0_30ck440 FIND v(dout0_30) AT=450.05n

.meas tran vdout0_31ck440 FIND v(dout0_31) AT=450.05n

.meas tran vdout0_32ck440 FIND v(dout0_32) AT=450.05n

.meas tran vdout0_0ck480 FIND v(dout0_0) AT=490.05n

.meas tran vdout0_1ck480 FIND v(dout0_1) AT=490.05n

.meas tran vdout0_2ck480 FIND v(dout0_2) AT=490.05n

.meas tran vdout0_3ck480 FIND v(dout0_3) AT=490.05n

.meas tran vdout0_4ck480 FIND v(dout0_4) AT=490.05n

.meas tran vdout0_5ck480 FIND v(dout0_5) AT=490.05n

.meas tran vdout0_6ck480 FIND v(dout0_6) AT=490.05n

.meas tran vdout0_7ck480 FIND v(dout0_7) AT=490.05n

.meas tran vdout0_8ck480 FIND v(dout0_8) AT=490.05n

.meas tran vdout0_9ck480 FIND v(dout0_9) AT=490.05n

.meas tran vdout0_10ck480 FIND v(dout0_10) AT=490.05n

.meas tran vdout0_11ck480 FIND v(dout0_11) AT=490.05n

.meas tran vdout0_12ck480 FIND v(dout0_12) AT=490.05n

.meas tran vdout0_13ck480 FIND v(dout0_13) AT=490.05n

.meas tran vdout0_14ck480 FIND v(dout0_14) AT=490.05n

.meas tran vdout0_15ck480 FIND v(dout0_15) AT=490.05n

.meas tran vdout0_16ck480 FIND v(dout0_16) AT=490.05n

.meas tran vdout0_17ck480 FIND v(dout0_17) AT=490.05n

.meas tran vdout0_18ck480 FIND v(dout0_18) AT=490.05n

.meas tran vdout0_19ck480 FIND v(dout0_19) AT=490.05n

.meas tran vdout0_20ck480 FIND v(dout0_20) AT=490.05n

.meas tran vdout0_21ck480 FIND v(dout0_21) AT=490.05n

.meas tran vdout0_22ck480 FIND v(dout0_22) AT=490.05n

.meas tran vdout0_23ck480 FIND v(dout0_23) AT=490.05n

.meas tran vdout0_24ck480 FIND v(dout0_24) AT=490.05n

.meas tran vdout0_25ck480 FIND v(dout0_25) AT=490.05n

.meas tran vdout0_26ck480 FIND v(dout0_26) AT=490.05n

.meas tran vdout0_27ck480 FIND v(dout0_27) AT=490.05n

.meas tran vdout0_28ck480 FIND v(dout0_28) AT=490.05n

.meas tran vdout0_29ck480 FIND v(dout0_29) AT=490.05n

.meas tran vdout0_30ck480 FIND v(dout0_30) AT=490.05n

.meas tran vdout0_31ck480 FIND v(dout0_31) AT=490.05n

.meas tran vdout0_32ck480 FIND v(dout0_32) AT=490.05n

.meas tran vdout0_0ck490 FIND v(dout0_0) AT=500.05n

.meas tran vdout0_1ck490 FIND v(dout0_1) AT=500.05n

.meas tran vdout0_2ck490 FIND v(dout0_2) AT=500.05n

.meas tran vdout0_3ck490 FIND v(dout0_3) AT=500.05n

.meas tran vdout0_4ck490 FIND v(dout0_4) AT=500.05n

.meas tran vdout0_5ck490 FIND v(dout0_5) AT=500.05n

.meas tran vdout0_6ck490 FIND v(dout0_6) AT=500.05n

.meas tran vdout0_7ck490 FIND v(dout0_7) AT=500.05n

.meas tran vdout0_8ck490 FIND v(dout0_8) AT=500.05n

.meas tran vdout0_9ck490 FIND v(dout0_9) AT=500.05n

.meas tran vdout0_10ck490 FIND v(dout0_10) AT=500.05n

.meas tran vdout0_11ck490 FIND v(dout0_11) AT=500.05n

.meas tran vdout0_12ck490 FIND v(dout0_12) AT=500.05n

.meas tran vdout0_13ck490 FIND v(dout0_13) AT=500.05n

.meas tran vdout0_14ck490 FIND v(dout0_14) AT=500.05n

.meas tran vdout0_15ck490 FIND v(dout0_15) AT=500.05n

.meas tran vdout0_16ck490 FIND v(dout0_16) AT=500.05n

.meas tran vdout0_17ck490 FIND v(dout0_17) AT=500.05n

.meas tran vdout0_18ck490 FIND v(dout0_18) AT=500.05n

.meas tran vdout0_19ck490 FIND v(dout0_19) AT=500.05n

.meas tran vdout0_20ck490 FIND v(dout0_20) AT=500.05n

.meas tran vdout0_21ck490 FIND v(dout0_21) AT=500.05n

.meas tran vdout0_22ck490 FIND v(dout0_22) AT=500.05n

.meas tran vdout0_23ck490 FIND v(dout0_23) AT=500.05n

.meas tran vdout0_24ck490 FIND v(dout0_24) AT=500.05n

.meas tran vdout0_25ck490 FIND v(dout0_25) AT=500.05n

.meas tran vdout0_26ck490 FIND v(dout0_26) AT=500.05n

.meas tran vdout0_27ck490 FIND v(dout0_27) AT=500.05n

.meas tran vdout0_28ck490 FIND v(dout0_28) AT=500.05n

.meas tran vdout0_29ck490 FIND v(dout0_29) AT=500.05n

.meas tran vdout0_30ck490 FIND v(dout0_30) AT=500.05n

.meas tran vdout0_31ck490 FIND v(dout0_31) AT=500.05n

.meas tran vdout0_32ck490 FIND v(dout0_32) AT=500.05n

.meas tran vdout0_0ck510 FIND v(dout0_0) AT=520.05n

.meas tran vdout0_1ck510 FIND v(dout0_1) AT=520.05n

.meas tran vdout0_2ck510 FIND v(dout0_2) AT=520.05n

.meas tran vdout0_3ck510 FIND v(dout0_3) AT=520.05n

.meas tran vdout0_4ck510 FIND v(dout0_4) AT=520.05n

.meas tran vdout0_5ck510 FIND v(dout0_5) AT=520.05n

.meas tran vdout0_6ck510 FIND v(dout0_6) AT=520.05n

.meas tran vdout0_7ck510 FIND v(dout0_7) AT=520.05n

.meas tran vdout0_8ck510 FIND v(dout0_8) AT=520.05n

.meas tran vdout0_9ck510 FIND v(dout0_9) AT=520.05n

.meas tran vdout0_10ck510 FIND v(dout0_10) AT=520.05n

.meas tran vdout0_11ck510 FIND v(dout0_11) AT=520.05n

.meas tran vdout0_12ck510 FIND v(dout0_12) AT=520.05n

.meas tran vdout0_13ck510 FIND v(dout0_13) AT=520.05n

.meas tran vdout0_14ck510 FIND v(dout0_14) AT=520.05n

.meas tran vdout0_15ck510 FIND v(dout0_15) AT=520.05n

.meas tran vdout0_16ck510 FIND v(dout0_16) AT=520.05n

.meas tran vdout0_17ck510 FIND v(dout0_17) AT=520.05n

.meas tran vdout0_18ck510 FIND v(dout0_18) AT=520.05n

.meas tran vdout0_19ck510 FIND v(dout0_19) AT=520.05n

.meas tran vdout0_20ck510 FIND v(dout0_20) AT=520.05n

.meas tran vdout0_21ck510 FIND v(dout0_21) AT=520.05n

.meas tran vdout0_22ck510 FIND v(dout0_22) AT=520.05n

.meas tran vdout0_23ck510 FIND v(dout0_23) AT=520.05n

.meas tran vdout0_24ck510 FIND v(dout0_24) AT=520.05n

.meas tran vdout0_25ck510 FIND v(dout0_25) AT=520.05n

.meas tran vdout0_26ck510 FIND v(dout0_26) AT=520.05n

.meas tran vdout0_27ck510 FIND v(dout0_27) AT=520.05n

.meas tran vdout0_28ck510 FIND v(dout0_28) AT=520.05n

.meas tran vdout0_29ck510 FIND v(dout0_29) AT=520.05n

.meas tran vdout0_30ck510 FIND v(dout0_30) AT=520.05n

.meas tran vdout0_31ck510 FIND v(dout0_31) AT=520.05n

.meas tran vdout0_32ck510 FIND v(dout0_32) AT=520.05n

.meas tran vdout0_0ck520 FIND v(dout0_0) AT=530.05n

.meas tran vdout0_1ck520 FIND v(dout0_1) AT=530.05n

.meas tran vdout0_2ck520 FIND v(dout0_2) AT=530.05n

.meas tran vdout0_3ck520 FIND v(dout0_3) AT=530.05n

.meas tran vdout0_4ck520 FIND v(dout0_4) AT=530.05n

.meas tran vdout0_5ck520 FIND v(dout0_5) AT=530.05n

.meas tran vdout0_6ck520 FIND v(dout0_6) AT=530.05n

.meas tran vdout0_7ck520 FIND v(dout0_7) AT=530.05n

.meas tran vdout0_8ck520 FIND v(dout0_8) AT=530.05n

.meas tran vdout0_9ck520 FIND v(dout0_9) AT=530.05n

.meas tran vdout0_10ck520 FIND v(dout0_10) AT=530.05n

.meas tran vdout0_11ck520 FIND v(dout0_11) AT=530.05n

.meas tran vdout0_12ck520 FIND v(dout0_12) AT=530.05n

.meas tran vdout0_13ck520 FIND v(dout0_13) AT=530.05n

.meas tran vdout0_14ck520 FIND v(dout0_14) AT=530.05n

.meas tran vdout0_15ck520 FIND v(dout0_15) AT=530.05n

.meas tran vdout0_16ck520 FIND v(dout0_16) AT=530.05n

.meas tran vdout0_17ck520 FIND v(dout0_17) AT=530.05n

.meas tran vdout0_18ck520 FIND v(dout0_18) AT=530.05n

.meas tran vdout0_19ck520 FIND v(dout0_19) AT=530.05n

.meas tran vdout0_20ck520 FIND v(dout0_20) AT=530.05n

.meas tran vdout0_21ck520 FIND v(dout0_21) AT=530.05n

.meas tran vdout0_22ck520 FIND v(dout0_22) AT=530.05n

.meas tran vdout0_23ck520 FIND v(dout0_23) AT=530.05n

.meas tran vdout0_24ck520 FIND v(dout0_24) AT=530.05n

.meas tran vdout0_25ck520 FIND v(dout0_25) AT=530.05n

.meas tran vdout0_26ck520 FIND v(dout0_26) AT=530.05n

.meas tran vdout0_27ck520 FIND v(dout0_27) AT=530.05n

.meas tran vdout0_28ck520 FIND v(dout0_28) AT=530.05n

.meas tran vdout0_29ck520 FIND v(dout0_29) AT=530.05n

.meas tran vdout0_30ck520 FIND v(dout0_30) AT=530.05n

.meas tran vdout0_31ck520 FIND v(dout0_31) AT=530.05n

.meas tran vdout0_32ck520 FIND v(dout0_32) AT=530.05n

.meas tran vdout0_0ck530 FIND v(dout0_0) AT=540.05n

.meas tran vdout0_1ck530 FIND v(dout0_1) AT=540.05n

.meas tran vdout0_2ck530 FIND v(dout0_2) AT=540.05n

.meas tran vdout0_3ck530 FIND v(dout0_3) AT=540.05n

.meas tran vdout0_4ck530 FIND v(dout0_4) AT=540.05n

.meas tran vdout0_5ck530 FIND v(dout0_5) AT=540.05n

.meas tran vdout0_6ck530 FIND v(dout0_6) AT=540.05n

.meas tran vdout0_7ck530 FIND v(dout0_7) AT=540.05n

.meas tran vdout0_8ck530 FIND v(dout0_8) AT=540.05n

.meas tran vdout0_9ck530 FIND v(dout0_9) AT=540.05n

.meas tran vdout0_10ck530 FIND v(dout0_10) AT=540.05n

.meas tran vdout0_11ck530 FIND v(dout0_11) AT=540.05n

.meas tran vdout0_12ck530 FIND v(dout0_12) AT=540.05n

.meas tran vdout0_13ck530 FIND v(dout0_13) AT=540.05n

.meas tran vdout0_14ck530 FIND v(dout0_14) AT=540.05n

.meas tran vdout0_15ck530 FIND v(dout0_15) AT=540.05n

.meas tran vdout0_16ck530 FIND v(dout0_16) AT=540.05n

.meas tran vdout0_17ck530 FIND v(dout0_17) AT=540.05n

.meas tran vdout0_18ck530 FIND v(dout0_18) AT=540.05n

.meas tran vdout0_19ck530 FIND v(dout0_19) AT=540.05n

.meas tran vdout0_20ck530 FIND v(dout0_20) AT=540.05n

.meas tran vdout0_21ck530 FIND v(dout0_21) AT=540.05n

.meas tran vdout0_22ck530 FIND v(dout0_22) AT=540.05n

.meas tran vdout0_23ck530 FIND v(dout0_23) AT=540.05n

.meas tran vdout0_24ck530 FIND v(dout0_24) AT=540.05n

.meas tran vdout0_25ck530 FIND v(dout0_25) AT=540.05n

.meas tran vdout0_26ck530 FIND v(dout0_26) AT=540.05n

.meas tran vdout0_27ck530 FIND v(dout0_27) AT=540.05n

.meas tran vdout0_28ck530 FIND v(dout0_28) AT=540.05n

.meas tran vdout0_29ck530 FIND v(dout0_29) AT=540.05n

.meas tran vdout0_30ck530 FIND v(dout0_30) AT=540.05n

.meas tran vdout0_31ck530 FIND v(dout0_31) AT=540.05n

.meas tran vdout0_32ck530 FIND v(dout0_32) AT=540.05n

.meas tran vdout0_0ck550 FIND v(dout0_0) AT=560.05n

.meas tran vdout0_1ck550 FIND v(dout0_1) AT=560.05n

.meas tran vdout0_2ck550 FIND v(dout0_2) AT=560.05n

.meas tran vdout0_3ck550 FIND v(dout0_3) AT=560.05n

.meas tran vdout0_4ck550 FIND v(dout0_4) AT=560.05n

.meas tran vdout0_5ck550 FIND v(dout0_5) AT=560.05n

.meas tran vdout0_6ck550 FIND v(dout0_6) AT=560.05n

.meas tran vdout0_7ck550 FIND v(dout0_7) AT=560.05n

.meas tran vdout0_8ck550 FIND v(dout0_8) AT=560.05n

.meas tran vdout0_9ck550 FIND v(dout0_9) AT=560.05n

.meas tran vdout0_10ck550 FIND v(dout0_10) AT=560.05n

.meas tran vdout0_11ck550 FIND v(dout0_11) AT=560.05n

.meas tran vdout0_12ck550 FIND v(dout0_12) AT=560.05n

.meas tran vdout0_13ck550 FIND v(dout0_13) AT=560.05n

.meas tran vdout0_14ck550 FIND v(dout0_14) AT=560.05n

.meas tran vdout0_15ck550 FIND v(dout0_15) AT=560.05n

.meas tran vdout0_16ck550 FIND v(dout0_16) AT=560.05n

.meas tran vdout0_17ck550 FIND v(dout0_17) AT=560.05n

.meas tran vdout0_18ck550 FIND v(dout0_18) AT=560.05n

.meas tran vdout0_19ck550 FIND v(dout0_19) AT=560.05n

.meas tran vdout0_20ck550 FIND v(dout0_20) AT=560.05n

.meas tran vdout0_21ck550 FIND v(dout0_21) AT=560.05n

.meas tran vdout0_22ck550 FIND v(dout0_22) AT=560.05n

.meas tran vdout0_23ck550 FIND v(dout0_23) AT=560.05n

.meas tran vdout0_24ck550 FIND v(dout0_24) AT=560.05n

.meas tran vdout0_25ck550 FIND v(dout0_25) AT=560.05n

.meas tran vdout0_26ck550 FIND v(dout0_26) AT=560.05n

.meas tran vdout0_27ck550 FIND v(dout0_27) AT=560.05n

.meas tran vdout0_28ck550 FIND v(dout0_28) AT=560.05n

.meas tran vdout0_29ck550 FIND v(dout0_29) AT=560.05n

.meas tran vdout0_30ck550 FIND v(dout0_30) AT=560.05n

.meas tran vdout0_31ck550 FIND v(dout0_31) AT=560.05n

.meas tran vdout0_32ck550 FIND v(dout0_32) AT=560.05n

.meas tran vdout0_0ck580 FIND v(dout0_0) AT=590.05n

.meas tran vdout0_1ck580 FIND v(dout0_1) AT=590.05n

.meas tran vdout0_2ck580 FIND v(dout0_2) AT=590.05n

.meas tran vdout0_3ck580 FIND v(dout0_3) AT=590.05n

.meas tran vdout0_4ck580 FIND v(dout0_4) AT=590.05n

.meas tran vdout0_5ck580 FIND v(dout0_5) AT=590.05n

.meas tran vdout0_6ck580 FIND v(dout0_6) AT=590.05n

.meas tran vdout0_7ck580 FIND v(dout0_7) AT=590.05n

.meas tran vdout0_8ck580 FIND v(dout0_8) AT=590.05n

.meas tran vdout0_9ck580 FIND v(dout0_9) AT=590.05n

.meas tran vdout0_10ck580 FIND v(dout0_10) AT=590.05n

.meas tran vdout0_11ck580 FIND v(dout0_11) AT=590.05n

.meas tran vdout0_12ck580 FIND v(dout0_12) AT=590.05n

.meas tran vdout0_13ck580 FIND v(dout0_13) AT=590.05n

.meas tran vdout0_14ck580 FIND v(dout0_14) AT=590.05n

.meas tran vdout0_15ck580 FIND v(dout0_15) AT=590.05n

.meas tran vdout0_16ck580 FIND v(dout0_16) AT=590.05n

.meas tran vdout0_17ck580 FIND v(dout0_17) AT=590.05n

.meas tran vdout0_18ck580 FIND v(dout0_18) AT=590.05n

.meas tran vdout0_19ck580 FIND v(dout0_19) AT=590.05n

.meas tran vdout0_20ck580 FIND v(dout0_20) AT=590.05n

.meas tran vdout0_21ck580 FIND v(dout0_21) AT=590.05n

.meas tran vdout0_22ck580 FIND v(dout0_22) AT=590.05n

.meas tran vdout0_23ck580 FIND v(dout0_23) AT=590.05n

.meas tran vdout0_24ck580 FIND v(dout0_24) AT=590.05n

.meas tran vdout0_25ck580 FIND v(dout0_25) AT=590.05n

.meas tran vdout0_26ck580 FIND v(dout0_26) AT=590.05n

.meas tran vdout0_27ck580 FIND v(dout0_27) AT=590.05n

.meas tran vdout0_28ck580 FIND v(dout0_28) AT=590.05n

.meas tran vdout0_29ck580 FIND v(dout0_29) AT=590.05n

.meas tran vdout0_30ck580 FIND v(dout0_30) AT=590.05n

.meas tran vdout0_31ck580 FIND v(dout0_31) AT=590.05n

.meas tran vdout0_32ck580 FIND v(dout0_32) AT=590.05n

.meas tran vdout0_0ck610 FIND v(dout0_0) AT=620.05n

.meas tran vdout0_1ck610 FIND v(dout0_1) AT=620.05n

.meas tran vdout0_2ck610 FIND v(dout0_2) AT=620.05n

.meas tran vdout0_3ck610 FIND v(dout0_3) AT=620.05n

.meas tran vdout0_4ck610 FIND v(dout0_4) AT=620.05n

.meas tran vdout0_5ck610 FIND v(dout0_5) AT=620.05n

.meas tran vdout0_6ck610 FIND v(dout0_6) AT=620.05n

.meas tran vdout0_7ck610 FIND v(dout0_7) AT=620.05n

.meas tran vdout0_8ck610 FIND v(dout0_8) AT=620.05n

.meas tran vdout0_9ck610 FIND v(dout0_9) AT=620.05n

.meas tran vdout0_10ck610 FIND v(dout0_10) AT=620.05n

.meas tran vdout0_11ck610 FIND v(dout0_11) AT=620.05n

.meas tran vdout0_12ck610 FIND v(dout0_12) AT=620.05n

.meas tran vdout0_13ck610 FIND v(dout0_13) AT=620.05n

.meas tran vdout0_14ck610 FIND v(dout0_14) AT=620.05n

.meas tran vdout0_15ck610 FIND v(dout0_15) AT=620.05n

.meas tran vdout0_16ck610 FIND v(dout0_16) AT=620.05n

.meas tran vdout0_17ck610 FIND v(dout0_17) AT=620.05n

.meas tran vdout0_18ck610 FIND v(dout0_18) AT=620.05n

.meas tran vdout0_19ck610 FIND v(dout0_19) AT=620.05n

.meas tran vdout0_20ck610 FIND v(dout0_20) AT=620.05n

.meas tran vdout0_21ck610 FIND v(dout0_21) AT=620.05n

.meas tran vdout0_22ck610 FIND v(dout0_22) AT=620.05n

.meas tran vdout0_23ck610 FIND v(dout0_23) AT=620.05n

.meas tran vdout0_24ck610 FIND v(dout0_24) AT=620.05n

.meas tran vdout0_25ck610 FIND v(dout0_25) AT=620.05n

.meas tran vdout0_26ck610 FIND v(dout0_26) AT=620.05n

.meas tran vdout0_27ck610 FIND v(dout0_27) AT=620.05n

.meas tran vdout0_28ck610 FIND v(dout0_28) AT=620.05n

.meas tran vdout0_29ck610 FIND v(dout0_29) AT=620.05n

.meas tran vdout0_30ck610 FIND v(dout0_30) AT=620.05n

.meas tran vdout0_31ck610 FIND v(dout0_31) AT=620.05n

.meas tran vdout0_32ck610 FIND v(dout0_32) AT=620.05n

.meas tran vdout0_0ck650 FIND v(dout0_0) AT=660.05n

.meas tran vdout0_1ck650 FIND v(dout0_1) AT=660.05n

.meas tran vdout0_2ck650 FIND v(dout0_2) AT=660.05n

.meas tran vdout0_3ck650 FIND v(dout0_3) AT=660.05n

.meas tran vdout0_4ck650 FIND v(dout0_4) AT=660.05n

.meas tran vdout0_5ck650 FIND v(dout0_5) AT=660.05n

.meas tran vdout0_6ck650 FIND v(dout0_6) AT=660.05n

.meas tran vdout0_7ck650 FIND v(dout0_7) AT=660.05n

.meas tran vdout0_8ck650 FIND v(dout0_8) AT=660.05n

.meas tran vdout0_9ck650 FIND v(dout0_9) AT=660.05n

.meas tran vdout0_10ck650 FIND v(dout0_10) AT=660.05n

.meas tran vdout0_11ck650 FIND v(dout0_11) AT=660.05n

.meas tran vdout0_12ck650 FIND v(dout0_12) AT=660.05n

.meas tran vdout0_13ck650 FIND v(dout0_13) AT=660.05n

.meas tran vdout0_14ck650 FIND v(dout0_14) AT=660.05n

.meas tran vdout0_15ck650 FIND v(dout0_15) AT=660.05n

.meas tran vdout0_16ck650 FIND v(dout0_16) AT=660.05n

.meas tran vdout0_17ck650 FIND v(dout0_17) AT=660.05n

.meas tran vdout0_18ck650 FIND v(dout0_18) AT=660.05n

.meas tran vdout0_19ck650 FIND v(dout0_19) AT=660.05n

.meas tran vdout0_20ck650 FIND v(dout0_20) AT=660.05n

.meas tran vdout0_21ck650 FIND v(dout0_21) AT=660.05n

.meas tran vdout0_22ck650 FIND v(dout0_22) AT=660.05n

.meas tran vdout0_23ck650 FIND v(dout0_23) AT=660.05n

.meas tran vdout0_24ck650 FIND v(dout0_24) AT=660.05n

.meas tran vdout0_25ck650 FIND v(dout0_25) AT=660.05n

.meas tran vdout0_26ck650 FIND v(dout0_26) AT=660.05n

.meas tran vdout0_27ck650 FIND v(dout0_27) AT=660.05n

.meas tran vdout0_28ck650 FIND v(dout0_28) AT=660.05n

.meas tran vdout0_29ck650 FIND v(dout0_29) AT=660.05n

.meas tran vdout0_30ck650 FIND v(dout0_30) AT=660.05n

.meas tran vdout0_31ck650 FIND v(dout0_31) AT=660.05n

.meas tran vdout0_32ck650 FIND v(dout0_32) AT=660.05n

.meas tran vdout0_0ck680 FIND v(dout0_0) AT=690.05n

.meas tran vdout0_1ck680 FIND v(dout0_1) AT=690.05n

.meas tran vdout0_2ck680 FIND v(dout0_2) AT=690.05n

.meas tran vdout0_3ck680 FIND v(dout0_3) AT=690.05n

.meas tran vdout0_4ck680 FIND v(dout0_4) AT=690.05n

.meas tran vdout0_5ck680 FIND v(dout0_5) AT=690.05n

.meas tran vdout0_6ck680 FIND v(dout0_6) AT=690.05n

.meas tran vdout0_7ck680 FIND v(dout0_7) AT=690.05n

.meas tran vdout0_8ck680 FIND v(dout0_8) AT=690.05n

.meas tran vdout0_9ck680 FIND v(dout0_9) AT=690.05n

.meas tran vdout0_10ck680 FIND v(dout0_10) AT=690.05n

.meas tran vdout0_11ck680 FIND v(dout0_11) AT=690.05n

.meas tran vdout0_12ck680 FIND v(dout0_12) AT=690.05n

.meas tran vdout0_13ck680 FIND v(dout0_13) AT=690.05n

.meas tran vdout0_14ck680 FIND v(dout0_14) AT=690.05n

.meas tran vdout0_15ck680 FIND v(dout0_15) AT=690.05n

.meas tran vdout0_16ck680 FIND v(dout0_16) AT=690.05n

.meas tran vdout0_17ck680 FIND v(dout0_17) AT=690.05n

.meas tran vdout0_18ck680 FIND v(dout0_18) AT=690.05n

.meas tran vdout0_19ck680 FIND v(dout0_19) AT=690.05n

.meas tran vdout0_20ck680 FIND v(dout0_20) AT=690.05n

.meas tran vdout0_21ck680 FIND v(dout0_21) AT=690.05n

.meas tran vdout0_22ck680 FIND v(dout0_22) AT=690.05n

.meas tran vdout0_23ck680 FIND v(dout0_23) AT=690.05n

.meas tran vdout0_24ck680 FIND v(dout0_24) AT=690.05n

.meas tran vdout0_25ck680 FIND v(dout0_25) AT=690.05n

.meas tran vdout0_26ck680 FIND v(dout0_26) AT=690.05n

.meas tran vdout0_27ck680 FIND v(dout0_27) AT=690.05n

.meas tran vdout0_28ck680 FIND v(dout0_28) AT=690.05n

.meas tran vdout0_29ck680 FIND v(dout0_29) AT=690.05n

.meas tran vdout0_30ck680 FIND v(dout0_30) AT=690.05n

.meas tran vdout0_31ck680 FIND v(dout0_31) AT=690.05n

.meas tran vdout0_32ck680 FIND v(dout0_32) AT=690.05n

.meas tran vdout0_0ck710 FIND v(dout0_0) AT=720.05n

.meas tran vdout0_1ck710 FIND v(dout0_1) AT=720.05n

.meas tran vdout0_2ck710 FIND v(dout0_2) AT=720.05n

.meas tran vdout0_3ck710 FIND v(dout0_3) AT=720.05n

.meas tran vdout0_4ck710 FIND v(dout0_4) AT=720.05n

.meas tran vdout0_5ck710 FIND v(dout0_5) AT=720.05n

.meas tran vdout0_6ck710 FIND v(dout0_6) AT=720.05n

.meas tran vdout0_7ck710 FIND v(dout0_7) AT=720.05n

.meas tran vdout0_8ck710 FIND v(dout0_8) AT=720.05n

.meas tran vdout0_9ck710 FIND v(dout0_9) AT=720.05n

.meas tran vdout0_10ck710 FIND v(dout0_10) AT=720.05n

.meas tran vdout0_11ck710 FIND v(dout0_11) AT=720.05n

.meas tran vdout0_12ck710 FIND v(dout0_12) AT=720.05n

.meas tran vdout0_13ck710 FIND v(dout0_13) AT=720.05n

.meas tran vdout0_14ck710 FIND v(dout0_14) AT=720.05n

.meas tran vdout0_15ck710 FIND v(dout0_15) AT=720.05n

.meas tran vdout0_16ck710 FIND v(dout0_16) AT=720.05n

.meas tran vdout0_17ck710 FIND v(dout0_17) AT=720.05n

.meas tran vdout0_18ck710 FIND v(dout0_18) AT=720.05n

.meas tran vdout0_19ck710 FIND v(dout0_19) AT=720.05n

.meas tran vdout0_20ck710 FIND v(dout0_20) AT=720.05n

.meas tran vdout0_21ck710 FIND v(dout0_21) AT=720.05n

.meas tran vdout0_22ck710 FIND v(dout0_22) AT=720.05n

.meas tran vdout0_23ck710 FIND v(dout0_23) AT=720.05n

.meas tran vdout0_24ck710 FIND v(dout0_24) AT=720.05n

.meas tran vdout0_25ck710 FIND v(dout0_25) AT=720.05n

.meas tran vdout0_26ck710 FIND v(dout0_26) AT=720.05n

.meas tran vdout0_27ck710 FIND v(dout0_27) AT=720.05n

.meas tran vdout0_28ck710 FIND v(dout0_28) AT=720.05n

.meas tran vdout0_29ck710 FIND v(dout0_29) AT=720.05n

.meas tran vdout0_30ck710 FIND v(dout0_30) AT=720.05n

.meas tran vdout0_31ck710 FIND v(dout0_31) AT=720.05n

.meas tran vdout0_32ck710 FIND v(dout0_32) AT=720.05n

.meas tran vdout0_0ck720 FIND v(dout0_0) AT=730.05n

.meas tran vdout0_1ck720 FIND v(dout0_1) AT=730.05n

.meas tran vdout0_2ck720 FIND v(dout0_2) AT=730.05n

.meas tran vdout0_3ck720 FIND v(dout0_3) AT=730.05n

.meas tran vdout0_4ck720 FIND v(dout0_4) AT=730.05n

.meas tran vdout0_5ck720 FIND v(dout0_5) AT=730.05n

.meas tran vdout0_6ck720 FIND v(dout0_6) AT=730.05n

.meas tran vdout0_7ck720 FIND v(dout0_7) AT=730.05n

.meas tran vdout0_8ck720 FIND v(dout0_8) AT=730.05n

.meas tran vdout0_9ck720 FIND v(dout0_9) AT=730.05n

.meas tran vdout0_10ck720 FIND v(dout0_10) AT=730.05n

.meas tran vdout0_11ck720 FIND v(dout0_11) AT=730.05n

.meas tran vdout0_12ck720 FIND v(dout0_12) AT=730.05n

.meas tran vdout0_13ck720 FIND v(dout0_13) AT=730.05n

.meas tran vdout0_14ck720 FIND v(dout0_14) AT=730.05n

.meas tran vdout0_15ck720 FIND v(dout0_15) AT=730.05n

.meas tran vdout0_16ck720 FIND v(dout0_16) AT=730.05n

.meas tran vdout0_17ck720 FIND v(dout0_17) AT=730.05n

.meas tran vdout0_18ck720 FIND v(dout0_18) AT=730.05n

.meas tran vdout0_19ck720 FIND v(dout0_19) AT=730.05n

.meas tran vdout0_20ck720 FIND v(dout0_20) AT=730.05n

.meas tran vdout0_21ck720 FIND v(dout0_21) AT=730.05n

.meas tran vdout0_22ck720 FIND v(dout0_22) AT=730.05n

.meas tran vdout0_23ck720 FIND v(dout0_23) AT=730.05n

.meas tran vdout0_24ck720 FIND v(dout0_24) AT=730.05n

.meas tran vdout0_25ck720 FIND v(dout0_25) AT=730.05n

.meas tran vdout0_26ck720 FIND v(dout0_26) AT=730.05n

.meas tran vdout0_27ck720 FIND v(dout0_27) AT=730.05n

.meas tran vdout0_28ck720 FIND v(dout0_28) AT=730.05n

.meas tran vdout0_29ck720 FIND v(dout0_29) AT=730.05n

.meas tran vdout0_30ck720 FIND v(dout0_30) AT=730.05n

.meas tran vdout0_31ck720 FIND v(dout0_31) AT=730.05n

.meas tran vdout0_32ck720 FIND v(dout0_32) AT=730.05n

.meas tran vdout0_0ck730 FIND v(dout0_0) AT=740.05n

.meas tran vdout0_1ck730 FIND v(dout0_1) AT=740.05n

.meas tran vdout0_2ck730 FIND v(dout0_2) AT=740.05n

.meas tran vdout0_3ck730 FIND v(dout0_3) AT=740.05n

.meas tran vdout0_4ck730 FIND v(dout0_4) AT=740.05n

.meas tran vdout0_5ck730 FIND v(dout0_5) AT=740.05n

.meas tran vdout0_6ck730 FIND v(dout0_6) AT=740.05n

.meas tran vdout0_7ck730 FIND v(dout0_7) AT=740.05n

.meas tran vdout0_8ck730 FIND v(dout0_8) AT=740.05n

.meas tran vdout0_9ck730 FIND v(dout0_9) AT=740.05n

.meas tran vdout0_10ck730 FIND v(dout0_10) AT=740.05n

.meas tran vdout0_11ck730 FIND v(dout0_11) AT=740.05n

.meas tran vdout0_12ck730 FIND v(dout0_12) AT=740.05n

.meas tran vdout0_13ck730 FIND v(dout0_13) AT=740.05n

.meas tran vdout0_14ck730 FIND v(dout0_14) AT=740.05n

.meas tran vdout0_15ck730 FIND v(dout0_15) AT=740.05n

.meas tran vdout0_16ck730 FIND v(dout0_16) AT=740.05n

.meas tran vdout0_17ck730 FIND v(dout0_17) AT=740.05n

.meas tran vdout0_18ck730 FIND v(dout0_18) AT=740.05n

.meas tran vdout0_19ck730 FIND v(dout0_19) AT=740.05n

.meas tran vdout0_20ck730 FIND v(dout0_20) AT=740.05n

.meas tran vdout0_21ck730 FIND v(dout0_21) AT=740.05n

.meas tran vdout0_22ck730 FIND v(dout0_22) AT=740.05n

.meas tran vdout0_23ck730 FIND v(dout0_23) AT=740.05n

.meas tran vdout0_24ck730 FIND v(dout0_24) AT=740.05n

.meas tran vdout0_25ck730 FIND v(dout0_25) AT=740.05n

.meas tran vdout0_26ck730 FIND v(dout0_26) AT=740.05n

.meas tran vdout0_27ck730 FIND v(dout0_27) AT=740.05n

.meas tran vdout0_28ck730 FIND v(dout0_28) AT=740.05n

.meas tran vdout0_29ck730 FIND v(dout0_29) AT=740.05n

.meas tran vdout0_30ck730 FIND v(dout0_30) AT=740.05n

.meas tran vdout0_31ck730 FIND v(dout0_31) AT=740.05n

.meas tran vdout0_32ck730 FIND v(dout0_32) AT=740.05n

.meas tran vdout0_0ck760 FIND v(dout0_0) AT=770.05n

.meas tran vdout0_1ck760 FIND v(dout0_1) AT=770.05n

.meas tran vdout0_2ck760 FIND v(dout0_2) AT=770.05n

.meas tran vdout0_3ck760 FIND v(dout0_3) AT=770.05n

.meas tran vdout0_4ck760 FIND v(dout0_4) AT=770.05n

.meas tran vdout0_5ck760 FIND v(dout0_5) AT=770.05n

.meas tran vdout0_6ck760 FIND v(dout0_6) AT=770.05n

.meas tran vdout0_7ck760 FIND v(dout0_7) AT=770.05n

.meas tran vdout0_8ck760 FIND v(dout0_8) AT=770.05n

.meas tran vdout0_9ck760 FIND v(dout0_9) AT=770.05n

.meas tran vdout0_10ck760 FIND v(dout0_10) AT=770.05n

.meas tran vdout0_11ck760 FIND v(dout0_11) AT=770.05n

.meas tran vdout0_12ck760 FIND v(dout0_12) AT=770.05n

.meas tran vdout0_13ck760 FIND v(dout0_13) AT=770.05n

.meas tran vdout0_14ck760 FIND v(dout0_14) AT=770.05n

.meas tran vdout0_15ck760 FIND v(dout0_15) AT=770.05n

.meas tran vdout0_16ck760 FIND v(dout0_16) AT=770.05n

.meas tran vdout0_17ck760 FIND v(dout0_17) AT=770.05n

.meas tran vdout0_18ck760 FIND v(dout0_18) AT=770.05n

.meas tran vdout0_19ck760 FIND v(dout0_19) AT=770.05n

.meas tran vdout0_20ck760 FIND v(dout0_20) AT=770.05n

.meas tran vdout0_21ck760 FIND v(dout0_21) AT=770.05n

.meas tran vdout0_22ck760 FIND v(dout0_22) AT=770.05n

.meas tran vdout0_23ck760 FIND v(dout0_23) AT=770.05n

.meas tran vdout0_24ck760 FIND v(dout0_24) AT=770.05n

.meas tran vdout0_25ck760 FIND v(dout0_25) AT=770.05n

.meas tran vdout0_26ck760 FIND v(dout0_26) AT=770.05n

.meas tran vdout0_27ck760 FIND v(dout0_27) AT=770.05n

.meas tran vdout0_28ck760 FIND v(dout0_28) AT=770.05n

.meas tran vdout0_29ck760 FIND v(dout0_29) AT=770.05n

.meas tran vdout0_30ck760 FIND v(dout0_30) AT=770.05n

.meas tran vdout0_31ck760 FIND v(dout0_31) AT=770.05n

.meas tran vdout0_32ck760 FIND v(dout0_32) AT=770.05n

.meas tran vdout0_0ck790 FIND v(dout0_0) AT=800.05n

.meas tran vdout0_1ck790 FIND v(dout0_1) AT=800.05n

.meas tran vdout0_2ck790 FIND v(dout0_2) AT=800.05n

.meas tran vdout0_3ck790 FIND v(dout0_3) AT=800.05n

.meas tran vdout0_4ck790 FIND v(dout0_4) AT=800.05n

.meas tran vdout0_5ck790 FIND v(dout0_5) AT=800.05n

.meas tran vdout0_6ck790 FIND v(dout0_6) AT=800.05n

.meas tran vdout0_7ck790 FIND v(dout0_7) AT=800.05n

.meas tran vdout0_8ck790 FIND v(dout0_8) AT=800.05n

.meas tran vdout0_9ck790 FIND v(dout0_9) AT=800.05n

.meas tran vdout0_10ck790 FIND v(dout0_10) AT=800.05n

.meas tran vdout0_11ck790 FIND v(dout0_11) AT=800.05n

.meas tran vdout0_12ck790 FIND v(dout0_12) AT=800.05n

.meas tran vdout0_13ck790 FIND v(dout0_13) AT=800.05n

.meas tran vdout0_14ck790 FIND v(dout0_14) AT=800.05n

.meas tran vdout0_15ck790 FIND v(dout0_15) AT=800.05n

.meas tran vdout0_16ck790 FIND v(dout0_16) AT=800.05n

.meas tran vdout0_17ck790 FIND v(dout0_17) AT=800.05n

.meas tran vdout0_18ck790 FIND v(dout0_18) AT=800.05n

.meas tran vdout0_19ck790 FIND v(dout0_19) AT=800.05n

.meas tran vdout0_20ck790 FIND v(dout0_20) AT=800.05n

.meas tran vdout0_21ck790 FIND v(dout0_21) AT=800.05n

.meas tran vdout0_22ck790 FIND v(dout0_22) AT=800.05n

.meas tran vdout0_23ck790 FIND v(dout0_23) AT=800.05n

.meas tran vdout0_24ck790 FIND v(dout0_24) AT=800.05n

.meas tran vdout0_25ck790 FIND v(dout0_25) AT=800.05n

.meas tran vdout0_26ck790 FIND v(dout0_26) AT=800.05n

.meas tran vdout0_27ck790 FIND v(dout0_27) AT=800.05n

.meas tran vdout0_28ck790 FIND v(dout0_28) AT=800.05n

.meas tran vdout0_29ck790 FIND v(dout0_29) AT=800.05n

.meas tran vdout0_30ck790 FIND v(dout0_30) AT=800.05n

.meas tran vdout0_31ck790 FIND v(dout0_31) AT=800.05n

.meas tran vdout0_32ck790 FIND v(dout0_32) AT=800.05n

.meas tran vdout0_0ck800 FIND v(dout0_0) AT=810.05n

.meas tran vdout0_1ck800 FIND v(dout0_1) AT=810.05n

.meas tran vdout0_2ck800 FIND v(dout0_2) AT=810.05n

.meas tran vdout0_3ck800 FIND v(dout0_3) AT=810.05n

.meas tran vdout0_4ck800 FIND v(dout0_4) AT=810.05n

.meas tran vdout0_5ck800 FIND v(dout0_5) AT=810.05n

.meas tran vdout0_6ck800 FIND v(dout0_6) AT=810.05n

.meas tran vdout0_7ck800 FIND v(dout0_7) AT=810.05n

.meas tran vdout0_8ck800 FIND v(dout0_8) AT=810.05n

.meas tran vdout0_9ck800 FIND v(dout0_9) AT=810.05n

.meas tran vdout0_10ck800 FIND v(dout0_10) AT=810.05n

.meas tran vdout0_11ck800 FIND v(dout0_11) AT=810.05n

.meas tran vdout0_12ck800 FIND v(dout0_12) AT=810.05n

.meas tran vdout0_13ck800 FIND v(dout0_13) AT=810.05n

.meas tran vdout0_14ck800 FIND v(dout0_14) AT=810.05n

.meas tran vdout0_15ck800 FIND v(dout0_15) AT=810.05n

.meas tran vdout0_16ck800 FIND v(dout0_16) AT=810.05n

.meas tran vdout0_17ck800 FIND v(dout0_17) AT=810.05n

.meas tran vdout0_18ck800 FIND v(dout0_18) AT=810.05n

.meas tran vdout0_19ck800 FIND v(dout0_19) AT=810.05n

.meas tran vdout0_20ck800 FIND v(dout0_20) AT=810.05n

.meas tran vdout0_21ck800 FIND v(dout0_21) AT=810.05n

.meas tran vdout0_22ck800 FIND v(dout0_22) AT=810.05n

.meas tran vdout0_23ck800 FIND v(dout0_23) AT=810.05n

.meas tran vdout0_24ck800 FIND v(dout0_24) AT=810.05n

.meas tran vdout0_25ck800 FIND v(dout0_25) AT=810.05n

.meas tran vdout0_26ck800 FIND v(dout0_26) AT=810.05n

.meas tran vdout0_27ck800 FIND v(dout0_27) AT=810.05n

.meas tran vdout0_28ck800 FIND v(dout0_28) AT=810.05n

.meas tran vdout0_29ck800 FIND v(dout0_29) AT=810.05n

.meas tran vdout0_30ck800 FIND v(dout0_30) AT=810.05n

.meas tran vdout0_31ck800 FIND v(dout0_31) AT=810.05n

.meas tran vdout0_32ck800 FIND v(dout0_32) AT=810.05n

.meas tran vdout0_0ck810 FIND v(dout0_0) AT=820.05n

.meas tran vdout0_1ck810 FIND v(dout0_1) AT=820.05n

.meas tran vdout0_2ck810 FIND v(dout0_2) AT=820.05n

.meas tran vdout0_3ck810 FIND v(dout0_3) AT=820.05n

.meas tran vdout0_4ck810 FIND v(dout0_4) AT=820.05n

.meas tran vdout0_5ck810 FIND v(dout0_5) AT=820.05n

.meas tran vdout0_6ck810 FIND v(dout0_6) AT=820.05n

.meas tran vdout0_7ck810 FIND v(dout0_7) AT=820.05n

.meas tran vdout0_8ck810 FIND v(dout0_8) AT=820.05n

.meas tran vdout0_9ck810 FIND v(dout0_9) AT=820.05n

.meas tran vdout0_10ck810 FIND v(dout0_10) AT=820.05n

.meas tran vdout0_11ck810 FIND v(dout0_11) AT=820.05n

.meas tran vdout0_12ck810 FIND v(dout0_12) AT=820.05n

.meas tran vdout0_13ck810 FIND v(dout0_13) AT=820.05n

.meas tran vdout0_14ck810 FIND v(dout0_14) AT=820.05n

.meas tran vdout0_15ck810 FIND v(dout0_15) AT=820.05n

.meas tran vdout0_16ck810 FIND v(dout0_16) AT=820.05n

.meas tran vdout0_17ck810 FIND v(dout0_17) AT=820.05n

.meas tran vdout0_18ck810 FIND v(dout0_18) AT=820.05n

.meas tran vdout0_19ck810 FIND v(dout0_19) AT=820.05n

.meas tran vdout0_20ck810 FIND v(dout0_20) AT=820.05n

.meas tran vdout0_21ck810 FIND v(dout0_21) AT=820.05n

.meas tran vdout0_22ck810 FIND v(dout0_22) AT=820.05n

.meas tran vdout0_23ck810 FIND v(dout0_23) AT=820.05n

.meas tran vdout0_24ck810 FIND v(dout0_24) AT=820.05n

.meas tran vdout0_25ck810 FIND v(dout0_25) AT=820.05n

.meas tran vdout0_26ck810 FIND v(dout0_26) AT=820.05n

.meas tran vdout0_27ck810 FIND v(dout0_27) AT=820.05n

.meas tran vdout0_28ck810 FIND v(dout0_28) AT=820.05n

.meas tran vdout0_29ck810 FIND v(dout0_29) AT=820.05n

.meas tran vdout0_30ck810 FIND v(dout0_30) AT=820.05n

.meas tran vdout0_31ck810 FIND v(dout0_31) AT=820.05n

.meas tran vdout0_32ck810 FIND v(dout0_32) AT=820.05n

.meas tran vdout0_0ck840 FIND v(dout0_0) AT=850.05n

.meas tran vdout0_1ck840 FIND v(dout0_1) AT=850.05n

.meas tran vdout0_2ck840 FIND v(dout0_2) AT=850.05n

.meas tran vdout0_3ck840 FIND v(dout0_3) AT=850.05n

.meas tran vdout0_4ck840 FIND v(dout0_4) AT=850.05n

.meas tran vdout0_5ck840 FIND v(dout0_5) AT=850.05n

.meas tran vdout0_6ck840 FIND v(dout0_6) AT=850.05n

.meas tran vdout0_7ck840 FIND v(dout0_7) AT=850.05n

.meas tran vdout0_8ck840 FIND v(dout0_8) AT=850.05n

.meas tran vdout0_9ck840 FIND v(dout0_9) AT=850.05n

.meas tran vdout0_10ck840 FIND v(dout0_10) AT=850.05n

.meas tran vdout0_11ck840 FIND v(dout0_11) AT=850.05n

.meas tran vdout0_12ck840 FIND v(dout0_12) AT=850.05n

.meas tran vdout0_13ck840 FIND v(dout0_13) AT=850.05n

.meas tran vdout0_14ck840 FIND v(dout0_14) AT=850.05n

.meas tran vdout0_15ck840 FIND v(dout0_15) AT=850.05n

.meas tran vdout0_16ck840 FIND v(dout0_16) AT=850.05n

.meas tran vdout0_17ck840 FIND v(dout0_17) AT=850.05n

.meas tran vdout0_18ck840 FIND v(dout0_18) AT=850.05n

.meas tran vdout0_19ck840 FIND v(dout0_19) AT=850.05n

.meas tran vdout0_20ck840 FIND v(dout0_20) AT=850.05n

.meas tran vdout0_21ck840 FIND v(dout0_21) AT=850.05n

.meas tran vdout0_22ck840 FIND v(dout0_22) AT=850.05n

.meas tran vdout0_23ck840 FIND v(dout0_23) AT=850.05n

.meas tran vdout0_24ck840 FIND v(dout0_24) AT=850.05n

.meas tran vdout0_25ck840 FIND v(dout0_25) AT=850.05n

.meas tran vdout0_26ck840 FIND v(dout0_26) AT=850.05n

.meas tran vdout0_27ck840 FIND v(dout0_27) AT=850.05n

.meas tran vdout0_28ck840 FIND v(dout0_28) AT=850.05n

.meas tran vdout0_29ck840 FIND v(dout0_29) AT=850.05n

.meas tran vdout0_30ck840 FIND v(dout0_30) AT=850.05n

.meas tran vdout0_31ck840 FIND v(dout0_31) AT=850.05n

.meas tran vdout0_32ck840 FIND v(dout0_32) AT=850.05n

.meas tran vdout0_0ck860 FIND v(dout0_0) AT=870.05n

.meas tran vdout0_1ck860 FIND v(dout0_1) AT=870.05n

.meas tran vdout0_2ck860 FIND v(dout0_2) AT=870.05n

.meas tran vdout0_3ck860 FIND v(dout0_3) AT=870.05n

.meas tran vdout0_4ck860 FIND v(dout0_4) AT=870.05n

.meas tran vdout0_5ck860 FIND v(dout0_5) AT=870.05n

.meas tran vdout0_6ck860 FIND v(dout0_6) AT=870.05n

.meas tran vdout0_7ck860 FIND v(dout0_7) AT=870.05n

.meas tran vdout0_8ck860 FIND v(dout0_8) AT=870.05n

.meas tran vdout0_9ck860 FIND v(dout0_9) AT=870.05n

.meas tran vdout0_10ck860 FIND v(dout0_10) AT=870.05n

.meas tran vdout0_11ck860 FIND v(dout0_11) AT=870.05n

.meas tran vdout0_12ck860 FIND v(dout0_12) AT=870.05n

.meas tran vdout0_13ck860 FIND v(dout0_13) AT=870.05n

.meas tran vdout0_14ck860 FIND v(dout0_14) AT=870.05n

.meas tran vdout0_15ck860 FIND v(dout0_15) AT=870.05n

.meas tran vdout0_16ck860 FIND v(dout0_16) AT=870.05n

.meas tran vdout0_17ck860 FIND v(dout0_17) AT=870.05n

.meas tran vdout0_18ck860 FIND v(dout0_18) AT=870.05n

.meas tran vdout0_19ck860 FIND v(dout0_19) AT=870.05n

.meas tran vdout0_20ck860 FIND v(dout0_20) AT=870.05n

.meas tran vdout0_21ck860 FIND v(dout0_21) AT=870.05n

.meas tran vdout0_22ck860 FIND v(dout0_22) AT=870.05n

.meas tran vdout0_23ck860 FIND v(dout0_23) AT=870.05n

.meas tran vdout0_24ck860 FIND v(dout0_24) AT=870.05n

.meas tran vdout0_25ck860 FIND v(dout0_25) AT=870.05n

.meas tran vdout0_26ck860 FIND v(dout0_26) AT=870.05n

.meas tran vdout0_27ck860 FIND v(dout0_27) AT=870.05n

.meas tran vdout0_28ck860 FIND v(dout0_28) AT=870.05n

.meas tran vdout0_29ck860 FIND v(dout0_29) AT=870.05n

.meas tran vdout0_30ck860 FIND v(dout0_30) AT=870.05n

.meas tran vdout0_31ck860 FIND v(dout0_31) AT=870.05n

.meas tran vdout0_32ck860 FIND v(dout0_32) AT=870.05n

.meas tran vdout0_0ck870 FIND v(dout0_0) AT=880.05n

.meas tran vdout0_1ck870 FIND v(dout0_1) AT=880.05n

.meas tran vdout0_2ck870 FIND v(dout0_2) AT=880.05n

.meas tran vdout0_3ck870 FIND v(dout0_3) AT=880.05n

.meas tran vdout0_4ck870 FIND v(dout0_4) AT=880.05n

.meas tran vdout0_5ck870 FIND v(dout0_5) AT=880.05n

.meas tran vdout0_6ck870 FIND v(dout0_6) AT=880.05n

.meas tran vdout0_7ck870 FIND v(dout0_7) AT=880.05n

.meas tran vdout0_8ck870 FIND v(dout0_8) AT=880.05n

.meas tran vdout0_9ck870 FIND v(dout0_9) AT=880.05n

.meas tran vdout0_10ck870 FIND v(dout0_10) AT=880.05n

.meas tran vdout0_11ck870 FIND v(dout0_11) AT=880.05n

.meas tran vdout0_12ck870 FIND v(dout0_12) AT=880.05n

.meas tran vdout0_13ck870 FIND v(dout0_13) AT=880.05n

.meas tran vdout0_14ck870 FIND v(dout0_14) AT=880.05n

.meas tran vdout0_15ck870 FIND v(dout0_15) AT=880.05n

.meas tran vdout0_16ck870 FIND v(dout0_16) AT=880.05n

.meas tran vdout0_17ck870 FIND v(dout0_17) AT=880.05n

.meas tran vdout0_18ck870 FIND v(dout0_18) AT=880.05n

.meas tran vdout0_19ck870 FIND v(dout0_19) AT=880.05n

.meas tran vdout0_20ck870 FIND v(dout0_20) AT=880.05n

.meas tran vdout0_21ck870 FIND v(dout0_21) AT=880.05n

.meas tran vdout0_22ck870 FIND v(dout0_22) AT=880.05n

.meas tran vdout0_23ck870 FIND v(dout0_23) AT=880.05n

.meas tran vdout0_24ck870 FIND v(dout0_24) AT=880.05n

.meas tran vdout0_25ck870 FIND v(dout0_25) AT=880.05n

.meas tran vdout0_26ck870 FIND v(dout0_26) AT=880.05n

.meas tran vdout0_27ck870 FIND v(dout0_27) AT=880.05n

.meas tran vdout0_28ck870 FIND v(dout0_28) AT=880.05n

.meas tran vdout0_29ck870 FIND v(dout0_29) AT=880.05n

.meas tran vdout0_30ck870 FIND v(dout0_30) AT=880.05n

.meas tran vdout0_31ck870 FIND v(dout0_31) AT=880.05n

.meas tran vdout0_32ck870 FIND v(dout0_32) AT=880.05n

.meas tran vdout0_0ck920 FIND v(dout0_0) AT=930.05n

.meas tran vdout0_1ck920 FIND v(dout0_1) AT=930.05n

.meas tran vdout0_2ck920 FIND v(dout0_2) AT=930.05n

.meas tran vdout0_3ck920 FIND v(dout0_3) AT=930.05n

.meas tran vdout0_4ck920 FIND v(dout0_4) AT=930.05n

.meas tran vdout0_5ck920 FIND v(dout0_5) AT=930.05n

.meas tran vdout0_6ck920 FIND v(dout0_6) AT=930.05n

.meas tran vdout0_7ck920 FIND v(dout0_7) AT=930.05n

.meas tran vdout0_8ck920 FIND v(dout0_8) AT=930.05n

.meas tran vdout0_9ck920 FIND v(dout0_9) AT=930.05n

.meas tran vdout0_10ck920 FIND v(dout0_10) AT=930.05n

.meas tran vdout0_11ck920 FIND v(dout0_11) AT=930.05n

.meas tran vdout0_12ck920 FIND v(dout0_12) AT=930.05n

.meas tran vdout0_13ck920 FIND v(dout0_13) AT=930.05n

.meas tran vdout0_14ck920 FIND v(dout0_14) AT=930.05n

.meas tran vdout0_15ck920 FIND v(dout0_15) AT=930.05n

.meas tran vdout0_16ck920 FIND v(dout0_16) AT=930.05n

.meas tran vdout0_17ck920 FIND v(dout0_17) AT=930.05n

.meas tran vdout0_18ck920 FIND v(dout0_18) AT=930.05n

.meas tran vdout0_19ck920 FIND v(dout0_19) AT=930.05n

.meas tran vdout0_20ck920 FIND v(dout0_20) AT=930.05n

.meas tran vdout0_21ck920 FIND v(dout0_21) AT=930.05n

.meas tran vdout0_22ck920 FIND v(dout0_22) AT=930.05n

.meas tran vdout0_23ck920 FIND v(dout0_23) AT=930.05n

.meas tran vdout0_24ck920 FIND v(dout0_24) AT=930.05n

.meas tran vdout0_25ck920 FIND v(dout0_25) AT=930.05n

.meas tran vdout0_26ck920 FIND v(dout0_26) AT=930.05n

.meas tran vdout0_27ck920 FIND v(dout0_27) AT=930.05n

.meas tran vdout0_28ck920 FIND v(dout0_28) AT=930.05n

.meas tran vdout0_29ck920 FIND v(dout0_29) AT=930.05n

.meas tran vdout0_30ck920 FIND v(dout0_30) AT=930.05n

.meas tran vdout0_31ck920 FIND v(dout0_31) AT=930.05n

.meas tran vdout0_32ck920 FIND v(dout0_32) AT=930.05n

.meas tran vdout0_0ck930 FIND v(dout0_0) AT=940.05n

.meas tran vdout0_1ck930 FIND v(dout0_1) AT=940.05n

.meas tran vdout0_2ck930 FIND v(dout0_2) AT=940.05n

.meas tran vdout0_3ck930 FIND v(dout0_3) AT=940.05n

.meas tran vdout0_4ck930 FIND v(dout0_4) AT=940.05n

.meas tran vdout0_5ck930 FIND v(dout0_5) AT=940.05n

.meas tran vdout0_6ck930 FIND v(dout0_6) AT=940.05n

.meas tran vdout0_7ck930 FIND v(dout0_7) AT=940.05n

.meas tran vdout0_8ck930 FIND v(dout0_8) AT=940.05n

.meas tran vdout0_9ck930 FIND v(dout0_9) AT=940.05n

.meas tran vdout0_10ck930 FIND v(dout0_10) AT=940.05n

.meas tran vdout0_11ck930 FIND v(dout0_11) AT=940.05n

.meas tran vdout0_12ck930 FIND v(dout0_12) AT=940.05n

.meas tran vdout0_13ck930 FIND v(dout0_13) AT=940.05n

.meas tran vdout0_14ck930 FIND v(dout0_14) AT=940.05n

.meas tran vdout0_15ck930 FIND v(dout0_15) AT=940.05n

.meas tran vdout0_16ck930 FIND v(dout0_16) AT=940.05n

.meas tran vdout0_17ck930 FIND v(dout0_17) AT=940.05n

.meas tran vdout0_18ck930 FIND v(dout0_18) AT=940.05n

.meas tran vdout0_19ck930 FIND v(dout0_19) AT=940.05n

.meas tran vdout0_20ck930 FIND v(dout0_20) AT=940.05n

.meas tran vdout0_21ck930 FIND v(dout0_21) AT=940.05n

.meas tran vdout0_22ck930 FIND v(dout0_22) AT=940.05n

.meas tran vdout0_23ck930 FIND v(dout0_23) AT=940.05n

.meas tran vdout0_24ck930 FIND v(dout0_24) AT=940.05n

.meas tran vdout0_25ck930 FIND v(dout0_25) AT=940.05n

.meas tran vdout0_26ck930 FIND v(dout0_26) AT=940.05n

.meas tran vdout0_27ck930 FIND v(dout0_27) AT=940.05n

.meas tran vdout0_28ck930 FIND v(dout0_28) AT=940.05n

.meas tran vdout0_29ck930 FIND v(dout0_29) AT=940.05n

.meas tran vdout0_30ck930 FIND v(dout0_30) AT=940.05n

.meas tran vdout0_31ck930 FIND v(dout0_31) AT=940.05n

.meas tran vdout0_32ck930 FIND v(dout0_32) AT=940.05n

.meas tran vdout0_0ck950 FIND v(dout0_0) AT=960.05n

.meas tran vdout0_1ck950 FIND v(dout0_1) AT=960.05n

.meas tran vdout0_2ck950 FIND v(dout0_2) AT=960.05n

.meas tran vdout0_3ck950 FIND v(dout0_3) AT=960.05n

.meas tran vdout0_4ck950 FIND v(dout0_4) AT=960.05n

.meas tran vdout0_5ck950 FIND v(dout0_5) AT=960.05n

.meas tran vdout0_6ck950 FIND v(dout0_6) AT=960.05n

.meas tran vdout0_7ck950 FIND v(dout0_7) AT=960.05n

.meas tran vdout0_8ck950 FIND v(dout0_8) AT=960.05n

.meas tran vdout0_9ck950 FIND v(dout0_9) AT=960.05n

.meas tran vdout0_10ck950 FIND v(dout0_10) AT=960.05n

.meas tran vdout0_11ck950 FIND v(dout0_11) AT=960.05n

.meas tran vdout0_12ck950 FIND v(dout0_12) AT=960.05n

.meas tran vdout0_13ck950 FIND v(dout0_13) AT=960.05n

.meas tran vdout0_14ck950 FIND v(dout0_14) AT=960.05n

.meas tran vdout0_15ck950 FIND v(dout0_15) AT=960.05n

.meas tran vdout0_16ck950 FIND v(dout0_16) AT=960.05n

.meas tran vdout0_17ck950 FIND v(dout0_17) AT=960.05n

.meas tran vdout0_18ck950 FIND v(dout0_18) AT=960.05n

.meas tran vdout0_19ck950 FIND v(dout0_19) AT=960.05n

.meas tran vdout0_20ck950 FIND v(dout0_20) AT=960.05n

.meas tran vdout0_21ck950 FIND v(dout0_21) AT=960.05n

.meas tran vdout0_22ck950 FIND v(dout0_22) AT=960.05n

.meas tran vdout0_23ck950 FIND v(dout0_23) AT=960.05n

.meas tran vdout0_24ck950 FIND v(dout0_24) AT=960.05n

.meas tran vdout0_25ck950 FIND v(dout0_25) AT=960.05n

.meas tran vdout0_26ck950 FIND v(dout0_26) AT=960.05n

.meas tran vdout0_27ck950 FIND v(dout0_27) AT=960.05n

.meas tran vdout0_28ck950 FIND v(dout0_28) AT=960.05n

.meas tran vdout0_29ck950 FIND v(dout0_29) AT=960.05n

.meas tran vdout0_30ck950 FIND v(dout0_30) AT=960.05n

.meas tran vdout0_31ck950 FIND v(dout0_31) AT=960.05n

.meas tran vdout0_32ck950 FIND v(dout0_32) AT=960.05n

.meas tran vdout0_0ck960 FIND v(dout0_0) AT=970.05n

.meas tran vdout0_1ck960 FIND v(dout0_1) AT=970.05n

.meas tran vdout0_2ck960 FIND v(dout0_2) AT=970.05n

.meas tran vdout0_3ck960 FIND v(dout0_3) AT=970.05n

.meas tran vdout0_4ck960 FIND v(dout0_4) AT=970.05n

.meas tran vdout0_5ck960 FIND v(dout0_5) AT=970.05n

.meas tran vdout0_6ck960 FIND v(dout0_6) AT=970.05n

.meas tran vdout0_7ck960 FIND v(dout0_7) AT=970.05n

.meas tran vdout0_8ck960 FIND v(dout0_8) AT=970.05n

.meas tran vdout0_9ck960 FIND v(dout0_9) AT=970.05n

.meas tran vdout0_10ck960 FIND v(dout0_10) AT=970.05n

.meas tran vdout0_11ck960 FIND v(dout0_11) AT=970.05n

.meas tran vdout0_12ck960 FIND v(dout0_12) AT=970.05n

.meas tran vdout0_13ck960 FIND v(dout0_13) AT=970.05n

.meas tran vdout0_14ck960 FIND v(dout0_14) AT=970.05n

.meas tran vdout0_15ck960 FIND v(dout0_15) AT=970.05n

.meas tran vdout0_16ck960 FIND v(dout0_16) AT=970.05n

.meas tran vdout0_17ck960 FIND v(dout0_17) AT=970.05n

.meas tran vdout0_18ck960 FIND v(dout0_18) AT=970.05n

.meas tran vdout0_19ck960 FIND v(dout0_19) AT=970.05n

.meas tran vdout0_20ck960 FIND v(dout0_20) AT=970.05n

.meas tran vdout0_21ck960 FIND v(dout0_21) AT=970.05n

.meas tran vdout0_22ck960 FIND v(dout0_22) AT=970.05n

.meas tran vdout0_23ck960 FIND v(dout0_23) AT=970.05n

.meas tran vdout0_24ck960 FIND v(dout0_24) AT=970.05n

.meas tran vdout0_25ck960 FIND v(dout0_25) AT=970.05n

.meas tran vdout0_26ck960 FIND v(dout0_26) AT=970.05n

.meas tran vdout0_27ck960 FIND v(dout0_27) AT=970.05n

.meas tran vdout0_28ck960 FIND v(dout0_28) AT=970.05n

.meas tran vdout0_29ck960 FIND v(dout0_29) AT=970.05n

.meas tran vdout0_30ck960 FIND v(dout0_30) AT=970.05n

.meas tran vdout0_31ck960 FIND v(dout0_31) AT=970.05n

.meas tran vdout0_32ck960 FIND v(dout0_32) AT=970.05n

.meas tran vdout0_0ck980 FIND v(dout0_0) AT=990.05n

.meas tran vdout0_1ck980 FIND v(dout0_1) AT=990.05n

.meas tran vdout0_2ck980 FIND v(dout0_2) AT=990.05n

.meas tran vdout0_3ck980 FIND v(dout0_3) AT=990.05n

.meas tran vdout0_4ck980 FIND v(dout0_4) AT=990.05n

.meas tran vdout0_5ck980 FIND v(dout0_5) AT=990.05n

.meas tran vdout0_6ck980 FIND v(dout0_6) AT=990.05n

.meas tran vdout0_7ck980 FIND v(dout0_7) AT=990.05n

.meas tran vdout0_8ck980 FIND v(dout0_8) AT=990.05n

.meas tran vdout0_9ck980 FIND v(dout0_9) AT=990.05n

.meas tran vdout0_10ck980 FIND v(dout0_10) AT=990.05n

.meas tran vdout0_11ck980 FIND v(dout0_11) AT=990.05n

.meas tran vdout0_12ck980 FIND v(dout0_12) AT=990.05n

.meas tran vdout0_13ck980 FIND v(dout0_13) AT=990.05n

.meas tran vdout0_14ck980 FIND v(dout0_14) AT=990.05n

.meas tran vdout0_15ck980 FIND v(dout0_15) AT=990.05n

.meas tran vdout0_16ck980 FIND v(dout0_16) AT=990.05n

.meas tran vdout0_17ck980 FIND v(dout0_17) AT=990.05n

.meas tran vdout0_18ck980 FIND v(dout0_18) AT=990.05n

.meas tran vdout0_19ck980 FIND v(dout0_19) AT=990.05n

.meas tran vdout0_20ck980 FIND v(dout0_20) AT=990.05n

.meas tran vdout0_21ck980 FIND v(dout0_21) AT=990.05n

.meas tran vdout0_22ck980 FIND v(dout0_22) AT=990.05n

.meas tran vdout0_23ck980 FIND v(dout0_23) AT=990.05n

.meas tran vdout0_24ck980 FIND v(dout0_24) AT=990.05n

.meas tran vdout0_25ck980 FIND v(dout0_25) AT=990.05n

.meas tran vdout0_26ck980 FIND v(dout0_26) AT=990.05n

.meas tran vdout0_27ck980 FIND v(dout0_27) AT=990.05n

.meas tran vdout0_28ck980 FIND v(dout0_28) AT=990.05n

.meas tran vdout0_29ck980 FIND v(dout0_29) AT=990.05n

.meas tran vdout0_30ck980 FIND v(dout0_30) AT=990.05n

.meas tran vdout0_31ck980 FIND v(dout0_31) AT=990.05n

.meas tran vdout0_32ck980 FIND v(dout0_32) AT=990.05n

.meas tran vdout0_0ck990 FIND v(dout0_0) AT=1000.05n

.meas tran vdout0_1ck990 FIND v(dout0_1) AT=1000.05n

.meas tran vdout0_2ck990 FIND v(dout0_2) AT=1000.05n

.meas tran vdout0_3ck990 FIND v(dout0_3) AT=1000.05n

.meas tran vdout0_4ck990 FIND v(dout0_4) AT=1000.05n

.meas tran vdout0_5ck990 FIND v(dout0_5) AT=1000.05n

.meas tran vdout0_6ck990 FIND v(dout0_6) AT=1000.05n

.meas tran vdout0_7ck990 FIND v(dout0_7) AT=1000.05n

.meas tran vdout0_8ck990 FIND v(dout0_8) AT=1000.05n

.meas tran vdout0_9ck990 FIND v(dout0_9) AT=1000.05n

.meas tran vdout0_10ck990 FIND v(dout0_10) AT=1000.05n

.meas tran vdout0_11ck990 FIND v(dout0_11) AT=1000.05n

.meas tran vdout0_12ck990 FIND v(dout0_12) AT=1000.05n

.meas tran vdout0_13ck990 FIND v(dout0_13) AT=1000.05n

.meas tran vdout0_14ck990 FIND v(dout0_14) AT=1000.05n

.meas tran vdout0_15ck990 FIND v(dout0_15) AT=1000.05n

.meas tran vdout0_16ck990 FIND v(dout0_16) AT=1000.05n

.meas tran vdout0_17ck990 FIND v(dout0_17) AT=1000.05n

.meas tran vdout0_18ck990 FIND v(dout0_18) AT=1000.05n

.meas tran vdout0_19ck990 FIND v(dout0_19) AT=1000.05n

.meas tran vdout0_20ck990 FIND v(dout0_20) AT=1000.05n

.meas tran vdout0_21ck990 FIND v(dout0_21) AT=1000.05n

.meas tran vdout0_22ck990 FIND v(dout0_22) AT=1000.05n

.meas tran vdout0_23ck990 FIND v(dout0_23) AT=1000.05n

.meas tran vdout0_24ck990 FIND v(dout0_24) AT=1000.05n

.meas tran vdout0_25ck990 FIND v(dout0_25) AT=1000.05n

.meas tran vdout0_26ck990 FIND v(dout0_26) AT=1000.05n

.meas tran vdout0_27ck990 FIND v(dout0_27) AT=1000.05n

.meas tran vdout0_28ck990 FIND v(dout0_28) AT=1000.05n

.meas tran vdout0_29ck990 FIND v(dout0_29) AT=1000.05n

.meas tran vdout0_30ck990 FIND v(dout0_30) AT=1000.05n

.meas tran vdout0_31ck990 FIND v(dout0_31) AT=1000.05n

.meas tran vdout0_32ck990 FIND v(dout0_32) AT=1000.05n

.meas tran vdout0_0ck1010 FIND v(dout0_0) AT=1020.05n

.meas tran vdout0_1ck1010 FIND v(dout0_1) AT=1020.05n

.meas tran vdout0_2ck1010 FIND v(dout0_2) AT=1020.05n

.meas tran vdout0_3ck1010 FIND v(dout0_3) AT=1020.05n

.meas tran vdout0_4ck1010 FIND v(dout0_4) AT=1020.05n

.meas tran vdout0_5ck1010 FIND v(dout0_5) AT=1020.05n

.meas tran vdout0_6ck1010 FIND v(dout0_6) AT=1020.05n

.meas tran vdout0_7ck1010 FIND v(dout0_7) AT=1020.05n

.meas tran vdout0_8ck1010 FIND v(dout0_8) AT=1020.05n

.meas tran vdout0_9ck1010 FIND v(dout0_9) AT=1020.05n

.meas tran vdout0_10ck1010 FIND v(dout0_10) AT=1020.05n

.meas tran vdout0_11ck1010 FIND v(dout0_11) AT=1020.05n

.meas tran vdout0_12ck1010 FIND v(dout0_12) AT=1020.05n

.meas tran vdout0_13ck1010 FIND v(dout0_13) AT=1020.05n

.meas tran vdout0_14ck1010 FIND v(dout0_14) AT=1020.05n

.meas tran vdout0_15ck1010 FIND v(dout0_15) AT=1020.05n

.meas tran vdout0_16ck1010 FIND v(dout0_16) AT=1020.05n

.meas tran vdout0_17ck1010 FIND v(dout0_17) AT=1020.05n

.meas tran vdout0_18ck1010 FIND v(dout0_18) AT=1020.05n

.meas tran vdout0_19ck1010 FIND v(dout0_19) AT=1020.05n

.meas tran vdout0_20ck1010 FIND v(dout0_20) AT=1020.05n

.meas tran vdout0_21ck1010 FIND v(dout0_21) AT=1020.05n

.meas tran vdout0_22ck1010 FIND v(dout0_22) AT=1020.05n

.meas tran vdout0_23ck1010 FIND v(dout0_23) AT=1020.05n

.meas tran vdout0_24ck1010 FIND v(dout0_24) AT=1020.05n

.meas tran vdout0_25ck1010 FIND v(dout0_25) AT=1020.05n

.meas tran vdout0_26ck1010 FIND v(dout0_26) AT=1020.05n

.meas tran vdout0_27ck1010 FIND v(dout0_27) AT=1020.05n

.meas tran vdout0_28ck1010 FIND v(dout0_28) AT=1020.05n

.meas tran vdout0_29ck1010 FIND v(dout0_29) AT=1020.05n

.meas tran vdout0_30ck1010 FIND v(dout0_30) AT=1020.05n

.meas tran vdout0_31ck1010 FIND v(dout0_31) AT=1020.05n

.meas tran vdout0_32ck1010 FIND v(dout0_32) AT=1020.05n

.meas tran vdout0_0ck1040 FIND v(dout0_0) AT=1050.05n

.meas tran vdout0_1ck1040 FIND v(dout0_1) AT=1050.05n

.meas tran vdout0_2ck1040 FIND v(dout0_2) AT=1050.05n

.meas tran vdout0_3ck1040 FIND v(dout0_3) AT=1050.05n

.meas tran vdout0_4ck1040 FIND v(dout0_4) AT=1050.05n

.meas tran vdout0_5ck1040 FIND v(dout0_5) AT=1050.05n

.meas tran vdout0_6ck1040 FIND v(dout0_6) AT=1050.05n

.meas tran vdout0_7ck1040 FIND v(dout0_7) AT=1050.05n

.meas tran vdout0_8ck1040 FIND v(dout0_8) AT=1050.05n

.meas tran vdout0_9ck1040 FIND v(dout0_9) AT=1050.05n

.meas tran vdout0_10ck1040 FIND v(dout0_10) AT=1050.05n

.meas tran vdout0_11ck1040 FIND v(dout0_11) AT=1050.05n

.meas tran vdout0_12ck1040 FIND v(dout0_12) AT=1050.05n

.meas tran vdout0_13ck1040 FIND v(dout0_13) AT=1050.05n

.meas tran vdout0_14ck1040 FIND v(dout0_14) AT=1050.05n

.meas tran vdout0_15ck1040 FIND v(dout0_15) AT=1050.05n

.meas tran vdout0_16ck1040 FIND v(dout0_16) AT=1050.05n

.meas tran vdout0_17ck1040 FIND v(dout0_17) AT=1050.05n

.meas tran vdout0_18ck1040 FIND v(dout0_18) AT=1050.05n

.meas tran vdout0_19ck1040 FIND v(dout0_19) AT=1050.05n

.meas tran vdout0_20ck1040 FIND v(dout0_20) AT=1050.05n

.meas tran vdout0_21ck1040 FIND v(dout0_21) AT=1050.05n

.meas tran vdout0_22ck1040 FIND v(dout0_22) AT=1050.05n

.meas tran vdout0_23ck1040 FIND v(dout0_23) AT=1050.05n

.meas tran vdout0_24ck1040 FIND v(dout0_24) AT=1050.05n

.meas tran vdout0_25ck1040 FIND v(dout0_25) AT=1050.05n

.meas tran vdout0_26ck1040 FIND v(dout0_26) AT=1050.05n

.meas tran vdout0_27ck1040 FIND v(dout0_27) AT=1050.05n

.meas tran vdout0_28ck1040 FIND v(dout0_28) AT=1050.05n

.meas tran vdout0_29ck1040 FIND v(dout0_29) AT=1050.05n

.meas tran vdout0_30ck1040 FIND v(dout0_30) AT=1050.05n

.meas tran vdout0_31ck1040 FIND v(dout0_31) AT=1050.05n

.meas tran vdout0_32ck1040 FIND v(dout0_32) AT=1050.05n

.meas tran vdout0_0ck1050 FIND v(dout0_0) AT=1060.05n

.meas tran vdout0_1ck1050 FIND v(dout0_1) AT=1060.05n

.meas tran vdout0_2ck1050 FIND v(dout0_2) AT=1060.05n

.meas tran vdout0_3ck1050 FIND v(dout0_3) AT=1060.05n

.meas tran vdout0_4ck1050 FIND v(dout0_4) AT=1060.05n

.meas tran vdout0_5ck1050 FIND v(dout0_5) AT=1060.05n

.meas tran vdout0_6ck1050 FIND v(dout0_6) AT=1060.05n

.meas tran vdout0_7ck1050 FIND v(dout0_7) AT=1060.05n

.meas tran vdout0_8ck1050 FIND v(dout0_8) AT=1060.05n

.meas tran vdout0_9ck1050 FIND v(dout0_9) AT=1060.05n

.meas tran vdout0_10ck1050 FIND v(dout0_10) AT=1060.05n

.meas tran vdout0_11ck1050 FIND v(dout0_11) AT=1060.05n

.meas tran vdout0_12ck1050 FIND v(dout0_12) AT=1060.05n

.meas tran vdout0_13ck1050 FIND v(dout0_13) AT=1060.05n

.meas tran vdout0_14ck1050 FIND v(dout0_14) AT=1060.05n

.meas tran vdout0_15ck1050 FIND v(dout0_15) AT=1060.05n

.meas tran vdout0_16ck1050 FIND v(dout0_16) AT=1060.05n

.meas tran vdout0_17ck1050 FIND v(dout0_17) AT=1060.05n

.meas tran vdout0_18ck1050 FIND v(dout0_18) AT=1060.05n

.meas tran vdout0_19ck1050 FIND v(dout0_19) AT=1060.05n

.meas tran vdout0_20ck1050 FIND v(dout0_20) AT=1060.05n

.meas tran vdout0_21ck1050 FIND v(dout0_21) AT=1060.05n

.meas tran vdout0_22ck1050 FIND v(dout0_22) AT=1060.05n

.meas tran vdout0_23ck1050 FIND v(dout0_23) AT=1060.05n

.meas tran vdout0_24ck1050 FIND v(dout0_24) AT=1060.05n

.meas tran vdout0_25ck1050 FIND v(dout0_25) AT=1060.05n

.meas tran vdout0_26ck1050 FIND v(dout0_26) AT=1060.05n

.meas tran vdout0_27ck1050 FIND v(dout0_27) AT=1060.05n

.meas tran vdout0_28ck1050 FIND v(dout0_28) AT=1060.05n

.meas tran vdout0_29ck1050 FIND v(dout0_29) AT=1060.05n

.meas tran vdout0_30ck1050 FIND v(dout0_30) AT=1060.05n

.meas tran vdout0_31ck1050 FIND v(dout0_31) AT=1060.05n

.meas tran vdout0_32ck1050 FIND v(dout0_32) AT=1060.05n

.meas tran vdout0_0ck1060 FIND v(dout0_0) AT=1070.05n

.meas tran vdout0_1ck1060 FIND v(dout0_1) AT=1070.05n

.meas tran vdout0_2ck1060 FIND v(dout0_2) AT=1070.05n

.meas tran vdout0_3ck1060 FIND v(dout0_3) AT=1070.05n

.meas tran vdout0_4ck1060 FIND v(dout0_4) AT=1070.05n

.meas tran vdout0_5ck1060 FIND v(dout0_5) AT=1070.05n

.meas tran vdout0_6ck1060 FIND v(dout0_6) AT=1070.05n

.meas tran vdout0_7ck1060 FIND v(dout0_7) AT=1070.05n

.meas tran vdout0_8ck1060 FIND v(dout0_8) AT=1070.05n

.meas tran vdout0_9ck1060 FIND v(dout0_9) AT=1070.05n

.meas tran vdout0_10ck1060 FIND v(dout0_10) AT=1070.05n

.meas tran vdout0_11ck1060 FIND v(dout0_11) AT=1070.05n

.meas tran vdout0_12ck1060 FIND v(dout0_12) AT=1070.05n

.meas tran vdout0_13ck1060 FIND v(dout0_13) AT=1070.05n

.meas tran vdout0_14ck1060 FIND v(dout0_14) AT=1070.05n

.meas tran vdout0_15ck1060 FIND v(dout0_15) AT=1070.05n

.meas tran vdout0_16ck1060 FIND v(dout0_16) AT=1070.05n

.meas tran vdout0_17ck1060 FIND v(dout0_17) AT=1070.05n

.meas tran vdout0_18ck1060 FIND v(dout0_18) AT=1070.05n

.meas tran vdout0_19ck1060 FIND v(dout0_19) AT=1070.05n

.meas tran vdout0_20ck1060 FIND v(dout0_20) AT=1070.05n

.meas tran vdout0_21ck1060 FIND v(dout0_21) AT=1070.05n

.meas tran vdout0_22ck1060 FIND v(dout0_22) AT=1070.05n

.meas tran vdout0_23ck1060 FIND v(dout0_23) AT=1070.05n

.meas tran vdout0_24ck1060 FIND v(dout0_24) AT=1070.05n

.meas tran vdout0_25ck1060 FIND v(dout0_25) AT=1070.05n

.meas tran vdout0_26ck1060 FIND v(dout0_26) AT=1070.05n

.meas tran vdout0_27ck1060 FIND v(dout0_27) AT=1070.05n

.meas tran vdout0_28ck1060 FIND v(dout0_28) AT=1070.05n

.meas tran vdout0_29ck1060 FIND v(dout0_29) AT=1070.05n

.meas tran vdout0_30ck1060 FIND v(dout0_30) AT=1070.05n

.meas tran vdout0_31ck1060 FIND v(dout0_31) AT=1070.05n

.meas tran vdout0_32ck1060 FIND v(dout0_32) AT=1070.05n

.meas tran vdout0_0ck1100 FIND v(dout0_0) AT=1110.05n

.meas tran vdout0_1ck1100 FIND v(dout0_1) AT=1110.05n

.meas tran vdout0_2ck1100 FIND v(dout0_2) AT=1110.05n

.meas tran vdout0_3ck1100 FIND v(dout0_3) AT=1110.05n

.meas tran vdout0_4ck1100 FIND v(dout0_4) AT=1110.05n

.meas tran vdout0_5ck1100 FIND v(dout0_5) AT=1110.05n

.meas tran vdout0_6ck1100 FIND v(dout0_6) AT=1110.05n

.meas tran vdout0_7ck1100 FIND v(dout0_7) AT=1110.05n

.meas tran vdout0_8ck1100 FIND v(dout0_8) AT=1110.05n

.meas tran vdout0_9ck1100 FIND v(dout0_9) AT=1110.05n

.meas tran vdout0_10ck1100 FIND v(dout0_10) AT=1110.05n

.meas tran vdout0_11ck1100 FIND v(dout0_11) AT=1110.05n

.meas tran vdout0_12ck1100 FIND v(dout0_12) AT=1110.05n

.meas tran vdout0_13ck1100 FIND v(dout0_13) AT=1110.05n

.meas tran vdout0_14ck1100 FIND v(dout0_14) AT=1110.05n

.meas tran vdout0_15ck1100 FIND v(dout0_15) AT=1110.05n

.meas tran vdout0_16ck1100 FIND v(dout0_16) AT=1110.05n

.meas tran vdout0_17ck1100 FIND v(dout0_17) AT=1110.05n

.meas tran vdout0_18ck1100 FIND v(dout0_18) AT=1110.05n

.meas tran vdout0_19ck1100 FIND v(dout0_19) AT=1110.05n

.meas tran vdout0_20ck1100 FIND v(dout0_20) AT=1110.05n

.meas tran vdout0_21ck1100 FIND v(dout0_21) AT=1110.05n

.meas tran vdout0_22ck1100 FIND v(dout0_22) AT=1110.05n

.meas tran vdout0_23ck1100 FIND v(dout0_23) AT=1110.05n

.meas tran vdout0_24ck1100 FIND v(dout0_24) AT=1110.05n

.meas tran vdout0_25ck1100 FIND v(dout0_25) AT=1110.05n

.meas tran vdout0_26ck1100 FIND v(dout0_26) AT=1110.05n

.meas tran vdout0_27ck1100 FIND v(dout0_27) AT=1110.05n

.meas tran vdout0_28ck1100 FIND v(dout0_28) AT=1110.05n

.meas tran vdout0_29ck1100 FIND v(dout0_29) AT=1110.05n

.meas tran vdout0_30ck1100 FIND v(dout0_30) AT=1110.05n

.meas tran vdout0_31ck1100 FIND v(dout0_31) AT=1110.05n

.meas tran vdout0_32ck1100 FIND v(dout0_32) AT=1110.05n

.meas tran vdout0_0ck1150 FIND v(dout0_0) AT=1160.05n

.meas tran vdout0_1ck1150 FIND v(dout0_1) AT=1160.05n

.meas tran vdout0_2ck1150 FIND v(dout0_2) AT=1160.05n

.meas tran vdout0_3ck1150 FIND v(dout0_3) AT=1160.05n

.meas tran vdout0_4ck1150 FIND v(dout0_4) AT=1160.05n

.meas tran vdout0_5ck1150 FIND v(dout0_5) AT=1160.05n

.meas tran vdout0_6ck1150 FIND v(dout0_6) AT=1160.05n

.meas tran vdout0_7ck1150 FIND v(dout0_7) AT=1160.05n

.meas tran vdout0_8ck1150 FIND v(dout0_8) AT=1160.05n

.meas tran vdout0_9ck1150 FIND v(dout0_9) AT=1160.05n

.meas tran vdout0_10ck1150 FIND v(dout0_10) AT=1160.05n

.meas tran vdout0_11ck1150 FIND v(dout0_11) AT=1160.05n

.meas tran vdout0_12ck1150 FIND v(dout0_12) AT=1160.05n

.meas tran vdout0_13ck1150 FIND v(dout0_13) AT=1160.05n

.meas tran vdout0_14ck1150 FIND v(dout0_14) AT=1160.05n

.meas tran vdout0_15ck1150 FIND v(dout0_15) AT=1160.05n

.meas tran vdout0_16ck1150 FIND v(dout0_16) AT=1160.05n

.meas tran vdout0_17ck1150 FIND v(dout0_17) AT=1160.05n

.meas tran vdout0_18ck1150 FIND v(dout0_18) AT=1160.05n

.meas tran vdout0_19ck1150 FIND v(dout0_19) AT=1160.05n

.meas tran vdout0_20ck1150 FIND v(dout0_20) AT=1160.05n

.meas tran vdout0_21ck1150 FIND v(dout0_21) AT=1160.05n

.meas tran vdout0_22ck1150 FIND v(dout0_22) AT=1160.05n

.meas tran vdout0_23ck1150 FIND v(dout0_23) AT=1160.05n

.meas tran vdout0_24ck1150 FIND v(dout0_24) AT=1160.05n

.meas tran vdout0_25ck1150 FIND v(dout0_25) AT=1160.05n

.meas tran vdout0_26ck1150 FIND v(dout0_26) AT=1160.05n

.meas tran vdout0_27ck1150 FIND v(dout0_27) AT=1160.05n

.meas tran vdout0_28ck1150 FIND v(dout0_28) AT=1160.05n

.meas tran vdout0_29ck1150 FIND v(dout0_29) AT=1160.05n

.meas tran vdout0_30ck1150 FIND v(dout0_30) AT=1160.05n

.meas tran vdout0_31ck1150 FIND v(dout0_31) AT=1160.05n

.meas tran vdout0_32ck1150 FIND v(dout0_32) AT=1160.05n

.meas tran vdout0_0ck1160 FIND v(dout0_0) AT=1170.05n

.meas tran vdout0_1ck1160 FIND v(dout0_1) AT=1170.05n

.meas tran vdout0_2ck1160 FIND v(dout0_2) AT=1170.05n

.meas tran vdout0_3ck1160 FIND v(dout0_3) AT=1170.05n

.meas tran vdout0_4ck1160 FIND v(dout0_4) AT=1170.05n

.meas tran vdout0_5ck1160 FIND v(dout0_5) AT=1170.05n

.meas tran vdout0_6ck1160 FIND v(dout0_6) AT=1170.05n

.meas tran vdout0_7ck1160 FIND v(dout0_7) AT=1170.05n

.meas tran vdout0_8ck1160 FIND v(dout0_8) AT=1170.05n

.meas tran vdout0_9ck1160 FIND v(dout0_9) AT=1170.05n

.meas tran vdout0_10ck1160 FIND v(dout0_10) AT=1170.05n

.meas tran vdout0_11ck1160 FIND v(dout0_11) AT=1170.05n

.meas tran vdout0_12ck1160 FIND v(dout0_12) AT=1170.05n

.meas tran vdout0_13ck1160 FIND v(dout0_13) AT=1170.05n

.meas tran vdout0_14ck1160 FIND v(dout0_14) AT=1170.05n

.meas tran vdout0_15ck1160 FIND v(dout0_15) AT=1170.05n

.meas tran vdout0_16ck1160 FIND v(dout0_16) AT=1170.05n

.meas tran vdout0_17ck1160 FIND v(dout0_17) AT=1170.05n

.meas tran vdout0_18ck1160 FIND v(dout0_18) AT=1170.05n

.meas tran vdout0_19ck1160 FIND v(dout0_19) AT=1170.05n

.meas tran vdout0_20ck1160 FIND v(dout0_20) AT=1170.05n

.meas tran vdout0_21ck1160 FIND v(dout0_21) AT=1170.05n

.meas tran vdout0_22ck1160 FIND v(dout0_22) AT=1170.05n

.meas tran vdout0_23ck1160 FIND v(dout0_23) AT=1170.05n

.meas tran vdout0_24ck1160 FIND v(dout0_24) AT=1170.05n

.meas tran vdout0_25ck1160 FIND v(dout0_25) AT=1170.05n

.meas tran vdout0_26ck1160 FIND v(dout0_26) AT=1170.05n

.meas tran vdout0_27ck1160 FIND v(dout0_27) AT=1170.05n

.meas tran vdout0_28ck1160 FIND v(dout0_28) AT=1170.05n

.meas tran vdout0_29ck1160 FIND v(dout0_29) AT=1170.05n

.meas tran vdout0_30ck1160 FIND v(dout0_30) AT=1170.05n

.meas tran vdout0_31ck1160 FIND v(dout0_31) AT=1170.05n

.meas tran vdout0_32ck1160 FIND v(dout0_32) AT=1170.05n

.meas tran vdout0_0ck1180 FIND v(dout0_0) AT=1190.05n

.meas tran vdout0_1ck1180 FIND v(dout0_1) AT=1190.05n

.meas tran vdout0_2ck1180 FIND v(dout0_2) AT=1190.05n

.meas tran vdout0_3ck1180 FIND v(dout0_3) AT=1190.05n

.meas tran vdout0_4ck1180 FIND v(dout0_4) AT=1190.05n

.meas tran vdout0_5ck1180 FIND v(dout0_5) AT=1190.05n

.meas tran vdout0_6ck1180 FIND v(dout0_6) AT=1190.05n

.meas tran vdout0_7ck1180 FIND v(dout0_7) AT=1190.05n

.meas tran vdout0_8ck1180 FIND v(dout0_8) AT=1190.05n

.meas tran vdout0_9ck1180 FIND v(dout0_9) AT=1190.05n

.meas tran vdout0_10ck1180 FIND v(dout0_10) AT=1190.05n

.meas tran vdout0_11ck1180 FIND v(dout0_11) AT=1190.05n

.meas tran vdout0_12ck1180 FIND v(dout0_12) AT=1190.05n

.meas tran vdout0_13ck1180 FIND v(dout0_13) AT=1190.05n

.meas tran vdout0_14ck1180 FIND v(dout0_14) AT=1190.05n

.meas tran vdout0_15ck1180 FIND v(dout0_15) AT=1190.05n

.meas tran vdout0_16ck1180 FIND v(dout0_16) AT=1190.05n

.meas tran vdout0_17ck1180 FIND v(dout0_17) AT=1190.05n

.meas tran vdout0_18ck1180 FIND v(dout0_18) AT=1190.05n

.meas tran vdout0_19ck1180 FIND v(dout0_19) AT=1190.05n

.meas tran vdout0_20ck1180 FIND v(dout0_20) AT=1190.05n

.meas tran vdout0_21ck1180 FIND v(dout0_21) AT=1190.05n

.meas tran vdout0_22ck1180 FIND v(dout0_22) AT=1190.05n

.meas tran vdout0_23ck1180 FIND v(dout0_23) AT=1190.05n

.meas tran vdout0_24ck1180 FIND v(dout0_24) AT=1190.05n

.meas tran vdout0_25ck1180 FIND v(dout0_25) AT=1190.05n

.meas tran vdout0_26ck1180 FIND v(dout0_26) AT=1190.05n

.meas tran vdout0_27ck1180 FIND v(dout0_27) AT=1190.05n

.meas tran vdout0_28ck1180 FIND v(dout0_28) AT=1190.05n

.meas tran vdout0_29ck1180 FIND v(dout0_29) AT=1190.05n

.meas tran vdout0_30ck1180 FIND v(dout0_30) AT=1190.05n

.meas tran vdout0_31ck1180 FIND v(dout0_31) AT=1190.05n

.meas tran vdout0_32ck1180 FIND v(dout0_32) AT=1190.05n

.meas tran vdout0_0ck1190 FIND v(dout0_0) AT=1200.05n

.meas tran vdout0_1ck1190 FIND v(dout0_1) AT=1200.05n

.meas tran vdout0_2ck1190 FIND v(dout0_2) AT=1200.05n

.meas tran vdout0_3ck1190 FIND v(dout0_3) AT=1200.05n

.meas tran vdout0_4ck1190 FIND v(dout0_4) AT=1200.05n

.meas tran vdout0_5ck1190 FIND v(dout0_5) AT=1200.05n

.meas tran vdout0_6ck1190 FIND v(dout0_6) AT=1200.05n

.meas tran vdout0_7ck1190 FIND v(dout0_7) AT=1200.05n

.meas tran vdout0_8ck1190 FIND v(dout0_8) AT=1200.05n

.meas tran vdout0_9ck1190 FIND v(dout0_9) AT=1200.05n

.meas tran vdout0_10ck1190 FIND v(dout0_10) AT=1200.05n

.meas tran vdout0_11ck1190 FIND v(dout0_11) AT=1200.05n

.meas tran vdout0_12ck1190 FIND v(dout0_12) AT=1200.05n

.meas tran vdout0_13ck1190 FIND v(dout0_13) AT=1200.05n

.meas tran vdout0_14ck1190 FIND v(dout0_14) AT=1200.05n

.meas tran vdout0_15ck1190 FIND v(dout0_15) AT=1200.05n

.meas tran vdout0_16ck1190 FIND v(dout0_16) AT=1200.05n

.meas tran vdout0_17ck1190 FIND v(dout0_17) AT=1200.05n

.meas tran vdout0_18ck1190 FIND v(dout0_18) AT=1200.05n

.meas tran vdout0_19ck1190 FIND v(dout0_19) AT=1200.05n

.meas tran vdout0_20ck1190 FIND v(dout0_20) AT=1200.05n

.meas tran vdout0_21ck1190 FIND v(dout0_21) AT=1200.05n

.meas tran vdout0_22ck1190 FIND v(dout0_22) AT=1200.05n

.meas tran vdout0_23ck1190 FIND v(dout0_23) AT=1200.05n

.meas tran vdout0_24ck1190 FIND v(dout0_24) AT=1200.05n

.meas tran vdout0_25ck1190 FIND v(dout0_25) AT=1200.05n

.meas tran vdout0_26ck1190 FIND v(dout0_26) AT=1200.05n

.meas tran vdout0_27ck1190 FIND v(dout0_27) AT=1200.05n

.meas tran vdout0_28ck1190 FIND v(dout0_28) AT=1200.05n

.meas tran vdout0_29ck1190 FIND v(dout0_29) AT=1200.05n

.meas tran vdout0_30ck1190 FIND v(dout0_30) AT=1200.05n

.meas tran vdout0_31ck1190 FIND v(dout0_31) AT=1200.05n

.meas tran vdout0_32ck1190 FIND v(dout0_32) AT=1200.05n

.meas tran vdout0_0ck1200 FIND v(dout0_0) AT=1210.05n

.meas tran vdout0_1ck1200 FIND v(dout0_1) AT=1210.05n

.meas tran vdout0_2ck1200 FIND v(dout0_2) AT=1210.05n

.meas tran vdout0_3ck1200 FIND v(dout0_3) AT=1210.05n

.meas tran vdout0_4ck1200 FIND v(dout0_4) AT=1210.05n

.meas tran vdout0_5ck1200 FIND v(dout0_5) AT=1210.05n

.meas tran vdout0_6ck1200 FIND v(dout0_6) AT=1210.05n

.meas tran vdout0_7ck1200 FIND v(dout0_7) AT=1210.05n

.meas tran vdout0_8ck1200 FIND v(dout0_8) AT=1210.05n

.meas tran vdout0_9ck1200 FIND v(dout0_9) AT=1210.05n

.meas tran vdout0_10ck1200 FIND v(dout0_10) AT=1210.05n

.meas tran vdout0_11ck1200 FIND v(dout0_11) AT=1210.05n

.meas tran vdout0_12ck1200 FIND v(dout0_12) AT=1210.05n

.meas tran vdout0_13ck1200 FIND v(dout0_13) AT=1210.05n

.meas tran vdout0_14ck1200 FIND v(dout0_14) AT=1210.05n

.meas tran vdout0_15ck1200 FIND v(dout0_15) AT=1210.05n

.meas tran vdout0_16ck1200 FIND v(dout0_16) AT=1210.05n

.meas tran vdout0_17ck1200 FIND v(dout0_17) AT=1210.05n

.meas tran vdout0_18ck1200 FIND v(dout0_18) AT=1210.05n

.meas tran vdout0_19ck1200 FIND v(dout0_19) AT=1210.05n

.meas tran vdout0_20ck1200 FIND v(dout0_20) AT=1210.05n

.meas tran vdout0_21ck1200 FIND v(dout0_21) AT=1210.05n

.meas tran vdout0_22ck1200 FIND v(dout0_22) AT=1210.05n

.meas tran vdout0_23ck1200 FIND v(dout0_23) AT=1210.05n

.meas tran vdout0_24ck1200 FIND v(dout0_24) AT=1210.05n

.meas tran vdout0_25ck1200 FIND v(dout0_25) AT=1210.05n

.meas tran vdout0_26ck1200 FIND v(dout0_26) AT=1210.05n

.meas tran vdout0_27ck1200 FIND v(dout0_27) AT=1210.05n

.meas tran vdout0_28ck1200 FIND v(dout0_28) AT=1210.05n

.meas tran vdout0_29ck1200 FIND v(dout0_29) AT=1210.05n

.meas tran vdout0_30ck1200 FIND v(dout0_30) AT=1210.05n

.meas tran vdout0_31ck1200 FIND v(dout0_31) AT=1210.05n

.meas tran vdout0_32ck1200 FIND v(dout0_32) AT=1210.05n

.meas tran vdout0_0ck1220 FIND v(dout0_0) AT=1230.05n

.meas tran vdout0_1ck1220 FIND v(dout0_1) AT=1230.05n

.meas tran vdout0_2ck1220 FIND v(dout0_2) AT=1230.05n

.meas tran vdout0_3ck1220 FIND v(dout0_3) AT=1230.05n

.meas tran vdout0_4ck1220 FIND v(dout0_4) AT=1230.05n

.meas tran vdout0_5ck1220 FIND v(dout0_5) AT=1230.05n

.meas tran vdout0_6ck1220 FIND v(dout0_6) AT=1230.05n

.meas tran vdout0_7ck1220 FIND v(dout0_7) AT=1230.05n

.meas tran vdout0_8ck1220 FIND v(dout0_8) AT=1230.05n

.meas tran vdout0_9ck1220 FIND v(dout0_9) AT=1230.05n

.meas tran vdout0_10ck1220 FIND v(dout0_10) AT=1230.05n

.meas tran vdout0_11ck1220 FIND v(dout0_11) AT=1230.05n

.meas tran vdout0_12ck1220 FIND v(dout0_12) AT=1230.05n

.meas tran vdout0_13ck1220 FIND v(dout0_13) AT=1230.05n

.meas tran vdout0_14ck1220 FIND v(dout0_14) AT=1230.05n

.meas tran vdout0_15ck1220 FIND v(dout0_15) AT=1230.05n

.meas tran vdout0_16ck1220 FIND v(dout0_16) AT=1230.05n

.meas tran vdout0_17ck1220 FIND v(dout0_17) AT=1230.05n

.meas tran vdout0_18ck1220 FIND v(dout0_18) AT=1230.05n

.meas tran vdout0_19ck1220 FIND v(dout0_19) AT=1230.05n

.meas tran vdout0_20ck1220 FIND v(dout0_20) AT=1230.05n

.meas tran vdout0_21ck1220 FIND v(dout0_21) AT=1230.05n

.meas tran vdout0_22ck1220 FIND v(dout0_22) AT=1230.05n

.meas tran vdout0_23ck1220 FIND v(dout0_23) AT=1230.05n

.meas tran vdout0_24ck1220 FIND v(dout0_24) AT=1230.05n

.meas tran vdout0_25ck1220 FIND v(dout0_25) AT=1230.05n

.meas tran vdout0_26ck1220 FIND v(dout0_26) AT=1230.05n

.meas tran vdout0_27ck1220 FIND v(dout0_27) AT=1230.05n

.meas tran vdout0_28ck1220 FIND v(dout0_28) AT=1230.05n

.meas tran vdout0_29ck1220 FIND v(dout0_29) AT=1230.05n

.meas tran vdout0_30ck1220 FIND v(dout0_30) AT=1230.05n

.meas tran vdout0_31ck1220 FIND v(dout0_31) AT=1230.05n

.meas tran vdout0_32ck1220 FIND v(dout0_32) AT=1230.05n

.meas tran vdout0_0ck1250 FIND v(dout0_0) AT=1260.05n

.meas tran vdout0_1ck1250 FIND v(dout0_1) AT=1260.05n

.meas tran vdout0_2ck1250 FIND v(dout0_2) AT=1260.05n

.meas tran vdout0_3ck1250 FIND v(dout0_3) AT=1260.05n

.meas tran vdout0_4ck1250 FIND v(dout0_4) AT=1260.05n

.meas tran vdout0_5ck1250 FIND v(dout0_5) AT=1260.05n

.meas tran vdout0_6ck1250 FIND v(dout0_6) AT=1260.05n

.meas tran vdout0_7ck1250 FIND v(dout0_7) AT=1260.05n

.meas tran vdout0_8ck1250 FIND v(dout0_8) AT=1260.05n

.meas tran vdout0_9ck1250 FIND v(dout0_9) AT=1260.05n

.meas tran vdout0_10ck1250 FIND v(dout0_10) AT=1260.05n

.meas tran vdout0_11ck1250 FIND v(dout0_11) AT=1260.05n

.meas tran vdout0_12ck1250 FIND v(dout0_12) AT=1260.05n

.meas tran vdout0_13ck1250 FIND v(dout0_13) AT=1260.05n

.meas tran vdout0_14ck1250 FIND v(dout0_14) AT=1260.05n

.meas tran vdout0_15ck1250 FIND v(dout0_15) AT=1260.05n

.meas tran vdout0_16ck1250 FIND v(dout0_16) AT=1260.05n

.meas tran vdout0_17ck1250 FIND v(dout0_17) AT=1260.05n

.meas tran vdout0_18ck1250 FIND v(dout0_18) AT=1260.05n

.meas tran vdout0_19ck1250 FIND v(dout0_19) AT=1260.05n

.meas tran vdout0_20ck1250 FIND v(dout0_20) AT=1260.05n

.meas tran vdout0_21ck1250 FIND v(dout0_21) AT=1260.05n

.meas tran vdout0_22ck1250 FIND v(dout0_22) AT=1260.05n

.meas tran vdout0_23ck1250 FIND v(dout0_23) AT=1260.05n

.meas tran vdout0_24ck1250 FIND v(dout0_24) AT=1260.05n

.meas tran vdout0_25ck1250 FIND v(dout0_25) AT=1260.05n

.meas tran vdout0_26ck1250 FIND v(dout0_26) AT=1260.05n

.meas tran vdout0_27ck1250 FIND v(dout0_27) AT=1260.05n

.meas tran vdout0_28ck1250 FIND v(dout0_28) AT=1260.05n

.meas tran vdout0_29ck1250 FIND v(dout0_29) AT=1260.05n

.meas tran vdout0_30ck1250 FIND v(dout0_30) AT=1260.05n

.meas tran vdout0_31ck1250 FIND v(dout0_31) AT=1260.05n

.meas tran vdout0_32ck1250 FIND v(dout0_32) AT=1260.05n

.meas tran vdout0_0ck1270 FIND v(dout0_0) AT=1280.05n

.meas tran vdout0_1ck1270 FIND v(dout0_1) AT=1280.05n

.meas tran vdout0_2ck1270 FIND v(dout0_2) AT=1280.05n

.meas tran vdout0_3ck1270 FIND v(dout0_3) AT=1280.05n

.meas tran vdout0_4ck1270 FIND v(dout0_4) AT=1280.05n

.meas tran vdout0_5ck1270 FIND v(dout0_5) AT=1280.05n

.meas tran vdout0_6ck1270 FIND v(dout0_6) AT=1280.05n

.meas tran vdout0_7ck1270 FIND v(dout0_7) AT=1280.05n

.meas tran vdout0_8ck1270 FIND v(dout0_8) AT=1280.05n

.meas tran vdout0_9ck1270 FIND v(dout0_9) AT=1280.05n

.meas tran vdout0_10ck1270 FIND v(dout0_10) AT=1280.05n

.meas tran vdout0_11ck1270 FIND v(dout0_11) AT=1280.05n

.meas tran vdout0_12ck1270 FIND v(dout0_12) AT=1280.05n

.meas tran vdout0_13ck1270 FIND v(dout0_13) AT=1280.05n

.meas tran vdout0_14ck1270 FIND v(dout0_14) AT=1280.05n

.meas tran vdout0_15ck1270 FIND v(dout0_15) AT=1280.05n

.meas tran vdout0_16ck1270 FIND v(dout0_16) AT=1280.05n

.meas tran vdout0_17ck1270 FIND v(dout0_17) AT=1280.05n

.meas tran vdout0_18ck1270 FIND v(dout0_18) AT=1280.05n

.meas tran vdout0_19ck1270 FIND v(dout0_19) AT=1280.05n

.meas tran vdout0_20ck1270 FIND v(dout0_20) AT=1280.05n

.meas tran vdout0_21ck1270 FIND v(dout0_21) AT=1280.05n

.meas tran vdout0_22ck1270 FIND v(dout0_22) AT=1280.05n

.meas tran vdout0_23ck1270 FIND v(dout0_23) AT=1280.05n

.meas tran vdout0_24ck1270 FIND v(dout0_24) AT=1280.05n

.meas tran vdout0_25ck1270 FIND v(dout0_25) AT=1280.05n

.meas tran vdout0_26ck1270 FIND v(dout0_26) AT=1280.05n

.meas tran vdout0_27ck1270 FIND v(dout0_27) AT=1280.05n

.meas tran vdout0_28ck1270 FIND v(dout0_28) AT=1280.05n

.meas tran vdout0_29ck1270 FIND v(dout0_29) AT=1280.05n

.meas tran vdout0_30ck1270 FIND v(dout0_30) AT=1280.05n

.meas tran vdout0_31ck1270 FIND v(dout0_31) AT=1280.05n

.meas tran vdout0_32ck1270 FIND v(dout0_32) AT=1280.05n

.meas tran vdout0_0ck1320 FIND v(dout0_0) AT=1330.05n

.meas tran vdout0_1ck1320 FIND v(dout0_1) AT=1330.05n

.meas tran vdout0_2ck1320 FIND v(dout0_2) AT=1330.05n

.meas tran vdout0_3ck1320 FIND v(dout0_3) AT=1330.05n

.meas tran vdout0_4ck1320 FIND v(dout0_4) AT=1330.05n

.meas tran vdout0_5ck1320 FIND v(dout0_5) AT=1330.05n

.meas tran vdout0_6ck1320 FIND v(dout0_6) AT=1330.05n

.meas tran vdout0_7ck1320 FIND v(dout0_7) AT=1330.05n

.meas tran vdout0_8ck1320 FIND v(dout0_8) AT=1330.05n

.meas tran vdout0_9ck1320 FIND v(dout0_9) AT=1330.05n

.meas tran vdout0_10ck1320 FIND v(dout0_10) AT=1330.05n

.meas tran vdout0_11ck1320 FIND v(dout0_11) AT=1330.05n

.meas tran vdout0_12ck1320 FIND v(dout0_12) AT=1330.05n

.meas tran vdout0_13ck1320 FIND v(dout0_13) AT=1330.05n

.meas tran vdout0_14ck1320 FIND v(dout0_14) AT=1330.05n

.meas tran vdout0_15ck1320 FIND v(dout0_15) AT=1330.05n

.meas tran vdout0_16ck1320 FIND v(dout0_16) AT=1330.05n

.meas tran vdout0_17ck1320 FIND v(dout0_17) AT=1330.05n

.meas tran vdout0_18ck1320 FIND v(dout0_18) AT=1330.05n

.meas tran vdout0_19ck1320 FIND v(dout0_19) AT=1330.05n

.meas tran vdout0_20ck1320 FIND v(dout0_20) AT=1330.05n

.meas tran vdout0_21ck1320 FIND v(dout0_21) AT=1330.05n

.meas tran vdout0_22ck1320 FIND v(dout0_22) AT=1330.05n

.meas tran vdout0_23ck1320 FIND v(dout0_23) AT=1330.05n

.meas tran vdout0_24ck1320 FIND v(dout0_24) AT=1330.05n

.meas tran vdout0_25ck1320 FIND v(dout0_25) AT=1330.05n

.meas tran vdout0_26ck1320 FIND v(dout0_26) AT=1330.05n

.meas tran vdout0_27ck1320 FIND v(dout0_27) AT=1330.05n

.meas tran vdout0_28ck1320 FIND v(dout0_28) AT=1330.05n

.meas tran vdout0_29ck1320 FIND v(dout0_29) AT=1330.05n

.meas tran vdout0_30ck1320 FIND v(dout0_30) AT=1330.05n

.meas tran vdout0_31ck1320 FIND v(dout0_31) AT=1330.05n

.meas tran vdout0_32ck1320 FIND v(dout0_32) AT=1330.05n

.meas tran vdout0_0ck1330 FIND v(dout0_0) AT=1340.05n

.meas tran vdout0_1ck1330 FIND v(dout0_1) AT=1340.05n

.meas tran vdout0_2ck1330 FIND v(dout0_2) AT=1340.05n

.meas tran vdout0_3ck1330 FIND v(dout0_3) AT=1340.05n

.meas tran vdout0_4ck1330 FIND v(dout0_4) AT=1340.05n

.meas tran vdout0_5ck1330 FIND v(dout0_5) AT=1340.05n

.meas tran vdout0_6ck1330 FIND v(dout0_6) AT=1340.05n

.meas tran vdout0_7ck1330 FIND v(dout0_7) AT=1340.05n

.meas tran vdout0_8ck1330 FIND v(dout0_8) AT=1340.05n

.meas tran vdout0_9ck1330 FIND v(dout0_9) AT=1340.05n

.meas tran vdout0_10ck1330 FIND v(dout0_10) AT=1340.05n

.meas tran vdout0_11ck1330 FIND v(dout0_11) AT=1340.05n

.meas tran vdout0_12ck1330 FIND v(dout0_12) AT=1340.05n

.meas tran vdout0_13ck1330 FIND v(dout0_13) AT=1340.05n

.meas tran vdout0_14ck1330 FIND v(dout0_14) AT=1340.05n

.meas tran vdout0_15ck1330 FIND v(dout0_15) AT=1340.05n

.meas tran vdout0_16ck1330 FIND v(dout0_16) AT=1340.05n

.meas tran vdout0_17ck1330 FIND v(dout0_17) AT=1340.05n

.meas tran vdout0_18ck1330 FIND v(dout0_18) AT=1340.05n

.meas tran vdout0_19ck1330 FIND v(dout0_19) AT=1340.05n

.meas tran vdout0_20ck1330 FIND v(dout0_20) AT=1340.05n

.meas tran vdout0_21ck1330 FIND v(dout0_21) AT=1340.05n

.meas tran vdout0_22ck1330 FIND v(dout0_22) AT=1340.05n

.meas tran vdout0_23ck1330 FIND v(dout0_23) AT=1340.05n

.meas tran vdout0_24ck1330 FIND v(dout0_24) AT=1340.05n

.meas tran vdout0_25ck1330 FIND v(dout0_25) AT=1340.05n

.meas tran vdout0_26ck1330 FIND v(dout0_26) AT=1340.05n

.meas tran vdout0_27ck1330 FIND v(dout0_27) AT=1340.05n

.meas tran vdout0_28ck1330 FIND v(dout0_28) AT=1340.05n

.meas tran vdout0_29ck1330 FIND v(dout0_29) AT=1340.05n

.meas tran vdout0_30ck1330 FIND v(dout0_30) AT=1340.05n

.meas tran vdout0_31ck1330 FIND v(dout0_31) AT=1340.05n

.meas tran vdout0_32ck1330 FIND v(dout0_32) AT=1340.05n

.meas tran vdout0_0ck1350 FIND v(dout0_0) AT=1360.05n

.meas tran vdout0_1ck1350 FIND v(dout0_1) AT=1360.05n

.meas tran vdout0_2ck1350 FIND v(dout0_2) AT=1360.05n

.meas tran vdout0_3ck1350 FIND v(dout0_3) AT=1360.05n

.meas tran vdout0_4ck1350 FIND v(dout0_4) AT=1360.05n

.meas tran vdout0_5ck1350 FIND v(dout0_5) AT=1360.05n

.meas tran vdout0_6ck1350 FIND v(dout0_6) AT=1360.05n

.meas tran vdout0_7ck1350 FIND v(dout0_7) AT=1360.05n

.meas tran vdout0_8ck1350 FIND v(dout0_8) AT=1360.05n

.meas tran vdout0_9ck1350 FIND v(dout0_9) AT=1360.05n

.meas tran vdout0_10ck1350 FIND v(dout0_10) AT=1360.05n

.meas tran vdout0_11ck1350 FIND v(dout0_11) AT=1360.05n

.meas tran vdout0_12ck1350 FIND v(dout0_12) AT=1360.05n

.meas tran vdout0_13ck1350 FIND v(dout0_13) AT=1360.05n

.meas tran vdout0_14ck1350 FIND v(dout0_14) AT=1360.05n

.meas tran vdout0_15ck1350 FIND v(dout0_15) AT=1360.05n

.meas tran vdout0_16ck1350 FIND v(dout0_16) AT=1360.05n

.meas tran vdout0_17ck1350 FIND v(dout0_17) AT=1360.05n

.meas tran vdout0_18ck1350 FIND v(dout0_18) AT=1360.05n

.meas tran vdout0_19ck1350 FIND v(dout0_19) AT=1360.05n

.meas tran vdout0_20ck1350 FIND v(dout0_20) AT=1360.05n

.meas tran vdout0_21ck1350 FIND v(dout0_21) AT=1360.05n

.meas tran vdout0_22ck1350 FIND v(dout0_22) AT=1360.05n

.meas tran vdout0_23ck1350 FIND v(dout0_23) AT=1360.05n

.meas tran vdout0_24ck1350 FIND v(dout0_24) AT=1360.05n

.meas tran vdout0_25ck1350 FIND v(dout0_25) AT=1360.05n

.meas tran vdout0_26ck1350 FIND v(dout0_26) AT=1360.05n

.meas tran vdout0_27ck1350 FIND v(dout0_27) AT=1360.05n

.meas tran vdout0_28ck1350 FIND v(dout0_28) AT=1360.05n

.meas tran vdout0_29ck1350 FIND v(dout0_29) AT=1360.05n

.meas tran vdout0_30ck1350 FIND v(dout0_30) AT=1360.05n

.meas tran vdout0_31ck1350 FIND v(dout0_31) AT=1360.05n

.meas tran vdout0_32ck1350 FIND v(dout0_32) AT=1360.05n

.meas tran vdout0_0ck1380 FIND v(dout0_0) AT=1390.05n

.meas tran vdout0_1ck1380 FIND v(dout0_1) AT=1390.05n

.meas tran vdout0_2ck1380 FIND v(dout0_2) AT=1390.05n

.meas tran vdout0_3ck1380 FIND v(dout0_3) AT=1390.05n

.meas tran vdout0_4ck1380 FIND v(dout0_4) AT=1390.05n

.meas tran vdout0_5ck1380 FIND v(dout0_5) AT=1390.05n

.meas tran vdout0_6ck1380 FIND v(dout0_6) AT=1390.05n

.meas tran vdout0_7ck1380 FIND v(dout0_7) AT=1390.05n

.meas tran vdout0_8ck1380 FIND v(dout0_8) AT=1390.05n

.meas tran vdout0_9ck1380 FIND v(dout0_9) AT=1390.05n

.meas tran vdout0_10ck1380 FIND v(dout0_10) AT=1390.05n

.meas tran vdout0_11ck1380 FIND v(dout0_11) AT=1390.05n

.meas tran vdout0_12ck1380 FIND v(dout0_12) AT=1390.05n

.meas tran vdout0_13ck1380 FIND v(dout0_13) AT=1390.05n

.meas tran vdout0_14ck1380 FIND v(dout0_14) AT=1390.05n

.meas tran vdout0_15ck1380 FIND v(dout0_15) AT=1390.05n

.meas tran vdout0_16ck1380 FIND v(dout0_16) AT=1390.05n

.meas tran vdout0_17ck1380 FIND v(dout0_17) AT=1390.05n

.meas tran vdout0_18ck1380 FIND v(dout0_18) AT=1390.05n

.meas tran vdout0_19ck1380 FIND v(dout0_19) AT=1390.05n

.meas tran vdout0_20ck1380 FIND v(dout0_20) AT=1390.05n

.meas tran vdout0_21ck1380 FIND v(dout0_21) AT=1390.05n

.meas tran vdout0_22ck1380 FIND v(dout0_22) AT=1390.05n

.meas tran vdout0_23ck1380 FIND v(dout0_23) AT=1390.05n

.meas tran vdout0_24ck1380 FIND v(dout0_24) AT=1390.05n

.meas tran vdout0_25ck1380 FIND v(dout0_25) AT=1390.05n

.meas tran vdout0_26ck1380 FIND v(dout0_26) AT=1390.05n

.meas tran vdout0_27ck1380 FIND v(dout0_27) AT=1390.05n

.meas tran vdout0_28ck1380 FIND v(dout0_28) AT=1390.05n

.meas tran vdout0_29ck1380 FIND v(dout0_29) AT=1390.05n

.meas tran vdout0_30ck1380 FIND v(dout0_30) AT=1390.05n

.meas tran vdout0_31ck1380 FIND v(dout0_31) AT=1390.05n

.meas tran vdout0_32ck1380 FIND v(dout0_32) AT=1390.05n

.meas tran vdout0_0ck1390 FIND v(dout0_0) AT=1400.05n

.meas tran vdout0_1ck1390 FIND v(dout0_1) AT=1400.05n

.meas tran vdout0_2ck1390 FIND v(dout0_2) AT=1400.05n

.meas tran vdout0_3ck1390 FIND v(dout0_3) AT=1400.05n

.meas tran vdout0_4ck1390 FIND v(dout0_4) AT=1400.05n

.meas tran vdout0_5ck1390 FIND v(dout0_5) AT=1400.05n

.meas tran vdout0_6ck1390 FIND v(dout0_6) AT=1400.05n

.meas tran vdout0_7ck1390 FIND v(dout0_7) AT=1400.05n

.meas tran vdout0_8ck1390 FIND v(dout0_8) AT=1400.05n

.meas tran vdout0_9ck1390 FIND v(dout0_9) AT=1400.05n

.meas tran vdout0_10ck1390 FIND v(dout0_10) AT=1400.05n

.meas tran vdout0_11ck1390 FIND v(dout0_11) AT=1400.05n

.meas tran vdout0_12ck1390 FIND v(dout0_12) AT=1400.05n

.meas tran vdout0_13ck1390 FIND v(dout0_13) AT=1400.05n

.meas tran vdout0_14ck1390 FIND v(dout0_14) AT=1400.05n

.meas tran vdout0_15ck1390 FIND v(dout0_15) AT=1400.05n

.meas tran vdout0_16ck1390 FIND v(dout0_16) AT=1400.05n

.meas tran vdout0_17ck1390 FIND v(dout0_17) AT=1400.05n

.meas tran vdout0_18ck1390 FIND v(dout0_18) AT=1400.05n

.meas tran vdout0_19ck1390 FIND v(dout0_19) AT=1400.05n

.meas tran vdout0_20ck1390 FIND v(dout0_20) AT=1400.05n

.meas tran vdout0_21ck1390 FIND v(dout0_21) AT=1400.05n

.meas tran vdout0_22ck1390 FIND v(dout0_22) AT=1400.05n

.meas tran vdout0_23ck1390 FIND v(dout0_23) AT=1400.05n

.meas tran vdout0_24ck1390 FIND v(dout0_24) AT=1400.05n

.meas tran vdout0_25ck1390 FIND v(dout0_25) AT=1400.05n

.meas tran vdout0_26ck1390 FIND v(dout0_26) AT=1400.05n

.meas tran vdout0_27ck1390 FIND v(dout0_27) AT=1400.05n

.meas tran vdout0_28ck1390 FIND v(dout0_28) AT=1400.05n

.meas tran vdout0_29ck1390 FIND v(dout0_29) AT=1400.05n

.meas tran vdout0_30ck1390 FIND v(dout0_30) AT=1400.05n

.meas tran vdout0_31ck1390 FIND v(dout0_31) AT=1400.05n

.meas tran vdout0_32ck1390 FIND v(dout0_32) AT=1400.05n

.meas tran vdout0_0ck1420 FIND v(dout0_0) AT=1430.05n

.meas tran vdout0_1ck1420 FIND v(dout0_1) AT=1430.05n

.meas tran vdout0_2ck1420 FIND v(dout0_2) AT=1430.05n

.meas tran vdout0_3ck1420 FIND v(dout0_3) AT=1430.05n

.meas tran vdout0_4ck1420 FIND v(dout0_4) AT=1430.05n

.meas tran vdout0_5ck1420 FIND v(dout0_5) AT=1430.05n

.meas tran vdout0_6ck1420 FIND v(dout0_6) AT=1430.05n

.meas tran vdout0_7ck1420 FIND v(dout0_7) AT=1430.05n

.meas tran vdout0_8ck1420 FIND v(dout0_8) AT=1430.05n

.meas tran vdout0_9ck1420 FIND v(dout0_9) AT=1430.05n

.meas tran vdout0_10ck1420 FIND v(dout0_10) AT=1430.05n

.meas tran vdout0_11ck1420 FIND v(dout0_11) AT=1430.05n

.meas tran vdout0_12ck1420 FIND v(dout0_12) AT=1430.05n

.meas tran vdout0_13ck1420 FIND v(dout0_13) AT=1430.05n

.meas tran vdout0_14ck1420 FIND v(dout0_14) AT=1430.05n

.meas tran vdout0_15ck1420 FIND v(dout0_15) AT=1430.05n

.meas tran vdout0_16ck1420 FIND v(dout0_16) AT=1430.05n

.meas tran vdout0_17ck1420 FIND v(dout0_17) AT=1430.05n

.meas tran vdout0_18ck1420 FIND v(dout0_18) AT=1430.05n

.meas tran vdout0_19ck1420 FIND v(dout0_19) AT=1430.05n

.meas tran vdout0_20ck1420 FIND v(dout0_20) AT=1430.05n

.meas tran vdout0_21ck1420 FIND v(dout0_21) AT=1430.05n

.meas tran vdout0_22ck1420 FIND v(dout0_22) AT=1430.05n

.meas tran vdout0_23ck1420 FIND v(dout0_23) AT=1430.05n

.meas tran vdout0_24ck1420 FIND v(dout0_24) AT=1430.05n

.meas tran vdout0_25ck1420 FIND v(dout0_25) AT=1430.05n

.meas tran vdout0_26ck1420 FIND v(dout0_26) AT=1430.05n

.meas tran vdout0_27ck1420 FIND v(dout0_27) AT=1430.05n

.meas tran vdout0_28ck1420 FIND v(dout0_28) AT=1430.05n

.meas tran vdout0_29ck1420 FIND v(dout0_29) AT=1430.05n

.meas tran vdout0_30ck1420 FIND v(dout0_30) AT=1430.05n

.meas tran vdout0_31ck1420 FIND v(dout0_31) AT=1430.05n

.meas tran vdout0_32ck1420 FIND v(dout0_32) AT=1430.05n

.meas tran vdout0_0ck1450 FIND v(dout0_0) AT=1460.05n

.meas tran vdout0_1ck1450 FIND v(dout0_1) AT=1460.05n

.meas tran vdout0_2ck1450 FIND v(dout0_2) AT=1460.05n

.meas tran vdout0_3ck1450 FIND v(dout0_3) AT=1460.05n

.meas tran vdout0_4ck1450 FIND v(dout0_4) AT=1460.05n

.meas tran vdout0_5ck1450 FIND v(dout0_5) AT=1460.05n

.meas tran vdout0_6ck1450 FIND v(dout0_6) AT=1460.05n

.meas tran vdout0_7ck1450 FIND v(dout0_7) AT=1460.05n

.meas tran vdout0_8ck1450 FIND v(dout0_8) AT=1460.05n

.meas tran vdout0_9ck1450 FIND v(dout0_9) AT=1460.05n

.meas tran vdout0_10ck1450 FIND v(dout0_10) AT=1460.05n

.meas tran vdout0_11ck1450 FIND v(dout0_11) AT=1460.05n

.meas tran vdout0_12ck1450 FIND v(dout0_12) AT=1460.05n

.meas tran vdout0_13ck1450 FIND v(dout0_13) AT=1460.05n

.meas tran vdout0_14ck1450 FIND v(dout0_14) AT=1460.05n

.meas tran vdout0_15ck1450 FIND v(dout0_15) AT=1460.05n

.meas tran vdout0_16ck1450 FIND v(dout0_16) AT=1460.05n

.meas tran vdout0_17ck1450 FIND v(dout0_17) AT=1460.05n

.meas tran vdout0_18ck1450 FIND v(dout0_18) AT=1460.05n

.meas tran vdout0_19ck1450 FIND v(dout0_19) AT=1460.05n

.meas tran vdout0_20ck1450 FIND v(dout0_20) AT=1460.05n

.meas tran vdout0_21ck1450 FIND v(dout0_21) AT=1460.05n

.meas tran vdout0_22ck1450 FIND v(dout0_22) AT=1460.05n

.meas tran vdout0_23ck1450 FIND v(dout0_23) AT=1460.05n

.meas tran vdout0_24ck1450 FIND v(dout0_24) AT=1460.05n

.meas tran vdout0_25ck1450 FIND v(dout0_25) AT=1460.05n

.meas tran vdout0_26ck1450 FIND v(dout0_26) AT=1460.05n

.meas tran vdout0_27ck1450 FIND v(dout0_27) AT=1460.05n

.meas tran vdout0_28ck1450 FIND v(dout0_28) AT=1460.05n

.meas tran vdout0_29ck1450 FIND v(dout0_29) AT=1460.05n

.meas tran vdout0_30ck1450 FIND v(dout0_30) AT=1460.05n

.meas tran vdout0_31ck1450 FIND v(dout0_31) AT=1460.05n

.meas tran vdout0_32ck1450 FIND v(dout0_32) AT=1460.05n

.meas tran vdout0_0ck1500 FIND v(dout0_0) AT=1510.05n

.meas tran vdout0_1ck1500 FIND v(dout0_1) AT=1510.05n

.meas tran vdout0_2ck1500 FIND v(dout0_2) AT=1510.05n

.meas tran vdout0_3ck1500 FIND v(dout0_3) AT=1510.05n

.meas tran vdout0_4ck1500 FIND v(dout0_4) AT=1510.05n

.meas tran vdout0_5ck1500 FIND v(dout0_5) AT=1510.05n

.meas tran vdout0_6ck1500 FIND v(dout0_6) AT=1510.05n

.meas tran vdout0_7ck1500 FIND v(dout0_7) AT=1510.05n

.meas tran vdout0_8ck1500 FIND v(dout0_8) AT=1510.05n

.meas tran vdout0_9ck1500 FIND v(dout0_9) AT=1510.05n

.meas tran vdout0_10ck1500 FIND v(dout0_10) AT=1510.05n

.meas tran vdout0_11ck1500 FIND v(dout0_11) AT=1510.05n

.meas tran vdout0_12ck1500 FIND v(dout0_12) AT=1510.05n

.meas tran vdout0_13ck1500 FIND v(dout0_13) AT=1510.05n

.meas tran vdout0_14ck1500 FIND v(dout0_14) AT=1510.05n

.meas tran vdout0_15ck1500 FIND v(dout0_15) AT=1510.05n

.meas tran vdout0_16ck1500 FIND v(dout0_16) AT=1510.05n

.meas tran vdout0_17ck1500 FIND v(dout0_17) AT=1510.05n

.meas tran vdout0_18ck1500 FIND v(dout0_18) AT=1510.05n

.meas tran vdout0_19ck1500 FIND v(dout0_19) AT=1510.05n

.meas tran vdout0_20ck1500 FIND v(dout0_20) AT=1510.05n

.meas tran vdout0_21ck1500 FIND v(dout0_21) AT=1510.05n

.meas tran vdout0_22ck1500 FIND v(dout0_22) AT=1510.05n

.meas tran vdout0_23ck1500 FIND v(dout0_23) AT=1510.05n

.meas tran vdout0_24ck1500 FIND v(dout0_24) AT=1510.05n

.meas tran vdout0_25ck1500 FIND v(dout0_25) AT=1510.05n

.meas tran vdout0_26ck1500 FIND v(dout0_26) AT=1510.05n

.meas tran vdout0_27ck1500 FIND v(dout0_27) AT=1510.05n

.meas tran vdout0_28ck1500 FIND v(dout0_28) AT=1510.05n

.meas tran vdout0_29ck1500 FIND v(dout0_29) AT=1510.05n

.meas tran vdout0_30ck1500 FIND v(dout0_30) AT=1510.05n

.meas tran vdout0_31ck1500 FIND v(dout0_31) AT=1510.05n

.meas tran vdout0_32ck1500 FIND v(dout0_32) AT=1510.05n

.meas tran vdout0_0ck1510 FIND v(dout0_0) AT=1520.05n

.meas tran vdout0_1ck1510 FIND v(dout0_1) AT=1520.05n

.meas tran vdout0_2ck1510 FIND v(dout0_2) AT=1520.05n

.meas tran vdout0_3ck1510 FIND v(dout0_3) AT=1520.05n

.meas tran vdout0_4ck1510 FIND v(dout0_4) AT=1520.05n

.meas tran vdout0_5ck1510 FIND v(dout0_5) AT=1520.05n

.meas tran vdout0_6ck1510 FIND v(dout0_6) AT=1520.05n

.meas tran vdout0_7ck1510 FIND v(dout0_7) AT=1520.05n

.meas tran vdout0_8ck1510 FIND v(dout0_8) AT=1520.05n

.meas tran vdout0_9ck1510 FIND v(dout0_9) AT=1520.05n

.meas tran vdout0_10ck1510 FIND v(dout0_10) AT=1520.05n

.meas tran vdout0_11ck1510 FIND v(dout0_11) AT=1520.05n

.meas tran vdout0_12ck1510 FIND v(dout0_12) AT=1520.05n

.meas tran vdout0_13ck1510 FIND v(dout0_13) AT=1520.05n

.meas tran vdout0_14ck1510 FIND v(dout0_14) AT=1520.05n

.meas tran vdout0_15ck1510 FIND v(dout0_15) AT=1520.05n

.meas tran vdout0_16ck1510 FIND v(dout0_16) AT=1520.05n

.meas tran vdout0_17ck1510 FIND v(dout0_17) AT=1520.05n

.meas tran vdout0_18ck1510 FIND v(dout0_18) AT=1520.05n

.meas tran vdout0_19ck1510 FIND v(dout0_19) AT=1520.05n

.meas tran vdout0_20ck1510 FIND v(dout0_20) AT=1520.05n

.meas tran vdout0_21ck1510 FIND v(dout0_21) AT=1520.05n

.meas tran vdout0_22ck1510 FIND v(dout0_22) AT=1520.05n

.meas tran vdout0_23ck1510 FIND v(dout0_23) AT=1520.05n

.meas tran vdout0_24ck1510 FIND v(dout0_24) AT=1520.05n

.meas tran vdout0_25ck1510 FIND v(dout0_25) AT=1520.05n

.meas tran vdout0_26ck1510 FIND v(dout0_26) AT=1520.05n

.meas tran vdout0_27ck1510 FIND v(dout0_27) AT=1520.05n

.meas tran vdout0_28ck1510 FIND v(dout0_28) AT=1520.05n

.meas tran vdout0_29ck1510 FIND v(dout0_29) AT=1520.05n

.meas tran vdout0_30ck1510 FIND v(dout0_30) AT=1520.05n

.meas tran vdout0_31ck1510 FIND v(dout0_31) AT=1520.05n

.meas tran vdout0_32ck1510 FIND v(dout0_32) AT=1520.05n

.meas tran vdout0_0ck1530 FIND v(dout0_0) AT=1540.05n

.meas tran vdout0_1ck1530 FIND v(dout0_1) AT=1540.05n

.meas tran vdout0_2ck1530 FIND v(dout0_2) AT=1540.05n

.meas tran vdout0_3ck1530 FIND v(dout0_3) AT=1540.05n

.meas tran vdout0_4ck1530 FIND v(dout0_4) AT=1540.05n

.meas tran vdout0_5ck1530 FIND v(dout0_5) AT=1540.05n

.meas tran vdout0_6ck1530 FIND v(dout0_6) AT=1540.05n

.meas tran vdout0_7ck1530 FIND v(dout0_7) AT=1540.05n

.meas tran vdout0_8ck1530 FIND v(dout0_8) AT=1540.05n

.meas tran vdout0_9ck1530 FIND v(dout0_9) AT=1540.05n

.meas tran vdout0_10ck1530 FIND v(dout0_10) AT=1540.05n

.meas tran vdout0_11ck1530 FIND v(dout0_11) AT=1540.05n

.meas tran vdout0_12ck1530 FIND v(dout0_12) AT=1540.05n

.meas tran vdout0_13ck1530 FIND v(dout0_13) AT=1540.05n

.meas tran vdout0_14ck1530 FIND v(dout0_14) AT=1540.05n

.meas tran vdout0_15ck1530 FIND v(dout0_15) AT=1540.05n

.meas tran vdout0_16ck1530 FIND v(dout0_16) AT=1540.05n

.meas tran vdout0_17ck1530 FIND v(dout0_17) AT=1540.05n

.meas tran vdout0_18ck1530 FIND v(dout0_18) AT=1540.05n

.meas tran vdout0_19ck1530 FIND v(dout0_19) AT=1540.05n

.meas tran vdout0_20ck1530 FIND v(dout0_20) AT=1540.05n

.meas tran vdout0_21ck1530 FIND v(dout0_21) AT=1540.05n

.meas tran vdout0_22ck1530 FIND v(dout0_22) AT=1540.05n

.meas tran vdout0_23ck1530 FIND v(dout0_23) AT=1540.05n

.meas tran vdout0_24ck1530 FIND v(dout0_24) AT=1540.05n

.meas tran vdout0_25ck1530 FIND v(dout0_25) AT=1540.05n

.meas tran vdout0_26ck1530 FIND v(dout0_26) AT=1540.05n

.meas tran vdout0_27ck1530 FIND v(dout0_27) AT=1540.05n

.meas tran vdout0_28ck1530 FIND v(dout0_28) AT=1540.05n

.meas tran vdout0_29ck1530 FIND v(dout0_29) AT=1540.05n

.meas tran vdout0_30ck1530 FIND v(dout0_30) AT=1540.05n

.meas tran vdout0_31ck1530 FIND v(dout0_31) AT=1540.05n

.meas tran vdout0_32ck1530 FIND v(dout0_32) AT=1540.05n

.meas tran vdout0_0ck1540 FIND v(dout0_0) AT=1550.05n

.meas tran vdout0_1ck1540 FIND v(dout0_1) AT=1550.05n

.meas tran vdout0_2ck1540 FIND v(dout0_2) AT=1550.05n

.meas tran vdout0_3ck1540 FIND v(dout0_3) AT=1550.05n

.meas tran vdout0_4ck1540 FIND v(dout0_4) AT=1550.05n

.meas tran vdout0_5ck1540 FIND v(dout0_5) AT=1550.05n

.meas tran vdout0_6ck1540 FIND v(dout0_6) AT=1550.05n

.meas tran vdout0_7ck1540 FIND v(dout0_7) AT=1550.05n

.meas tran vdout0_8ck1540 FIND v(dout0_8) AT=1550.05n

.meas tran vdout0_9ck1540 FIND v(dout0_9) AT=1550.05n

.meas tran vdout0_10ck1540 FIND v(dout0_10) AT=1550.05n

.meas tran vdout0_11ck1540 FIND v(dout0_11) AT=1550.05n

.meas tran vdout0_12ck1540 FIND v(dout0_12) AT=1550.05n

.meas tran vdout0_13ck1540 FIND v(dout0_13) AT=1550.05n

.meas tran vdout0_14ck1540 FIND v(dout0_14) AT=1550.05n

.meas tran vdout0_15ck1540 FIND v(dout0_15) AT=1550.05n

.meas tran vdout0_16ck1540 FIND v(dout0_16) AT=1550.05n

.meas tran vdout0_17ck1540 FIND v(dout0_17) AT=1550.05n

.meas tran vdout0_18ck1540 FIND v(dout0_18) AT=1550.05n

.meas tran vdout0_19ck1540 FIND v(dout0_19) AT=1550.05n

.meas tran vdout0_20ck1540 FIND v(dout0_20) AT=1550.05n

.meas tran vdout0_21ck1540 FIND v(dout0_21) AT=1550.05n

.meas tran vdout0_22ck1540 FIND v(dout0_22) AT=1550.05n

.meas tran vdout0_23ck1540 FIND v(dout0_23) AT=1550.05n

.meas tran vdout0_24ck1540 FIND v(dout0_24) AT=1550.05n

.meas tran vdout0_25ck1540 FIND v(dout0_25) AT=1550.05n

.meas tran vdout0_26ck1540 FIND v(dout0_26) AT=1550.05n

.meas tran vdout0_27ck1540 FIND v(dout0_27) AT=1550.05n

.meas tran vdout0_28ck1540 FIND v(dout0_28) AT=1550.05n

.meas tran vdout0_29ck1540 FIND v(dout0_29) AT=1550.05n

.meas tran vdout0_30ck1540 FIND v(dout0_30) AT=1550.05n

.meas tran vdout0_31ck1540 FIND v(dout0_31) AT=1550.05n

.meas tran vdout0_32ck1540 FIND v(dout0_32) AT=1550.05n

.meas tran vdout0_0ck1560 FIND v(dout0_0) AT=1570.05n

.meas tran vdout0_1ck1560 FIND v(dout0_1) AT=1570.05n

.meas tran vdout0_2ck1560 FIND v(dout0_2) AT=1570.05n

.meas tran vdout0_3ck1560 FIND v(dout0_3) AT=1570.05n

.meas tran vdout0_4ck1560 FIND v(dout0_4) AT=1570.05n

.meas tran vdout0_5ck1560 FIND v(dout0_5) AT=1570.05n

.meas tran vdout0_6ck1560 FIND v(dout0_6) AT=1570.05n

.meas tran vdout0_7ck1560 FIND v(dout0_7) AT=1570.05n

.meas tran vdout0_8ck1560 FIND v(dout0_8) AT=1570.05n

.meas tran vdout0_9ck1560 FIND v(dout0_9) AT=1570.05n

.meas tran vdout0_10ck1560 FIND v(dout0_10) AT=1570.05n

.meas tran vdout0_11ck1560 FIND v(dout0_11) AT=1570.05n

.meas tran vdout0_12ck1560 FIND v(dout0_12) AT=1570.05n

.meas tran vdout0_13ck1560 FIND v(dout0_13) AT=1570.05n

.meas tran vdout0_14ck1560 FIND v(dout0_14) AT=1570.05n

.meas tran vdout0_15ck1560 FIND v(dout0_15) AT=1570.05n

.meas tran vdout0_16ck1560 FIND v(dout0_16) AT=1570.05n

.meas tran vdout0_17ck1560 FIND v(dout0_17) AT=1570.05n

.meas tran vdout0_18ck1560 FIND v(dout0_18) AT=1570.05n

.meas tran vdout0_19ck1560 FIND v(dout0_19) AT=1570.05n

.meas tran vdout0_20ck1560 FIND v(dout0_20) AT=1570.05n

.meas tran vdout0_21ck1560 FIND v(dout0_21) AT=1570.05n

.meas tran vdout0_22ck1560 FIND v(dout0_22) AT=1570.05n

.meas tran vdout0_23ck1560 FIND v(dout0_23) AT=1570.05n

.meas tran vdout0_24ck1560 FIND v(dout0_24) AT=1570.05n

.meas tran vdout0_25ck1560 FIND v(dout0_25) AT=1570.05n

.meas tran vdout0_26ck1560 FIND v(dout0_26) AT=1570.05n

.meas tran vdout0_27ck1560 FIND v(dout0_27) AT=1570.05n

.meas tran vdout0_28ck1560 FIND v(dout0_28) AT=1570.05n

.meas tran vdout0_29ck1560 FIND v(dout0_29) AT=1570.05n

.meas tran vdout0_30ck1560 FIND v(dout0_30) AT=1570.05n

.meas tran vdout0_31ck1560 FIND v(dout0_31) AT=1570.05n

.meas tran vdout0_32ck1560 FIND v(dout0_32) AT=1570.05n

.meas tran vdout0_0ck1570 FIND v(dout0_0) AT=1580.05n

.meas tran vdout0_1ck1570 FIND v(dout0_1) AT=1580.05n

.meas tran vdout0_2ck1570 FIND v(dout0_2) AT=1580.05n

.meas tran vdout0_3ck1570 FIND v(dout0_3) AT=1580.05n

.meas tran vdout0_4ck1570 FIND v(dout0_4) AT=1580.05n

.meas tran vdout0_5ck1570 FIND v(dout0_5) AT=1580.05n

.meas tran vdout0_6ck1570 FIND v(dout0_6) AT=1580.05n

.meas tran vdout0_7ck1570 FIND v(dout0_7) AT=1580.05n

.meas tran vdout0_8ck1570 FIND v(dout0_8) AT=1580.05n

.meas tran vdout0_9ck1570 FIND v(dout0_9) AT=1580.05n

.meas tran vdout0_10ck1570 FIND v(dout0_10) AT=1580.05n

.meas tran vdout0_11ck1570 FIND v(dout0_11) AT=1580.05n

.meas tran vdout0_12ck1570 FIND v(dout0_12) AT=1580.05n

.meas tran vdout0_13ck1570 FIND v(dout0_13) AT=1580.05n

.meas tran vdout0_14ck1570 FIND v(dout0_14) AT=1580.05n

.meas tran vdout0_15ck1570 FIND v(dout0_15) AT=1580.05n

.meas tran vdout0_16ck1570 FIND v(dout0_16) AT=1580.05n

.meas tran vdout0_17ck1570 FIND v(dout0_17) AT=1580.05n

.meas tran vdout0_18ck1570 FIND v(dout0_18) AT=1580.05n

.meas tran vdout0_19ck1570 FIND v(dout0_19) AT=1580.05n

.meas tran vdout0_20ck1570 FIND v(dout0_20) AT=1580.05n

.meas tran vdout0_21ck1570 FIND v(dout0_21) AT=1580.05n

.meas tran vdout0_22ck1570 FIND v(dout0_22) AT=1580.05n

.meas tran vdout0_23ck1570 FIND v(dout0_23) AT=1580.05n

.meas tran vdout0_24ck1570 FIND v(dout0_24) AT=1580.05n

.meas tran vdout0_25ck1570 FIND v(dout0_25) AT=1580.05n

.meas tran vdout0_26ck1570 FIND v(dout0_26) AT=1580.05n

.meas tran vdout0_27ck1570 FIND v(dout0_27) AT=1580.05n

.meas tran vdout0_28ck1570 FIND v(dout0_28) AT=1580.05n

.meas tran vdout0_29ck1570 FIND v(dout0_29) AT=1580.05n

.meas tran vdout0_30ck1570 FIND v(dout0_30) AT=1580.05n

.meas tran vdout0_31ck1570 FIND v(dout0_31) AT=1580.05n

.meas tran vdout0_32ck1570 FIND v(dout0_32) AT=1580.05n

.meas tran vdout0_0ck1600 FIND v(dout0_0) AT=1610.05n

.meas tran vdout0_1ck1600 FIND v(dout0_1) AT=1610.05n

.meas tran vdout0_2ck1600 FIND v(dout0_2) AT=1610.05n

.meas tran vdout0_3ck1600 FIND v(dout0_3) AT=1610.05n

.meas tran vdout0_4ck1600 FIND v(dout0_4) AT=1610.05n

.meas tran vdout0_5ck1600 FIND v(dout0_5) AT=1610.05n

.meas tran vdout0_6ck1600 FIND v(dout0_6) AT=1610.05n

.meas tran vdout0_7ck1600 FIND v(dout0_7) AT=1610.05n

.meas tran vdout0_8ck1600 FIND v(dout0_8) AT=1610.05n

.meas tran vdout0_9ck1600 FIND v(dout0_9) AT=1610.05n

.meas tran vdout0_10ck1600 FIND v(dout0_10) AT=1610.05n

.meas tran vdout0_11ck1600 FIND v(dout0_11) AT=1610.05n

.meas tran vdout0_12ck1600 FIND v(dout0_12) AT=1610.05n

.meas tran vdout0_13ck1600 FIND v(dout0_13) AT=1610.05n

.meas tran vdout0_14ck1600 FIND v(dout0_14) AT=1610.05n

.meas tran vdout0_15ck1600 FIND v(dout0_15) AT=1610.05n

.meas tran vdout0_16ck1600 FIND v(dout0_16) AT=1610.05n

.meas tran vdout0_17ck1600 FIND v(dout0_17) AT=1610.05n

.meas tran vdout0_18ck1600 FIND v(dout0_18) AT=1610.05n

.meas tran vdout0_19ck1600 FIND v(dout0_19) AT=1610.05n

.meas tran vdout0_20ck1600 FIND v(dout0_20) AT=1610.05n

.meas tran vdout0_21ck1600 FIND v(dout0_21) AT=1610.05n

.meas tran vdout0_22ck1600 FIND v(dout0_22) AT=1610.05n

.meas tran vdout0_23ck1600 FIND v(dout0_23) AT=1610.05n

.meas tran vdout0_24ck1600 FIND v(dout0_24) AT=1610.05n

.meas tran vdout0_25ck1600 FIND v(dout0_25) AT=1610.05n

.meas tran vdout0_26ck1600 FIND v(dout0_26) AT=1610.05n

.meas tran vdout0_27ck1600 FIND v(dout0_27) AT=1610.05n

.meas tran vdout0_28ck1600 FIND v(dout0_28) AT=1610.05n

.meas tran vdout0_29ck1600 FIND v(dout0_29) AT=1610.05n

.meas tran vdout0_30ck1600 FIND v(dout0_30) AT=1610.05n

.meas tran vdout0_31ck1600 FIND v(dout0_31) AT=1610.05n

.meas tran vdout0_32ck1600 FIND v(dout0_32) AT=1610.05n

.meas tran vdout0_0ck1610 FIND v(dout0_0) AT=1620.05n

.meas tran vdout0_1ck1610 FIND v(dout0_1) AT=1620.05n

.meas tran vdout0_2ck1610 FIND v(dout0_2) AT=1620.05n

.meas tran vdout0_3ck1610 FIND v(dout0_3) AT=1620.05n

.meas tran vdout0_4ck1610 FIND v(dout0_4) AT=1620.05n

.meas tran vdout0_5ck1610 FIND v(dout0_5) AT=1620.05n

.meas tran vdout0_6ck1610 FIND v(dout0_6) AT=1620.05n

.meas tran vdout0_7ck1610 FIND v(dout0_7) AT=1620.05n

.meas tran vdout0_8ck1610 FIND v(dout0_8) AT=1620.05n

.meas tran vdout0_9ck1610 FIND v(dout0_9) AT=1620.05n

.meas tran vdout0_10ck1610 FIND v(dout0_10) AT=1620.05n

.meas tran vdout0_11ck1610 FIND v(dout0_11) AT=1620.05n

.meas tran vdout0_12ck1610 FIND v(dout0_12) AT=1620.05n

.meas tran vdout0_13ck1610 FIND v(dout0_13) AT=1620.05n

.meas tran vdout0_14ck1610 FIND v(dout0_14) AT=1620.05n

.meas tran vdout0_15ck1610 FIND v(dout0_15) AT=1620.05n

.meas tran vdout0_16ck1610 FIND v(dout0_16) AT=1620.05n

.meas tran vdout0_17ck1610 FIND v(dout0_17) AT=1620.05n

.meas tran vdout0_18ck1610 FIND v(dout0_18) AT=1620.05n

.meas tran vdout0_19ck1610 FIND v(dout0_19) AT=1620.05n

.meas tran vdout0_20ck1610 FIND v(dout0_20) AT=1620.05n

.meas tran vdout0_21ck1610 FIND v(dout0_21) AT=1620.05n

.meas tran vdout0_22ck1610 FIND v(dout0_22) AT=1620.05n

.meas tran vdout0_23ck1610 FIND v(dout0_23) AT=1620.05n

.meas tran vdout0_24ck1610 FIND v(dout0_24) AT=1620.05n

.meas tran vdout0_25ck1610 FIND v(dout0_25) AT=1620.05n

.meas tran vdout0_26ck1610 FIND v(dout0_26) AT=1620.05n

.meas tran vdout0_27ck1610 FIND v(dout0_27) AT=1620.05n

.meas tran vdout0_28ck1610 FIND v(dout0_28) AT=1620.05n

.meas tran vdout0_29ck1610 FIND v(dout0_29) AT=1620.05n

.meas tran vdout0_30ck1610 FIND v(dout0_30) AT=1620.05n

.meas tran vdout0_31ck1610 FIND v(dout0_31) AT=1620.05n

.meas tran vdout0_32ck1610 FIND v(dout0_32) AT=1620.05n

.meas tran vdout0_0ck1650 FIND v(dout0_0) AT=1660.05n

.meas tran vdout0_1ck1650 FIND v(dout0_1) AT=1660.05n

.meas tran vdout0_2ck1650 FIND v(dout0_2) AT=1660.05n

.meas tran vdout0_3ck1650 FIND v(dout0_3) AT=1660.05n

.meas tran vdout0_4ck1650 FIND v(dout0_4) AT=1660.05n

.meas tran vdout0_5ck1650 FIND v(dout0_5) AT=1660.05n

.meas tran vdout0_6ck1650 FIND v(dout0_6) AT=1660.05n

.meas tran vdout0_7ck1650 FIND v(dout0_7) AT=1660.05n

.meas tran vdout0_8ck1650 FIND v(dout0_8) AT=1660.05n

.meas tran vdout0_9ck1650 FIND v(dout0_9) AT=1660.05n

.meas tran vdout0_10ck1650 FIND v(dout0_10) AT=1660.05n

.meas tran vdout0_11ck1650 FIND v(dout0_11) AT=1660.05n

.meas tran vdout0_12ck1650 FIND v(dout0_12) AT=1660.05n

.meas tran vdout0_13ck1650 FIND v(dout0_13) AT=1660.05n

.meas tran vdout0_14ck1650 FIND v(dout0_14) AT=1660.05n

.meas tran vdout0_15ck1650 FIND v(dout0_15) AT=1660.05n

.meas tran vdout0_16ck1650 FIND v(dout0_16) AT=1660.05n

.meas tran vdout0_17ck1650 FIND v(dout0_17) AT=1660.05n

.meas tran vdout0_18ck1650 FIND v(dout0_18) AT=1660.05n

.meas tran vdout0_19ck1650 FIND v(dout0_19) AT=1660.05n

.meas tran vdout0_20ck1650 FIND v(dout0_20) AT=1660.05n

.meas tran vdout0_21ck1650 FIND v(dout0_21) AT=1660.05n

.meas tran vdout0_22ck1650 FIND v(dout0_22) AT=1660.05n

.meas tran vdout0_23ck1650 FIND v(dout0_23) AT=1660.05n

.meas tran vdout0_24ck1650 FIND v(dout0_24) AT=1660.05n

.meas tran vdout0_25ck1650 FIND v(dout0_25) AT=1660.05n

.meas tran vdout0_26ck1650 FIND v(dout0_26) AT=1660.05n

.meas tran vdout0_27ck1650 FIND v(dout0_27) AT=1660.05n

.meas tran vdout0_28ck1650 FIND v(dout0_28) AT=1660.05n

.meas tran vdout0_29ck1650 FIND v(dout0_29) AT=1660.05n

.meas tran vdout0_30ck1650 FIND v(dout0_30) AT=1660.05n

.meas tran vdout0_31ck1650 FIND v(dout0_31) AT=1660.05n

.meas tran vdout0_32ck1650 FIND v(dout0_32) AT=1660.05n

.meas tran vdout0_0ck1670 FIND v(dout0_0) AT=1680.05n

.meas tran vdout0_1ck1670 FIND v(dout0_1) AT=1680.05n

.meas tran vdout0_2ck1670 FIND v(dout0_2) AT=1680.05n

.meas tran vdout0_3ck1670 FIND v(dout0_3) AT=1680.05n

.meas tran vdout0_4ck1670 FIND v(dout0_4) AT=1680.05n

.meas tran vdout0_5ck1670 FIND v(dout0_5) AT=1680.05n

.meas tran vdout0_6ck1670 FIND v(dout0_6) AT=1680.05n

.meas tran vdout0_7ck1670 FIND v(dout0_7) AT=1680.05n

.meas tran vdout0_8ck1670 FIND v(dout0_8) AT=1680.05n

.meas tran vdout0_9ck1670 FIND v(dout0_9) AT=1680.05n

.meas tran vdout0_10ck1670 FIND v(dout0_10) AT=1680.05n

.meas tran vdout0_11ck1670 FIND v(dout0_11) AT=1680.05n

.meas tran vdout0_12ck1670 FIND v(dout0_12) AT=1680.05n

.meas tran vdout0_13ck1670 FIND v(dout0_13) AT=1680.05n

.meas tran vdout0_14ck1670 FIND v(dout0_14) AT=1680.05n

.meas tran vdout0_15ck1670 FIND v(dout0_15) AT=1680.05n

.meas tran vdout0_16ck1670 FIND v(dout0_16) AT=1680.05n

.meas tran vdout0_17ck1670 FIND v(dout0_17) AT=1680.05n

.meas tran vdout0_18ck1670 FIND v(dout0_18) AT=1680.05n

.meas tran vdout0_19ck1670 FIND v(dout0_19) AT=1680.05n

.meas tran vdout0_20ck1670 FIND v(dout0_20) AT=1680.05n

.meas tran vdout0_21ck1670 FIND v(dout0_21) AT=1680.05n

.meas tran vdout0_22ck1670 FIND v(dout0_22) AT=1680.05n

.meas tran vdout0_23ck1670 FIND v(dout0_23) AT=1680.05n

.meas tran vdout0_24ck1670 FIND v(dout0_24) AT=1680.05n

.meas tran vdout0_25ck1670 FIND v(dout0_25) AT=1680.05n

.meas tran vdout0_26ck1670 FIND v(dout0_26) AT=1680.05n

.meas tran vdout0_27ck1670 FIND v(dout0_27) AT=1680.05n

.meas tran vdout0_28ck1670 FIND v(dout0_28) AT=1680.05n

.meas tran vdout0_29ck1670 FIND v(dout0_29) AT=1680.05n

.meas tran vdout0_30ck1670 FIND v(dout0_30) AT=1680.05n

.meas tran vdout0_31ck1670 FIND v(dout0_31) AT=1680.05n

.meas tran vdout0_32ck1670 FIND v(dout0_32) AT=1680.05n

.meas tran vdout0_0ck1740 FIND v(dout0_0) AT=1750.05n

.meas tran vdout0_1ck1740 FIND v(dout0_1) AT=1750.05n

.meas tran vdout0_2ck1740 FIND v(dout0_2) AT=1750.05n

.meas tran vdout0_3ck1740 FIND v(dout0_3) AT=1750.05n

.meas tran vdout0_4ck1740 FIND v(dout0_4) AT=1750.05n

.meas tran vdout0_5ck1740 FIND v(dout0_5) AT=1750.05n

.meas tran vdout0_6ck1740 FIND v(dout0_6) AT=1750.05n

.meas tran vdout0_7ck1740 FIND v(dout0_7) AT=1750.05n

.meas tran vdout0_8ck1740 FIND v(dout0_8) AT=1750.05n

.meas tran vdout0_9ck1740 FIND v(dout0_9) AT=1750.05n

.meas tran vdout0_10ck1740 FIND v(dout0_10) AT=1750.05n

.meas tran vdout0_11ck1740 FIND v(dout0_11) AT=1750.05n

.meas tran vdout0_12ck1740 FIND v(dout0_12) AT=1750.05n

.meas tran vdout0_13ck1740 FIND v(dout0_13) AT=1750.05n

.meas tran vdout0_14ck1740 FIND v(dout0_14) AT=1750.05n

.meas tran vdout0_15ck1740 FIND v(dout0_15) AT=1750.05n

.meas tran vdout0_16ck1740 FIND v(dout0_16) AT=1750.05n

.meas tran vdout0_17ck1740 FIND v(dout0_17) AT=1750.05n

.meas tran vdout0_18ck1740 FIND v(dout0_18) AT=1750.05n

.meas tran vdout0_19ck1740 FIND v(dout0_19) AT=1750.05n

.meas tran vdout0_20ck1740 FIND v(dout0_20) AT=1750.05n

.meas tran vdout0_21ck1740 FIND v(dout0_21) AT=1750.05n

.meas tran vdout0_22ck1740 FIND v(dout0_22) AT=1750.05n

.meas tran vdout0_23ck1740 FIND v(dout0_23) AT=1750.05n

.meas tran vdout0_24ck1740 FIND v(dout0_24) AT=1750.05n

.meas tran vdout0_25ck1740 FIND v(dout0_25) AT=1750.05n

.meas tran vdout0_26ck1740 FIND v(dout0_26) AT=1750.05n

.meas tran vdout0_27ck1740 FIND v(dout0_27) AT=1750.05n

.meas tran vdout0_28ck1740 FIND v(dout0_28) AT=1750.05n

.meas tran vdout0_29ck1740 FIND v(dout0_29) AT=1750.05n

.meas tran vdout0_30ck1740 FIND v(dout0_30) AT=1750.05n

.meas tran vdout0_31ck1740 FIND v(dout0_31) AT=1750.05n

.meas tran vdout0_32ck1740 FIND v(dout0_32) AT=1750.05n

.meas tran vdout0_0ck1750 FIND v(dout0_0) AT=1760.05n

.meas tran vdout0_1ck1750 FIND v(dout0_1) AT=1760.05n

.meas tran vdout0_2ck1750 FIND v(dout0_2) AT=1760.05n

.meas tran vdout0_3ck1750 FIND v(dout0_3) AT=1760.05n

.meas tran vdout0_4ck1750 FIND v(dout0_4) AT=1760.05n

.meas tran vdout0_5ck1750 FIND v(dout0_5) AT=1760.05n

.meas tran vdout0_6ck1750 FIND v(dout0_6) AT=1760.05n

.meas tran vdout0_7ck1750 FIND v(dout0_7) AT=1760.05n

.meas tran vdout0_8ck1750 FIND v(dout0_8) AT=1760.05n

.meas tran vdout0_9ck1750 FIND v(dout0_9) AT=1760.05n

.meas tran vdout0_10ck1750 FIND v(dout0_10) AT=1760.05n

.meas tran vdout0_11ck1750 FIND v(dout0_11) AT=1760.05n

.meas tran vdout0_12ck1750 FIND v(dout0_12) AT=1760.05n

.meas tran vdout0_13ck1750 FIND v(dout0_13) AT=1760.05n

.meas tran vdout0_14ck1750 FIND v(dout0_14) AT=1760.05n

.meas tran vdout0_15ck1750 FIND v(dout0_15) AT=1760.05n

.meas tran vdout0_16ck1750 FIND v(dout0_16) AT=1760.05n

.meas tran vdout0_17ck1750 FIND v(dout0_17) AT=1760.05n

.meas tran vdout0_18ck1750 FIND v(dout0_18) AT=1760.05n

.meas tran vdout0_19ck1750 FIND v(dout0_19) AT=1760.05n

.meas tran vdout0_20ck1750 FIND v(dout0_20) AT=1760.05n

.meas tran vdout0_21ck1750 FIND v(dout0_21) AT=1760.05n

.meas tran vdout0_22ck1750 FIND v(dout0_22) AT=1760.05n

.meas tran vdout0_23ck1750 FIND v(dout0_23) AT=1760.05n

.meas tran vdout0_24ck1750 FIND v(dout0_24) AT=1760.05n

.meas tran vdout0_25ck1750 FIND v(dout0_25) AT=1760.05n

.meas tran vdout0_26ck1750 FIND v(dout0_26) AT=1760.05n

.meas tran vdout0_27ck1750 FIND v(dout0_27) AT=1760.05n

.meas tran vdout0_28ck1750 FIND v(dout0_28) AT=1760.05n

.meas tran vdout0_29ck1750 FIND v(dout0_29) AT=1760.05n

.meas tran vdout0_30ck1750 FIND v(dout0_30) AT=1760.05n

.meas tran vdout0_31ck1750 FIND v(dout0_31) AT=1760.05n

.meas tran vdout0_32ck1750 FIND v(dout0_32) AT=1760.05n

.meas tran vdout0_0ck1760 FIND v(dout0_0) AT=1770.05n

.meas tran vdout0_1ck1760 FIND v(dout0_1) AT=1770.05n

.meas tran vdout0_2ck1760 FIND v(dout0_2) AT=1770.05n

.meas tran vdout0_3ck1760 FIND v(dout0_3) AT=1770.05n

.meas tran vdout0_4ck1760 FIND v(dout0_4) AT=1770.05n

.meas tran vdout0_5ck1760 FIND v(dout0_5) AT=1770.05n

.meas tran vdout0_6ck1760 FIND v(dout0_6) AT=1770.05n

.meas tran vdout0_7ck1760 FIND v(dout0_7) AT=1770.05n

.meas tran vdout0_8ck1760 FIND v(dout0_8) AT=1770.05n

.meas tran vdout0_9ck1760 FIND v(dout0_9) AT=1770.05n

.meas tran vdout0_10ck1760 FIND v(dout0_10) AT=1770.05n

.meas tran vdout0_11ck1760 FIND v(dout0_11) AT=1770.05n

.meas tran vdout0_12ck1760 FIND v(dout0_12) AT=1770.05n

.meas tran vdout0_13ck1760 FIND v(dout0_13) AT=1770.05n

.meas tran vdout0_14ck1760 FIND v(dout0_14) AT=1770.05n

.meas tran vdout0_15ck1760 FIND v(dout0_15) AT=1770.05n

.meas tran vdout0_16ck1760 FIND v(dout0_16) AT=1770.05n

.meas tran vdout0_17ck1760 FIND v(dout0_17) AT=1770.05n

.meas tran vdout0_18ck1760 FIND v(dout0_18) AT=1770.05n

.meas tran vdout0_19ck1760 FIND v(dout0_19) AT=1770.05n

.meas tran vdout0_20ck1760 FIND v(dout0_20) AT=1770.05n

.meas tran vdout0_21ck1760 FIND v(dout0_21) AT=1770.05n

.meas tran vdout0_22ck1760 FIND v(dout0_22) AT=1770.05n

.meas tran vdout0_23ck1760 FIND v(dout0_23) AT=1770.05n

.meas tran vdout0_24ck1760 FIND v(dout0_24) AT=1770.05n

.meas tran vdout0_25ck1760 FIND v(dout0_25) AT=1770.05n

.meas tran vdout0_26ck1760 FIND v(dout0_26) AT=1770.05n

.meas tran vdout0_27ck1760 FIND v(dout0_27) AT=1770.05n

.meas tran vdout0_28ck1760 FIND v(dout0_28) AT=1770.05n

.meas tran vdout0_29ck1760 FIND v(dout0_29) AT=1770.05n

.meas tran vdout0_30ck1760 FIND v(dout0_30) AT=1770.05n

.meas tran vdout0_31ck1760 FIND v(dout0_31) AT=1770.05n

.meas tran vdout0_32ck1760 FIND v(dout0_32) AT=1770.05n

.meas tran vdout0_0ck1770 FIND v(dout0_0) AT=1780.05n

.meas tran vdout0_1ck1770 FIND v(dout0_1) AT=1780.05n

.meas tran vdout0_2ck1770 FIND v(dout0_2) AT=1780.05n

.meas tran vdout0_3ck1770 FIND v(dout0_3) AT=1780.05n

.meas tran vdout0_4ck1770 FIND v(dout0_4) AT=1780.05n

.meas tran vdout0_5ck1770 FIND v(dout0_5) AT=1780.05n

.meas tran vdout0_6ck1770 FIND v(dout0_6) AT=1780.05n

.meas tran vdout0_7ck1770 FIND v(dout0_7) AT=1780.05n

.meas tran vdout0_8ck1770 FIND v(dout0_8) AT=1780.05n

.meas tran vdout0_9ck1770 FIND v(dout0_9) AT=1780.05n

.meas tran vdout0_10ck1770 FIND v(dout0_10) AT=1780.05n

.meas tran vdout0_11ck1770 FIND v(dout0_11) AT=1780.05n

.meas tran vdout0_12ck1770 FIND v(dout0_12) AT=1780.05n

.meas tran vdout0_13ck1770 FIND v(dout0_13) AT=1780.05n

.meas tran vdout0_14ck1770 FIND v(dout0_14) AT=1780.05n

.meas tran vdout0_15ck1770 FIND v(dout0_15) AT=1780.05n

.meas tran vdout0_16ck1770 FIND v(dout0_16) AT=1780.05n

.meas tran vdout0_17ck1770 FIND v(dout0_17) AT=1780.05n

.meas tran vdout0_18ck1770 FIND v(dout0_18) AT=1780.05n

.meas tran vdout0_19ck1770 FIND v(dout0_19) AT=1780.05n

.meas tran vdout0_20ck1770 FIND v(dout0_20) AT=1780.05n

.meas tran vdout0_21ck1770 FIND v(dout0_21) AT=1780.05n

.meas tran vdout0_22ck1770 FIND v(dout0_22) AT=1780.05n

.meas tran vdout0_23ck1770 FIND v(dout0_23) AT=1780.05n

.meas tran vdout0_24ck1770 FIND v(dout0_24) AT=1780.05n

.meas tran vdout0_25ck1770 FIND v(dout0_25) AT=1780.05n

.meas tran vdout0_26ck1770 FIND v(dout0_26) AT=1780.05n

.meas tran vdout0_27ck1770 FIND v(dout0_27) AT=1780.05n

.meas tran vdout0_28ck1770 FIND v(dout0_28) AT=1780.05n

.meas tran vdout0_29ck1770 FIND v(dout0_29) AT=1780.05n

.meas tran vdout0_30ck1770 FIND v(dout0_30) AT=1780.05n

.meas tran vdout0_31ck1770 FIND v(dout0_31) AT=1780.05n

.meas tran vdout0_32ck1770 FIND v(dout0_32) AT=1780.05n

.meas tran vdout0_0ck1790 FIND v(dout0_0) AT=1800.05n

.meas tran vdout0_1ck1790 FIND v(dout0_1) AT=1800.05n

.meas tran vdout0_2ck1790 FIND v(dout0_2) AT=1800.05n

.meas tran vdout0_3ck1790 FIND v(dout0_3) AT=1800.05n

.meas tran vdout0_4ck1790 FIND v(dout0_4) AT=1800.05n

.meas tran vdout0_5ck1790 FIND v(dout0_5) AT=1800.05n

.meas tran vdout0_6ck1790 FIND v(dout0_6) AT=1800.05n

.meas tran vdout0_7ck1790 FIND v(dout0_7) AT=1800.05n

.meas tran vdout0_8ck1790 FIND v(dout0_8) AT=1800.05n

.meas tran vdout0_9ck1790 FIND v(dout0_9) AT=1800.05n

.meas tran vdout0_10ck1790 FIND v(dout0_10) AT=1800.05n

.meas tran vdout0_11ck1790 FIND v(dout0_11) AT=1800.05n

.meas tran vdout0_12ck1790 FIND v(dout0_12) AT=1800.05n

.meas tran vdout0_13ck1790 FIND v(dout0_13) AT=1800.05n

.meas tran vdout0_14ck1790 FIND v(dout0_14) AT=1800.05n

.meas tran vdout0_15ck1790 FIND v(dout0_15) AT=1800.05n

.meas tran vdout0_16ck1790 FIND v(dout0_16) AT=1800.05n

.meas tran vdout0_17ck1790 FIND v(dout0_17) AT=1800.05n

.meas tran vdout0_18ck1790 FIND v(dout0_18) AT=1800.05n

.meas tran vdout0_19ck1790 FIND v(dout0_19) AT=1800.05n

.meas tran vdout0_20ck1790 FIND v(dout0_20) AT=1800.05n

.meas tran vdout0_21ck1790 FIND v(dout0_21) AT=1800.05n

.meas tran vdout0_22ck1790 FIND v(dout0_22) AT=1800.05n

.meas tran vdout0_23ck1790 FIND v(dout0_23) AT=1800.05n

.meas tran vdout0_24ck1790 FIND v(dout0_24) AT=1800.05n

.meas tran vdout0_25ck1790 FIND v(dout0_25) AT=1800.05n

.meas tran vdout0_26ck1790 FIND v(dout0_26) AT=1800.05n

.meas tran vdout0_27ck1790 FIND v(dout0_27) AT=1800.05n

.meas tran vdout0_28ck1790 FIND v(dout0_28) AT=1800.05n

.meas tran vdout0_29ck1790 FIND v(dout0_29) AT=1800.05n

.meas tran vdout0_30ck1790 FIND v(dout0_30) AT=1800.05n

.meas tran vdout0_31ck1790 FIND v(dout0_31) AT=1800.05n

.meas tran vdout0_32ck1790 FIND v(dout0_32) AT=1800.05n

.meas tran vdout0_0ck1810 FIND v(dout0_0) AT=1820.05n

.meas tran vdout0_1ck1810 FIND v(dout0_1) AT=1820.05n

.meas tran vdout0_2ck1810 FIND v(dout0_2) AT=1820.05n

.meas tran vdout0_3ck1810 FIND v(dout0_3) AT=1820.05n

.meas tran vdout0_4ck1810 FIND v(dout0_4) AT=1820.05n

.meas tran vdout0_5ck1810 FIND v(dout0_5) AT=1820.05n

.meas tran vdout0_6ck1810 FIND v(dout0_6) AT=1820.05n

.meas tran vdout0_7ck1810 FIND v(dout0_7) AT=1820.05n

.meas tran vdout0_8ck1810 FIND v(dout0_8) AT=1820.05n

.meas tran vdout0_9ck1810 FIND v(dout0_9) AT=1820.05n

.meas tran vdout0_10ck1810 FIND v(dout0_10) AT=1820.05n

.meas tran vdout0_11ck1810 FIND v(dout0_11) AT=1820.05n

.meas tran vdout0_12ck1810 FIND v(dout0_12) AT=1820.05n

.meas tran vdout0_13ck1810 FIND v(dout0_13) AT=1820.05n

.meas tran vdout0_14ck1810 FIND v(dout0_14) AT=1820.05n

.meas tran vdout0_15ck1810 FIND v(dout0_15) AT=1820.05n

.meas tran vdout0_16ck1810 FIND v(dout0_16) AT=1820.05n

.meas tran vdout0_17ck1810 FIND v(dout0_17) AT=1820.05n

.meas tran vdout0_18ck1810 FIND v(dout0_18) AT=1820.05n

.meas tran vdout0_19ck1810 FIND v(dout0_19) AT=1820.05n

.meas tran vdout0_20ck1810 FIND v(dout0_20) AT=1820.05n

.meas tran vdout0_21ck1810 FIND v(dout0_21) AT=1820.05n

.meas tran vdout0_22ck1810 FIND v(dout0_22) AT=1820.05n

.meas tran vdout0_23ck1810 FIND v(dout0_23) AT=1820.05n

.meas tran vdout0_24ck1810 FIND v(dout0_24) AT=1820.05n

.meas tran vdout0_25ck1810 FIND v(dout0_25) AT=1820.05n

.meas tran vdout0_26ck1810 FIND v(dout0_26) AT=1820.05n

.meas tran vdout0_27ck1810 FIND v(dout0_27) AT=1820.05n

.meas tran vdout0_28ck1810 FIND v(dout0_28) AT=1820.05n

.meas tran vdout0_29ck1810 FIND v(dout0_29) AT=1820.05n

.meas tran vdout0_30ck1810 FIND v(dout0_30) AT=1820.05n

.meas tran vdout0_31ck1810 FIND v(dout0_31) AT=1820.05n

.meas tran vdout0_32ck1810 FIND v(dout0_32) AT=1820.05n

.meas tran vdout0_0ck1820 FIND v(dout0_0) AT=1830.05n

.meas tran vdout0_1ck1820 FIND v(dout0_1) AT=1830.05n

.meas tran vdout0_2ck1820 FIND v(dout0_2) AT=1830.05n

.meas tran vdout0_3ck1820 FIND v(dout0_3) AT=1830.05n

.meas tran vdout0_4ck1820 FIND v(dout0_4) AT=1830.05n

.meas tran vdout0_5ck1820 FIND v(dout0_5) AT=1830.05n

.meas tran vdout0_6ck1820 FIND v(dout0_6) AT=1830.05n

.meas tran vdout0_7ck1820 FIND v(dout0_7) AT=1830.05n

.meas tran vdout0_8ck1820 FIND v(dout0_8) AT=1830.05n

.meas tran vdout0_9ck1820 FIND v(dout0_9) AT=1830.05n

.meas tran vdout0_10ck1820 FIND v(dout0_10) AT=1830.05n

.meas tran vdout0_11ck1820 FIND v(dout0_11) AT=1830.05n

.meas tran vdout0_12ck1820 FIND v(dout0_12) AT=1830.05n

.meas tran vdout0_13ck1820 FIND v(dout0_13) AT=1830.05n

.meas tran vdout0_14ck1820 FIND v(dout0_14) AT=1830.05n

.meas tran vdout0_15ck1820 FIND v(dout0_15) AT=1830.05n

.meas tran vdout0_16ck1820 FIND v(dout0_16) AT=1830.05n

.meas tran vdout0_17ck1820 FIND v(dout0_17) AT=1830.05n

.meas tran vdout0_18ck1820 FIND v(dout0_18) AT=1830.05n

.meas tran vdout0_19ck1820 FIND v(dout0_19) AT=1830.05n

.meas tran vdout0_20ck1820 FIND v(dout0_20) AT=1830.05n

.meas tran vdout0_21ck1820 FIND v(dout0_21) AT=1830.05n

.meas tran vdout0_22ck1820 FIND v(dout0_22) AT=1830.05n

.meas tran vdout0_23ck1820 FIND v(dout0_23) AT=1830.05n

.meas tran vdout0_24ck1820 FIND v(dout0_24) AT=1830.05n

.meas tran vdout0_25ck1820 FIND v(dout0_25) AT=1830.05n

.meas tran vdout0_26ck1820 FIND v(dout0_26) AT=1830.05n

.meas tran vdout0_27ck1820 FIND v(dout0_27) AT=1830.05n

.meas tran vdout0_28ck1820 FIND v(dout0_28) AT=1830.05n

.meas tran vdout0_29ck1820 FIND v(dout0_29) AT=1830.05n

.meas tran vdout0_30ck1820 FIND v(dout0_30) AT=1830.05n

.meas tran vdout0_31ck1820 FIND v(dout0_31) AT=1830.05n

.meas tran vdout0_32ck1820 FIND v(dout0_32) AT=1830.05n

.meas tran vdout0_0ck1830 FIND v(dout0_0) AT=1840.05n

.meas tran vdout0_1ck1830 FIND v(dout0_1) AT=1840.05n

.meas tran vdout0_2ck1830 FIND v(dout0_2) AT=1840.05n

.meas tran vdout0_3ck1830 FIND v(dout0_3) AT=1840.05n

.meas tran vdout0_4ck1830 FIND v(dout0_4) AT=1840.05n

.meas tran vdout0_5ck1830 FIND v(dout0_5) AT=1840.05n

.meas tran vdout0_6ck1830 FIND v(dout0_6) AT=1840.05n

.meas tran vdout0_7ck1830 FIND v(dout0_7) AT=1840.05n

.meas tran vdout0_8ck1830 FIND v(dout0_8) AT=1840.05n

.meas tran vdout0_9ck1830 FIND v(dout0_9) AT=1840.05n

.meas tran vdout0_10ck1830 FIND v(dout0_10) AT=1840.05n

.meas tran vdout0_11ck1830 FIND v(dout0_11) AT=1840.05n

.meas tran vdout0_12ck1830 FIND v(dout0_12) AT=1840.05n

.meas tran vdout0_13ck1830 FIND v(dout0_13) AT=1840.05n

.meas tran vdout0_14ck1830 FIND v(dout0_14) AT=1840.05n

.meas tran vdout0_15ck1830 FIND v(dout0_15) AT=1840.05n

.meas tran vdout0_16ck1830 FIND v(dout0_16) AT=1840.05n

.meas tran vdout0_17ck1830 FIND v(dout0_17) AT=1840.05n

.meas tran vdout0_18ck1830 FIND v(dout0_18) AT=1840.05n

.meas tran vdout0_19ck1830 FIND v(dout0_19) AT=1840.05n

.meas tran vdout0_20ck1830 FIND v(dout0_20) AT=1840.05n

.meas tran vdout0_21ck1830 FIND v(dout0_21) AT=1840.05n

.meas tran vdout0_22ck1830 FIND v(dout0_22) AT=1840.05n

.meas tran vdout0_23ck1830 FIND v(dout0_23) AT=1840.05n

.meas tran vdout0_24ck1830 FIND v(dout0_24) AT=1840.05n

.meas tran vdout0_25ck1830 FIND v(dout0_25) AT=1840.05n

.meas tran vdout0_26ck1830 FIND v(dout0_26) AT=1840.05n

.meas tran vdout0_27ck1830 FIND v(dout0_27) AT=1840.05n

.meas tran vdout0_28ck1830 FIND v(dout0_28) AT=1840.05n

.meas tran vdout0_29ck1830 FIND v(dout0_29) AT=1840.05n

.meas tran vdout0_30ck1830 FIND v(dout0_30) AT=1840.05n

.meas tran vdout0_31ck1830 FIND v(dout0_31) AT=1840.05n

.meas tran vdout0_32ck1830 FIND v(dout0_32) AT=1840.05n

.meas tran vdout0_0ck1850 FIND v(dout0_0) AT=1860.05n

.meas tran vdout0_1ck1850 FIND v(dout0_1) AT=1860.05n

.meas tran vdout0_2ck1850 FIND v(dout0_2) AT=1860.05n

.meas tran vdout0_3ck1850 FIND v(dout0_3) AT=1860.05n

.meas tran vdout0_4ck1850 FIND v(dout0_4) AT=1860.05n

.meas tran vdout0_5ck1850 FIND v(dout0_5) AT=1860.05n

.meas tran vdout0_6ck1850 FIND v(dout0_6) AT=1860.05n

.meas tran vdout0_7ck1850 FIND v(dout0_7) AT=1860.05n

.meas tran vdout0_8ck1850 FIND v(dout0_8) AT=1860.05n

.meas tran vdout0_9ck1850 FIND v(dout0_9) AT=1860.05n

.meas tran vdout0_10ck1850 FIND v(dout0_10) AT=1860.05n

.meas tran vdout0_11ck1850 FIND v(dout0_11) AT=1860.05n

.meas tran vdout0_12ck1850 FIND v(dout0_12) AT=1860.05n

.meas tran vdout0_13ck1850 FIND v(dout0_13) AT=1860.05n

.meas tran vdout0_14ck1850 FIND v(dout0_14) AT=1860.05n

.meas tran vdout0_15ck1850 FIND v(dout0_15) AT=1860.05n

.meas tran vdout0_16ck1850 FIND v(dout0_16) AT=1860.05n

.meas tran vdout0_17ck1850 FIND v(dout0_17) AT=1860.05n

.meas tran vdout0_18ck1850 FIND v(dout0_18) AT=1860.05n

.meas tran vdout0_19ck1850 FIND v(dout0_19) AT=1860.05n

.meas tran vdout0_20ck1850 FIND v(dout0_20) AT=1860.05n

.meas tran vdout0_21ck1850 FIND v(dout0_21) AT=1860.05n

.meas tran vdout0_22ck1850 FIND v(dout0_22) AT=1860.05n

.meas tran vdout0_23ck1850 FIND v(dout0_23) AT=1860.05n

.meas tran vdout0_24ck1850 FIND v(dout0_24) AT=1860.05n

.meas tran vdout0_25ck1850 FIND v(dout0_25) AT=1860.05n

.meas tran vdout0_26ck1850 FIND v(dout0_26) AT=1860.05n

.meas tran vdout0_27ck1850 FIND v(dout0_27) AT=1860.05n

.meas tran vdout0_28ck1850 FIND v(dout0_28) AT=1860.05n

.meas tran vdout0_29ck1850 FIND v(dout0_29) AT=1860.05n

.meas tran vdout0_30ck1850 FIND v(dout0_30) AT=1860.05n

.meas tran vdout0_31ck1850 FIND v(dout0_31) AT=1860.05n

.meas tran vdout0_32ck1850 FIND v(dout0_32) AT=1860.05n

.meas tran vdout0_0ck1870 FIND v(dout0_0) AT=1880.05n

.meas tran vdout0_1ck1870 FIND v(dout0_1) AT=1880.05n

.meas tran vdout0_2ck1870 FIND v(dout0_2) AT=1880.05n

.meas tran vdout0_3ck1870 FIND v(dout0_3) AT=1880.05n

.meas tran vdout0_4ck1870 FIND v(dout0_4) AT=1880.05n

.meas tran vdout0_5ck1870 FIND v(dout0_5) AT=1880.05n

.meas tran vdout0_6ck1870 FIND v(dout0_6) AT=1880.05n

.meas tran vdout0_7ck1870 FIND v(dout0_7) AT=1880.05n

.meas tran vdout0_8ck1870 FIND v(dout0_8) AT=1880.05n

.meas tran vdout0_9ck1870 FIND v(dout0_9) AT=1880.05n

.meas tran vdout0_10ck1870 FIND v(dout0_10) AT=1880.05n

.meas tran vdout0_11ck1870 FIND v(dout0_11) AT=1880.05n

.meas tran vdout0_12ck1870 FIND v(dout0_12) AT=1880.05n

.meas tran vdout0_13ck1870 FIND v(dout0_13) AT=1880.05n

.meas tran vdout0_14ck1870 FIND v(dout0_14) AT=1880.05n

.meas tran vdout0_15ck1870 FIND v(dout0_15) AT=1880.05n

.meas tran vdout0_16ck1870 FIND v(dout0_16) AT=1880.05n

.meas tran vdout0_17ck1870 FIND v(dout0_17) AT=1880.05n

.meas tran vdout0_18ck1870 FIND v(dout0_18) AT=1880.05n

.meas tran vdout0_19ck1870 FIND v(dout0_19) AT=1880.05n

.meas tran vdout0_20ck1870 FIND v(dout0_20) AT=1880.05n

.meas tran vdout0_21ck1870 FIND v(dout0_21) AT=1880.05n

.meas tran vdout0_22ck1870 FIND v(dout0_22) AT=1880.05n

.meas tran vdout0_23ck1870 FIND v(dout0_23) AT=1880.05n

.meas tran vdout0_24ck1870 FIND v(dout0_24) AT=1880.05n

.meas tran vdout0_25ck1870 FIND v(dout0_25) AT=1880.05n

.meas tran vdout0_26ck1870 FIND v(dout0_26) AT=1880.05n

.meas tran vdout0_27ck1870 FIND v(dout0_27) AT=1880.05n

.meas tran vdout0_28ck1870 FIND v(dout0_28) AT=1880.05n

.meas tran vdout0_29ck1870 FIND v(dout0_29) AT=1880.05n

.meas tran vdout0_30ck1870 FIND v(dout0_30) AT=1880.05n

.meas tran vdout0_31ck1870 FIND v(dout0_31) AT=1880.05n

.meas tran vdout0_32ck1870 FIND v(dout0_32) AT=1880.05n

.meas tran vdout0_0ck1880 FIND v(dout0_0) AT=1890.05n

.meas tran vdout0_1ck1880 FIND v(dout0_1) AT=1890.05n

.meas tran vdout0_2ck1880 FIND v(dout0_2) AT=1890.05n

.meas tran vdout0_3ck1880 FIND v(dout0_3) AT=1890.05n

.meas tran vdout0_4ck1880 FIND v(dout0_4) AT=1890.05n

.meas tran vdout0_5ck1880 FIND v(dout0_5) AT=1890.05n

.meas tran vdout0_6ck1880 FIND v(dout0_6) AT=1890.05n

.meas tran vdout0_7ck1880 FIND v(dout0_7) AT=1890.05n

.meas tran vdout0_8ck1880 FIND v(dout0_8) AT=1890.05n

.meas tran vdout0_9ck1880 FIND v(dout0_9) AT=1890.05n

.meas tran vdout0_10ck1880 FIND v(dout0_10) AT=1890.05n

.meas tran vdout0_11ck1880 FIND v(dout0_11) AT=1890.05n

.meas tran vdout0_12ck1880 FIND v(dout0_12) AT=1890.05n

.meas tran vdout0_13ck1880 FIND v(dout0_13) AT=1890.05n

.meas tran vdout0_14ck1880 FIND v(dout0_14) AT=1890.05n

.meas tran vdout0_15ck1880 FIND v(dout0_15) AT=1890.05n

.meas tran vdout0_16ck1880 FIND v(dout0_16) AT=1890.05n

.meas tran vdout0_17ck1880 FIND v(dout0_17) AT=1890.05n

.meas tran vdout0_18ck1880 FIND v(dout0_18) AT=1890.05n

.meas tran vdout0_19ck1880 FIND v(dout0_19) AT=1890.05n

.meas tran vdout0_20ck1880 FIND v(dout0_20) AT=1890.05n

.meas tran vdout0_21ck1880 FIND v(dout0_21) AT=1890.05n

.meas tran vdout0_22ck1880 FIND v(dout0_22) AT=1890.05n

.meas tran vdout0_23ck1880 FIND v(dout0_23) AT=1890.05n

.meas tran vdout0_24ck1880 FIND v(dout0_24) AT=1890.05n

.meas tran vdout0_25ck1880 FIND v(dout0_25) AT=1890.05n

.meas tran vdout0_26ck1880 FIND v(dout0_26) AT=1890.05n

.meas tran vdout0_27ck1880 FIND v(dout0_27) AT=1890.05n

.meas tran vdout0_28ck1880 FIND v(dout0_28) AT=1890.05n

.meas tran vdout0_29ck1880 FIND v(dout0_29) AT=1890.05n

.meas tran vdout0_30ck1880 FIND v(dout0_30) AT=1890.05n

.meas tran vdout0_31ck1880 FIND v(dout0_31) AT=1890.05n

.meas tran vdout0_32ck1880 FIND v(dout0_32) AT=1890.05n

.meas tran vdout0_0ck1920 FIND v(dout0_0) AT=1930.05n

.meas tran vdout0_1ck1920 FIND v(dout0_1) AT=1930.05n

.meas tran vdout0_2ck1920 FIND v(dout0_2) AT=1930.05n

.meas tran vdout0_3ck1920 FIND v(dout0_3) AT=1930.05n

.meas tran vdout0_4ck1920 FIND v(dout0_4) AT=1930.05n

.meas tran vdout0_5ck1920 FIND v(dout0_5) AT=1930.05n

.meas tran vdout0_6ck1920 FIND v(dout0_6) AT=1930.05n

.meas tran vdout0_7ck1920 FIND v(dout0_7) AT=1930.05n

.meas tran vdout0_8ck1920 FIND v(dout0_8) AT=1930.05n

.meas tran vdout0_9ck1920 FIND v(dout0_9) AT=1930.05n

.meas tran vdout0_10ck1920 FIND v(dout0_10) AT=1930.05n

.meas tran vdout0_11ck1920 FIND v(dout0_11) AT=1930.05n

.meas tran vdout0_12ck1920 FIND v(dout0_12) AT=1930.05n

.meas tran vdout0_13ck1920 FIND v(dout0_13) AT=1930.05n

.meas tran vdout0_14ck1920 FIND v(dout0_14) AT=1930.05n

.meas tran vdout0_15ck1920 FIND v(dout0_15) AT=1930.05n

.meas tran vdout0_16ck1920 FIND v(dout0_16) AT=1930.05n

.meas tran vdout0_17ck1920 FIND v(dout0_17) AT=1930.05n

.meas tran vdout0_18ck1920 FIND v(dout0_18) AT=1930.05n

.meas tran vdout0_19ck1920 FIND v(dout0_19) AT=1930.05n

.meas tran vdout0_20ck1920 FIND v(dout0_20) AT=1930.05n

.meas tran vdout0_21ck1920 FIND v(dout0_21) AT=1930.05n

.meas tran vdout0_22ck1920 FIND v(dout0_22) AT=1930.05n

.meas tran vdout0_23ck1920 FIND v(dout0_23) AT=1930.05n

.meas tran vdout0_24ck1920 FIND v(dout0_24) AT=1930.05n

.meas tran vdout0_25ck1920 FIND v(dout0_25) AT=1930.05n

.meas tran vdout0_26ck1920 FIND v(dout0_26) AT=1930.05n

.meas tran vdout0_27ck1920 FIND v(dout0_27) AT=1930.05n

.meas tran vdout0_28ck1920 FIND v(dout0_28) AT=1930.05n

.meas tran vdout0_29ck1920 FIND v(dout0_29) AT=1930.05n

.meas tran vdout0_30ck1920 FIND v(dout0_30) AT=1930.05n

.meas tran vdout0_31ck1920 FIND v(dout0_31) AT=1930.05n

.meas tran vdout0_32ck1920 FIND v(dout0_32) AT=1930.05n

.meas tran vdout0_0ck1930 FIND v(dout0_0) AT=1940.05n

.meas tran vdout0_1ck1930 FIND v(dout0_1) AT=1940.05n

.meas tran vdout0_2ck1930 FIND v(dout0_2) AT=1940.05n

.meas tran vdout0_3ck1930 FIND v(dout0_3) AT=1940.05n

.meas tran vdout0_4ck1930 FIND v(dout0_4) AT=1940.05n

.meas tran vdout0_5ck1930 FIND v(dout0_5) AT=1940.05n

.meas tran vdout0_6ck1930 FIND v(dout0_6) AT=1940.05n

.meas tran vdout0_7ck1930 FIND v(dout0_7) AT=1940.05n

.meas tran vdout0_8ck1930 FIND v(dout0_8) AT=1940.05n

.meas tran vdout0_9ck1930 FIND v(dout0_9) AT=1940.05n

.meas tran vdout0_10ck1930 FIND v(dout0_10) AT=1940.05n

.meas tran vdout0_11ck1930 FIND v(dout0_11) AT=1940.05n

.meas tran vdout0_12ck1930 FIND v(dout0_12) AT=1940.05n

.meas tran vdout0_13ck1930 FIND v(dout0_13) AT=1940.05n

.meas tran vdout0_14ck1930 FIND v(dout0_14) AT=1940.05n

.meas tran vdout0_15ck1930 FIND v(dout0_15) AT=1940.05n

.meas tran vdout0_16ck1930 FIND v(dout0_16) AT=1940.05n

.meas tran vdout0_17ck1930 FIND v(dout0_17) AT=1940.05n

.meas tran vdout0_18ck1930 FIND v(dout0_18) AT=1940.05n

.meas tran vdout0_19ck1930 FIND v(dout0_19) AT=1940.05n

.meas tran vdout0_20ck1930 FIND v(dout0_20) AT=1940.05n

.meas tran vdout0_21ck1930 FIND v(dout0_21) AT=1940.05n

.meas tran vdout0_22ck1930 FIND v(dout0_22) AT=1940.05n

.meas tran vdout0_23ck1930 FIND v(dout0_23) AT=1940.05n

.meas tran vdout0_24ck1930 FIND v(dout0_24) AT=1940.05n

.meas tran vdout0_25ck1930 FIND v(dout0_25) AT=1940.05n

.meas tran vdout0_26ck1930 FIND v(dout0_26) AT=1940.05n

.meas tran vdout0_27ck1930 FIND v(dout0_27) AT=1940.05n

.meas tran vdout0_28ck1930 FIND v(dout0_28) AT=1940.05n

.meas tran vdout0_29ck1930 FIND v(dout0_29) AT=1940.05n

.meas tran vdout0_30ck1930 FIND v(dout0_30) AT=1940.05n

.meas tran vdout0_31ck1930 FIND v(dout0_31) AT=1940.05n

.meas tran vdout0_32ck1930 FIND v(dout0_32) AT=1940.05n

.meas tran vdout0_0ck1940 FIND v(dout0_0) AT=1950.05n

.meas tran vdout0_1ck1940 FIND v(dout0_1) AT=1950.05n

.meas tran vdout0_2ck1940 FIND v(dout0_2) AT=1950.05n

.meas tran vdout0_3ck1940 FIND v(dout0_3) AT=1950.05n

.meas tran vdout0_4ck1940 FIND v(dout0_4) AT=1950.05n

.meas tran vdout0_5ck1940 FIND v(dout0_5) AT=1950.05n

.meas tran vdout0_6ck1940 FIND v(dout0_6) AT=1950.05n

.meas tran vdout0_7ck1940 FIND v(dout0_7) AT=1950.05n

.meas tran vdout0_8ck1940 FIND v(dout0_8) AT=1950.05n

.meas tran vdout0_9ck1940 FIND v(dout0_9) AT=1950.05n

.meas tran vdout0_10ck1940 FIND v(dout0_10) AT=1950.05n

.meas tran vdout0_11ck1940 FIND v(dout0_11) AT=1950.05n

.meas tran vdout0_12ck1940 FIND v(dout0_12) AT=1950.05n

.meas tran vdout0_13ck1940 FIND v(dout0_13) AT=1950.05n

.meas tran vdout0_14ck1940 FIND v(dout0_14) AT=1950.05n

.meas tran vdout0_15ck1940 FIND v(dout0_15) AT=1950.05n

.meas tran vdout0_16ck1940 FIND v(dout0_16) AT=1950.05n

.meas tran vdout0_17ck1940 FIND v(dout0_17) AT=1950.05n

.meas tran vdout0_18ck1940 FIND v(dout0_18) AT=1950.05n

.meas tran vdout0_19ck1940 FIND v(dout0_19) AT=1950.05n

.meas tran vdout0_20ck1940 FIND v(dout0_20) AT=1950.05n

.meas tran vdout0_21ck1940 FIND v(dout0_21) AT=1950.05n

.meas tran vdout0_22ck1940 FIND v(dout0_22) AT=1950.05n

.meas tran vdout0_23ck1940 FIND v(dout0_23) AT=1950.05n

.meas tran vdout0_24ck1940 FIND v(dout0_24) AT=1950.05n

.meas tran vdout0_25ck1940 FIND v(dout0_25) AT=1950.05n

.meas tran vdout0_26ck1940 FIND v(dout0_26) AT=1950.05n

.meas tran vdout0_27ck1940 FIND v(dout0_27) AT=1950.05n

.meas tran vdout0_28ck1940 FIND v(dout0_28) AT=1950.05n

.meas tran vdout0_29ck1940 FIND v(dout0_29) AT=1950.05n

.meas tran vdout0_30ck1940 FIND v(dout0_30) AT=1950.05n

.meas tran vdout0_31ck1940 FIND v(dout0_31) AT=1950.05n

.meas tran vdout0_32ck1940 FIND v(dout0_32) AT=1950.05n

.meas tran vdout0_0ck1950 FIND v(dout0_0) AT=1960.05n

.meas tran vdout0_1ck1950 FIND v(dout0_1) AT=1960.05n

.meas tran vdout0_2ck1950 FIND v(dout0_2) AT=1960.05n

.meas tran vdout0_3ck1950 FIND v(dout0_3) AT=1960.05n

.meas tran vdout0_4ck1950 FIND v(dout0_4) AT=1960.05n

.meas tran vdout0_5ck1950 FIND v(dout0_5) AT=1960.05n

.meas tran vdout0_6ck1950 FIND v(dout0_6) AT=1960.05n

.meas tran vdout0_7ck1950 FIND v(dout0_7) AT=1960.05n

.meas tran vdout0_8ck1950 FIND v(dout0_8) AT=1960.05n

.meas tran vdout0_9ck1950 FIND v(dout0_9) AT=1960.05n

.meas tran vdout0_10ck1950 FIND v(dout0_10) AT=1960.05n

.meas tran vdout0_11ck1950 FIND v(dout0_11) AT=1960.05n

.meas tran vdout0_12ck1950 FIND v(dout0_12) AT=1960.05n

.meas tran vdout0_13ck1950 FIND v(dout0_13) AT=1960.05n

.meas tran vdout0_14ck1950 FIND v(dout0_14) AT=1960.05n

.meas tran vdout0_15ck1950 FIND v(dout0_15) AT=1960.05n

.meas tran vdout0_16ck1950 FIND v(dout0_16) AT=1960.05n

.meas tran vdout0_17ck1950 FIND v(dout0_17) AT=1960.05n

.meas tran vdout0_18ck1950 FIND v(dout0_18) AT=1960.05n

.meas tran vdout0_19ck1950 FIND v(dout0_19) AT=1960.05n

.meas tran vdout0_20ck1950 FIND v(dout0_20) AT=1960.05n

.meas tran vdout0_21ck1950 FIND v(dout0_21) AT=1960.05n

.meas tran vdout0_22ck1950 FIND v(dout0_22) AT=1960.05n

.meas tran vdout0_23ck1950 FIND v(dout0_23) AT=1960.05n

.meas tran vdout0_24ck1950 FIND v(dout0_24) AT=1960.05n

.meas tran vdout0_25ck1950 FIND v(dout0_25) AT=1960.05n

.meas tran vdout0_26ck1950 FIND v(dout0_26) AT=1960.05n

.meas tran vdout0_27ck1950 FIND v(dout0_27) AT=1960.05n

.meas tran vdout0_28ck1950 FIND v(dout0_28) AT=1960.05n

.meas tran vdout0_29ck1950 FIND v(dout0_29) AT=1960.05n

.meas tran vdout0_30ck1950 FIND v(dout0_30) AT=1960.05n

.meas tran vdout0_31ck1950 FIND v(dout0_31) AT=1960.05n

.meas tran vdout0_32ck1950 FIND v(dout0_32) AT=1960.05n

.meas tran vdout0_0ck1980 FIND v(dout0_0) AT=1990.05n

.meas tran vdout0_1ck1980 FIND v(dout0_1) AT=1990.05n

.meas tran vdout0_2ck1980 FIND v(dout0_2) AT=1990.05n

.meas tran vdout0_3ck1980 FIND v(dout0_3) AT=1990.05n

.meas tran vdout0_4ck1980 FIND v(dout0_4) AT=1990.05n

.meas tran vdout0_5ck1980 FIND v(dout0_5) AT=1990.05n

.meas tran vdout0_6ck1980 FIND v(dout0_6) AT=1990.05n

.meas tran vdout0_7ck1980 FIND v(dout0_7) AT=1990.05n

.meas tran vdout0_8ck1980 FIND v(dout0_8) AT=1990.05n

.meas tran vdout0_9ck1980 FIND v(dout0_9) AT=1990.05n

.meas tran vdout0_10ck1980 FIND v(dout0_10) AT=1990.05n

.meas tran vdout0_11ck1980 FIND v(dout0_11) AT=1990.05n

.meas tran vdout0_12ck1980 FIND v(dout0_12) AT=1990.05n

.meas tran vdout0_13ck1980 FIND v(dout0_13) AT=1990.05n

.meas tran vdout0_14ck1980 FIND v(dout0_14) AT=1990.05n

.meas tran vdout0_15ck1980 FIND v(dout0_15) AT=1990.05n

.meas tran vdout0_16ck1980 FIND v(dout0_16) AT=1990.05n

.meas tran vdout0_17ck1980 FIND v(dout0_17) AT=1990.05n

.meas tran vdout0_18ck1980 FIND v(dout0_18) AT=1990.05n

.meas tran vdout0_19ck1980 FIND v(dout0_19) AT=1990.05n

.meas tran vdout0_20ck1980 FIND v(dout0_20) AT=1990.05n

.meas tran vdout0_21ck1980 FIND v(dout0_21) AT=1990.05n

.meas tran vdout0_22ck1980 FIND v(dout0_22) AT=1990.05n

.meas tran vdout0_23ck1980 FIND v(dout0_23) AT=1990.05n

.meas tran vdout0_24ck1980 FIND v(dout0_24) AT=1990.05n

.meas tran vdout0_25ck1980 FIND v(dout0_25) AT=1990.05n

.meas tran vdout0_26ck1980 FIND v(dout0_26) AT=1990.05n

.meas tran vdout0_27ck1980 FIND v(dout0_27) AT=1990.05n

.meas tran vdout0_28ck1980 FIND v(dout0_28) AT=1990.05n

.meas tran vdout0_29ck1980 FIND v(dout0_29) AT=1990.05n

.meas tran vdout0_30ck1980 FIND v(dout0_30) AT=1990.05n

.meas tran vdout0_31ck1980 FIND v(dout0_31) AT=1990.05n

.meas tran vdout0_32ck1980 FIND v(dout0_32) AT=1990.05n

.meas tran vdout0_0ck2010 FIND v(dout0_0) AT=2020.05n

.meas tran vdout0_1ck2010 FIND v(dout0_1) AT=2020.05n

.meas tran vdout0_2ck2010 FIND v(dout0_2) AT=2020.05n

.meas tran vdout0_3ck2010 FIND v(dout0_3) AT=2020.05n

.meas tran vdout0_4ck2010 FIND v(dout0_4) AT=2020.05n

.meas tran vdout0_5ck2010 FIND v(dout0_5) AT=2020.05n

.meas tran vdout0_6ck2010 FIND v(dout0_6) AT=2020.05n

.meas tran vdout0_7ck2010 FIND v(dout0_7) AT=2020.05n

.meas tran vdout0_8ck2010 FIND v(dout0_8) AT=2020.05n

.meas tran vdout0_9ck2010 FIND v(dout0_9) AT=2020.05n

.meas tran vdout0_10ck2010 FIND v(dout0_10) AT=2020.05n

.meas tran vdout0_11ck2010 FIND v(dout0_11) AT=2020.05n

.meas tran vdout0_12ck2010 FIND v(dout0_12) AT=2020.05n

.meas tran vdout0_13ck2010 FIND v(dout0_13) AT=2020.05n

.meas tran vdout0_14ck2010 FIND v(dout0_14) AT=2020.05n

.meas tran vdout0_15ck2010 FIND v(dout0_15) AT=2020.05n

.meas tran vdout0_16ck2010 FIND v(dout0_16) AT=2020.05n

.meas tran vdout0_17ck2010 FIND v(dout0_17) AT=2020.05n

.meas tran vdout0_18ck2010 FIND v(dout0_18) AT=2020.05n

.meas tran vdout0_19ck2010 FIND v(dout0_19) AT=2020.05n

.meas tran vdout0_20ck2010 FIND v(dout0_20) AT=2020.05n

.meas tran vdout0_21ck2010 FIND v(dout0_21) AT=2020.05n

.meas tran vdout0_22ck2010 FIND v(dout0_22) AT=2020.05n

.meas tran vdout0_23ck2010 FIND v(dout0_23) AT=2020.05n

.meas tran vdout0_24ck2010 FIND v(dout0_24) AT=2020.05n

.meas tran vdout0_25ck2010 FIND v(dout0_25) AT=2020.05n

.meas tran vdout0_26ck2010 FIND v(dout0_26) AT=2020.05n

.meas tran vdout0_27ck2010 FIND v(dout0_27) AT=2020.05n

.meas tran vdout0_28ck2010 FIND v(dout0_28) AT=2020.05n

.meas tran vdout0_29ck2010 FIND v(dout0_29) AT=2020.05n

.meas tran vdout0_30ck2010 FIND v(dout0_30) AT=2020.05n

.meas tran vdout0_31ck2010 FIND v(dout0_31) AT=2020.05n

.meas tran vdout0_32ck2010 FIND v(dout0_32) AT=2020.05n
