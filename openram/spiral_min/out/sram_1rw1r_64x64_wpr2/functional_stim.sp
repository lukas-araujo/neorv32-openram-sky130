* Functional test stimulus file for 10ns period

* TT process corner
.lib "/home/lukas/Projects/pdks/sky130A/libs.tech/ngspice/sky130.lib.spice" tt
.include "/tmp/openram_lukas_965268_temp/sram.sp"

* Global Power Supplies
Vvdd vdd 0 1.8

*Nodes gnd and 0 are the same global ground node in ngspice/hspice/xa. Otherwise, this source may be needed.
*Vgnd gnd 0 0.0

* Instantiation of the SRAM
Xsram_1rw1r_64x64_wpr2 din0_0 din0_1 din0_2 din0_3 din0_4 din0_5 din0_6 din0_7 din0_8 din0_9 din0_10 din0_11 din0_12 din0_13 din0_14 din0_15 din0_16 din0_17 din0_18 din0_19 din0_20 din0_21 din0_22 din0_23 din0_24 din0_25 din0_26 din0_27 din0_28 din0_29 din0_30 din0_31 din0_32 din0_33 din0_34 din0_35 din0_36 din0_37 din0_38 din0_39 din0_40 din0_41 din0_42 din0_43 din0_44 din0_45 din0_46 din0_47 din0_48 din0_49 din0_50 din0_51 din0_52 din0_53 din0_54 din0_55 din0_56 din0_57 din0_58 din0_59 din0_60 din0_61 din0_62 din0_63 a0_0 a0_1 a0_2 a0_3 a0_4 a0_5 a1_0 a1_1 a1_2 a1_3 a1_4 a1_5 CSB0 CSB1 WEB0 clk0 clk1 dout0_0 dout0_1 dout0_2 dout0_3 dout0_4 dout0_5 dout0_6 dout0_7 dout0_8 dout0_9 dout0_10 dout0_11 dout0_12 dout0_13 dout0_14 dout0_15 dout0_16 dout0_17 dout0_18 dout0_19 dout0_20 dout0_21 dout0_22 dout0_23 dout0_24 dout0_25 dout0_26 dout0_27 dout0_28 dout0_29 dout0_30 dout0_31 dout0_32 dout0_33 dout0_34 dout0_35 dout0_36 dout0_37 dout0_38 dout0_39 dout0_40 dout0_41 dout0_42 dout0_43 dout0_44 dout0_45 dout0_46 dout0_47 dout0_48 dout0_49 dout0_50 dout0_51 dout0_52 dout0_53 dout0_54 dout0_55 dout0_56 dout0_57 dout0_58 dout0_59 dout0_60 dout0_61 dout0_62 dout0_63 dout1_0 dout1_1 dout1_2 dout1_3 dout1_4 dout1_5 dout1_6 dout1_7 dout1_8 dout1_9 dout1_10 dout1_11 dout1_12 dout1_13 dout1_14 dout1_15 dout1_16 dout1_17 dout1_18 dout1_19 dout1_20 dout1_21 dout1_22 dout1_23 dout1_24 dout1_25 dout1_26 dout1_27 dout1_28 dout1_29 dout1_30 dout1_31 dout1_32 dout1_33 dout1_34 dout1_35 dout1_36 dout1_37 dout1_38 dout1_39 dout1_40 dout1_41 dout1_42 dout1_43 dout1_44 dout1_45 dout1_46 dout1_47 dout1_48 dout1_49 dout1_50 dout1_51 dout1_52 dout1_53 dout1_54 dout1_55 dout1_56 dout1_57 dout1_58 dout1_59 dout1_60 dout1_61 dout1_62 dout1_63 vdd gnd sram_1rw1r_64x64_wpr2

* SRAM output loads
CD00 dout0_0  0 27.56f
CD01 dout0_1  0 27.56f
CD02 dout0_2  0 27.56f
CD03 dout0_3  0 27.56f
CD04 dout0_4  0 27.56f
CD05 dout0_5  0 27.56f
CD06 dout0_6  0 27.56f
CD07 dout0_7  0 27.56f
CD08 dout0_8  0 27.56f
CD09 dout0_9  0 27.56f
CD010 dout0_10  0 27.56f
CD011 dout0_11  0 27.56f
CD012 dout0_12  0 27.56f
CD013 dout0_13  0 27.56f
CD014 dout0_14  0 27.56f
CD015 dout0_15  0 27.56f
CD016 dout0_16  0 27.56f
CD017 dout0_17  0 27.56f
CD018 dout0_18  0 27.56f
CD019 dout0_19  0 27.56f
CD020 dout0_20  0 27.56f
CD021 dout0_21  0 27.56f
CD022 dout0_22  0 27.56f
CD023 dout0_23  0 27.56f
CD024 dout0_24  0 27.56f
CD025 dout0_25  0 27.56f
CD026 dout0_26  0 27.56f
CD027 dout0_27  0 27.56f
CD028 dout0_28  0 27.56f
CD029 dout0_29  0 27.56f
CD030 dout0_30  0 27.56f
CD031 dout0_31  0 27.56f
CD032 dout0_32  0 27.56f
CD033 dout0_33  0 27.56f
CD034 dout0_34  0 27.56f
CD035 dout0_35  0 27.56f
CD036 dout0_36  0 27.56f
CD037 dout0_37  0 27.56f
CD038 dout0_38  0 27.56f
CD039 dout0_39  0 27.56f
CD040 dout0_40  0 27.56f
CD041 dout0_41  0 27.56f
CD042 dout0_42  0 27.56f
CD043 dout0_43  0 27.56f
CD044 dout0_44  0 27.56f
CD045 dout0_45  0 27.56f
CD046 dout0_46  0 27.56f
CD047 dout0_47  0 27.56f
CD048 dout0_48  0 27.56f
CD049 dout0_49  0 27.56f
CD050 dout0_50  0 27.56f
CD051 dout0_51  0 27.56f
CD052 dout0_52  0 27.56f
CD053 dout0_53  0 27.56f
CD054 dout0_54  0 27.56f
CD055 dout0_55  0 27.56f
CD056 dout0_56  0 27.56f
CD057 dout0_57  0 27.56f
CD058 dout0_58  0 27.56f
CD059 dout0_59  0 27.56f
CD060 dout0_60  0 27.56f
CD061 dout0_61  0 27.56f
CD062 dout0_62  0 27.56f
CD063 dout0_63  0 27.56f
CD10 dout1_0  0 27.56f
CD11 dout1_1  0 27.56f
CD12 dout1_2  0 27.56f
CD13 dout1_3  0 27.56f
CD14 dout1_4  0 27.56f
CD15 dout1_5  0 27.56f
CD16 dout1_6  0 27.56f
CD17 dout1_7  0 27.56f
CD18 dout1_8  0 27.56f
CD19 dout1_9  0 27.56f
CD110 dout1_10  0 27.56f
CD111 dout1_11  0 27.56f
CD112 dout1_12  0 27.56f
CD113 dout1_13  0 27.56f
CD114 dout1_14  0 27.56f
CD115 dout1_15  0 27.56f
CD116 dout1_16  0 27.56f
CD117 dout1_17  0 27.56f
CD118 dout1_18  0 27.56f
CD119 dout1_19  0 27.56f
CD120 dout1_20  0 27.56f
CD121 dout1_21  0 27.56f
CD122 dout1_22  0 27.56f
CD123 dout1_23  0 27.56f
CD124 dout1_24  0 27.56f
CD125 dout1_25  0 27.56f
CD126 dout1_26  0 27.56f
CD127 dout1_27  0 27.56f
CD128 dout1_28  0 27.56f
CD129 dout1_29  0 27.56f
CD130 dout1_30  0 27.56f
CD131 dout1_31  0 27.56f
CD132 dout1_32  0 27.56f
CD133 dout1_33  0 27.56f
CD134 dout1_34  0 27.56f
CD135 dout1_35  0 27.56f
CD136 dout1_36  0 27.56f
CD137 dout1_37  0 27.56f
CD138 dout1_38  0 27.56f
CD139 dout1_39  0 27.56f
CD140 dout1_40  0 27.56f
CD141 dout1_41  0 27.56f
CD142 dout1_42  0 27.56f
CD143 dout1_43  0 27.56f
CD144 dout1_44  0 27.56f
CD145 dout1_45  0 27.56f
CD146 dout1_46  0 27.56f
CD147 dout1_47  0 27.56f
CD148 dout1_48  0 27.56f
CD149 dout1_49  0 27.56f
CD150 dout1_50  0 27.56f
CD151 dout1_51  0 27.56f
CD152 dout1_52  0 27.56f
CD153 dout1_53  0 27.56f
CD154 dout1_54  0 27.56f
CD155 dout1_55  0 27.56f
CD156 dout1_56  0 27.56f
CD157 dout1_57  0 27.56f
CD158 dout1_58  0 27.56f
CD159 dout1_59  0 27.56f
CD160 dout1_60  0 27.56f
CD161 dout1_61  0 27.56f
CD162 dout1_62  0 27.56f
CD163 dout1_63  0 27.56f

* Important signals for debug
* bl:	xsram:xbank0:bl_0_1
* br:	xsram:xbank0:br_0_1
* s_en:	xsram:s_en
* q:	xsram:xbank0:xbitcell_array:xbitcell_array:xbit_r0_c0.Q
* qbar:	xsram:xbank0:xbitcell_array:xbitcell_array:xbit_r0_c0.Q_bar

* Sequence of operations
*	Idle during cycle 0 (0ns - 10ns)
*	Writing 0011000001010001011110110111001011000100110100101000001001111110  to  address 000000 (from port 0) during cycle 1 (10ns - 20ns)
*	Writing 0000101111110101100100001111010101000100111100000100110000101101  to  address 111110 (from port 0) during cycle 2 (20ns - 30ns)
*	Writing 1100010011000011011110000011011100011000110000011110000010111101  to  address 000000 (from port 0) during cycle 3 (30ns - 40ns)
*	Reading 0000101111110101100100001111010101000100111100000100110000101101 from address 111110 (from port 0) during cycle 4 (40ns - 50ns)
*	Reading 0000101111110101100100001111010101000100111100000100110000101101 from address 111110 (from port 1) during cycle 4 (40ns - 50ns)
*	Reading 1100010011000011011110000011011100011000110000011110000010111101 from address 000000 (from port 0) during cycle 5 (50ns - 60ns)
*	Reading 0000101111110101100100001111010101000100111100000100110000101101 from address 111110 (from port 1) during cycle 5 (50ns - 60ns)
*	Writing 0011110110101110101010010000111100110110011010110011111110010111  to  address 000001 (from port 0) during cycle 6 (60ns - 70ns)
*	Reading 1100010011000011011110000011011100011000110000011110000010111101 from address 000000 (from port 0) during cycle 7 (70ns - 80ns)
*	Reading 1100010011000011011110000011011100011000110000011110000010111101 from address 000000 (from port 0) during cycle 8 (80ns - 90ns)
*	Reading 1100010011000011011110000011011100011000110000011110000010111101 from address 000000 (from port 0) during cycle 9 (90ns - 100ns)
*	Reading 0011110110101110101010010000111100110110011010110011111110010111 from address 000001 (from port 1) during cycle 10 (100ns - 110ns)
*	Reading 0011110110101110101010010000111100110110011010110011111110010111 from address 000001 (from port 0) during cycle 11 (110ns - 120ns)
*	Reading 0000101111110101100100001111010101000100111100000100110000101101 from address 111110 (from port 0) during cycle 12 (120ns - 130ns)
*	Reading 1100010011000011011110000011011100011000110000011110000010111101 from address 000000 (from port 0) during cycle 13 (130ns - 140ns)
*	Reading 0000101111110101100100001111010101000100111100000100110000101101 from address 111110 (from port 0) during cycle 14 (140ns - 150ns)
*	Writing 1000100100010000011101000011000110111011001000100110001101100010  to  address 111110 (from port 0) during cycle 15 (150ns - 160ns)
*	Reading 1000100100010000011101000011000110111011001000100110001101100010 from address 111110 (from port 0) during cycle 16 (160ns - 170ns)
*	Reading 0011110110101110101010010000111100110110011010110011111110010111 from address 000001 (from port 1) during cycle 16 (160ns - 170ns)
*	Reading 1000100100010000011101000011000110111011001000100110001101100010 from address 111110 (from port 0) during cycle 17 (170ns - 180ns)
*	Reading 0011110110101110101010010000111100110110011010110011111110010111 from address 000001 (from port 1) during cycle 17 (170ns - 180ns)
*	Reading 1100010011000011011110000011011100011000110000011110000010111101 from address 000000 (from port 1) during cycle 18 (180ns - 190ns)
*	Reading 1000100100010000011101000011000110111011001000100110001101100010 from address 111110 (from port 0) during cycle 19 (190ns - 200ns)
*	Reading 1000100100010000011101000011000110111011001000100110001101100010 from address 111110 (from port 1) during cycle 19 (190ns - 200ns)
*	Reading 1100010011000011011110000011011100011000110000011110000010111101 from address 000000 (from port 0) during cycle 21 (210ns - 220ns)
*	Reading 1000100100010000011101000011000110111011001000100110001101100010 from address 111110 (from port 0) during cycle 22 (220ns - 230ns)
*	Reading 1000100100010000011101000011000110111011001000100110001101100010 from address 111110 (from port 1) during cycle 22 (220ns - 230ns)
*	Reading 1100010011000011011110000011011100011000110000011110000010111101 from address 000000 (from port 0) during cycle 23 (230ns - 240ns)
*	Reading 0011110110101110101010010000111100110110011010110011111110010111 from address 000001 (from port 1) during cycle 23 (230ns - 240ns)
*	Reading 1100010011000011011110000011011100011000110000011110000010111101 from address 000000 (from port 1) during cycle 24 (240ns - 250ns)
*	Reading 1000100100010000011101000011000110111011001000100110001101100010 from address 111110 (from port 0) during cycle 25 (250ns - 260ns)
*	Reading 0011110110101110101010010000111100110110011010110011111110010111 from address 000001 (from port 1) during cycle 25 (250ns - 260ns)
*	Writing 1101001111011100010000000010110001000101000111001011011010010011  to  address 000001 (from port 0) during cycle 26 (260ns - 270ns)
*	Reading 1000100100010000011101000011000110111011001000100110001101100010 from address 111110 (from port 0) during cycle 27 (270ns - 280ns)
*	Reading 1100010011000011011110000011011100011000110000011110000010111101 from address 000000 (from port 1) during cycle 27 (270ns - 280ns)
*	Reading 1101001111011100010000000010110001000101000111001011011010010011 from address 000001 (from port 0) during cycle 28 (280ns - 290ns)
*	Reading 1100010011000011011110000011011100011000110000011110000010111101 from address 000000 (from port 0) during cycle 29 (290ns - 300ns)
*	Reading 1101001111011100010000000010110001000101000111001011011010010011 from address 000001 (from port 1) during cycle 29 (290ns - 300ns)
*	Reading 1000100100010000011101000011000110111011001000100110001101100010 from address 111110 (from port 0) during cycle 30 (300ns - 310ns)
*	Reading 1100010011000011011110000011011100011000110000011110000010111101 from address 000000 (from port 1) during cycle 30 (300ns - 310ns)
*	Writing 0011110110101111101000000010111000110000110000111011010111010110  to  address 000000 (from port 0) during cycle 31 (310ns - 320ns)
*	Reading 1000100100010000011101000011000110111011001000100110001101100010 from address 111110 (from port 1) during cycle 31 (310ns - 320ns)
*	Reading 1101001111011100010000000010110001000101000111001011011010010011 from address 000001 (from port 0) during cycle 32 (320ns - 330ns)
*	Reading 0011110110101111101000000010111000110000110000111011010111010110 from address 000000 (from port 0) during cycle 34 (340ns - 350ns)
*	Writing 0100011011101000110011000010011001011001100101100111111000010110  to  address 111101 (from port 0) during cycle 35 (350ns - 360ns)
*	Reading 0011110110101111101000000010111000110000110000111011010111010110 from address 000000 (from port 1) during cycle 37 (370ns - 380ns)
*	Reading 1101001111011100010000000010110001000101000111001011011010010011 from address 000001 (from port 0) during cycle 38 (380ns - 390ns)
*	Writing 0001110110111110010010001011101111000100001111110011010110010011  to  address 000001 (from port 0) during cycle 39 (390ns - 400ns)
*	Reading 0100011011101000110011000010011001011001100101100111111000010110 from address 111101 (from port 1) during cycle 39 (390ns - 400ns)
*	Writing 1000110000100101001111001011011111011101110000111111001000101001  to  address 000001 (from port 0) during cycle 40 (400ns - 410ns)
*	Reading 1000100100010000011101000011000110111011001000100110001101100010 from address 111110 (from port 1) during cycle 40 (400ns - 410ns)
*	Reading 1000100100010000011101000011000110111011001000100110001101100010 from address 111110 (from port 0) during cycle 41 (410ns - 420ns)
*	Writing 0000101111100100100011100000110001011110111101001110100001001111  to  address 111101 (from port 0) during cycle 42 (420ns - 430ns)
*	Reading 1000110000100101001111001011011111011101110000111111001000101001 from address 000001 (from port 0) during cycle 43 (430ns - 440ns)
*	Reading 1000110000100101001111001011011111011101110000111111001000101001 from address 000001 (from port 1) during cycle 43 (430ns - 440ns)
*	Reading 0000101111100100100011100000110001011110111101001110100001001111 from address 111101 (from port 1) during cycle 44 (440ns - 450ns)
*	Writing 0001100111001101110110110011000001001001101111100011000111111001  to  address 000001 (from port 0) during cycle 45 (450ns - 460ns)
*	Reading 0000101111100100100011100000110001011110111101001110100001001111 from address 111101 (from port 0) during cycle 46 (460ns - 470ns)
*	Reading 1000100100010000011101000011000110111011001000100110001101100010 from address 111110 (from port 1) during cycle 46 (460ns - 470ns)
*	Writing 1000111000011101011100101011110111000001101110011110011010011010  to  address 111101 (from port 0) during cycle 47 (470ns - 480ns)
*	Reading 1000100100010000011101000011000110111011001000100110001101100010 from address 111110 (from port 0) during cycle 48 (480ns - 490ns)
*	Writing 1001001100010110011000100010010011001001101111110110110110101111  to  address 000000 (from port 0) during cycle 49 (490ns - 500ns)
*	Writing 0100100111111100000011110010100110110001010011011110101110001100  to  address 111101 (from port 0) during cycle 50 (500ns - 510ns)
*	Reading 0001100111001101110110110011000001001001101111100011000111111001 from address 000001 (from port 1) during cycle 50 (500ns - 510ns)
*	Reading 1000100100010000011101000011000110111011001000100110001101100010 from address 111110 (from port 0) during cycle 52 (520ns - 530ns)
*	Reading 1000100100010000011101000011000110111011001000100110001101100010 from address 111110 (from port 1) during cycle 52 (520ns - 530ns)
*	Reading 0001100111001101110110110011000001001001101111100011000111111001 from address 000001 (from port 0) during cycle 53 (530ns - 540ns)
*	Reading 0001100111001101110110110011000001001001101111100011000111111001 from address 000001 (from port 1) during cycle 54 (540ns - 550ns)
*	Reading 0001100111001101110110110011000001001001101111100011000111111001 from address 000001 (from port 0) during cycle 55 (550ns - 560ns)
*	Reading 0001100111001101110110110011000001001001101111100011000111111001 from address 000001 (from port 0) during cycle 56 (560ns - 570ns)
*	Reading 1001001100010110011000100010010011001001101111110110110110101111 from address 000000 (from port 1) during cycle 56 (560ns - 570ns)
*	Reading 1000100100010000011101000011000110111011001000100110001101100010 from address 111110 (from port 1) during cycle 58 (580ns - 590ns)
*	Reading 1001001100010110011000100010010011001001101111110110110110101111 from address 000000 (from port 0) during cycle 59 (590ns - 600ns)
*	Reading 1001001100010110011000100010010011001001101111110110110110101111 from address 000000 (from port 1) during cycle 59 (590ns - 600ns)
*	Reading 0100100111111100000011110010100110110001010011011110101110001100 from address 111101 (from port 0) during cycle 60 (600ns - 610ns)
*	Reading 0100100111111100000011110010100110110001010011011110101110001100 from address 111101 (from port 1) during cycle 60 (600ns - 610ns)
*	Reading 1001001100010110011000100010010011001001101111110110110110101111 from address 000000 (from port 0) during cycle 61 (610ns - 620ns)
*	Writing 1110100101010110101111111100011110100100011000100011000100011011  to  address 000000 (from port 0) during cycle 62 (620ns - 630ns)
*	Reading 1000100100010000011101000011000110111011001000100110001101100010 from address 111110 (from port 0) during cycle 64 (640ns - 650ns)
*	Reading 0001100111001101110110110011000001001001101111100011000111111001 from address 000001 (from port 0) during cycle 65 (650ns - 660ns)
*	Writing 1110010100001110001100111001100011110101001011001101101010101101  to  address 111101 (from port 0) during cycle 66 (660ns - 670ns)
*	Reading 1110100101010110101111111100011110100100011000100011000100011011 from address 000000 (from port 1) during cycle 66 (660ns - 670ns)
*	Writing 1000011000010011111001001011000011101100111000111010100110110101  to  address 111110 (from port 0) during cycle 67 (670ns - 680ns)
*	Reading 1110100101010110101111111100011110100100011000100011000100011011 from address 000000 (from port 0) during cycle 68 (680ns - 690ns)
*	Reading 1000011000010011111001001011000011101100111000111010100110110101 from address 111110 (from port 1) during cycle 68 (680ns - 690ns)
*	Reading 1110010100001110001100111001100011110101001011001101101010101101 from address 111101 (from port 1) during cycle 69 (690ns - 700ns)
*	Reading 0001100111001101110110110011000001001001101111100011000111111001 from address 000001 (from port 0) during cycle 70 (700ns - 710ns)
*	Reading 0001100111001101110110110011000001001001101111100011000111111001 from address 000001 (from port 1) during cycle 70 (700ns - 710ns)
*	Writing 1000100100110011111101101001011011001001000010011100010110010110  to  address 000000 (from port 0) during cycle 71 (710ns - 720ns)
*	Reading 1110010100001110001100111001100011110101001011001101101010101101 from address 111101 (from port 1) during cycle 71 (710ns - 720ns)
*	Reading 0001100111001101110110110011000001001001101111100011000111111001 from address 000001 (from port 0) during cycle 72 (720ns - 730ns)
*	Reading 0001100111001101110110110011000001001001101111100011000111111001 from address 000001 (from port 0) during cycle 73 (730ns - 740ns)
*	Reading 1000100100110011111101101001011011001001000010011100010110010110 from address 000000 (from port 1) during cycle 73 (730ns - 740ns)
*	Reading 0001100111001101110110110011000001001001101111100011000111111001 from address 000001 (from port 0) during cycle 74 (740ns - 750ns)
*	Reading 0001100111001101110110110011000001001001101111100011000111111001 from address 000001 (from port 1) during cycle 74 (740ns - 750ns)
*	Reading 0001100111001101110110110011000001001001101111100011000111111001 from address 000001 (from port 0) during cycle 75 (750ns - 760ns)
*	Reading 1000100100110011111101101001011011001001000010011100010110010110 from address 000000 (from port 1) during cycle 75 (750ns - 760ns)
*	Reading 1000011000010011111001001011000011101100111000111010100110110101 from address 111110 (from port 1) during cycle 76 (760ns - 770ns)
*	Writing 1100011001100001010000100010011010011111101101101110101001100101  to  address 000001 (from port 0) during cycle 77 (770ns - 780ns)
*	Reading 1110010100001110001100111001100011110101001011001101101010101101 from address 111101 (from port 1) during cycle 77 (770ns - 780ns)
*	Reading 1110010100001110001100111001100011110101001011001101101010101101 from address 111101 (from port 1) during cycle 78 (780ns - 790ns)
*	Reading 1000011000010011111001001011000011101100111000111010100110110101 from address 111110 (from port 0) during cycle 79 (790ns - 800ns)
*	Reading 1000011000010011111001001011000011101100111000111010100110110101 from address 111110 (from port 0) during cycle 80 (800ns - 810ns)
*	Reading 1000100100110011111101101001011011001001000010011100010110010110 from address 000000 (from port 0) during cycle 81 (810ns - 820ns)
*	Reading 1110010100001110001100111001100011110101001011001101101010101101 from address 111101 (from port 1) during cycle 81 (810ns - 820ns)
*	Writing 1110000100000011001111000110011101000000100011010001001100001010  to  address 111110 (from port 0) during cycle 82 (820ns - 830ns)
*	Reading 1000100100110011111101101001011011001001000010011100010110010110 from address 000000 (from port 1) during cycle 82 (820ns - 830ns)
*	Reading 1000100100110011111101101001011011001001000010011100010110010110 from address 000000 (from port 0) during cycle 83 (830ns - 840ns)
*	Reading 1110000100000011001111000110011101000000100011010001001100001010 from address 111110 (from port 1) during cycle 83 (830ns - 840ns)
*	Writing 1000010001110100110010101110100000101000111001000101001000100110  to  address 111110 (from port 0) during cycle 84 (840ns - 850ns)
*	Reading 1110010100001110001100111001100011110101001011001101101010101101 from address 111101 (from port 1) during cycle 84 (840ns - 850ns)
*	Reading 1110010100001110001100111001100011110101001011001101101010101101 from address 111101 (from port 0) during cycle 85 (850ns - 860ns)
*	Reading 1100011001100001010000100010011010011111101101101110101001100101 from address 000001 (from port 0) during cycle 86 (860ns - 870ns)
*	Reading 1110010100001110001100111001100011110101001011001101101010101101 from address 111101 (from port 1) during cycle 86 (860ns - 870ns)
*	Reading 1000010001110100110010101110100000101000111001000101001000100110 from address 111110 (from port 0) during cycle 88 (880ns - 890ns)
*	Writing 1100010110011101001011111101100001010000100000101111111101100010  to  address 000001 (from port 0) during cycle 89 (890ns - 900ns)
*	Reading 1000100100110011111101101001011011001001000010011100010110010110 from address 000000 (from port 1) during cycle 89 (890ns - 900ns)
*	Reading 1000100100110011111101101001011011001001000010011100010110010110 from address 000000 (from port 0) during cycle 90 (900ns - 910ns)
*	Reading 1000100100110011111101101001011011001001000010011100010110010110 from address 000000 (from port 0) during cycle 91 (910ns - 920ns)
*	Reading 1000100100110011111101101001011011001001000010011100010110010110 from address 000000 (from port 1) during cycle 91 (910ns - 920ns)
*	Reading 1110010100001110001100111001100011110101001011001101101010101101 from address 111101 (from port 0) during cycle 92 (920ns - 930ns)
*	Writing 0110110110100110011010110001111100001100010111101100000001110010  to  address 000000 (from port 0) during cycle 93 (930ns - 940ns)
*	Reading 0110110110100110011010110001111100001100010111101100000001110010 from address 000000 (from port 0) during cycle 94 (940ns - 950ns)
*	Reading 1000010001110100110010101110100000101000111001000101001000100110 from address 111110 (from port 0) during cycle 95 (950ns - 960ns)
*	Reading 1000010001110100110010101110100000101000111001000101001000100110 from address 111110 (from port 1) during cycle 95 (950ns - 960ns)
*	Writing 1100000011010011101001100111001001011100100100010111110110000000  to  address 111110 (from port 0) during cycle 96 (960ns - 970ns)
*	Reading 0110110110100110011010110001111100001100010111101100000001110010 from address 000000 (from port 0) during cycle 98 (980ns - 990ns)
*	Reading 1100000011010011101001100111001001011100100100010111110110000000 from address 111110 (from port 0) during cycle 99 (990ns - 1000ns)
*	Reading 0110110110100110011010110001111100001100010111101100000001110010 from address 000000 (from port 1) during cycle 101 (1010ns - 1020ns)
*	Reading 1100000011010011101001100111001001011100100100010111110110000000 from address 111110 (from port 0) during cycle 102 (1020ns - 1030ns)
*	Reading 1110010100001110001100111001100011110101001011001101101010101101 from address 111101 (from port 1) during cycle 103 (1030ns - 1040ns)
*	Reading 1100000011010011101001100111001001011100100100010111110110000000 from address 111110 (from port 0) during cycle 105 (1050ns - 1060ns)
*	Reading 1110010100001110001100111001100011110101001011001101101010101101 from address 111101 (from port 0) during cycle 107 (1070ns - 1080ns)
*	Reading 0110110110100110011010110001111100001100010111101100000001110010 from address 000000 (from port 1) during cycle 107 (1070ns - 1080ns)
*	Writing 0101001111100011101010010000011000100000011100101001000001101111  to  address 000001 (from port 0) during cycle 108 (1080ns - 1090ns)
*	Reading 0101001111100011101010010000011000100000011100101001000001101111 from address 000001 (from port 0) during cycle 109 (1090ns - 1100ns)
*	Reading 0110110110100110011010110001111100001100010111101100000001110010 from address 000000 (from port 0) during cycle 110 (1100ns - 1110ns)
*	Reading 0101001111100011101010010000011000100000011100101001000001101111 from address 000001 (from port 0) during cycle 111 (1110ns - 1120ns)
*	Reading 1100000011010011101001100111001001011100100100010111110110000000 from address 111110 (from port 1) during cycle 111 (1110ns - 1120ns)
*	Writing 0011101111111011110000011000010001000110010100011111100100010010  to  address 111110 (from port 0) during cycle 113 (1130ns - 1140ns)
*	Reading 1110010100001110001100111001100011110101001011001101101010101101 from address 111101 (from port 0) during cycle 115 (1150ns - 1160ns)
*	Reading 0101001111100011101010010000011000100000011100101001000001101111 from address 000001 (from port 0) during cycle 117 (1170ns - 1180ns)
*	Reading 1110010100001110001100111001100011110101001011001101101010101101 from address 111101 (from port 0) during cycle 118 (1180ns - 1190ns)
*	Reading 0011101111111011110000011000010001000110010100011111100100010010 from address 111110 (from port 0) during cycle 119 (1190ns - 1200ns)
*	Reading 0110110110100110011010110001111100001100010111101100000001110010 from address 000000 (from port 0) during cycle 120 (1200ns - 1210ns)
*	Reading 1110010100001110001100111001100011110101001011001101101010101101 from address 111101 (from port 1) during cycle 120 (1200ns - 1210ns)
*	Reading 1110010100001110001100111001100011110101001011001101101010101101 from address 111101 (from port 0) during cycle 121 (1210ns - 1220ns)
*	Reading 0110110110100110011010110001111100001100010111101100000001110010 from address 000000 (from port 1) during cycle 121 (1210ns - 1220ns)
*	Reading 0110110110100110011010110001111100001100010111101100000001110010 from address 000000 (from port 0) during cycle 122 (1220ns - 1230ns)
*	Reading 0011101111111011110000011000010001000110010100011111100100010010 from address 111110 (from port 1) during cycle 122 (1220ns - 1230ns)
*	Reading 0011101111111011110000011000010001000110010100011111100100010010 from address 111110 (from port 1) during cycle 123 (1230ns - 1240ns)
*	Reading 0110110110100110011010110001111100001100010111101100000001110010 from address 000000 (from port 0) during cycle 124 (1240ns - 1250ns)
*	Reading 1110010100001110001100111001100011110101001011001101101010101101 from address 111101 (from port 1) during cycle 124 (1240ns - 1250ns)
*	Reading 0110110110100110011010110001111100001100010111101100000001110010 from address 000000 (from port 0) during cycle 125 (1250ns - 1260ns)
*	Writing 0110011010010001111100000111101111001111011001011011111001000010  to  address 000000 (from port 0) during cycle 126 (1260ns - 1270ns)
*	Reading 0110011010010001111100000111101111001111011001011011111001000010 from address 000000 (from port 0) during cycle 127 (1270ns - 1280ns)
*	Writing 0001011111101011110000001001101111001010010011010110010101111100  to  address 000001 (from port 0) during cycle 128 (1280ns - 1290ns)
*	Reading 0001011111101011110000001001101111001010010011010110010101111100 from address 000001 (from port 0) during cycle 129 (1290ns - 1300ns)
*	Reading 0011101111111011110000011000010001000110010100011111100100010010 from address 111110 (from port 1) during cycle 130 (1300ns - 1310ns)
*	Reading 0001011111101011110000001001101111001010010011010110010101111100 from address 000001 (from port 1) during cycle 131 (1310ns - 1320ns)
*	Reading 0001011111101011110000001001101111001010010011010110010101111100 from address 000001 (from port 0) during cycle 132 (1320ns - 1330ns)
*	Reading 0011101111111011110000011000010001000110010100011111100100010010 from address 111110 (from port 0) during cycle 133 (1330ns - 1340ns)
*	Reading 0011101111111011110000011000010001000110010100011111100100010010 from address 111110 (from port 1) during cycle 133 (1330ns - 1340ns)
*	Reading 0001011111101011110000001001101111001010010011010110010101111100 from address 000001 (from port 0) during cycle 135 (1350ns - 1360ns)
*	Reading 1110010100001110001100111001100011110101001011001101101010101101 from address 111101 (from port 1) during cycle 135 (1350ns - 1360ns)
*	Reading 0011101111111011110000011000010001000110010100011111100100010010 from address 111110 (from port 0) during cycle 136 (1360ns - 1370ns)
*	Reading 0001011111101011110000001001101111001010010011010110010101111100 from address 000001 (from port 1) during cycle 136 (1360ns - 1370ns)
*	Writing 1000000100110010101111110111110011100110000011110101001001100000  to  address 000000 (from port 0) during cycle 137 (1370ns - 1380ns)
*	Reading 0001011111101011110000001001101111001010010011010110010101111100 from address 000001 (from port 0) during cycle 138 (1380ns - 1390ns)
*	Reading 1000000100110010101111110111110011100110000011110101001001100000 from address 000000 (from port 1) during cycle 138 (1380ns - 1390ns)
*	Reading 0001011111101011110000001001101111001010010011010110010101111100 from address 000001 (from port 0) during cycle 139 (1390ns - 1400ns)
*	Writing 1011101101111001001111000011010110000001011110001010000010100011  to  address 000000 (from port 0) during cycle 140 (1400ns - 1410ns)
*	Reading 1110010100001110001100111001100011110101001011001101101010101101 from address 111101 (from port 0) during cycle 141 (1410ns - 1420ns)
*	Reading 1110010100001110001100111001100011110101001011001101101010101101 from address 111101 (from port 1) during cycle 141 (1410ns - 1420ns)
*	Reading 1110010100001110001100111001100011110101001011001101101010101101 from address 111101 (from port 0) during cycle 142 (1420ns - 1430ns)
*	Reading 0011101111111011110000011000010001000110010100011111100100010010 from address 111110 (from port 1) during cycle 142 (1420ns - 1430ns)
*	Writing 0010101111100110101000010000100001010100101110110010000000011000  to  address 000001 (from port 0) during cycle 143 (1430ns - 1440ns)
*	Reading 1011101101111001001111000011010110000001011110001010000010100011 from address 000000 (from port 0) during cycle 144 (1440ns - 1450ns)
*	Reading 0011101111111011110000011000010001000110010100011111100100010010 from address 111110 (from port 0) during cycle 145 (1450ns - 1460ns)
*	Reading 1110010100001110001100111001100011110101001011001101101010101101 from address 111101 (from port 0) during cycle 146 (1460ns - 1470ns)
*	Reading 0011101111111011110000011000010001000110010100011111100100010010 from address 111110 (from port 1) during cycle 146 (1460ns - 1470ns)
*	Reading 0011101111111011110000011000010001000110010100011111100100010010 from address 111110 (from port 0) during cycle 147 (1470ns - 1480ns)
*	Reading 1110010100001110001100111001100011110101001011001101101010101101 from address 111101 (from port 1) during cycle 147 (1470ns - 1480ns)
*	Writing 0010001100001111001111011001010100101010101000110111010101100010  to  address 000001 (from port 0) during cycle 148 (1480ns - 1490ns)
*	Reading 0011101111111011110000011000010001000110010100011111100100010010 from address 111110 (from port 1) during cycle 148 (1480ns - 1490ns)
*	Writing 0100000011111101101110110011110000111101011110111000111111100011  to  address 111101 (from port 0) during cycle 150 (1500ns - 1510ns)
*	Reading 0010001100001111001111011001010100101010101000110111010101100010 from address 000001 (from port 0) during cycle 151 (1510ns - 1520ns)
*	Reading 0011101111111011110000011000010001000110010100011111100100010010 from address 111110 (from port 1) during cycle 151 (1510ns - 1520ns)
*	Reading 1011101101111001001111000011010110000001011110001010000010100011 from address 000000 (from port 0) during cycle 153 (1530ns - 1540ns)
*	Reading 0010001100001111001111011001010100101010101000110111010101100010 from address 000001 (from port 1) during cycle 154 (1540ns - 1550ns)
*	Reading 0010001100001111001111011001010100101010101000110111010101100010 from address 000001 (from port 0) during cycle 155 (1550ns - 1560ns)
*	Reading 0100000011111101101110110011110000111101011110111000111111100011 from address 111101 (from port 1) during cycle 155 (1550ns - 1560ns)
*	Reading 0100000011111101101110110011110000111101011110111000111111100011 from address 111101 (from port 0) during cycle 156 (1560ns - 1570ns)
*	Writing 1111000000000010000110111011100011111110000001110001110100111110  to  address 111110 (from port 0) during cycle 157 (1570ns - 1580ns)
*	Writing 1001000000100100010000110000011010001010100110010100100100011110  to  address 111101 (from port 0) during cycle 158 (1580ns - 1590ns)
*	Writing 0100000011001001100101010001000011011110011111100000110000001000  to  address 000001 (from port 0) during cycle 159 (1590ns - 1600ns)
*	Reading 1111000000000010000110111011100011111110000001110001110100111110 from address 111110 (from port 1) during cycle 159 (1590ns - 1600ns)
*	Reading 1011101101111001001111000011010110000001011110001010000010100011 from address 000000 (from port 0) during cycle 160 (1600ns - 1610ns)
*	Reading 1111000000000010000110111011100011111110000001110001110100111110 from address 111110 (from port 1) during cycle 160 (1600ns - 1610ns)
*	Reading 1011101101111001001111000011010110000001011110001010000010100011 from address 000000 (from port 1) during cycle 161 (1610ns - 1620ns)
*	Writing 1111110000000110100000010101011001000000100100011110000000101100  to  address 000000 (from port 0) during cycle 162 (1620ns - 1630ns)
*	Reading 1111000000000010000110111011100011111110000001110001110100111110 from address 111110 (from port 1) during cycle 162 (1620ns - 1630ns)
*	Reading 1111110000000110100000010101011001000000100100011110000000101100 from address 000000 (from port 0) during cycle 163 (1630ns - 1640ns)
*	Reading 0100000011001001100101010001000011011110011111100000110000001000 from address 000001 (from port 1) during cycle 163 (1630ns - 1640ns)
*	Reading 1111110000000110100000010101011001000000100100011110000000101100 from address 000000 (from port 0) during cycle 164 (1640ns - 1650ns)
*	Reading 0100000011001001100101010001000011011110011111100000110000001000 from address 000001 (from port 0) during cycle 165 (1650ns - 1660ns)
*	Reading 0100000011001001100101010001000011011110011111100000110000001000 from address 000001 (from port 1) during cycle 166 (1660ns - 1670ns)
*	Reading 1111000000000010000110111011100011111110000001110001110100111110 from address 111110 (from port 0) during cycle 168 (1680ns - 1690ns)
*	Writing 0010011011010011010110000000100000000001011010100101000010111100  to  address 111110 (from port 0) during cycle 169 (1690ns - 1700ns)
*	Reading 1001000000100100010000110000011010001010100110010100100100011110 from address 111101 (from port 0) during cycle 170 (1700ns - 1710ns)
*	Writing 0101111101111011000011010111011010111110000001101010101000001111  to  address 111110 (from port 0) during cycle 171 (1710ns - 1720ns)
*	Reading 0100000011001001100101010001000011011110011111100000110000001000 from address 000001 (from port 0) during cycle 172 (1720ns - 1730ns)
*	Writing 0000011111001010101010101011111000111101000011000111000011111000  to  address 111110 (from port 0) during cycle 173 (1730ns - 1740ns)
*	Reading 1001000000100100010000110000011010001010100110010100100100011110 from address 111101 (from port 1) during cycle 173 (1730ns - 1740ns)
*	Writing 1110101001100011111011101101100101000100011000100110000010010101  to  address 000001 (from port 0) during cycle 174 (1740ns - 1750ns)
*	Reading 0000011111001010101010101011111000111101000011000111000011111000 from address 111110 (from port 1) during cycle 174 (1740ns - 1750ns)
*	Reading 0000011111001010101010101011111000111101000011000111000011111000 from address 111110 (from port 0) during cycle 176 (1760ns - 1770ns)
*	Reading 1001000000100100010000110000011010001010100110010100100100011110 from address 111101 (from port 1) during cycle 177 (1770ns - 1780ns)
*	Reading 0000011111001010101010101011111000111101000011000111000011111000 from address 111110 (from port 0) during cycle 178 (1780ns - 1790ns)
*	Writing 0001100010000010000110110111110100010100010110010011100001011010  to  address 000000 (from port 0) during cycle 179 (1790ns - 1800ns)
*	Reading 1110101001100011111011101101100101000100011000100110000010010101 from address 000001 (from port 0) during cycle 180 (1800ns - 1810ns)
*	Reading 0000011111001010101010101011111000111101000011000111000011111000 from address 111110 (from port 1) during cycle 180 (1800ns - 1810ns)
*	Reading 1110101001100011111011101101100101000100011000100110000010010101 from address 000001 (from port 1) during cycle 181 (1810ns - 1820ns)
*	Reading 1001000000100100010000110000011010001010100110010100100100011110 from address 111101 (from port 0) during cycle 182 (1820ns - 1830ns)
*	Reading 1110101001100011111011101101100101000100011000100110000010010101 from address 000001 (from port 0) during cycle 183 (1830ns - 1840ns)
*	Reading 0001100010000010000110110111110100010100010110010011100001011010 from address 000000 (from port 1) during cycle 184 (1840ns - 1850ns)
*	Writing 1011100011000111010101001100111001111011101001101101100110010010  to  address 111101 (from port 0) during cycle 185 (1850ns - 1860ns)
*	Reading 0000011111001010101010101011111000111101000011000111000011111000 from address 111110 (from port 1) during cycle 185 (1850ns - 1860ns)
*	Writing 0100111111001111111010100110110111110111000010110101010000001001  to  address 111101 (from port 0) during cycle 186 (1860ns - 1870ns)
*	Writing 0111010111000001100101010110100010101111111111111011110010111100  to  address 000000 (from port 0) during cycle 187 (1870ns - 1880ns)
*	Writing 1011110110101110010011010000110100010000010110011000011000010101  to  address 000000 (from port 0) during cycle 188 (1880ns - 1890ns)
*	Reading 0100111111001111111010100110110111110111000010110101010000001001 from address 111101 (from port 1) during cycle 188 (1880ns - 1890ns)
*	Writing 1111110110110111000101100001010110110100101000001001111101011101  to  address 000000 (from port 0) during cycle 189 (1890ns - 1900ns)
*	Reading 0000011111001010101010101011111000111101000011000111000011111000 from address 111110 (from port 1) during cycle 190 (1900ns - 1910ns)
*	Writing 1001101010111111010001100110010000001010101110111001110110100010  to  address 111101 (from port 0) during cycle 191 (1910ns - 1920ns)
*	Reading 1110101001100011111011101101100101000100011000100110000010010101 from address 000001 (from port 0) during cycle 192 (1920ns - 1930ns)
*	Reading 1110101001100011111011101101100101000100011000100110000010010101 from address 000001 (from port 0) during cycle 194 (1940ns - 1950ns)
*	Reading 1001101010111111010001100110010000001010101110111001110110100010 from address 111101 (from port 0) during cycle 195 (1950ns - 1960ns)
*	Reading 1111110110110111000101100001010110110100101000001001111101011101 from address 000000 (from port 0) during cycle 196 (1960ns - 1970ns)
*	Reading 1001101010111111010001100110010000001010101110111001110110100010 from address 111101 (from port 0) during cycle 197 (1970ns - 1980ns)
*	Reading 1110101001100011111011101101100101000100011000100110000010010101 from address 000001 (from port 1) during cycle 197 (1970ns - 1980ns)
*	Reading 1111110110110111000101100001010110110100101000001001111101011101 from address 000000 (from port 1) during cycle 198 (1980ns - 1990ns)
*	Reading 1001101010111111010001100110010000001010101110111001110110100010 from address 111101 (from port 1) during cycle 199 (1990ns - 2000ns)
*	Reading 1110101001100011111011101101100101000100011000100110000010010101 from address 000001 (from port 0) during cycle 201 (2010ns - 2020ns)
*	Reading 0000011111001010101010101011111000111101000011000111000011111000 from address 111110 (from port 0) during cycle 202 (2020ns - 2030ns)
*	Writing 1111010011001100110010000001010101010001010100110110100001111111  to  address 111110 (from port 0) during cycle 203 (2030ns - 2040ns)
*	Reading 1111010011001100110010000001010101010001010100110110100001111111 from address 111110 (from port 0) during cycle 204 (2040ns - 2050ns)
*	Reading 1001101010111111010001100110010000001010101110111001110110100010 from address 111101 (from port 1) during cycle 204 (2040ns - 2050ns)
*	Idle during cycle 205 (2050ns - 2060ns)

* Generation of data and address signals
* (time, data): [(0, 0), (10, 0), (20, 1), (30, 1), (40, 1), (50, 1), (60, 1), (70, 1), (80, 1), (90, 1), (100, 1), (110, 1), (120, 1), (130, 1), (140, 1), (150, 0), (160, 0), (170, 0), (180, 0), (190, 0), (200, 0), (210, 0), (220, 0), (230, 0), (240, 0), (250, 0), (260, 1), (270, 1), (280, 1), (290, 1), (300, 1), (310, 0), (320, 0), (330, 0), (340, 0), (350, 0), (360, 0), (370, 0), (380, 0), (390, 1), (400, 1), (410, 1), (420, 1), (430, 1), (440, 1), (450, 1), (460, 1), (470, 0), (480, 0), (490, 1), (500, 0), (510, 0), (520, 0), (530, 0), (540, 0), (550, 0), (560, 0), (570, 0), (580, 0), (590, 0), (600, 0), (610, 0), (620, 1), (630, 1), (640, 1), (650, 1), (660, 1), (670, 1), (680, 1), (690, 1), (700, 1), (710, 0), (720, 0), (730, 0), (740, 0), (750, 0), (760, 0), (770, 1), (780, 1), (790, 1), (800, 1), (810, 1), (820, 0), (830, 0), (840, 0), (850, 0), (860, 0), (870, 0), (880, 0), (890, 0), (900, 0), (910, 0), (920, 0), (930, 0), (940, 0), (950, 0), (960, 0), (970, 0), (980, 0), (990, 0), (1000, 0), (1010, 0), (1020, 0), (1030, 0), (1040, 0), (1050, 0), (1060, 0), (1070, 0), (1080, 1), (1090, 1), (1100, 1), (1110, 1), (1120, 1), (1130, 0), (1140, 0), (1150, 0), (1160, 0), (1170, 0), (1180, 0), (1190, 0), (1200, 0), (1210, 0), (1220, 0), (1230, 0), (1240, 0), (1250, 0), (1260, 0), (1270, 0), (1280, 0), (1290, 0), (1300, 0), (1310, 0), (1320, 0), (1330, 0), (1340, 0), (1350, 0), (1360, 0), (1370, 0), (1380, 0), (1390, 0), (1400, 1), (1410, 1), (1420, 1), (1430, 0), (1440, 0), (1450, 0), (1460, 0), (1470, 0), (1480, 0), (1490, 0), (1500, 1), (1510, 1), (1520, 1), (1530, 1), (1540, 1), (1550, 1), (1560, 1), (1570, 0), (1580, 0), (1590, 0), (1600, 0), (1610, 0), (1620, 0), (1630, 0), (1640, 0), (1650, 0), (1660, 0), (1670, 0), (1680, 0), (1690, 0), (1700, 0), (1710, 1), (1720, 1), (1730, 0), (1740, 1), (1750, 1), (1760, 1), (1770, 1), (1780, 1), (1790, 0), (1800, 0), (1810, 0), (1820, 0), (1830, 0), (1840, 0), (1850, 0), (1860, 1), (1870, 0), (1880, 1), (1890, 1), (1900, 1), (1910, 0), (1920, 0), (1930, 0), (1940, 0), (1950, 0), (1960, 0), (1970, 0), (1980, 0), (1990, 0), (2000, 0), (2010, 0), (2020, 0), (2030, 1), (2040, 1), (2050, 1)]
Vdin0_0  din0_0  0 PWL (0n 0.0v 9.495n 0.0v 9.505n 0.0v 19.495n 0.0v 19.505n 1.8v 29.495n 1.8v 29.505n 1.8v 39.495n 1.8v 39.505n 1.8v 49.495n 1.8v 49.505n 1.8v 59.495n 1.8v 59.505n 1.8v 69.495n 1.8v 69.505n 1.8v 79.495n 1.8v 79.505n 1.8v 89.495n 1.8v 89.505n 1.8v 99.495n 1.8v 99.505n 1.8v 109.495n 1.8v 109.505n 1.8v 119.495n 1.8v 119.505n 1.8v 129.495n 1.8v 129.505n 1.8v 139.495n 1.8v 139.505n 1.8v 149.495n 1.8v 149.505n 0.0v 159.495n 0.0v 159.505n 0.0v 169.495n 0.0v 169.505n 0.0v 179.495n 0.0v 179.505n 0.0v 189.495n 0.0v 189.505n 0.0v 199.495n 0.0v 199.505n 0.0v 209.495n 0.0v 209.505n 0.0v 219.495n 0.0v 219.505n 0.0v 229.495n 0.0v 229.505n 0.0v 239.495n 0.0v 239.505n 0.0v 249.495n 0.0v 249.505n 0.0v 259.495n 0.0v 259.505n 1.8v 269.495n 1.8v 269.505n 1.8v 279.495n 1.8v 279.505n 1.8v 289.495n 1.8v 289.505n 1.8v 299.495n 1.8v 299.505n 1.8v 309.495n 1.8v 309.505n 0.0v 319.495n 0.0v 319.505n 0.0v 329.495n 0.0v 329.505n 0.0v 339.495n 0.0v 339.505n 0.0v 349.495n 0.0v 349.505n 0.0v 359.495n 0.0v 359.505n 0.0v 369.495n 0.0v 369.505n 0.0v 379.495n 0.0v 379.505n 0.0v 389.495n 0.0v 389.505n 1.8v 399.495n 1.8v 399.505n 1.8v 409.495n 1.8v 409.505n 1.8v 419.495n 1.8v 419.505n 1.8v 429.495n 1.8v 429.505n 1.8v 439.495n 1.8v 439.505n 1.8v 449.495n 1.8v 449.505n 1.8v 459.495n 1.8v 459.505n 1.8v 469.495n 1.8v 469.505n 0.0v 479.495n 0.0v 479.505n 0.0v 489.495n 0.0v 489.505n 1.8v 499.495n 1.8v 499.505n 0.0v 509.495n 0.0v 509.505n 0.0v 519.495n 0.0v 519.505n 0.0v 529.495n 0.0v 529.505n 0.0v 539.495n 0.0v 539.505n 0.0v 549.495n 0.0v 549.505n 0.0v 559.495n 0.0v 559.505n 0.0v 569.495n 0.0v 569.505n 0.0v 579.495n 0.0v 579.505n 0.0v 589.495n 0.0v 589.505n 0.0v 599.495n 0.0v 599.505n 0.0v 609.495n 0.0v 609.505n 0.0v 619.495n 0.0v 619.505n 1.8v 629.495n 1.8v 629.505n 1.8v 639.495n 1.8v 639.505n 1.8v 649.495n 1.8v 649.505n 1.8v 659.495n 1.8v 659.505n 1.8v 669.495n 1.8v 669.505n 1.8v 679.495n 1.8v 679.505n 1.8v 689.495n 1.8v 689.505n 1.8v 699.495n 1.8v 699.505n 1.8v 709.495n 1.8v 709.505n 0.0v 719.495n 0.0v 719.505n 0.0v 729.495n 0.0v 729.505n 0.0v 739.495n 0.0v 739.505n 0.0v 749.495n 0.0v 749.505n 0.0v 759.495n 0.0v 759.505n 0.0v 769.495n 0.0v 769.505n 1.8v 779.495n 1.8v 779.505n 1.8v 789.495n 1.8v 789.505n 1.8v 799.495n 1.8v 799.505n 1.8v 809.495n 1.8v 809.505n 1.8v 819.495n 1.8v 819.505n 0.0v 829.495n 0.0v 829.505n 0.0v 839.495n 0.0v 839.505n 0.0v 849.495n 0.0v 849.505n 0.0v 859.495n 0.0v 859.505n 0.0v 869.495n 0.0v 869.505n 0.0v 879.495n 0.0v 879.505n 0.0v 889.495n 0.0v 889.505n 0.0v 899.495n 0.0v 899.505n 0.0v 909.495n 0.0v 909.505n 0.0v 919.495n 0.0v 919.505n 0.0v 929.495n 0.0v 929.505n 0.0v 939.495n 0.0v 939.505n 0.0v 949.495n 0.0v 949.505n 0.0v 959.495n 0.0v 959.505n 0.0v 969.495n 0.0v 969.505n 0.0v 979.495n 0.0v 979.505n 0.0v 989.495n 0.0v 989.505n 0.0v 999.495n 0.0v 999.505n 0.0v 1009.495n 0.0v 1009.505n 0.0v 1019.495n 0.0v 1019.505n 0.0v 1029.495n 0.0v 1029.505n 0.0v 1039.495n 0.0v 1039.505n 0.0v 1049.495n 0.0v 1049.505n 0.0v 1059.495n 0.0v 1059.505n 0.0v 1069.495n 0.0v 1069.505n 0.0v 1079.495n 0.0v 1079.505n 1.8v 1089.495n 1.8v 1089.505n 1.8v 1099.495n 1.8v 1099.505n 1.8v 1109.495n 1.8v 1109.505n 1.8v 1119.495n 1.8v 1119.505n 1.8v 1129.495n 1.8v 1129.505n 0.0v 1139.495n 0.0v 1139.505n 0.0v 1149.495n 0.0v 1149.505n 0.0v 1159.495n 0.0v 1159.505n 0.0v 1169.495n 0.0v 1169.505n 0.0v 1179.495n 0.0v 1179.505n 0.0v 1189.495n 0.0v 1189.505n 0.0v 1199.495n 0.0v 1199.505n 0.0v 1209.495n 0.0v 1209.505n 0.0v 1219.495n 0.0v 1219.505n 0.0v 1229.495n 0.0v 1229.505n 0.0v 1239.495n 0.0v 1239.505n 0.0v 1249.495n 0.0v 1249.505n 0.0v 1259.495n 0.0v 1259.505n 0.0v 1269.495n 0.0v 1269.505n 0.0v 1279.495n 0.0v 1279.505n 0.0v 1289.495n 0.0v 1289.505n 0.0v 1299.495n 0.0v 1299.505n 0.0v 1309.495n 0.0v 1309.505n 0.0v 1319.495n 0.0v 1319.505n 0.0v 1329.495n 0.0v 1329.505n 0.0v 1339.495n 0.0v 1339.505n 0.0v 1349.495n 0.0v 1349.505n 0.0v 1359.495n 0.0v 1359.505n 0.0v 1369.495n 0.0v 1369.505n 0.0v 1379.495n 0.0v 1379.505n 0.0v 1389.495n 0.0v 1389.505n 0.0v 1399.495n 0.0v 1399.505n 1.8v 1409.495n 1.8v 1409.505n 1.8v 1419.495n 1.8v 1419.505n 1.8v 1429.495n 1.8v 1429.505n 0.0v 1439.495n 0.0v 1439.505n 0.0v 1449.495n 0.0v 1449.505n 0.0v 1459.495n 0.0v 1459.505n 0.0v 1469.495n 0.0v 1469.505n 0.0v 1479.495n 0.0v 1479.505n 0.0v 1489.495n 0.0v 1489.505n 0.0v 1499.495n 0.0v 1499.505n 1.8v 1509.495n 1.8v 1509.505n 1.8v 1519.495n 1.8v 1519.505n 1.8v 1529.495n 1.8v 1529.505n 1.8v 1539.495n 1.8v 1539.505n 1.8v 1549.495n 1.8v 1549.505n 1.8v 1559.495n 1.8v 1559.505n 1.8v 1569.495n 1.8v 1569.505n 0.0v 1579.495n 0.0v 1579.505n 0.0v 1589.495n 0.0v 1589.505n 0.0v 1599.495n 0.0v 1599.505n 0.0v 1609.495n 0.0v 1609.505n 0.0v 1619.495n 0.0v 1619.505n 0.0v 1629.495n 0.0v 1629.505n 0.0v 1639.495n 0.0v 1639.505n 0.0v 1649.495n 0.0v 1649.505n 0.0v 1659.495n 0.0v 1659.505n 0.0v 1669.495n 0.0v 1669.505n 0.0v 1679.495n 0.0v 1679.505n 0.0v 1689.495n 0.0v 1689.505n 0.0v 1699.495n 0.0v 1699.505n 0.0v 1709.495n 0.0v 1709.505n 1.8v 1719.495n 1.8v 1719.505n 1.8v 1729.495n 1.8v 1729.505n 0.0v 1739.495n 0.0v 1739.505n 1.8v 1749.495n 1.8v 1749.505n 1.8v 1759.495n 1.8v 1759.505n 1.8v 1769.495n 1.8v 1769.505n 1.8v 1779.495n 1.8v 1779.505n 1.8v 1789.495n 1.8v 1789.505n 0.0v 1799.495n 0.0v 1799.505n 0.0v 1809.495n 0.0v 1809.505n 0.0v 1819.495n 0.0v 1819.505n 0.0v 1829.495n 0.0v 1829.505n 0.0v 1839.495n 0.0v 1839.505n 0.0v 1849.495n 0.0v 1849.505n 0.0v 1859.495n 0.0v 1859.505n 1.8v 1869.495n 1.8v 1869.505n 0.0v 1879.495n 0.0v 1879.505n 1.8v 1889.495n 1.8v 1889.505n 1.8v 1899.495n 1.8v 1899.505n 1.8v 1909.495n 1.8v 1909.505n 0.0v 1919.495n 0.0v 1919.505n 0.0v 1929.495n 0.0v 1929.505n 0.0v 1939.495n 0.0v 1939.505n 0.0v 1949.495n 0.0v 1949.505n 0.0v 1959.495n 0.0v 1959.505n 0.0v 1969.495n 0.0v 1969.505n 0.0v 1979.495n 0.0v 1979.505n 0.0v 1989.495n 0.0v 1989.505n 0.0v 1999.495n 0.0v 1999.505n 0.0v 2009.495n 0.0v 2009.505n 0.0v 2019.495n 0.0v 2019.505n 0.0v 2029.495n 0.0v 2029.505n 1.8v 2039.495n 1.8v 2039.505n 1.8v 2049.495n 1.8v 2049.505n 1.8v )
* (time, data): [(0, 0), (10, 1), (20, 0), (30, 0), (40, 0), (50, 0), (60, 1), (70, 1), (80, 1), (90, 1), (100, 1), (110, 1), (120, 1), (130, 1), (140, 1), (150, 1), (160, 1), (170, 1), (180, 1), (190, 1), (200, 1), (210, 1), (220, 1), (230, 1), (240, 1), (250, 1), (260, 1), (270, 1), (280, 1), (290, 1), (300, 1), (310, 1), (320, 1), (330, 1), (340, 1), (350, 1), (360, 1), (370, 1), (380, 1), (390, 1), (400, 0), (410, 0), (420, 1), (430, 1), (440, 1), (450, 0), (460, 0), (470, 1), (480, 1), (490, 1), (500, 0), (510, 0), (520, 0), (530, 0), (540, 0), (550, 0), (560, 0), (570, 0), (580, 0), (590, 0), (600, 0), (610, 0), (620, 1), (630, 1), (640, 1), (650, 1), (660, 0), (670, 0), (680, 0), (690, 0), (700, 0), (710, 1), (720, 1), (730, 1), (740, 1), (750, 1), (760, 1), (770, 0), (780, 0), (790, 0), (800, 0), (810, 0), (820, 1), (830, 1), (840, 1), (850, 1), (860, 1), (870, 1), (880, 1), (890, 1), (900, 1), (910, 1), (920, 1), (930, 1), (940, 1), (950, 1), (960, 0), (970, 0), (980, 0), (990, 0), (1000, 0), (1010, 0), (1020, 0), (1030, 0), (1040, 0), (1050, 0), (1060, 0), (1070, 0), (1080, 1), (1090, 1), (1100, 1), (1110, 1), (1120, 1), (1130, 1), (1140, 1), (1150, 1), (1160, 1), (1170, 1), (1180, 1), (1190, 1), (1200, 1), (1210, 1), (1220, 1), (1230, 1), (1240, 1), (1250, 1), (1260, 1), (1270, 1), (1280, 0), (1290, 0), (1300, 0), (1310, 0), (1320, 0), (1330, 0), (1340, 0), (1350, 0), (1360, 0), (1370, 0), (1380, 0), (1390, 0), (1400, 1), (1410, 1), (1420, 1), (1430, 0), (1440, 0), (1450, 0), (1460, 0), (1470, 0), (1480, 1), (1490, 1), (1500, 1), (1510, 1), (1520, 1), (1530, 1), (1540, 1), (1550, 1), (1560, 1), (1570, 1), (1580, 1), (1590, 0), (1600, 0), (1610, 0), (1620, 0), (1630, 0), (1640, 0), (1650, 0), (1660, 0), (1670, 0), (1680, 0), (1690, 0), (1700, 0), (1710, 1), (1720, 1), (1730, 0), (1740, 0), (1750, 0), (1760, 0), (1770, 0), (1780, 0), (1790, 1), (1800, 1), (1810, 1), (1820, 1), (1830, 1), (1840, 1), (1850, 1), (1860, 0), (1870, 0), (1880, 0), (1890, 0), (1900, 0), (1910, 1), (1920, 1), (1930, 1), (1940, 1), (1950, 1), (1960, 1), (1970, 1), (1980, 1), (1990, 1), (2000, 1), (2010, 1), (2020, 1), (2030, 1), (2040, 1), (2050, 1)]
Vdin0_1  din0_1  0 PWL (0n 0.0v 9.495n 0.0v 9.505n 1.8v 19.495n 1.8v 19.505n 0.0v 29.495n 0.0v 29.505n 0.0v 39.495n 0.0v 39.505n 0.0v 49.495n 0.0v 49.505n 0.0v 59.495n 0.0v 59.505n 1.8v 69.495n 1.8v 69.505n 1.8v 79.495n 1.8v 79.505n 1.8v 89.495n 1.8v 89.505n 1.8v 99.495n 1.8v 99.505n 1.8v 109.495n 1.8v 109.505n 1.8v 119.495n 1.8v 119.505n 1.8v 129.495n 1.8v 129.505n 1.8v 139.495n 1.8v 139.505n 1.8v 149.495n 1.8v 149.505n 1.8v 159.495n 1.8v 159.505n 1.8v 169.495n 1.8v 169.505n 1.8v 179.495n 1.8v 179.505n 1.8v 189.495n 1.8v 189.505n 1.8v 199.495n 1.8v 199.505n 1.8v 209.495n 1.8v 209.505n 1.8v 219.495n 1.8v 219.505n 1.8v 229.495n 1.8v 229.505n 1.8v 239.495n 1.8v 239.505n 1.8v 249.495n 1.8v 249.505n 1.8v 259.495n 1.8v 259.505n 1.8v 269.495n 1.8v 269.505n 1.8v 279.495n 1.8v 279.505n 1.8v 289.495n 1.8v 289.505n 1.8v 299.495n 1.8v 299.505n 1.8v 309.495n 1.8v 309.505n 1.8v 319.495n 1.8v 319.505n 1.8v 329.495n 1.8v 329.505n 1.8v 339.495n 1.8v 339.505n 1.8v 349.495n 1.8v 349.505n 1.8v 359.495n 1.8v 359.505n 1.8v 369.495n 1.8v 369.505n 1.8v 379.495n 1.8v 379.505n 1.8v 389.495n 1.8v 389.505n 1.8v 399.495n 1.8v 399.505n 0.0v 409.495n 0.0v 409.505n 0.0v 419.495n 0.0v 419.505n 1.8v 429.495n 1.8v 429.505n 1.8v 439.495n 1.8v 439.505n 1.8v 449.495n 1.8v 449.505n 0.0v 459.495n 0.0v 459.505n 0.0v 469.495n 0.0v 469.505n 1.8v 479.495n 1.8v 479.505n 1.8v 489.495n 1.8v 489.505n 1.8v 499.495n 1.8v 499.505n 0.0v 509.495n 0.0v 509.505n 0.0v 519.495n 0.0v 519.505n 0.0v 529.495n 0.0v 529.505n 0.0v 539.495n 0.0v 539.505n 0.0v 549.495n 0.0v 549.505n 0.0v 559.495n 0.0v 559.505n 0.0v 569.495n 0.0v 569.505n 0.0v 579.495n 0.0v 579.505n 0.0v 589.495n 0.0v 589.505n 0.0v 599.495n 0.0v 599.505n 0.0v 609.495n 0.0v 609.505n 0.0v 619.495n 0.0v 619.505n 1.8v 629.495n 1.8v 629.505n 1.8v 639.495n 1.8v 639.505n 1.8v 649.495n 1.8v 649.505n 1.8v 659.495n 1.8v 659.505n 0.0v 669.495n 0.0v 669.505n 0.0v 679.495n 0.0v 679.505n 0.0v 689.495n 0.0v 689.505n 0.0v 699.495n 0.0v 699.505n 0.0v 709.495n 0.0v 709.505n 1.8v 719.495n 1.8v 719.505n 1.8v 729.495n 1.8v 729.505n 1.8v 739.495n 1.8v 739.505n 1.8v 749.495n 1.8v 749.505n 1.8v 759.495n 1.8v 759.505n 1.8v 769.495n 1.8v 769.505n 0.0v 779.495n 0.0v 779.505n 0.0v 789.495n 0.0v 789.505n 0.0v 799.495n 0.0v 799.505n 0.0v 809.495n 0.0v 809.505n 0.0v 819.495n 0.0v 819.505n 1.8v 829.495n 1.8v 829.505n 1.8v 839.495n 1.8v 839.505n 1.8v 849.495n 1.8v 849.505n 1.8v 859.495n 1.8v 859.505n 1.8v 869.495n 1.8v 869.505n 1.8v 879.495n 1.8v 879.505n 1.8v 889.495n 1.8v 889.505n 1.8v 899.495n 1.8v 899.505n 1.8v 909.495n 1.8v 909.505n 1.8v 919.495n 1.8v 919.505n 1.8v 929.495n 1.8v 929.505n 1.8v 939.495n 1.8v 939.505n 1.8v 949.495n 1.8v 949.505n 1.8v 959.495n 1.8v 959.505n 0.0v 969.495n 0.0v 969.505n 0.0v 979.495n 0.0v 979.505n 0.0v 989.495n 0.0v 989.505n 0.0v 999.495n 0.0v 999.505n 0.0v 1009.495n 0.0v 1009.505n 0.0v 1019.495n 0.0v 1019.505n 0.0v 1029.495n 0.0v 1029.505n 0.0v 1039.495n 0.0v 1039.505n 0.0v 1049.495n 0.0v 1049.505n 0.0v 1059.495n 0.0v 1059.505n 0.0v 1069.495n 0.0v 1069.505n 0.0v 1079.495n 0.0v 1079.505n 1.8v 1089.495n 1.8v 1089.505n 1.8v 1099.495n 1.8v 1099.505n 1.8v 1109.495n 1.8v 1109.505n 1.8v 1119.495n 1.8v 1119.505n 1.8v 1129.495n 1.8v 1129.505n 1.8v 1139.495n 1.8v 1139.505n 1.8v 1149.495n 1.8v 1149.505n 1.8v 1159.495n 1.8v 1159.505n 1.8v 1169.495n 1.8v 1169.505n 1.8v 1179.495n 1.8v 1179.505n 1.8v 1189.495n 1.8v 1189.505n 1.8v 1199.495n 1.8v 1199.505n 1.8v 1209.495n 1.8v 1209.505n 1.8v 1219.495n 1.8v 1219.505n 1.8v 1229.495n 1.8v 1229.505n 1.8v 1239.495n 1.8v 1239.505n 1.8v 1249.495n 1.8v 1249.505n 1.8v 1259.495n 1.8v 1259.505n 1.8v 1269.495n 1.8v 1269.505n 1.8v 1279.495n 1.8v 1279.505n 0.0v 1289.495n 0.0v 1289.505n 0.0v 1299.495n 0.0v 1299.505n 0.0v 1309.495n 0.0v 1309.505n 0.0v 1319.495n 0.0v 1319.505n 0.0v 1329.495n 0.0v 1329.505n 0.0v 1339.495n 0.0v 1339.505n 0.0v 1349.495n 0.0v 1349.505n 0.0v 1359.495n 0.0v 1359.505n 0.0v 1369.495n 0.0v 1369.505n 0.0v 1379.495n 0.0v 1379.505n 0.0v 1389.495n 0.0v 1389.505n 0.0v 1399.495n 0.0v 1399.505n 1.8v 1409.495n 1.8v 1409.505n 1.8v 1419.495n 1.8v 1419.505n 1.8v 1429.495n 1.8v 1429.505n 0.0v 1439.495n 0.0v 1439.505n 0.0v 1449.495n 0.0v 1449.505n 0.0v 1459.495n 0.0v 1459.505n 0.0v 1469.495n 0.0v 1469.505n 0.0v 1479.495n 0.0v 1479.505n 1.8v 1489.495n 1.8v 1489.505n 1.8v 1499.495n 1.8v 1499.505n 1.8v 1509.495n 1.8v 1509.505n 1.8v 1519.495n 1.8v 1519.505n 1.8v 1529.495n 1.8v 1529.505n 1.8v 1539.495n 1.8v 1539.505n 1.8v 1549.495n 1.8v 1549.505n 1.8v 1559.495n 1.8v 1559.505n 1.8v 1569.495n 1.8v 1569.505n 1.8v 1579.495n 1.8v 1579.505n 1.8v 1589.495n 1.8v 1589.505n 0.0v 1599.495n 0.0v 1599.505n 0.0v 1609.495n 0.0v 1609.505n 0.0v 1619.495n 0.0v 1619.505n 0.0v 1629.495n 0.0v 1629.505n 0.0v 1639.495n 0.0v 1639.505n 0.0v 1649.495n 0.0v 1649.505n 0.0v 1659.495n 0.0v 1659.505n 0.0v 1669.495n 0.0v 1669.505n 0.0v 1679.495n 0.0v 1679.505n 0.0v 1689.495n 0.0v 1689.505n 0.0v 1699.495n 0.0v 1699.505n 0.0v 1709.495n 0.0v 1709.505n 1.8v 1719.495n 1.8v 1719.505n 1.8v 1729.495n 1.8v 1729.505n 0.0v 1739.495n 0.0v 1739.505n 0.0v 1749.495n 0.0v 1749.505n 0.0v 1759.495n 0.0v 1759.505n 0.0v 1769.495n 0.0v 1769.505n 0.0v 1779.495n 0.0v 1779.505n 0.0v 1789.495n 0.0v 1789.505n 1.8v 1799.495n 1.8v 1799.505n 1.8v 1809.495n 1.8v 1809.505n 1.8v 1819.495n 1.8v 1819.505n 1.8v 1829.495n 1.8v 1829.505n 1.8v 1839.495n 1.8v 1839.505n 1.8v 1849.495n 1.8v 1849.505n 1.8v 1859.495n 1.8v 1859.505n 0.0v 1869.495n 0.0v 1869.505n 0.0v 1879.495n 0.0v 1879.505n 0.0v 1889.495n 0.0v 1889.505n 0.0v 1899.495n 0.0v 1899.505n 0.0v 1909.495n 0.0v 1909.505n 1.8v 1919.495n 1.8v 1919.505n 1.8v 1929.495n 1.8v 1929.505n 1.8v 1939.495n 1.8v 1939.505n 1.8v 1949.495n 1.8v 1949.505n 1.8v 1959.495n 1.8v 1959.505n 1.8v 1969.495n 1.8v 1969.505n 1.8v 1979.495n 1.8v 1979.505n 1.8v 1989.495n 1.8v 1989.505n 1.8v 1999.495n 1.8v 1999.505n 1.8v 2009.495n 1.8v 2009.505n 1.8v 2019.495n 1.8v 2019.505n 1.8v 2029.495n 1.8v 2029.505n 1.8v 2039.495n 1.8v 2039.505n 1.8v 2049.495n 1.8v 2049.505n 1.8v )
* (time, data): [(0, 0), (10, 1), (20, 1), (30, 1), (40, 1), (50, 1), (60, 1), (70, 1), (80, 1), (90, 1), (100, 1), (110, 1), (120, 1), (130, 1), (140, 1), (150, 0), (160, 0), (170, 0), (180, 0), (190, 0), (200, 0), (210, 0), (220, 0), (230, 0), (240, 0), (250, 0), (260, 0), (270, 0), (280, 0), (290, 0), (300, 0), (310, 1), (320, 1), (330, 1), (340, 1), (350, 1), (360, 1), (370, 1), (380, 1), (390, 0), (400, 0), (410, 0), (420, 1), (430, 1), (440, 1), (450, 0), (460, 0), (470, 0), (480, 0), (490, 1), (500, 1), (510, 1), (520, 1), (530, 1), (540, 1), (550, 1), (560, 1), (570, 1), (580, 1), (590, 1), (600, 1), (610, 1), (620, 0), (630, 0), (640, 0), (650, 0), (660, 1), (670, 1), (680, 1), (690, 1), (700, 1), (710, 1), (720, 1), (730, 1), (740, 1), (750, 1), (760, 1), (770, 1), (780, 1), (790, 1), (800, 1), (810, 1), (820, 0), (830, 0), (840, 1), (850, 1), (860, 1), (870, 1), (880, 1), (890, 0), (900, 0), (910, 0), (920, 0), (930, 0), (940, 0), (950, 0), (960, 0), (970, 0), (980, 0), (990, 0), (1000, 0), (1010, 0), (1020, 0), (1030, 0), (1040, 0), (1050, 0), (1060, 0), (1070, 0), (1080, 1), (1090, 1), (1100, 1), (1110, 1), (1120, 1), (1130, 0), (1140, 0), (1150, 0), (1160, 0), (1170, 0), (1180, 0), (1190, 0), (1200, 0), (1210, 0), (1220, 0), (1230, 0), (1240, 0), (1250, 0), (1260, 0), (1270, 0), (1280, 1), (1290, 1), (1300, 1), (1310, 1), (1320, 1), (1330, 1), (1340, 1), (1350, 1), (1360, 1), (1370, 0), (1380, 0), (1390, 0), (1400, 0), (1410, 0), (1420, 0), (1430, 0), (1440, 0), (1450, 0), (1460, 0), (1470, 0), (1480, 0), (1490, 0), (1500, 0), (1510, 0), (1520, 0), (1530, 0), (1540, 0), (1550, 0), (1560, 0), (1570, 1), (1580, 1), (1590, 0), (1600, 0), (1610, 0), (1620, 1), (1630, 1), (1640, 1), (1650, 1), (1660, 1), (1670, 1), (1680, 1), (1690, 1), (1700, 1), (1710, 1), (1720, 1), (1730, 0), (1740, 1), (1750, 1), (1760, 1), (1770, 1), (1780, 1), (1790, 0), (1800, 0), (1810, 0), (1820, 0), (1830, 0), (1840, 0), (1850, 0), (1860, 0), (1870, 1), (1880, 1), (1890, 1), (1900, 1), (1910, 0), (1920, 0), (1930, 0), (1940, 0), (1950, 0), (1960, 0), (1970, 0), (1980, 0), (1990, 0), (2000, 0), (2010, 0), (2020, 0), (2030, 1), (2040, 1), (2050, 1)]
Vdin0_2  din0_2  0 PWL (0n 0.0v 9.495n 0.0v 9.505n 1.8v 19.495n 1.8v 19.505n 1.8v 29.495n 1.8v 29.505n 1.8v 39.495n 1.8v 39.505n 1.8v 49.495n 1.8v 49.505n 1.8v 59.495n 1.8v 59.505n 1.8v 69.495n 1.8v 69.505n 1.8v 79.495n 1.8v 79.505n 1.8v 89.495n 1.8v 89.505n 1.8v 99.495n 1.8v 99.505n 1.8v 109.495n 1.8v 109.505n 1.8v 119.495n 1.8v 119.505n 1.8v 129.495n 1.8v 129.505n 1.8v 139.495n 1.8v 139.505n 1.8v 149.495n 1.8v 149.505n 0.0v 159.495n 0.0v 159.505n 0.0v 169.495n 0.0v 169.505n 0.0v 179.495n 0.0v 179.505n 0.0v 189.495n 0.0v 189.505n 0.0v 199.495n 0.0v 199.505n 0.0v 209.495n 0.0v 209.505n 0.0v 219.495n 0.0v 219.505n 0.0v 229.495n 0.0v 229.505n 0.0v 239.495n 0.0v 239.505n 0.0v 249.495n 0.0v 249.505n 0.0v 259.495n 0.0v 259.505n 0.0v 269.495n 0.0v 269.505n 0.0v 279.495n 0.0v 279.505n 0.0v 289.495n 0.0v 289.505n 0.0v 299.495n 0.0v 299.505n 0.0v 309.495n 0.0v 309.505n 1.8v 319.495n 1.8v 319.505n 1.8v 329.495n 1.8v 329.505n 1.8v 339.495n 1.8v 339.505n 1.8v 349.495n 1.8v 349.505n 1.8v 359.495n 1.8v 359.505n 1.8v 369.495n 1.8v 369.505n 1.8v 379.495n 1.8v 379.505n 1.8v 389.495n 1.8v 389.505n 0.0v 399.495n 0.0v 399.505n 0.0v 409.495n 0.0v 409.505n 0.0v 419.495n 0.0v 419.505n 1.8v 429.495n 1.8v 429.505n 1.8v 439.495n 1.8v 439.505n 1.8v 449.495n 1.8v 449.505n 0.0v 459.495n 0.0v 459.505n 0.0v 469.495n 0.0v 469.505n 0.0v 479.495n 0.0v 479.505n 0.0v 489.495n 0.0v 489.505n 1.8v 499.495n 1.8v 499.505n 1.8v 509.495n 1.8v 509.505n 1.8v 519.495n 1.8v 519.505n 1.8v 529.495n 1.8v 529.505n 1.8v 539.495n 1.8v 539.505n 1.8v 549.495n 1.8v 549.505n 1.8v 559.495n 1.8v 559.505n 1.8v 569.495n 1.8v 569.505n 1.8v 579.495n 1.8v 579.505n 1.8v 589.495n 1.8v 589.505n 1.8v 599.495n 1.8v 599.505n 1.8v 609.495n 1.8v 609.505n 1.8v 619.495n 1.8v 619.505n 0.0v 629.495n 0.0v 629.505n 0.0v 639.495n 0.0v 639.505n 0.0v 649.495n 0.0v 649.505n 0.0v 659.495n 0.0v 659.505n 1.8v 669.495n 1.8v 669.505n 1.8v 679.495n 1.8v 679.505n 1.8v 689.495n 1.8v 689.505n 1.8v 699.495n 1.8v 699.505n 1.8v 709.495n 1.8v 709.505n 1.8v 719.495n 1.8v 719.505n 1.8v 729.495n 1.8v 729.505n 1.8v 739.495n 1.8v 739.505n 1.8v 749.495n 1.8v 749.505n 1.8v 759.495n 1.8v 759.505n 1.8v 769.495n 1.8v 769.505n 1.8v 779.495n 1.8v 779.505n 1.8v 789.495n 1.8v 789.505n 1.8v 799.495n 1.8v 799.505n 1.8v 809.495n 1.8v 809.505n 1.8v 819.495n 1.8v 819.505n 0.0v 829.495n 0.0v 829.505n 0.0v 839.495n 0.0v 839.505n 1.8v 849.495n 1.8v 849.505n 1.8v 859.495n 1.8v 859.505n 1.8v 869.495n 1.8v 869.505n 1.8v 879.495n 1.8v 879.505n 1.8v 889.495n 1.8v 889.505n 0.0v 899.495n 0.0v 899.505n 0.0v 909.495n 0.0v 909.505n 0.0v 919.495n 0.0v 919.505n 0.0v 929.495n 0.0v 929.505n 0.0v 939.495n 0.0v 939.505n 0.0v 949.495n 0.0v 949.505n 0.0v 959.495n 0.0v 959.505n 0.0v 969.495n 0.0v 969.505n 0.0v 979.495n 0.0v 979.505n 0.0v 989.495n 0.0v 989.505n 0.0v 999.495n 0.0v 999.505n 0.0v 1009.495n 0.0v 1009.505n 0.0v 1019.495n 0.0v 1019.505n 0.0v 1029.495n 0.0v 1029.505n 0.0v 1039.495n 0.0v 1039.505n 0.0v 1049.495n 0.0v 1049.505n 0.0v 1059.495n 0.0v 1059.505n 0.0v 1069.495n 0.0v 1069.505n 0.0v 1079.495n 0.0v 1079.505n 1.8v 1089.495n 1.8v 1089.505n 1.8v 1099.495n 1.8v 1099.505n 1.8v 1109.495n 1.8v 1109.505n 1.8v 1119.495n 1.8v 1119.505n 1.8v 1129.495n 1.8v 1129.505n 0.0v 1139.495n 0.0v 1139.505n 0.0v 1149.495n 0.0v 1149.505n 0.0v 1159.495n 0.0v 1159.505n 0.0v 1169.495n 0.0v 1169.505n 0.0v 1179.495n 0.0v 1179.505n 0.0v 1189.495n 0.0v 1189.505n 0.0v 1199.495n 0.0v 1199.505n 0.0v 1209.495n 0.0v 1209.505n 0.0v 1219.495n 0.0v 1219.505n 0.0v 1229.495n 0.0v 1229.505n 0.0v 1239.495n 0.0v 1239.505n 0.0v 1249.495n 0.0v 1249.505n 0.0v 1259.495n 0.0v 1259.505n 0.0v 1269.495n 0.0v 1269.505n 0.0v 1279.495n 0.0v 1279.505n 1.8v 1289.495n 1.8v 1289.505n 1.8v 1299.495n 1.8v 1299.505n 1.8v 1309.495n 1.8v 1309.505n 1.8v 1319.495n 1.8v 1319.505n 1.8v 1329.495n 1.8v 1329.505n 1.8v 1339.495n 1.8v 1339.505n 1.8v 1349.495n 1.8v 1349.505n 1.8v 1359.495n 1.8v 1359.505n 1.8v 1369.495n 1.8v 1369.505n 0.0v 1379.495n 0.0v 1379.505n 0.0v 1389.495n 0.0v 1389.505n 0.0v 1399.495n 0.0v 1399.505n 0.0v 1409.495n 0.0v 1409.505n 0.0v 1419.495n 0.0v 1419.505n 0.0v 1429.495n 0.0v 1429.505n 0.0v 1439.495n 0.0v 1439.505n 0.0v 1449.495n 0.0v 1449.505n 0.0v 1459.495n 0.0v 1459.505n 0.0v 1469.495n 0.0v 1469.505n 0.0v 1479.495n 0.0v 1479.505n 0.0v 1489.495n 0.0v 1489.505n 0.0v 1499.495n 0.0v 1499.505n 0.0v 1509.495n 0.0v 1509.505n 0.0v 1519.495n 0.0v 1519.505n 0.0v 1529.495n 0.0v 1529.505n 0.0v 1539.495n 0.0v 1539.505n 0.0v 1549.495n 0.0v 1549.505n 0.0v 1559.495n 0.0v 1559.505n 0.0v 1569.495n 0.0v 1569.505n 1.8v 1579.495n 1.8v 1579.505n 1.8v 1589.495n 1.8v 1589.505n 0.0v 1599.495n 0.0v 1599.505n 0.0v 1609.495n 0.0v 1609.505n 0.0v 1619.495n 0.0v 1619.505n 1.8v 1629.495n 1.8v 1629.505n 1.8v 1639.495n 1.8v 1639.505n 1.8v 1649.495n 1.8v 1649.505n 1.8v 1659.495n 1.8v 1659.505n 1.8v 1669.495n 1.8v 1669.505n 1.8v 1679.495n 1.8v 1679.505n 1.8v 1689.495n 1.8v 1689.505n 1.8v 1699.495n 1.8v 1699.505n 1.8v 1709.495n 1.8v 1709.505n 1.8v 1719.495n 1.8v 1719.505n 1.8v 1729.495n 1.8v 1729.505n 0.0v 1739.495n 0.0v 1739.505n 1.8v 1749.495n 1.8v 1749.505n 1.8v 1759.495n 1.8v 1759.505n 1.8v 1769.495n 1.8v 1769.505n 1.8v 1779.495n 1.8v 1779.505n 1.8v 1789.495n 1.8v 1789.505n 0.0v 1799.495n 0.0v 1799.505n 0.0v 1809.495n 0.0v 1809.505n 0.0v 1819.495n 0.0v 1819.505n 0.0v 1829.495n 0.0v 1829.505n 0.0v 1839.495n 0.0v 1839.505n 0.0v 1849.495n 0.0v 1849.505n 0.0v 1859.495n 0.0v 1859.505n 0.0v 1869.495n 0.0v 1869.505n 1.8v 1879.495n 1.8v 1879.505n 1.8v 1889.495n 1.8v 1889.505n 1.8v 1899.495n 1.8v 1899.505n 1.8v 1909.495n 1.8v 1909.505n 0.0v 1919.495n 0.0v 1919.505n 0.0v 1929.495n 0.0v 1929.505n 0.0v 1939.495n 0.0v 1939.505n 0.0v 1949.495n 0.0v 1949.505n 0.0v 1959.495n 0.0v 1959.505n 0.0v 1969.495n 0.0v 1969.505n 0.0v 1979.495n 0.0v 1979.505n 0.0v 1989.495n 0.0v 1989.505n 0.0v 1999.495n 0.0v 1999.505n 0.0v 2009.495n 0.0v 2009.505n 0.0v 2019.495n 0.0v 2019.505n 0.0v 2029.495n 0.0v 2029.505n 1.8v 2039.495n 1.8v 2039.505n 1.8v 2049.495n 1.8v 2049.505n 1.8v )
* (time, data): [(0, 0), (10, 1), (20, 1), (30, 1), (40, 1), (50, 1), (60, 0), (70, 0), (80, 0), (90, 0), (100, 0), (110, 0), (120, 0), (130, 0), (140, 0), (150, 0), (160, 0), (170, 0), (180, 0), (190, 0), (200, 0), (210, 0), (220, 0), (230, 0), (240, 0), (250, 0), (260, 0), (270, 0), (280, 0), (290, 0), (300, 0), (310, 0), (320, 0), (330, 0), (340, 0), (350, 0), (360, 0), (370, 0), (380, 0), (390, 0), (400, 1), (410, 1), (420, 1), (430, 1), (440, 1), (450, 1), (460, 1), (470, 1), (480, 1), (490, 1), (500, 1), (510, 1), (520, 1), (530, 1), (540, 1), (550, 1), (560, 1), (570, 1), (580, 1), (590, 1), (600, 1), (610, 1), (620, 1), (630, 1), (640, 1), (650, 1), (660, 1), (670, 0), (680, 0), (690, 0), (700, 0), (710, 0), (720, 0), (730, 0), (740, 0), (750, 0), (760, 0), (770, 0), (780, 0), (790, 0), (800, 0), (810, 0), (820, 1), (830, 1), (840, 0), (850, 0), (860, 0), (870, 0), (880, 0), (890, 0), (900, 0), (910, 0), (920, 0), (930, 0), (940, 0), (950, 0), (960, 0), (970, 0), (980, 0), (990, 0), (1000, 0), (1010, 0), (1020, 0), (1030, 0), (1040, 0), (1050, 0), (1060, 0), (1070, 0), (1080, 1), (1090, 1), (1100, 1), (1110, 1), (1120, 1), (1130, 0), (1140, 0), (1150, 0), (1160, 0), (1170, 0), (1180, 0), (1190, 0), (1200, 0), (1210, 0), (1220, 0), (1230, 0), (1240, 0), (1250, 0), (1260, 0), (1270, 0), (1280, 1), (1290, 1), (1300, 1), (1310, 1), (1320, 1), (1330, 1), (1340, 1), (1350, 1), (1360, 1), (1370, 0), (1380, 0), (1390, 0), (1400, 0), (1410, 0), (1420, 0), (1430, 1), (1440, 1), (1450, 1), (1460, 1), (1470, 1), (1480, 0), (1490, 0), (1500, 0), (1510, 0), (1520, 0), (1530, 0), (1540, 0), (1550, 0), (1560, 0), (1570, 1), (1580, 1), (1590, 1), (1600, 1), (1610, 1), (1620, 1), (1630, 1), (1640, 1), (1650, 1), (1660, 1), (1670, 1), (1680, 1), (1690, 1), (1700, 1), (1710, 1), (1720, 1), (1730, 1), (1740, 0), (1750, 0), (1760, 0), (1770, 0), (1780, 0), (1790, 1), (1800, 1), (1810, 1), (1820, 1), (1830, 1), (1840, 1), (1850, 0), (1860, 1), (1870, 1), (1880, 0), (1890, 1), (1900, 1), (1910, 0), (1920, 0), (1930, 0), (1940, 0), (1950, 0), (1960, 0), (1970, 0), (1980, 0), (1990, 0), (2000, 0), (2010, 0), (2020, 0), (2030, 1), (2040, 1), (2050, 1)]
Vdin0_3  din0_3  0 PWL (0n 0.0v 9.495n 0.0v 9.505n 1.8v 19.495n 1.8v 19.505n 1.8v 29.495n 1.8v 29.505n 1.8v 39.495n 1.8v 39.505n 1.8v 49.495n 1.8v 49.505n 1.8v 59.495n 1.8v 59.505n 0.0v 69.495n 0.0v 69.505n 0.0v 79.495n 0.0v 79.505n 0.0v 89.495n 0.0v 89.505n 0.0v 99.495n 0.0v 99.505n 0.0v 109.495n 0.0v 109.505n 0.0v 119.495n 0.0v 119.505n 0.0v 129.495n 0.0v 129.505n 0.0v 139.495n 0.0v 139.505n 0.0v 149.495n 0.0v 149.505n 0.0v 159.495n 0.0v 159.505n 0.0v 169.495n 0.0v 169.505n 0.0v 179.495n 0.0v 179.505n 0.0v 189.495n 0.0v 189.505n 0.0v 199.495n 0.0v 199.505n 0.0v 209.495n 0.0v 209.505n 0.0v 219.495n 0.0v 219.505n 0.0v 229.495n 0.0v 229.505n 0.0v 239.495n 0.0v 239.505n 0.0v 249.495n 0.0v 249.505n 0.0v 259.495n 0.0v 259.505n 0.0v 269.495n 0.0v 269.505n 0.0v 279.495n 0.0v 279.505n 0.0v 289.495n 0.0v 289.505n 0.0v 299.495n 0.0v 299.505n 0.0v 309.495n 0.0v 309.505n 0.0v 319.495n 0.0v 319.505n 0.0v 329.495n 0.0v 329.505n 0.0v 339.495n 0.0v 339.505n 0.0v 349.495n 0.0v 349.505n 0.0v 359.495n 0.0v 359.505n 0.0v 369.495n 0.0v 369.505n 0.0v 379.495n 0.0v 379.505n 0.0v 389.495n 0.0v 389.505n 0.0v 399.495n 0.0v 399.505n 1.8v 409.495n 1.8v 409.505n 1.8v 419.495n 1.8v 419.505n 1.8v 429.495n 1.8v 429.505n 1.8v 439.495n 1.8v 439.505n 1.8v 449.495n 1.8v 449.505n 1.8v 459.495n 1.8v 459.505n 1.8v 469.495n 1.8v 469.505n 1.8v 479.495n 1.8v 479.505n 1.8v 489.495n 1.8v 489.505n 1.8v 499.495n 1.8v 499.505n 1.8v 509.495n 1.8v 509.505n 1.8v 519.495n 1.8v 519.505n 1.8v 529.495n 1.8v 529.505n 1.8v 539.495n 1.8v 539.505n 1.8v 549.495n 1.8v 549.505n 1.8v 559.495n 1.8v 559.505n 1.8v 569.495n 1.8v 569.505n 1.8v 579.495n 1.8v 579.505n 1.8v 589.495n 1.8v 589.505n 1.8v 599.495n 1.8v 599.505n 1.8v 609.495n 1.8v 609.505n 1.8v 619.495n 1.8v 619.505n 1.8v 629.495n 1.8v 629.505n 1.8v 639.495n 1.8v 639.505n 1.8v 649.495n 1.8v 649.505n 1.8v 659.495n 1.8v 659.505n 1.8v 669.495n 1.8v 669.505n 0.0v 679.495n 0.0v 679.505n 0.0v 689.495n 0.0v 689.505n 0.0v 699.495n 0.0v 699.505n 0.0v 709.495n 0.0v 709.505n 0.0v 719.495n 0.0v 719.505n 0.0v 729.495n 0.0v 729.505n 0.0v 739.495n 0.0v 739.505n 0.0v 749.495n 0.0v 749.505n 0.0v 759.495n 0.0v 759.505n 0.0v 769.495n 0.0v 769.505n 0.0v 779.495n 0.0v 779.505n 0.0v 789.495n 0.0v 789.505n 0.0v 799.495n 0.0v 799.505n 0.0v 809.495n 0.0v 809.505n 0.0v 819.495n 0.0v 819.505n 1.8v 829.495n 1.8v 829.505n 1.8v 839.495n 1.8v 839.505n 0.0v 849.495n 0.0v 849.505n 0.0v 859.495n 0.0v 859.505n 0.0v 869.495n 0.0v 869.505n 0.0v 879.495n 0.0v 879.505n 0.0v 889.495n 0.0v 889.505n 0.0v 899.495n 0.0v 899.505n 0.0v 909.495n 0.0v 909.505n 0.0v 919.495n 0.0v 919.505n 0.0v 929.495n 0.0v 929.505n 0.0v 939.495n 0.0v 939.505n 0.0v 949.495n 0.0v 949.505n 0.0v 959.495n 0.0v 959.505n 0.0v 969.495n 0.0v 969.505n 0.0v 979.495n 0.0v 979.505n 0.0v 989.495n 0.0v 989.505n 0.0v 999.495n 0.0v 999.505n 0.0v 1009.495n 0.0v 1009.505n 0.0v 1019.495n 0.0v 1019.505n 0.0v 1029.495n 0.0v 1029.505n 0.0v 1039.495n 0.0v 1039.505n 0.0v 1049.495n 0.0v 1049.505n 0.0v 1059.495n 0.0v 1059.505n 0.0v 1069.495n 0.0v 1069.505n 0.0v 1079.495n 0.0v 1079.505n 1.8v 1089.495n 1.8v 1089.505n 1.8v 1099.495n 1.8v 1099.505n 1.8v 1109.495n 1.8v 1109.505n 1.8v 1119.495n 1.8v 1119.505n 1.8v 1129.495n 1.8v 1129.505n 0.0v 1139.495n 0.0v 1139.505n 0.0v 1149.495n 0.0v 1149.505n 0.0v 1159.495n 0.0v 1159.505n 0.0v 1169.495n 0.0v 1169.505n 0.0v 1179.495n 0.0v 1179.505n 0.0v 1189.495n 0.0v 1189.505n 0.0v 1199.495n 0.0v 1199.505n 0.0v 1209.495n 0.0v 1209.505n 0.0v 1219.495n 0.0v 1219.505n 0.0v 1229.495n 0.0v 1229.505n 0.0v 1239.495n 0.0v 1239.505n 0.0v 1249.495n 0.0v 1249.505n 0.0v 1259.495n 0.0v 1259.505n 0.0v 1269.495n 0.0v 1269.505n 0.0v 1279.495n 0.0v 1279.505n 1.8v 1289.495n 1.8v 1289.505n 1.8v 1299.495n 1.8v 1299.505n 1.8v 1309.495n 1.8v 1309.505n 1.8v 1319.495n 1.8v 1319.505n 1.8v 1329.495n 1.8v 1329.505n 1.8v 1339.495n 1.8v 1339.505n 1.8v 1349.495n 1.8v 1349.505n 1.8v 1359.495n 1.8v 1359.505n 1.8v 1369.495n 1.8v 1369.505n 0.0v 1379.495n 0.0v 1379.505n 0.0v 1389.495n 0.0v 1389.505n 0.0v 1399.495n 0.0v 1399.505n 0.0v 1409.495n 0.0v 1409.505n 0.0v 1419.495n 0.0v 1419.505n 0.0v 1429.495n 0.0v 1429.505n 1.8v 1439.495n 1.8v 1439.505n 1.8v 1449.495n 1.8v 1449.505n 1.8v 1459.495n 1.8v 1459.505n 1.8v 1469.495n 1.8v 1469.505n 1.8v 1479.495n 1.8v 1479.505n 0.0v 1489.495n 0.0v 1489.505n 0.0v 1499.495n 0.0v 1499.505n 0.0v 1509.495n 0.0v 1509.505n 0.0v 1519.495n 0.0v 1519.505n 0.0v 1529.495n 0.0v 1529.505n 0.0v 1539.495n 0.0v 1539.505n 0.0v 1549.495n 0.0v 1549.505n 0.0v 1559.495n 0.0v 1559.505n 0.0v 1569.495n 0.0v 1569.505n 1.8v 1579.495n 1.8v 1579.505n 1.8v 1589.495n 1.8v 1589.505n 1.8v 1599.495n 1.8v 1599.505n 1.8v 1609.495n 1.8v 1609.505n 1.8v 1619.495n 1.8v 1619.505n 1.8v 1629.495n 1.8v 1629.505n 1.8v 1639.495n 1.8v 1639.505n 1.8v 1649.495n 1.8v 1649.505n 1.8v 1659.495n 1.8v 1659.505n 1.8v 1669.495n 1.8v 1669.505n 1.8v 1679.495n 1.8v 1679.505n 1.8v 1689.495n 1.8v 1689.505n 1.8v 1699.495n 1.8v 1699.505n 1.8v 1709.495n 1.8v 1709.505n 1.8v 1719.495n 1.8v 1719.505n 1.8v 1729.495n 1.8v 1729.505n 1.8v 1739.495n 1.8v 1739.505n 0.0v 1749.495n 0.0v 1749.505n 0.0v 1759.495n 0.0v 1759.505n 0.0v 1769.495n 0.0v 1769.505n 0.0v 1779.495n 0.0v 1779.505n 0.0v 1789.495n 0.0v 1789.505n 1.8v 1799.495n 1.8v 1799.505n 1.8v 1809.495n 1.8v 1809.505n 1.8v 1819.495n 1.8v 1819.505n 1.8v 1829.495n 1.8v 1829.505n 1.8v 1839.495n 1.8v 1839.505n 1.8v 1849.495n 1.8v 1849.505n 0.0v 1859.495n 0.0v 1859.505n 1.8v 1869.495n 1.8v 1869.505n 1.8v 1879.495n 1.8v 1879.505n 0.0v 1889.495n 0.0v 1889.505n 1.8v 1899.495n 1.8v 1899.505n 1.8v 1909.495n 1.8v 1909.505n 0.0v 1919.495n 0.0v 1919.505n 0.0v 1929.495n 0.0v 1929.505n 0.0v 1939.495n 0.0v 1939.505n 0.0v 1949.495n 0.0v 1949.505n 0.0v 1959.495n 0.0v 1959.505n 0.0v 1969.495n 0.0v 1969.505n 0.0v 1979.495n 0.0v 1979.505n 0.0v 1989.495n 0.0v 1989.505n 0.0v 1999.495n 0.0v 1999.505n 0.0v 2009.495n 0.0v 2009.505n 0.0v 2019.495n 0.0v 2019.505n 0.0v 2029.495n 0.0v 2029.505n 1.8v 2039.495n 1.8v 2039.505n 1.8v 2049.495n 1.8v 2049.505n 1.8v )
* (time, data): [(0, 0), (10, 1), (20, 0), (30, 1), (40, 1), (50, 1), (60, 1), (70, 1), (80, 1), (90, 1), (100, 1), (110, 1), (120, 1), (130, 1), (140, 1), (150, 0), (160, 0), (170, 0), (180, 0), (190, 0), (200, 0), (210, 0), (220, 0), (230, 0), (240, 0), (250, 0), (260, 1), (270, 1), (280, 1), (290, 1), (300, 1), (310, 1), (320, 1), (330, 1), (340, 1), (350, 1), (360, 1), (370, 1), (380, 1), (390, 1), (400, 0), (410, 0), (420, 0), (430, 0), (440, 0), (450, 1), (460, 1), (470, 1), (480, 1), (490, 0), (500, 0), (510, 0), (520, 0), (530, 0), (540, 0), (550, 0), (560, 0), (570, 0), (580, 0), (590, 0), (600, 0), (610, 0), (620, 1), (630, 1), (640, 1), (650, 1), (660, 0), (670, 1), (680, 1), (690, 1), (700, 1), (710, 1), (720, 1), (730, 1), (740, 1), (750, 1), (760, 1), (770, 0), (780, 0), (790, 0), (800, 0), (810, 0), (820, 0), (830, 0), (840, 0), (850, 0), (860, 0), (870, 0), (880, 0), (890, 0), (900, 0), (910, 0), (920, 0), (930, 1), (940, 1), (950, 1), (960, 0), (970, 0), (980, 0), (990, 0), (1000, 0), (1010, 0), (1020, 0), (1030, 0), (1040, 0), (1050, 0), (1060, 0), (1070, 0), (1080, 0), (1090, 0), (1100, 0), (1110, 0), (1120, 0), (1130, 1), (1140, 1), (1150, 1), (1160, 1), (1170, 1), (1180, 1), (1190, 1), (1200, 1), (1210, 1), (1220, 1), (1230, 1), (1240, 1), (1250, 1), (1260, 0), (1270, 0), (1280, 1), (1290, 1), (1300, 1), (1310, 1), (1320, 1), (1330, 1), (1340, 1), (1350, 1), (1360, 1), (1370, 0), (1380, 0), (1390, 0), (1400, 0), (1410, 0), (1420, 0), (1430, 1), (1440, 1), (1450, 1), (1460, 1), (1470, 1), (1480, 0), (1490, 0), (1500, 0), (1510, 0), (1520, 0), (1530, 0), (1540, 0), (1550, 0), (1560, 0), (1570, 1), (1580, 1), (1590, 0), (1600, 0), (1610, 0), (1620, 0), (1630, 0), (1640, 0), (1650, 0), (1660, 0), (1670, 0), (1680, 0), (1690, 1), (1700, 1), (1710, 0), (1720, 0), (1730, 1), (1740, 1), (1750, 1), (1760, 1), (1770, 1), (1780, 1), (1790, 1), (1800, 1), (1810, 1), (1820, 1), (1830, 1), (1840, 1), (1850, 1), (1860, 0), (1870, 1), (1880, 1), (1890, 1), (1900, 1), (1910, 0), (1920, 0), (1930, 0), (1940, 0), (1950, 0), (1960, 0), (1970, 0), (1980, 0), (1990, 0), (2000, 0), (2010, 0), (2020, 0), (2030, 1), (2040, 1), (2050, 1)]
Vdin0_4  din0_4  0 PWL (0n 0.0v 9.495n 0.0v 9.505n 1.8v 19.495n 1.8v 19.505n 0.0v 29.495n 0.0v 29.505n 1.8v 39.495n 1.8v 39.505n 1.8v 49.495n 1.8v 49.505n 1.8v 59.495n 1.8v 59.505n 1.8v 69.495n 1.8v 69.505n 1.8v 79.495n 1.8v 79.505n 1.8v 89.495n 1.8v 89.505n 1.8v 99.495n 1.8v 99.505n 1.8v 109.495n 1.8v 109.505n 1.8v 119.495n 1.8v 119.505n 1.8v 129.495n 1.8v 129.505n 1.8v 139.495n 1.8v 139.505n 1.8v 149.495n 1.8v 149.505n 0.0v 159.495n 0.0v 159.505n 0.0v 169.495n 0.0v 169.505n 0.0v 179.495n 0.0v 179.505n 0.0v 189.495n 0.0v 189.505n 0.0v 199.495n 0.0v 199.505n 0.0v 209.495n 0.0v 209.505n 0.0v 219.495n 0.0v 219.505n 0.0v 229.495n 0.0v 229.505n 0.0v 239.495n 0.0v 239.505n 0.0v 249.495n 0.0v 249.505n 0.0v 259.495n 0.0v 259.505n 1.8v 269.495n 1.8v 269.505n 1.8v 279.495n 1.8v 279.505n 1.8v 289.495n 1.8v 289.505n 1.8v 299.495n 1.8v 299.505n 1.8v 309.495n 1.8v 309.505n 1.8v 319.495n 1.8v 319.505n 1.8v 329.495n 1.8v 329.505n 1.8v 339.495n 1.8v 339.505n 1.8v 349.495n 1.8v 349.505n 1.8v 359.495n 1.8v 359.505n 1.8v 369.495n 1.8v 369.505n 1.8v 379.495n 1.8v 379.505n 1.8v 389.495n 1.8v 389.505n 1.8v 399.495n 1.8v 399.505n 0.0v 409.495n 0.0v 409.505n 0.0v 419.495n 0.0v 419.505n 0.0v 429.495n 0.0v 429.505n 0.0v 439.495n 0.0v 439.505n 0.0v 449.495n 0.0v 449.505n 1.8v 459.495n 1.8v 459.505n 1.8v 469.495n 1.8v 469.505n 1.8v 479.495n 1.8v 479.505n 1.8v 489.495n 1.8v 489.505n 0.0v 499.495n 0.0v 499.505n 0.0v 509.495n 0.0v 509.505n 0.0v 519.495n 0.0v 519.505n 0.0v 529.495n 0.0v 529.505n 0.0v 539.495n 0.0v 539.505n 0.0v 549.495n 0.0v 549.505n 0.0v 559.495n 0.0v 559.505n 0.0v 569.495n 0.0v 569.505n 0.0v 579.495n 0.0v 579.505n 0.0v 589.495n 0.0v 589.505n 0.0v 599.495n 0.0v 599.505n 0.0v 609.495n 0.0v 609.505n 0.0v 619.495n 0.0v 619.505n 1.8v 629.495n 1.8v 629.505n 1.8v 639.495n 1.8v 639.505n 1.8v 649.495n 1.8v 649.505n 1.8v 659.495n 1.8v 659.505n 0.0v 669.495n 0.0v 669.505n 1.8v 679.495n 1.8v 679.505n 1.8v 689.495n 1.8v 689.505n 1.8v 699.495n 1.8v 699.505n 1.8v 709.495n 1.8v 709.505n 1.8v 719.495n 1.8v 719.505n 1.8v 729.495n 1.8v 729.505n 1.8v 739.495n 1.8v 739.505n 1.8v 749.495n 1.8v 749.505n 1.8v 759.495n 1.8v 759.505n 1.8v 769.495n 1.8v 769.505n 0.0v 779.495n 0.0v 779.505n 0.0v 789.495n 0.0v 789.505n 0.0v 799.495n 0.0v 799.505n 0.0v 809.495n 0.0v 809.505n 0.0v 819.495n 0.0v 819.505n 0.0v 829.495n 0.0v 829.505n 0.0v 839.495n 0.0v 839.505n 0.0v 849.495n 0.0v 849.505n 0.0v 859.495n 0.0v 859.505n 0.0v 869.495n 0.0v 869.505n 0.0v 879.495n 0.0v 879.505n 0.0v 889.495n 0.0v 889.505n 0.0v 899.495n 0.0v 899.505n 0.0v 909.495n 0.0v 909.505n 0.0v 919.495n 0.0v 919.505n 0.0v 929.495n 0.0v 929.505n 1.8v 939.495n 1.8v 939.505n 1.8v 949.495n 1.8v 949.505n 1.8v 959.495n 1.8v 959.505n 0.0v 969.495n 0.0v 969.505n 0.0v 979.495n 0.0v 979.505n 0.0v 989.495n 0.0v 989.505n 0.0v 999.495n 0.0v 999.505n 0.0v 1009.495n 0.0v 1009.505n 0.0v 1019.495n 0.0v 1019.505n 0.0v 1029.495n 0.0v 1029.505n 0.0v 1039.495n 0.0v 1039.505n 0.0v 1049.495n 0.0v 1049.505n 0.0v 1059.495n 0.0v 1059.505n 0.0v 1069.495n 0.0v 1069.505n 0.0v 1079.495n 0.0v 1079.505n 0.0v 1089.495n 0.0v 1089.505n 0.0v 1099.495n 0.0v 1099.505n 0.0v 1109.495n 0.0v 1109.505n 0.0v 1119.495n 0.0v 1119.505n 0.0v 1129.495n 0.0v 1129.505n 1.8v 1139.495n 1.8v 1139.505n 1.8v 1149.495n 1.8v 1149.505n 1.8v 1159.495n 1.8v 1159.505n 1.8v 1169.495n 1.8v 1169.505n 1.8v 1179.495n 1.8v 1179.505n 1.8v 1189.495n 1.8v 1189.505n 1.8v 1199.495n 1.8v 1199.505n 1.8v 1209.495n 1.8v 1209.505n 1.8v 1219.495n 1.8v 1219.505n 1.8v 1229.495n 1.8v 1229.505n 1.8v 1239.495n 1.8v 1239.505n 1.8v 1249.495n 1.8v 1249.505n 1.8v 1259.495n 1.8v 1259.505n 0.0v 1269.495n 0.0v 1269.505n 0.0v 1279.495n 0.0v 1279.505n 1.8v 1289.495n 1.8v 1289.505n 1.8v 1299.495n 1.8v 1299.505n 1.8v 1309.495n 1.8v 1309.505n 1.8v 1319.495n 1.8v 1319.505n 1.8v 1329.495n 1.8v 1329.505n 1.8v 1339.495n 1.8v 1339.505n 1.8v 1349.495n 1.8v 1349.505n 1.8v 1359.495n 1.8v 1359.505n 1.8v 1369.495n 1.8v 1369.505n 0.0v 1379.495n 0.0v 1379.505n 0.0v 1389.495n 0.0v 1389.505n 0.0v 1399.495n 0.0v 1399.505n 0.0v 1409.495n 0.0v 1409.505n 0.0v 1419.495n 0.0v 1419.505n 0.0v 1429.495n 0.0v 1429.505n 1.8v 1439.495n 1.8v 1439.505n 1.8v 1449.495n 1.8v 1449.505n 1.8v 1459.495n 1.8v 1459.505n 1.8v 1469.495n 1.8v 1469.505n 1.8v 1479.495n 1.8v 1479.505n 0.0v 1489.495n 0.0v 1489.505n 0.0v 1499.495n 0.0v 1499.505n 0.0v 1509.495n 0.0v 1509.505n 0.0v 1519.495n 0.0v 1519.505n 0.0v 1529.495n 0.0v 1529.505n 0.0v 1539.495n 0.0v 1539.505n 0.0v 1549.495n 0.0v 1549.505n 0.0v 1559.495n 0.0v 1559.505n 0.0v 1569.495n 0.0v 1569.505n 1.8v 1579.495n 1.8v 1579.505n 1.8v 1589.495n 1.8v 1589.505n 0.0v 1599.495n 0.0v 1599.505n 0.0v 1609.495n 0.0v 1609.505n 0.0v 1619.495n 0.0v 1619.505n 0.0v 1629.495n 0.0v 1629.505n 0.0v 1639.495n 0.0v 1639.505n 0.0v 1649.495n 0.0v 1649.505n 0.0v 1659.495n 0.0v 1659.505n 0.0v 1669.495n 0.0v 1669.505n 0.0v 1679.495n 0.0v 1679.505n 0.0v 1689.495n 0.0v 1689.505n 1.8v 1699.495n 1.8v 1699.505n 1.8v 1709.495n 1.8v 1709.505n 0.0v 1719.495n 0.0v 1719.505n 0.0v 1729.495n 0.0v 1729.505n 1.8v 1739.495n 1.8v 1739.505n 1.8v 1749.495n 1.8v 1749.505n 1.8v 1759.495n 1.8v 1759.505n 1.8v 1769.495n 1.8v 1769.505n 1.8v 1779.495n 1.8v 1779.505n 1.8v 1789.495n 1.8v 1789.505n 1.8v 1799.495n 1.8v 1799.505n 1.8v 1809.495n 1.8v 1809.505n 1.8v 1819.495n 1.8v 1819.505n 1.8v 1829.495n 1.8v 1829.505n 1.8v 1839.495n 1.8v 1839.505n 1.8v 1849.495n 1.8v 1849.505n 1.8v 1859.495n 1.8v 1859.505n 0.0v 1869.495n 0.0v 1869.505n 1.8v 1879.495n 1.8v 1879.505n 1.8v 1889.495n 1.8v 1889.505n 1.8v 1899.495n 1.8v 1899.505n 1.8v 1909.495n 1.8v 1909.505n 0.0v 1919.495n 0.0v 1919.505n 0.0v 1929.495n 0.0v 1929.505n 0.0v 1939.495n 0.0v 1939.505n 0.0v 1949.495n 0.0v 1949.505n 0.0v 1959.495n 0.0v 1959.505n 0.0v 1969.495n 0.0v 1969.505n 0.0v 1979.495n 0.0v 1979.505n 0.0v 1989.495n 0.0v 1989.505n 0.0v 1999.495n 0.0v 1999.505n 0.0v 2009.495n 0.0v 2009.505n 0.0v 2019.495n 0.0v 2019.505n 0.0v 2029.495n 0.0v 2029.505n 1.8v 2039.495n 1.8v 2039.505n 1.8v 2049.495n 1.8v 2049.505n 1.8v )
* (time, data): [(0, 0), (10, 1), (20, 1), (30, 1), (40, 1), (50, 1), (60, 0), (70, 0), (80, 0), (90, 0), (100, 0), (110, 0), (120, 0), (130, 0), (140, 0), (150, 1), (160, 1), (170, 1), (180, 1), (190, 1), (200, 1), (210, 1), (220, 1), (230, 1), (240, 1), (250, 1), (260, 0), (270, 0), (280, 0), (290, 0), (300, 0), (310, 0), (320, 0), (330, 0), (340, 0), (350, 0), (360, 0), (370, 0), (380, 0), (390, 0), (400, 1), (410, 1), (420, 0), (430, 0), (440, 0), (450, 1), (460, 1), (470, 0), (480, 0), (490, 1), (500, 0), (510, 0), (520, 0), (530, 0), (540, 0), (550, 0), (560, 0), (570, 0), (580, 0), (590, 0), (600, 0), (610, 0), (620, 0), (630, 0), (640, 0), (650, 0), (660, 1), (670, 1), (680, 1), (690, 1), (700, 1), (710, 0), (720, 0), (730, 0), (740, 0), (750, 0), (760, 0), (770, 1), (780, 1), (790, 1), (800, 1), (810, 1), (820, 0), (830, 0), (840, 1), (850, 1), (860, 1), (870, 1), (880, 1), (890, 1), (900, 1), (910, 1), (920, 1), (930, 1), (940, 1), (950, 1), (960, 0), (970, 0), (980, 0), (990, 0), (1000, 0), (1010, 0), (1020, 0), (1030, 0), (1040, 0), (1050, 0), (1060, 0), (1070, 0), (1080, 1), (1090, 1), (1100, 1), (1110, 1), (1120, 1), (1130, 0), (1140, 0), (1150, 0), (1160, 0), (1170, 0), (1180, 0), (1190, 0), (1200, 0), (1210, 0), (1220, 0), (1230, 0), (1240, 0), (1250, 0), (1260, 0), (1270, 0), (1280, 1), (1290, 1), (1300, 1), (1310, 1), (1320, 1), (1330, 1), (1340, 1), (1350, 1), (1360, 1), (1370, 1), (1380, 1), (1390, 1), (1400, 1), (1410, 1), (1420, 1), (1430, 0), (1440, 0), (1450, 0), (1460, 0), (1470, 0), (1480, 1), (1490, 1), (1500, 1), (1510, 1), (1520, 1), (1530, 1), (1540, 1), (1550, 1), (1560, 1), (1570, 1), (1580, 0), (1590, 0), (1600, 0), (1610, 0), (1620, 1), (1630, 1), (1640, 1), (1650, 1), (1660, 1), (1670, 1), (1680, 1), (1690, 1), (1700, 1), (1710, 0), (1720, 0), (1730, 1), (1740, 0), (1750, 0), (1760, 0), (1770, 0), (1780, 0), (1790, 0), (1800, 0), (1810, 0), (1820, 0), (1830, 0), (1840, 0), (1850, 0), (1860, 0), (1870, 1), (1880, 0), (1890, 0), (1900, 0), (1910, 1), (1920, 1), (1930, 1), (1940, 1), (1950, 1), (1960, 1), (1970, 1), (1980, 1), (1990, 1), (2000, 1), (2010, 1), (2020, 1), (2030, 1), (2040, 1), (2050, 1)]
Vdin0_5  din0_5  0 PWL (0n 0.0v 9.495n 0.0v 9.505n 1.8v 19.495n 1.8v 19.505n 1.8v 29.495n 1.8v 29.505n 1.8v 39.495n 1.8v 39.505n 1.8v 49.495n 1.8v 49.505n 1.8v 59.495n 1.8v 59.505n 0.0v 69.495n 0.0v 69.505n 0.0v 79.495n 0.0v 79.505n 0.0v 89.495n 0.0v 89.505n 0.0v 99.495n 0.0v 99.505n 0.0v 109.495n 0.0v 109.505n 0.0v 119.495n 0.0v 119.505n 0.0v 129.495n 0.0v 129.505n 0.0v 139.495n 0.0v 139.505n 0.0v 149.495n 0.0v 149.505n 1.8v 159.495n 1.8v 159.505n 1.8v 169.495n 1.8v 169.505n 1.8v 179.495n 1.8v 179.505n 1.8v 189.495n 1.8v 189.505n 1.8v 199.495n 1.8v 199.505n 1.8v 209.495n 1.8v 209.505n 1.8v 219.495n 1.8v 219.505n 1.8v 229.495n 1.8v 229.505n 1.8v 239.495n 1.8v 239.505n 1.8v 249.495n 1.8v 249.505n 1.8v 259.495n 1.8v 259.505n 0.0v 269.495n 0.0v 269.505n 0.0v 279.495n 0.0v 279.505n 0.0v 289.495n 0.0v 289.505n 0.0v 299.495n 0.0v 299.505n 0.0v 309.495n 0.0v 309.505n 0.0v 319.495n 0.0v 319.505n 0.0v 329.495n 0.0v 329.505n 0.0v 339.495n 0.0v 339.505n 0.0v 349.495n 0.0v 349.505n 0.0v 359.495n 0.0v 359.505n 0.0v 369.495n 0.0v 369.505n 0.0v 379.495n 0.0v 379.505n 0.0v 389.495n 0.0v 389.505n 0.0v 399.495n 0.0v 399.505n 1.8v 409.495n 1.8v 409.505n 1.8v 419.495n 1.8v 419.505n 0.0v 429.495n 0.0v 429.505n 0.0v 439.495n 0.0v 439.505n 0.0v 449.495n 0.0v 449.505n 1.8v 459.495n 1.8v 459.505n 1.8v 469.495n 1.8v 469.505n 0.0v 479.495n 0.0v 479.505n 0.0v 489.495n 0.0v 489.505n 1.8v 499.495n 1.8v 499.505n 0.0v 509.495n 0.0v 509.505n 0.0v 519.495n 0.0v 519.505n 0.0v 529.495n 0.0v 529.505n 0.0v 539.495n 0.0v 539.505n 0.0v 549.495n 0.0v 549.505n 0.0v 559.495n 0.0v 559.505n 0.0v 569.495n 0.0v 569.505n 0.0v 579.495n 0.0v 579.505n 0.0v 589.495n 0.0v 589.505n 0.0v 599.495n 0.0v 599.505n 0.0v 609.495n 0.0v 609.505n 0.0v 619.495n 0.0v 619.505n 0.0v 629.495n 0.0v 629.505n 0.0v 639.495n 0.0v 639.505n 0.0v 649.495n 0.0v 649.505n 0.0v 659.495n 0.0v 659.505n 1.8v 669.495n 1.8v 669.505n 1.8v 679.495n 1.8v 679.505n 1.8v 689.495n 1.8v 689.505n 1.8v 699.495n 1.8v 699.505n 1.8v 709.495n 1.8v 709.505n 0.0v 719.495n 0.0v 719.505n 0.0v 729.495n 0.0v 729.505n 0.0v 739.495n 0.0v 739.505n 0.0v 749.495n 0.0v 749.505n 0.0v 759.495n 0.0v 759.505n 0.0v 769.495n 0.0v 769.505n 1.8v 779.495n 1.8v 779.505n 1.8v 789.495n 1.8v 789.505n 1.8v 799.495n 1.8v 799.505n 1.8v 809.495n 1.8v 809.505n 1.8v 819.495n 1.8v 819.505n 0.0v 829.495n 0.0v 829.505n 0.0v 839.495n 0.0v 839.505n 1.8v 849.495n 1.8v 849.505n 1.8v 859.495n 1.8v 859.505n 1.8v 869.495n 1.8v 869.505n 1.8v 879.495n 1.8v 879.505n 1.8v 889.495n 1.8v 889.505n 1.8v 899.495n 1.8v 899.505n 1.8v 909.495n 1.8v 909.505n 1.8v 919.495n 1.8v 919.505n 1.8v 929.495n 1.8v 929.505n 1.8v 939.495n 1.8v 939.505n 1.8v 949.495n 1.8v 949.505n 1.8v 959.495n 1.8v 959.505n 0.0v 969.495n 0.0v 969.505n 0.0v 979.495n 0.0v 979.505n 0.0v 989.495n 0.0v 989.505n 0.0v 999.495n 0.0v 999.505n 0.0v 1009.495n 0.0v 1009.505n 0.0v 1019.495n 0.0v 1019.505n 0.0v 1029.495n 0.0v 1029.505n 0.0v 1039.495n 0.0v 1039.505n 0.0v 1049.495n 0.0v 1049.505n 0.0v 1059.495n 0.0v 1059.505n 0.0v 1069.495n 0.0v 1069.505n 0.0v 1079.495n 0.0v 1079.505n 1.8v 1089.495n 1.8v 1089.505n 1.8v 1099.495n 1.8v 1099.505n 1.8v 1109.495n 1.8v 1109.505n 1.8v 1119.495n 1.8v 1119.505n 1.8v 1129.495n 1.8v 1129.505n 0.0v 1139.495n 0.0v 1139.505n 0.0v 1149.495n 0.0v 1149.505n 0.0v 1159.495n 0.0v 1159.505n 0.0v 1169.495n 0.0v 1169.505n 0.0v 1179.495n 0.0v 1179.505n 0.0v 1189.495n 0.0v 1189.505n 0.0v 1199.495n 0.0v 1199.505n 0.0v 1209.495n 0.0v 1209.505n 0.0v 1219.495n 0.0v 1219.505n 0.0v 1229.495n 0.0v 1229.505n 0.0v 1239.495n 0.0v 1239.505n 0.0v 1249.495n 0.0v 1249.505n 0.0v 1259.495n 0.0v 1259.505n 0.0v 1269.495n 0.0v 1269.505n 0.0v 1279.495n 0.0v 1279.505n 1.8v 1289.495n 1.8v 1289.505n 1.8v 1299.495n 1.8v 1299.505n 1.8v 1309.495n 1.8v 1309.505n 1.8v 1319.495n 1.8v 1319.505n 1.8v 1329.495n 1.8v 1329.505n 1.8v 1339.495n 1.8v 1339.505n 1.8v 1349.495n 1.8v 1349.505n 1.8v 1359.495n 1.8v 1359.505n 1.8v 1369.495n 1.8v 1369.505n 1.8v 1379.495n 1.8v 1379.505n 1.8v 1389.495n 1.8v 1389.505n 1.8v 1399.495n 1.8v 1399.505n 1.8v 1409.495n 1.8v 1409.505n 1.8v 1419.495n 1.8v 1419.505n 1.8v 1429.495n 1.8v 1429.505n 0.0v 1439.495n 0.0v 1439.505n 0.0v 1449.495n 0.0v 1449.505n 0.0v 1459.495n 0.0v 1459.505n 0.0v 1469.495n 0.0v 1469.505n 0.0v 1479.495n 0.0v 1479.505n 1.8v 1489.495n 1.8v 1489.505n 1.8v 1499.495n 1.8v 1499.505n 1.8v 1509.495n 1.8v 1509.505n 1.8v 1519.495n 1.8v 1519.505n 1.8v 1529.495n 1.8v 1529.505n 1.8v 1539.495n 1.8v 1539.505n 1.8v 1549.495n 1.8v 1549.505n 1.8v 1559.495n 1.8v 1559.505n 1.8v 1569.495n 1.8v 1569.505n 1.8v 1579.495n 1.8v 1579.505n 0.0v 1589.495n 0.0v 1589.505n 0.0v 1599.495n 0.0v 1599.505n 0.0v 1609.495n 0.0v 1609.505n 0.0v 1619.495n 0.0v 1619.505n 1.8v 1629.495n 1.8v 1629.505n 1.8v 1639.495n 1.8v 1639.505n 1.8v 1649.495n 1.8v 1649.505n 1.8v 1659.495n 1.8v 1659.505n 1.8v 1669.495n 1.8v 1669.505n 1.8v 1679.495n 1.8v 1679.505n 1.8v 1689.495n 1.8v 1689.505n 1.8v 1699.495n 1.8v 1699.505n 1.8v 1709.495n 1.8v 1709.505n 0.0v 1719.495n 0.0v 1719.505n 0.0v 1729.495n 0.0v 1729.505n 1.8v 1739.495n 1.8v 1739.505n 0.0v 1749.495n 0.0v 1749.505n 0.0v 1759.495n 0.0v 1759.505n 0.0v 1769.495n 0.0v 1769.505n 0.0v 1779.495n 0.0v 1779.505n 0.0v 1789.495n 0.0v 1789.505n 0.0v 1799.495n 0.0v 1799.505n 0.0v 1809.495n 0.0v 1809.505n 0.0v 1819.495n 0.0v 1819.505n 0.0v 1829.495n 0.0v 1829.505n 0.0v 1839.495n 0.0v 1839.505n 0.0v 1849.495n 0.0v 1849.505n 0.0v 1859.495n 0.0v 1859.505n 0.0v 1869.495n 0.0v 1869.505n 1.8v 1879.495n 1.8v 1879.505n 0.0v 1889.495n 0.0v 1889.505n 0.0v 1899.495n 0.0v 1899.505n 0.0v 1909.495n 0.0v 1909.505n 1.8v 1919.495n 1.8v 1919.505n 1.8v 1929.495n 1.8v 1929.505n 1.8v 1939.495n 1.8v 1939.505n 1.8v 1949.495n 1.8v 1949.505n 1.8v 1959.495n 1.8v 1959.505n 1.8v 1969.495n 1.8v 1969.505n 1.8v 1979.495n 1.8v 1979.505n 1.8v 1989.495n 1.8v 1989.505n 1.8v 1999.495n 1.8v 1999.505n 1.8v 2009.495n 1.8v 2009.505n 1.8v 2019.495n 1.8v 2019.505n 1.8v 2029.495n 1.8v 2029.505n 1.8v 2039.495n 1.8v 2039.505n 1.8v 2049.495n 1.8v 2049.505n 1.8v )
* (time, data): [(0, 0), (10, 1), (20, 0), (30, 0), (40, 0), (50, 0), (60, 0), (70, 0), (80, 0), (90, 0), (100, 0), (110, 0), (120, 0), (130, 0), (140, 0), (150, 1), (160, 1), (170, 1), (180, 1), (190, 1), (200, 1), (210, 1), (220, 1), (230, 1), (240, 1), (250, 1), (260, 0), (270, 0), (280, 0), (290, 0), (300, 0), (310, 1), (320, 1), (330, 1), (340, 1), (350, 0), (360, 0), (370, 0), (380, 0), (390, 0), (400, 0), (410, 0), (420, 1), (430, 1), (440, 1), (450, 1), (460, 1), (470, 0), (480, 0), (490, 0), (500, 0), (510, 0), (520, 0), (530, 0), (540, 0), (550, 0), (560, 0), (570, 0), (580, 0), (590, 0), (600, 0), (610, 0), (620, 0), (630, 0), (640, 0), (650, 0), (660, 0), (670, 0), (680, 0), (690, 0), (700, 0), (710, 0), (720, 0), (730, 0), (740, 0), (750, 0), (760, 0), (770, 1), (780, 1), (790, 1), (800, 1), (810, 1), (820, 0), (830, 0), (840, 0), (850, 0), (860, 0), (870, 0), (880, 0), (890, 1), (900, 1), (910, 1), (920, 1), (930, 1), (940, 1), (950, 1), (960, 0), (970, 0), (980, 0), (990, 0), (1000, 0), (1010, 0), (1020, 0), (1030, 0), (1040, 0), (1050, 0), (1060, 0), (1070, 0), (1080, 1), (1090, 1), (1100, 1), (1110, 1), (1120, 1), (1130, 0), (1140, 0), (1150, 0), (1160, 0), (1170, 0), (1180, 0), (1190, 0), (1200, 0), (1210, 0), (1220, 0), (1230, 0), (1240, 0), (1250, 0), (1260, 1), (1270, 1), (1280, 1), (1290, 1), (1300, 1), (1310, 1), (1320, 1), (1330, 1), (1340, 1), (1350, 1), (1360, 1), (1370, 1), (1380, 1), (1390, 1), (1400, 0), (1410, 0), (1420, 0), (1430, 0), (1440, 0), (1450, 0), (1460, 0), (1470, 0), (1480, 1), (1490, 1), (1500, 1), (1510, 1), (1520, 1), (1530, 1), (1540, 1), (1550, 1), (1560, 1), (1570, 0), (1580, 0), (1590, 0), (1600, 0), (1610, 0), (1620, 0), (1630, 0), (1640, 0), (1650, 0), (1660, 0), (1670, 0), (1680, 0), (1690, 0), (1700, 0), (1710, 0), (1720, 0), (1730, 1), (1740, 0), (1750, 0), (1760, 0), (1770, 0), (1780, 0), (1790, 1), (1800, 1), (1810, 1), (1820, 1), (1830, 1), (1840, 1), (1850, 0), (1860, 0), (1870, 0), (1880, 0), (1890, 1), (1900, 1), (1910, 0), (1920, 0), (1930, 0), (1940, 0), (1950, 0), (1960, 0), (1970, 0), (1980, 0), (1990, 0), (2000, 0), (2010, 0), (2020, 0), (2030, 1), (2040, 1), (2050, 1)]
Vdin0_6  din0_6  0 PWL (0n 0.0v 9.495n 0.0v 9.505n 1.8v 19.495n 1.8v 19.505n 0.0v 29.495n 0.0v 29.505n 0.0v 39.495n 0.0v 39.505n 0.0v 49.495n 0.0v 49.505n 0.0v 59.495n 0.0v 59.505n 0.0v 69.495n 0.0v 69.505n 0.0v 79.495n 0.0v 79.505n 0.0v 89.495n 0.0v 89.505n 0.0v 99.495n 0.0v 99.505n 0.0v 109.495n 0.0v 109.505n 0.0v 119.495n 0.0v 119.505n 0.0v 129.495n 0.0v 129.505n 0.0v 139.495n 0.0v 139.505n 0.0v 149.495n 0.0v 149.505n 1.8v 159.495n 1.8v 159.505n 1.8v 169.495n 1.8v 169.505n 1.8v 179.495n 1.8v 179.505n 1.8v 189.495n 1.8v 189.505n 1.8v 199.495n 1.8v 199.505n 1.8v 209.495n 1.8v 209.505n 1.8v 219.495n 1.8v 219.505n 1.8v 229.495n 1.8v 229.505n 1.8v 239.495n 1.8v 239.505n 1.8v 249.495n 1.8v 249.505n 1.8v 259.495n 1.8v 259.505n 0.0v 269.495n 0.0v 269.505n 0.0v 279.495n 0.0v 279.505n 0.0v 289.495n 0.0v 289.505n 0.0v 299.495n 0.0v 299.505n 0.0v 309.495n 0.0v 309.505n 1.8v 319.495n 1.8v 319.505n 1.8v 329.495n 1.8v 329.505n 1.8v 339.495n 1.8v 339.505n 1.8v 349.495n 1.8v 349.505n 0.0v 359.495n 0.0v 359.505n 0.0v 369.495n 0.0v 369.505n 0.0v 379.495n 0.0v 379.505n 0.0v 389.495n 0.0v 389.505n 0.0v 399.495n 0.0v 399.505n 0.0v 409.495n 0.0v 409.505n 0.0v 419.495n 0.0v 419.505n 1.8v 429.495n 1.8v 429.505n 1.8v 439.495n 1.8v 439.505n 1.8v 449.495n 1.8v 449.505n 1.8v 459.495n 1.8v 459.505n 1.8v 469.495n 1.8v 469.505n 0.0v 479.495n 0.0v 479.505n 0.0v 489.495n 0.0v 489.505n 0.0v 499.495n 0.0v 499.505n 0.0v 509.495n 0.0v 509.505n 0.0v 519.495n 0.0v 519.505n 0.0v 529.495n 0.0v 529.505n 0.0v 539.495n 0.0v 539.505n 0.0v 549.495n 0.0v 549.505n 0.0v 559.495n 0.0v 559.505n 0.0v 569.495n 0.0v 569.505n 0.0v 579.495n 0.0v 579.505n 0.0v 589.495n 0.0v 589.505n 0.0v 599.495n 0.0v 599.505n 0.0v 609.495n 0.0v 609.505n 0.0v 619.495n 0.0v 619.505n 0.0v 629.495n 0.0v 629.505n 0.0v 639.495n 0.0v 639.505n 0.0v 649.495n 0.0v 649.505n 0.0v 659.495n 0.0v 659.505n 0.0v 669.495n 0.0v 669.505n 0.0v 679.495n 0.0v 679.505n 0.0v 689.495n 0.0v 689.505n 0.0v 699.495n 0.0v 699.505n 0.0v 709.495n 0.0v 709.505n 0.0v 719.495n 0.0v 719.505n 0.0v 729.495n 0.0v 729.505n 0.0v 739.495n 0.0v 739.505n 0.0v 749.495n 0.0v 749.505n 0.0v 759.495n 0.0v 759.505n 0.0v 769.495n 0.0v 769.505n 1.8v 779.495n 1.8v 779.505n 1.8v 789.495n 1.8v 789.505n 1.8v 799.495n 1.8v 799.505n 1.8v 809.495n 1.8v 809.505n 1.8v 819.495n 1.8v 819.505n 0.0v 829.495n 0.0v 829.505n 0.0v 839.495n 0.0v 839.505n 0.0v 849.495n 0.0v 849.505n 0.0v 859.495n 0.0v 859.505n 0.0v 869.495n 0.0v 869.505n 0.0v 879.495n 0.0v 879.505n 0.0v 889.495n 0.0v 889.505n 1.8v 899.495n 1.8v 899.505n 1.8v 909.495n 1.8v 909.505n 1.8v 919.495n 1.8v 919.505n 1.8v 929.495n 1.8v 929.505n 1.8v 939.495n 1.8v 939.505n 1.8v 949.495n 1.8v 949.505n 1.8v 959.495n 1.8v 959.505n 0.0v 969.495n 0.0v 969.505n 0.0v 979.495n 0.0v 979.505n 0.0v 989.495n 0.0v 989.505n 0.0v 999.495n 0.0v 999.505n 0.0v 1009.495n 0.0v 1009.505n 0.0v 1019.495n 0.0v 1019.505n 0.0v 1029.495n 0.0v 1029.505n 0.0v 1039.495n 0.0v 1039.505n 0.0v 1049.495n 0.0v 1049.505n 0.0v 1059.495n 0.0v 1059.505n 0.0v 1069.495n 0.0v 1069.505n 0.0v 1079.495n 0.0v 1079.505n 1.8v 1089.495n 1.8v 1089.505n 1.8v 1099.495n 1.8v 1099.505n 1.8v 1109.495n 1.8v 1109.505n 1.8v 1119.495n 1.8v 1119.505n 1.8v 1129.495n 1.8v 1129.505n 0.0v 1139.495n 0.0v 1139.505n 0.0v 1149.495n 0.0v 1149.505n 0.0v 1159.495n 0.0v 1159.505n 0.0v 1169.495n 0.0v 1169.505n 0.0v 1179.495n 0.0v 1179.505n 0.0v 1189.495n 0.0v 1189.505n 0.0v 1199.495n 0.0v 1199.505n 0.0v 1209.495n 0.0v 1209.505n 0.0v 1219.495n 0.0v 1219.505n 0.0v 1229.495n 0.0v 1229.505n 0.0v 1239.495n 0.0v 1239.505n 0.0v 1249.495n 0.0v 1249.505n 0.0v 1259.495n 0.0v 1259.505n 1.8v 1269.495n 1.8v 1269.505n 1.8v 1279.495n 1.8v 1279.505n 1.8v 1289.495n 1.8v 1289.505n 1.8v 1299.495n 1.8v 1299.505n 1.8v 1309.495n 1.8v 1309.505n 1.8v 1319.495n 1.8v 1319.505n 1.8v 1329.495n 1.8v 1329.505n 1.8v 1339.495n 1.8v 1339.505n 1.8v 1349.495n 1.8v 1349.505n 1.8v 1359.495n 1.8v 1359.505n 1.8v 1369.495n 1.8v 1369.505n 1.8v 1379.495n 1.8v 1379.505n 1.8v 1389.495n 1.8v 1389.505n 1.8v 1399.495n 1.8v 1399.505n 0.0v 1409.495n 0.0v 1409.505n 0.0v 1419.495n 0.0v 1419.505n 0.0v 1429.495n 0.0v 1429.505n 0.0v 1439.495n 0.0v 1439.505n 0.0v 1449.495n 0.0v 1449.505n 0.0v 1459.495n 0.0v 1459.505n 0.0v 1469.495n 0.0v 1469.505n 0.0v 1479.495n 0.0v 1479.505n 1.8v 1489.495n 1.8v 1489.505n 1.8v 1499.495n 1.8v 1499.505n 1.8v 1509.495n 1.8v 1509.505n 1.8v 1519.495n 1.8v 1519.505n 1.8v 1529.495n 1.8v 1529.505n 1.8v 1539.495n 1.8v 1539.505n 1.8v 1549.495n 1.8v 1549.505n 1.8v 1559.495n 1.8v 1559.505n 1.8v 1569.495n 1.8v 1569.505n 0.0v 1579.495n 0.0v 1579.505n 0.0v 1589.495n 0.0v 1589.505n 0.0v 1599.495n 0.0v 1599.505n 0.0v 1609.495n 0.0v 1609.505n 0.0v 1619.495n 0.0v 1619.505n 0.0v 1629.495n 0.0v 1629.505n 0.0v 1639.495n 0.0v 1639.505n 0.0v 1649.495n 0.0v 1649.505n 0.0v 1659.495n 0.0v 1659.505n 0.0v 1669.495n 0.0v 1669.505n 0.0v 1679.495n 0.0v 1679.505n 0.0v 1689.495n 0.0v 1689.505n 0.0v 1699.495n 0.0v 1699.505n 0.0v 1709.495n 0.0v 1709.505n 0.0v 1719.495n 0.0v 1719.505n 0.0v 1729.495n 0.0v 1729.505n 1.8v 1739.495n 1.8v 1739.505n 0.0v 1749.495n 0.0v 1749.505n 0.0v 1759.495n 0.0v 1759.505n 0.0v 1769.495n 0.0v 1769.505n 0.0v 1779.495n 0.0v 1779.505n 0.0v 1789.495n 0.0v 1789.505n 1.8v 1799.495n 1.8v 1799.505n 1.8v 1809.495n 1.8v 1809.505n 1.8v 1819.495n 1.8v 1819.505n 1.8v 1829.495n 1.8v 1829.505n 1.8v 1839.495n 1.8v 1839.505n 1.8v 1849.495n 1.8v 1849.505n 0.0v 1859.495n 0.0v 1859.505n 0.0v 1869.495n 0.0v 1869.505n 0.0v 1879.495n 0.0v 1879.505n 0.0v 1889.495n 0.0v 1889.505n 1.8v 1899.495n 1.8v 1899.505n 1.8v 1909.495n 1.8v 1909.505n 0.0v 1919.495n 0.0v 1919.505n 0.0v 1929.495n 0.0v 1929.505n 0.0v 1939.495n 0.0v 1939.505n 0.0v 1949.495n 0.0v 1949.505n 0.0v 1959.495n 0.0v 1959.505n 0.0v 1969.495n 0.0v 1969.505n 0.0v 1979.495n 0.0v 1979.505n 0.0v 1989.495n 0.0v 1989.505n 0.0v 1999.495n 0.0v 1999.505n 0.0v 2009.495n 0.0v 2009.505n 0.0v 2019.495n 0.0v 2019.505n 0.0v 2029.495n 0.0v 2029.505n 1.8v 2039.495n 1.8v 2039.505n 1.8v 2049.495n 1.8v 2049.505n 1.8v )
* (time, data): [(0, 0), (10, 0), (20, 0), (30, 1), (40, 1), (50, 1), (60, 1), (70, 1), (80, 1), (90, 1), (100, 1), (110, 1), (120, 1), (130, 1), (140, 1), (150, 0), (160, 0), (170, 0), (180, 0), (190, 0), (200, 0), (210, 0), (220, 0), (230, 0), (240, 0), (250, 0), (260, 1), (270, 1), (280, 1), (290, 1), (300, 1), (310, 1), (320, 1), (330, 1), (340, 1), (350, 0), (360, 0), (370, 0), (380, 0), (390, 1), (400, 0), (410, 0), (420, 0), (430, 0), (440, 0), (450, 1), (460, 1), (470, 1), (480, 1), (490, 1), (500, 1), (510, 1), (520, 1), (530, 1), (540, 1), (550, 1), (560, 1), (570, 1), (580, 1), (590, 1), (600, 1), (610, 1), (620, 0), (630, 0), (640, 0), (650, 0), (660, 1), (670, 1), (680, 1), (690, 1), (700, 1), (710, 1), (720, 1), (730, 1), (740, 1), (750, 1), (760, 1), (770, 0), (780, 0), (790, 0), (800, 0), (810, 0), (820, 0), (830, 0), (840, 0), (850, 0), (860, 0), (870, 0), (880, 0), (890, 0), (900, 0), (910, 0), (920, 0), (930, 0), (940, 0), (950, 0), (960, 1), (970, 1), (980, 1), (990, 1), (1000, 1), (1010, 1), (1020, 1), (1030, 1), (1040, 1), (1050, 1), (1060, 1), (1070, 1), (1080, 0), (1090, 0), (1100, 0), (1110, 0), (1120, 0), (1130, 0), (1140, 0), (1150, 0), (1160, 0), (1170, 0), (1180, 0), (1190, 0), (1200, 0), (1210, 0), (1220, 0), (1230, 0), (1240, 0), (1250, 0), (1260, 0), (1270, 0), (1280, 0), (1290, 0), (1300, 0), (1310, 0), (1320, 0), (1330, 0), (1340, 0), (1350, 0), (1360, 0), (1370, 0), (1380, 0), (1390, 0), (1400, 1), (1410, 1), (1420, 1), (1430, 0), (1440, 0), (1450, 0), (1460, 0), (1470, 0), (1480, 0), (1490, 0), (1500, 1), (1510, 1), (1520, 1), (1530, 1), (1540, 1), (1550, 1), (1560, 1), (1570, 0), (1580, 0), (1590, 0), (1600, 0), (1610, 0), (1620, 0), (1630, 0), (1640, 0), (1650, 0), (1660, 0), (1670, 0), (1680, 0), (1690, 1), (1700, 1), (1710, 0), (1720, 0), (1730, 1), (1740, 1), (1750, 1), (1760, 1), (1770, 1), (1780, 1), (1790, 0), (1800, 0), (1810, 0), (1820, 0), (1830, 0), (1840, 0), (1850, 1), (1860, 0), (1870, 1), (1880, 0), (1890, 0), (1900, 0), (1910, 1), (1920, 1), (1930, 1), (1940, 1), (1950, 1), (1960, 1), (1970, 1), (1980, 1), (1990, 1), (2000, 1), (2010, 1), (2020, 1), (2030, 0), (2040, 0), (2050, 0)]
Vdin0_7  din0_7  0 PWL (0n 0.0v 9.495n 0.0v 9.505n 0.0v 19.495n 0.0v 19.505n 0.0v 29.495n 0.0v 29.505n 1.8v 39.495n 1.8v 39.505n 1.8v 49.495n 1.8v 49.505n 1.8v 59.495n 1.8v 59.505n 1.8v 69.495n 1.8v 69.505n 1.8v 79.495n 1.8v 79.505n 1.8v 89.495n 1.8v 89.505n 1.8v 99.495n 1.8v 99.505n 1.8v 109.495n 1.8v 109.505n 1.8v 119.495n 1.8v 119.505n 1.8v 129.495n 1.8v 129.505n 1.8v 139.495n 1.8v 139.505n 1.8v 149.495n 1.8v 149.505n 0.0v 159.495n 0.0v 159.505n 0.0v 169.495n 0.0v 169.505n 0.0v 179.495n 0.0v 179.505n 0.0v 189.495n 0.0v 189.505n 0.0v 199.495n 0.0v 199.505n 0.0v 209.495n 0.0v 209.505n 0.0v 219.495n 0.0v 219.505n 0.0v 229.495n 0.0v 229.505n 0.0v 239.495n 0.0v 239.505n 0.0v 249.495n 0.0v 249.505n 0.0v 259.495n 0.0v 259.505n 1.8v 269.495n 1.8v 269.505n 1.8v 279.495n 1.8v 279.505n 1.8v 289.495n 1.8v 289.505n 1.8v 299.495n 1.8v 299.505n 1.8v 309.495n 1.8v 309.505n 1.8v 319.495n 1.8v 319.505n 1.8v 329.495n 1.8v 329.505n 1.8v 339.495n 1.8v 339.505n 1.8v 349.495n 1.8v 349.505n 0.0v 359.495n 0.0v 359.505n 0.0v 369.495n 0.0v 369.505n 0.0v 379.495n 0.0v 379.505n 0.0v 389.495n 0.0v 389.505n 1.8v 399.495n 1.8v 399.505n 0.0v 409.495n 0.0v 409.505n 0.0v 419.495n 0.0v 419.505n 0.0v 429.495n 0.0v 429.505n 0.0v 439.495n 0.0v 439.505n 0.0v 449.495n 0.0v 449.505n 1.8v 459.495n 1.8v 459.505n 1.8v 469.495n 1.8v 469.505n 1.8v 479.495n 1.8v 479.505n 1.8v 489.495n 1.8v 489.505n 1.8v 499.495n 1.8v 499.505n 1.8v 509.495n 1.8v 509.505n 1.8v 519.495n 1.8v 519.505n 1.8v 529.495n 1.8v 529.505n 1.8v 539.495n 1.8v 539.505n 1.8v 549.495n 1.8v 549.505n 1.8v 559.495n 1.8v 559.505n 1.8v 569.495n 1.8v 569.505n 1.8v 579.495n 1.8v 579.505n 1.8v 589.495n 1.8v 589.505n 1.8v 599.495n 1.8v 599.505n 1.8v 609.495n 1.8v 609.505n 1.8v 619.495n 1.8v 619.505n 0.0v 629.495n 0.0v 629.505n 0.0v 639.495n 0.0v 639.505n 0.0v 649.495n 0.0v 649.505n 0.0v 659.495n 0.0v 659.505n 1.8v 669.495n 1.8v 669.505n 1.8v 679.495n 1.8v 679.505n 1.8v 689.495n 1.8v 689.505n 1.8v 699.495n 1.8v 699.505n 1.8v 709.495n 1.8v 709.505n 1.8v 719.495n 1.8v 719.505n 1.8v 729.495n 1.8v 729.505n 1.8v 739.495n 1.8v 739.505n 1.8v 749.495n 1.8v 749.505n 1.8v 759.495n 1.8v 759.505n 1.8v 769.495n 1.8v 769.505n 0.0v 779.495n 0.0v 779.505n 0.0v 789.495n 0.0v 789.505n 0.0v 799.495n 0.0v 799.505n 0.0v 809.495n 0.0v 809.505n 0.0v 819.495n 0.0v 819.505n 0.0v 829.495n 0.0v 829.505n 0.0v 839.495n 0.0v 839.505n 0.0v 849.495n 0.0v 849.505n 0.0v 859.495n 0.0v 859.505n 0.0v 869.495n 0.0v 869.505n 0.0v 879.495n 0.0v 879.505n 0.0v 889.495n 0.0v 889.505n 0.0v 899.495n 0.0v 899.505n 0.0v 909.495n 0.0v 909.505n 0.0v 919.495n 0.0v 919.505n 0.0v 929.495n 0.0v 929.505n 0.0v 939.495n 0.0v 939.505n 0.0v 949.495n 0.0v 949.505n 0.0v 959.495n 0.0v 959.505n 1.8v 969.495n 1.8v 969.505n 1.8v 979.495n 1.8v 979.505n 1.8v 989.495n 1.8v 989.505n 1.8v 999.495n 1.8v 999.505n 1.8v 1009.495n 1.8v 1009.505n 1.8v 1019.495n 1.8v 1019.505n 1.8v 1029.495n 1.8v 1029.505n 1.8v 1039.495n 1.8v 1039.505n 1.8v 1049.495n 1.8v 1049.505n 1.8v 1059.495n 1.8v 1059.505n 1.8v 1069.495n 1.8v 1069.505n 1.8v 1079.495n 1.8v 1079.505n 0.0v 1089.495n 0.0v 1089.505n 0.0v 1099.495n 0.0v 1099.505n 0.0v 1109.495n 0.0v 1109.505n 0.0v 1119.495n 0.0v 1119.505n 0.0v 1129.495n 0.0v 1129.505n 0.0v 1139.495n 0.0v 1139.505n 0.0v 1149.495n 0.0v 1149.505n 0.0v 1159.495n 0.0v 1159.505n 0.0v 1169.495n 0.0v 1169.505n 0.0v 1179.495n 0.0v 1179.505n 0.0v 1189.495n 0.0v 1189.505n 0.0v 1199.495n 0.0v 1199.505n 0.0v 1209.495n 0.0v 1209.505n 0.0v 1219.495n 0.0v 1219.505n 0.0v 1229.495n 0.0v 1229.505n 0.0v 1239.495n 0.0v 1239.505n 0.0v 1249.495n 0.0v 1249.505n 0.0v 1259.495n 0.0v 1259.505n 0.0v 1269.495n 0.0v 1269.505n 0.0v 1279.495n 0.0v 1279.505n 0.0v 1289.495n 0.0v 1289.505n 0.0v 1299.495n 0.0v 1299.505n 0.0v 1309.495n 0.0v 1309.505n 0.0v 1319.495n 0.0v 1319.505n 0.0v 1329.495n 0.0v 1329.505n 0.0v 1339.495n 0.0v 1339.505n 0.0v 1349.495n 0.0v 1349.505n 0.0v 1359.495n 0.0v 1359.505n 0.0v 1369.495n 0.0v 1369.505n 0.0v 1379.495n 0.0v 1379.505n 0.0v 1389.495n 0.0v 1389.505n 0.0v 1399.495n 0.0v 1399.505n 1.8v 1409.495n 1.8v 1409.505n 1.8v 1419.495n 1.8v 1419.505n 1.8v 1429.495n 1.8v 1429.505n 0.0v 1439.495n 0.0v 1439.505n 0.0v 1449.495n 0.0v 1449.505n 0.0v 1459.495n 0.0v 1459.505n 0.0v 1469.495n 0.0v 1469.505n 0.0v 1479.495n 0.0v 1479.505n 0.0v 1489.495n 0.0v 1489.505n 0.0v 1499.495n 0.0v 1499.505n 1.8v 1509.495n 1.8v 1509.505n 1.8v 1519.495n 1.8v 1519.505n 1.8v 1529.495n 1.8v 1529.505n 1.8v 1539.495n 1.8v 1539.505n 1.8v 1549.495n 1.8v 1549.505n 1.8v 1559.495n 1.8v 1559.505n 1.8v 1569.495n 1.8v 1569.505n 0.0v 1579.495n 0.0v 1579.505n 0.0v 1589.495n 0.0v 1589.505n 0.0v 1599.495n 0.0v 1599.505n 0.0v 1609.495n 0.0v 1609.505n 0.0v 1619.495n 0.0v 1619.505n 0.0v 1629.495n 0.0v 1629.505n 0.0v 1639.495n 0.0v 1639.505n 0.0v 1649.495n 0.0v 1649.505n 0.0v 1659.495n 0.0v 1659.505n 0.0v 1669.495n 0.0v 1669.505n 0.0v 1679.495n 0.0v 1679.505n 0.0v 1689.495n 0.0v 1689.505n 1.8v 1699.495n 1.8v 1699.505n 1.8v 1709.495n 1.8v 1709.505n 0.0v 1719.495n 0.0v 1719.505n 0.0v 1729.495n 0.0v 1729.505n 1.8v 1739.495n 1.8v 1739.505n 1.8v 1749.495n 1.8v 1749.505n 1.8v 1759.495n 1.8v 1759.505n 1.8v 1769.495n 1.8v 1769.505n 1.8v 1779.495n 1.8v 1779.505n 1.8v 1789.495n 1.8v 1789.505n 0.0v 1799.495n 0.0v 1799.505n 0.0v 1809.495n 0.0v 1809.505n 0.0v 1819.495n 0.0v 1819.505n 0.0v 1829.495n 0.0v 1829.505n 0.0v 1839.495n 0.0v 1839.505n 0.0v 1849.495n 0.0v 1849.505n 1.8v 1859.495n 1.8v 1859.505n 0.0v 1869.495n 0.0v 1869.505n 1.8v 1879.495n 1.8v 1879.505n 0.0v 1889.495n 0.0v 1889.505n 0.0v 1899.495n 0.0v 1899.505n 0.0v 1909.495n 0.0v 1909.505n 1.8v 1919.495n 1.8v 1919.505n 1.8v 1929.495n 1.8v 1929.505n 1.8v 1939.495n 1.8v 1939.505n 1.8v 1949.495n 1.8v 1949.505n 1.8v 1959.495n 1.8v 1959.505n 1.8v 1969.495n 1.8v 1969.505n 1.8v 1979.495n 1.8v 1979.505n 1.8v 1989.495n 1.8v 1989.505n 1.8v 1999.495n 1.8v 1999.505n 1.8v 2009.495n 1.8v 2009.505n 1.8v 2019.495n 1.8v 2019.505n 1.8v 2029.495n 1.8v 2029.505n 0.0v 2039.495n 0.0v 2039.505n 0.0v 2049.495n 0.0v 2049.505n 0.0v )
* (time, data): [(0, 0), (10, 0), (20, 0), (30, 0), (40, 0), (50, 0), (60, 1), (70, 1), (80, 1), (90, 1), (100, 1), (110, 1), (120, 1), (130, 1), (140, 1), (150, 1), (160, 1), (170, 1), (180, 1), (190, 1), (200, 1), (210, 1), (220, 1), (230, 1), (240, 1), (250, 1), (260, 0), (270, 0), (280, 0), (290, 0), (300, 0), (310, 1), (320, 1), (330, 1), (340, 1), (350, 0), (360, 0), (370, 0), (380, 0), (390, 1), (400, 0), (410, 0), (420, 0), (430, 0), (440, 0), (450, 1), (460, 1), (470, 0), (480, 0), (490, 1), (500, 1), (510, 1), (520, 1), (530, 1), (540, 1), (550, 1), (560, 1), (570, 1), (580, 1), (590, 1), (600, 1), (610, 1), (620, 1), (630, 1), (640, 1), (650, 1), (660, 0), (670, 1), (680, 1), (690, 1), (700, 1), (710, 1), (720, 1), (730, 1), (740, 1), (750, 1), (760, 1), (770, 0), (780, 0), (790, 0), (800, 0), (810, 0), (820, 1), (830, 1), (840, 0), (850, 0), (860, 0), (870, 0), (880, 0), (890, 1), (900, 1), (910, 1), (920, 1), (930, 0), (940, 0), (950, 0), (960, 1), (970, 1), (980, 1), (990, 1), (1000, 1), (1010, 1), (1020, 1), (1030, 1), (1040, 1), (1050, 1), (1060, 1), (1070, 1), (1080, 0), (1090, 0), (1100, 0), (1110, 0), (1120, 0), (1130, 1), (1140, 1), (1150, 1), (1160, 1), (1170, 1), (1180, 1), (1190, 1), (1200, 1), (1210, 1), (1220, 1), (1230, 1), (1240, 1), (1250, 1), (1260, 0), (1270, 0), (1280, 1), (1290, 1), (1300, 1), (1310, 1), (1320, 1), (1330, 1), (1340, 1), (1350, 1), (1360, 1), (1370, 0), (1380, 0), (1390, 0), (1400, 0), (1410, 0), (1420, 0), (1430, 0), (1440, 0), (1450, 0), (1460, 0), (1470, 0), (1480, 1), (1490, 1), (1500, 1), (1510, 1), (1520, 1), (1530, 1), (1540, 1), (1550, 1), (1560, 1), (1570, 1), (1580, 1), (1590, 0), (1600, 0), (1610, 0), (1620, 0), (1630, 0), (1640, 0), (1650, 0), (1660, 0), (1670, 0), (1680, 0), (1690, 0), (1700, 0), (1710, 0), (1720, 0), (1730, 0), (1740, 0), (1750, 0), (1760, 0), (1770, 0), (1780, 0), (1790, 0), (1800, 0), (1810, 0), (1820, 0), (1830, 0), (1840, 0), (1850, 1), (1860, 0), (1870, 0), (1880, 0), (1890, 1), (1900, 1), (1910, 1), (1920, 1), (1930, 1), (1940, 1), (1950, 1), (1960, 1), (1970, 1), (1980, 1), (1990, 1), (2000, 1), (2010, 1), (2020, 1), (2030, 0), (2040, 0), (2050, 0)]
Vdin0_8  din0_8  0 PWL (0n 0.0v 9.495n 0.0v 9.505n 0.0v 19.495n 0.0v 19.505n 0.0v 29.495n 0.0v 29.505n 0.0v 39.495n 0.0v 39.505n 0.0v 49.495n 0.0v 49.505n 0.0v 59.495n 0.0v 59.505n 1.8v 69.495n 1.8v 69.505n 1.8v 79.495n 1.8v 79.505n 1.8v 89.495n 1.8v 89.505n 1.8v 99.495n 1.8v 99.505n 1.8v 109.495n 1.8v 109.505n 1.8v 119.495n 1.8v 119.505n 1.8v 129.495n 1.8v 129.505n 1.8v 139.495n 1.8v 139.505n 1.8v 149.495n 1.8v 149.505n 1.8v 159.495n 1.8v 159.505n 1.8v 169.495n 1.8v 169.505n 1.8v 179.495n 1.8v 179.505n 1.8v 189.495n 1.8v 189.505n 1.8v 199.495n 1.8v 199.505n 1.8v 209.495n 1.8v 209.505n 1.8v 219.495n 1.8v 219.505n 1.8v 229.495n 1.8v 229.505n 1.8v 239.495n 1.8v 239.505n 1.8v 249.495n 1.8v 249.505n 1.8v 259.495n 1.8v 259.505n 0.0v 269.495n 0.0v 269.505n 0.0v 279.495n 0.0v 279.505n 0.0v 289.495n 0.0v 289.505n 0.0v 299.495n 0.0v 299.505n 0.0v 309.495n 0.0v 309.505n 1.8v 319.495n 1.8v 319.505n 1.8v 329.495n 1.8v 329.505n 1.8v 339.495n 1.8v 339.505n 1.8v 349.495n 1.8v 349.505n 0.0v 359.495n 0.0v 359.505n 0.0v 369.495n 0.0v 369.505n 0.0v 379.495n 0.0v 379.505n 0.0v 389.495n 0.0v 389.505n 1.8v 399.495n 1.8v 399.505n 0.0v 409.495n 0.0v 409.505n 0.0v 419.495n 0.0v 419.505n 0.0v 429.495n 0.0v 429.505n 0.0v 439.495n 0.0v 439.505n 0.0v 449.495n 0.0v 449.505n 1.8v 459.495n 1.8v 459.505n 1.8v 469.495n 1.8v 469.505n 0.0v 479.495n 0.0v 479.505n 0.0v 489.495n 0.0v 489.505n 1.8v 499.495n 1.8v 499.505n 1.8v 509.495n 1.8v 509.505n 1.8v 519.495n 1.8v 519.505n 1.8v 529.495n 1.8v 529.505n 1.8v 539.495n 1.8v 539.505n 1.8v 549.495n 1.8v 549.505n 1.8v 559.495n 1.8v 559.505n 1.8v 569.495n 1.8v 569.505n 1.8v 579.495n 1.8v 579.505n 1.8v 589.495n 1.8v 589.505n 1.8v 599.495n 1.8v 599.505n 1.8v 609.495n 1.8v 609.505n 1.8v 619.495n 1.8v 619.505n 1.8v 629.495n 1.8v 629.505n 1.8v 639.495n 1.8v 639.505n 1.8v 649.495n 1.8v 649.505n 1.8v 659.495n 1.8v 659.505n 0.0v 669.495n 0.0v 669.505n 1.8v 679.495n 1.8v 679.505n 1.8v 689.495n 1.8v 689.505n 1.8v 699.495n 1.8v 699.505n 1.8v 709.495n 1.8v 709.505n 1.8v 719.495n 1.8v 719.505n 1.8v 729.495n 1.8v 729.505n 1.8v 739.495n 1.8v 739.505n 1.8v 749.495n 1.8v 749.505n 1.8v 759.495n 1.8v 759.505n 1.8v 769.495n 1.8v 769.505n 0.0v 779.495n 0.0v 779.505n 0.0v 789.495n 0.0v 789.505n 0.0v 799.495n 0.0v 799.505n 0.0v 809.495n 0.0v 809.505n 0.0v 819.495n 0.0v 819.505n 1.8v 829.495n 1.8v 829.505n 1.8v 839.495n 1.8v 839.505n 0.0v 849.495n 0.0v 849.505n 0.0v 859.495n 0.0v 859.505n 0.0v 869.495n 0.0v 869.505n 0.0v 879.495n 0.0v 879.505n 0.0v 889.495n 0.0v 889.505n 1.8v 899.495n 1.8v 899.505n 1.8v 909.495n 1.8v 909.505n 1.8v 919.495n 1.8v 919.505n 1.8v 929.495n 1.8v 929.505n 0.0v 939.495n 0.0v 939.505n 0.0v 949.495n 0.0v 949.505n 0.0v 959.495n 0.0v 959.505n 1.8v 969.495n 1.8v 969.505n 1.8v 979.495n 1.8v 979.505n 1.8v 989.495n 1.8v 989.505n 1.8v 999.495n 1.8v 999.505n 1.8v 1009.495n 1.8v 1009.505n 1.8v 1019.495n 1.8v 1019.505n 1.8v 1029.495n 1.8v 1029.505n 1.8v 1039.495n 1.8v 1039.505n 1.8v 1049.495n 1.8v 1049.505n 1.8v 1059.495n 1.8v 1059.505n 1.8v 1069.495n 1.8v 1069.505n 1.8v 1079.495n 1.8v 1079.505n 0.0v 1089.495n 0.0v 1089.505n 0.0v 1099.495n 0.0v 1099.505n 0.0v 1109.495n 0.0v 1109.505n 0.0v 1119.495n 0.0v 1119.505n 0.0v 1129.495n 0.0v 1129.505n 1.8v 1139.495n 1.8v 1139.505n 1.8v 1149.495n 1.8v 1149.505n 1.8v 1159.495n 1.8v 1159.505n 1.8v 1169.495n 1.8v 1169.505n 1.8v 1179.495n 1.8v 1179.505n 1.8v 1189.495n 1.8v 1189.505n 1.8v 1199.495n 1.8v 1199.505n 1.8v 1209.495n 1.8v 1209.505n 1.8v 1219.495n 1.8v 1219.505n 1.8v 1229.495n 1.8v 1229.505n 1.8v 1239.495n 1.8v 1239.505n 1.8v 1249.495n 1.8v 1249.505n 1.8v 1259.495n 1.8v 1259.505n 0.0v 1269.495n 0.0v 1269.505n 0.0v 1279.495n 0.0v 1279.505n 1.8v 1289.495n 1.8v 1289.505n 1.8v 1299.495n 1.8v 1299.505n 1.8v 1309.495n 1.8v 1309.505n 1.8v 1319.495n 1.8v 1319.505n 1.8v 1329.495n 1.8v 1329.505n 1.8v 1339.495n 1.8v 1339.505n 1.8v 1349.495n 1.8v 1349.505n 1.8v 1359.495n 1.8v 1359.505n 1.8v 1369.495n 1.8v 1369.505n 0.0v 1379.495n 0.0v 1379.505n 0.0v 1389.495n 0.0v 1389.505n 0.0v 1399.495n 0.0v 1399.505n 0.0v 1409.495n 0.0v 1409.505n 0.0v 1419.495n 0.0v 1419.505n 0.0v 1429.495n 0.0v 1429.505n 0.0v 1439.495n 0.0v 1439.505n 0.0v 1449.495n 0.0v 1449.505n 0.0v 1459.495n 0.0v 1459.505n 0.0v 1469.495n 0.0v 1469.505n 0.0v 1479.495n 0.0v 1479.505n 1.8v 1489.495n 1.8v 1489.505n 1.8v 1499.495n 1.8v 1499.505n 1.8v 1509.495n 1.8v 1509.505n 1.8v 1519.495n 1.8v 1519.505n 1.8v 1529.495n 1.8v 1529.505n 1.8v 1539.495n 1.8v 1539.505n 1.8v 1549.495n 1.8v 1549.505n 1.8v 1559.495n 1.8v 1559.505n 1.8v 1569.495n 1.8v 1569.505n 1.8v 1579.495n 1.8v 1579.505n 1.8v 1589.495n 1.8v 1589.505n 0.0v 1599.495n 0.0v 1599.505n 0.0v 1609.495n 0.0v 1609.505n 0.0v 1619.495n 0.0v 1619.505n 0.0v 1629.495n 0.0v 1629.505n 0.0v 1639.495n 0.0v 1639.505n 0.0v 1649.495n 0.0v 1649.505n 0.0v 1659.495n 0.0v 1659.505n 0.0v 1669.495n 0.0v 1669.505n 0.0v 1679.495n 0.0v 1679.505n 0.0v 1689.495n 0.0v 1689.505n 0.0v 1699.495n 0.0v 1699.505n 0.0v 1709.495n 0.0v 1709.505n 0.0v 1719.495n 0.0v 1719.505n 0.0v 1729.495n 0.0v 1729.505n 0.0v 1739.495n 0.0v 1739.505n 0.0v 1749.495n 0.0v 1749.505n 0.0v 1759.495n 0.0v 1759.505n 0.0v 1769.495n 0.0v 1769.505n 0.0v 1779.495n 0.0v 1779.505n 0.0v 1789.495n 0.0v 1789.505n 0.0v 1799.495n 0.0v 1799.505n 0.0v 1809.495n 0.0v 1809.505n 0.0v 1819.495n 0.0v 1819.505n 0.0v 1829.495n 0.0v 1829.505n 0.0v 1839.495n 0.0v 1839.505n 0.0v 1849.495n 0.0v 1849.505n 1.8v 1859.495n 1.8v 1859.505n 0.0v 1869.495n 0.0v 1869.505n 0.0v 1879.495n 0.0v 1879.505n 0.0v 1889.495n 0.0v 1889.505n 1.8v 1899.495n 1.8v 1899.505n 1.8v 1909.495n 1.8v 1909.505n 1.8v 1919.495n 1.8v 1919.505n 1.8v 1929.495n 1.8v 1929.505n 1.8v 1939.495n 1.8v 1939.505n 1.8v 1949.495n 1.8v 1949.505n 1.8v 1959.495n 1.8v 1959.505n 1.8v 1969.495n 1.8v 1969.505n 1.8v 1979.495n 1.8v 1979.505n 1.8v 1989.495n 1.8v 1989.505n 1.8v 1999.495n 1.8v 1999.505n 1.8v 2009.495n 1.8v 2009.505n 1.8v 2019.495n 1.8v 2019.505n 1.8v 2029.495n 1.8v 2029.505n 0.0v 2039.495n 0.0v 2039.505n 0.0v 2049.495n 0.0v 2049.505n 0.0v )
* (time, data): [(0, 0), (10, 1), (20, 0), (30, 0), (40, 0), (50, 0), (60, 1), (70, 1), (80, 1), (90, 1), (100, 1), (110, 1), (120, 1), (130, 1), (140, 1), (150, 1), (160, 1), (170, 1), (180, 1), (190, 1), (200, 1), (210, 1), (220, 1), (230, 1), (240, 1), (250, 1), (260, 1), (270, 1), (280, 1), (290, 1), (300, 1), (310, 0), (320, 0), (330, 0), (340, 0), (350, 1), (360, 1), (370, 1), (380, 1), (390, 0), (400, 1), (410, 1), (420, 0), (430, 0), (440, 0), (450, 0), (460, 0), (470, 1), (480, 1), (490, 0), (500, 1), (510, 1), (520, 1), (530, 1), (540, 1), (550, 1), (560, 1), (570, 1), (580, 1), (590, 1), (600, 1), (610, 1), (620, 0), (630, 0), (640, 0), (650, 0), (660, 1), (670, 0), (680, 0), (690, 0), (700, 0), (710, 0), (720, 0), (730, 0), (740, 0), (750, 0), (760, 0), (770, 1), (780, 1), (790, 1), (800, 1), (810, 1), (820, 1), (830, 1), (840, 1), (850, 1), (860, 1), (870, 1), (880, 1), (890, 1), (900, 1), (910, 1), (920, 1), (930, 0), (940, 0), (950, 0), (960, 0), (970, 0), (980, 0), (990, 0), (1000, 0), (1010, 0), (1020, 0), (1030, 0), (1040, 0), (1050, 0), (1060, 0), (1070, 0), (1080, 0), (1090, 0), (1100, 0), (1110, 0), (1120, 0), (1130, 0), (1140, 0), (1150, 0), (1160, 0), (1170, 0), (1180, 0), (1190, 0), (1200, 0), (1210, 0), (1220, 0), (1230, 0), (1240, 0), (1250, 0), (1260, 1), (1270, 1), (1280, 0), (1290, 0), (1300, 0), (1310, 0), (1320, 0), (1330, 0), (1340, 0), (1350, 0), (1360, 0), (1370, 1), (1380, 1), (1390, 1), (1400, 0), (1410, 0), (1420, 0), (1430, 0), (1440, 0), (1450, 0), (1460, 0), (1470, 0), (1480, 0), (1490, 0), (1500, 1), (1510, 1), (1520, 1), (1530, 1), (1540, 1), (1550, 1), (1560, 1), (1570, 0), (1580, 0), (1590, 0), (1600, 0), (1610, 0), (1620, 0), (1630, 0), (1640, 0), (1650, 0), (1660, 0), (1670, 0), (1680, 0), (1690, 0), (1700, 0), (1710, 1), (1720, 1), (1730, 0), (1740, 0), (1750, 0), (1760, 0), (1770, 0), (1780, 0), (1790, 0), (1800, 0), (1810, 0), (1820, 0), (1830, 0), (1840, 0), (1850, 0), (1860, 0), (1870, 0), (1880, 1), (1890, 1), (1900, 1), (1910, 0), (1920, 0), (1930, 0), (1940, 0), (1950, 0), (1960, 0), (1970, 0), (1980, 0), (1990, 0), (2000, 0), (2010, 0), (2020, 0), (2030, 0), (2040, 0), (2050, 0)]
Vdin0_9  din0_9  0 PWL (0n 0.0v 9.495n 0.0v 9.505n 1.8v 19.495n 1.8v 19.505n 0.0v 29.495n 0.0v 29.505n 0.0v 39.495n 0.0v 39.505n 0.0v 49.495n 0.0v 49.505n 0.0v 59.495n 0.0v 59.505n 1.8v 69.495n 1.8v 69.505n 1.8v 79.495n 1.8v 79.505n 1.8v 89.495n 1.8v 89.505n 1.8v 99.495n 1.8v 99.505n 1.8v 109.495n 1.8v 109.505n 1.8v 119.495n 1.8v 119.505n 1.8v 129.495n 1.8v 129.505n 1.8v 139.495n 1.8v 139.505n 1.8v 149.495n 1.8v 149.505n 1.8v 159.495n 1.8v 159.505n 1.8v 169.495n 1.8v 169.505n 1.8v 179.495n 1.8v 179.505n 1.8v 189.495n 1.8v 189.505n 1.8v 199.495n 1.8v 199.505n 1.8v 209.495n 1.8v 209.505n 1.8v 219.495n 1.8v 219.505n 1.8v 229.495n 1.8v 229.505n 1.8v 239.495n 1.8v 239.505n 1.8v 249.495n 1.8v 249.505n 1.8v 259.495n 1.8v 259.505n 1.8v 269.495n 1.8v 269.505n 1.8v 279.495n 1.8v 279.505n 1.8v 289.495n 1.8v 289.505n 1.8v 299.495n 1.8v 299.505n 1.8v 309.495n 1.8v 309.505n 0.0v 319.495n 0.0v 319.505n 0.0v 329.495n 0.0v 329.505n 0.0v 339.495n 0.0v 339.505n 0.0v 349.495n 0.0v 349.505n 1.8v 359.495n 1.8v 359.505n 1.8v 369.495n 1.8v 369.505n 1.8v 379.495n 1.8v 379.505n 1.8v 389.495n 1.8v 389.505n 0.0v 399.495n 0.0v 399.505n 1.8v 409.495n 1.8v 409.505n 1.8v 419.495n 1.8v 419.505n 0.0v 429.495n 0.0v 429.505n 0.0v 439.495n 0.0v 439.505n 0.0v 449.495n 0.0v 449.505n 0.0v 459.495n 0.0v 459.505n 0.0v 469.495n 0.0v 469.505n 1.8v 479.495n 1.8v 479.505n 1.8v 489.495n 1.8v 489.505n 0.0v 499.495n 0.0v 499.505n 1.8v 509.495n 1.8v 509.505n 1.8v 519.495n 1.8v 519.505n 1.8v 529.495n 1.8v 529.505n 1.8v 539.495n 1.8v 539.505n 1.8v 549.495n 1.8v 549.505n 1.8v 559.495n 1.8v 559.505n 1.8v 569.495n 1.8v 569.505n 1.8v 579.495n 1.8v 579.505n 1.8v 589.495n 1.8v 589.505n 1.8v 599.495n 1.8v 599.505n 1.8v 609.495n 1.8v 609.505n 1.8v 619.495n 1.8v 619.505n 0.0v 629.495n 0.0v 629.505n 0.0v 639.495n 0.0v 639.505n 0.0v 649.495n 0.0v 649.505n 0.0v 659.495n 0.0v 659.505n 1.8v 669.495n 1.8v 669.505n 0.0v 679.495n 0.0v 679.505n 0.0v 689.495n 0.0v 689.505n 0.0v 699.495n 0.0v 699.505n 0.0v 709.495n 0.0v 709.505n 0.0v 719.495n 0.0v 719.505n 0.0v 729.495n 0.0v 729.505n 0.0v 739.495n 0.0v 739.505n 0.0v 749.495n 0.0v 749.505n 0.0v 759.495n 0.0v 759.505n 0.0v 769.495n 0.0v 769.505n 1.8v 779.495n 1.8v 779.505n 1.8v 789.495n 1.8v 789.505n 1.8v 799.495n 1.8v 799.505n 1.8v 809.495n 1.8v 809.505n 1.8v 819.495n 1.8v 819.505n 1.8v 829.495n 1.8v 829.505n 1.8v 839.495n 1.8v 839.505n 1.8v 849.495n 1.8v 849.505n 1.8v 859.495n 1.8v 859.505n 1.8v 869.495n 1.8v 869.505n 1.8v 879.495n 1.8v 879.505n 1.8v 889.495n 1.8v 889.505n 1.8v 899.495n 1.8v 899.505n 1.8v 909.495n 1.8v 909.505n 1.8v 919.495n 1.8v 919.505n 1.8v 929.495n 1.8v 929.505n 0.0v 939.495n 0.0v 939.505n 0.0v 949.495n 0.0v 949.505n 0.0v 959.495n 0.0v 959.505n 0.0v 969.495n 0.0v 969.505n 0.0v 979.495n 0.0v 979.505n 0.0v 989.495n 0.0v 989.505n 0.0v 999.495n 0.0v 999.505n 0.0v 1009.495n 0.0v 1009.505n 0.0v 1019.495n 0.0v 1019.505n 0.0v 1029.495n 0.0v 1029.505n 0.0v 1039.495n 0.0v 1039.505n 0.0v 1049.495n 0.0v 1049.505n 0.0v 1059.495n 0.0v 1059.505n 0.0v 1069.495n 0.0v 1069.505n 0.0v 1079.495n 0.0v 1079.505n 0.0v 1089.495n 0.0v 1089.505n 0.0v 1099.495n 0.0v 1099.505n 0.0v 1109.495n 0.0v 1109.505n 0.0v 1119.495n 0.0v 1119.505n 0.0v 1129.495n 0.0v 1129.505n 0.0v 1139.495n 0.0v 1139.505n 0.0v 1149.495n 0.0v 1149.505n 0.0v 1159.495n 0.0v 1159.505n 0.0v 1169.495n 0.0v 1169.505n 0.0v 1179.495n 0.0v 1179.505n 0.0v 1189.495n 0.0v 1189.505n 0.0v 1199.495n 0.0v 1199.505n 0.0v 1209.495n 0.0v 1209.505n 0.0v 1219.495n 0.0v 1219.505n 0.0v 1229.495n 0.0v 1229.505n 0.0v 1239.495n 0.0v 1239.505n 0.0v 1249.495n 0.0v 1249.505n 0.0v 1259.495n 0.0v 1259.505n 1.8v 1269.495n 1.8v 1269.505n 1.8v 1279.495n 1.8v 1279.505n 0.0v 1289.495n 0.0v 1289.505n 0.0v 1299.495n 0.0v 1299.505n 0.0v 1309.495n 0.0v 1309.505n 0.0v 1319.495n 0.0v 1319.505n 0.0v 1329.495n 0.0v 1329.505n 0.0v 1339.495n 0.0v 1339.505n 0.0v 1349.495n 0.0v 1349.505n 0.0v 1359.495n 0.0v 1359.505n 0.0v 1369.495n 0.0v 1369.505n 1.8v 1379.495n 1.8v 1379.505n 1.8v 1389.495n 1.8v 1389.505n 1.8v 1399.495n 1.8v 1399.505n 0.0v 1409.495n 0.0v 1409.505n 0.0v 1419.495n 0.0v 1419.505n 0.0v 1429.495n 0.0v 1429.505n 0.0v 1439.495n 0.0v 1439.505n 0.0v 1449.495n 0.0v 1449.505n 0.0v 1459.495n 0.0v 1459.505n 0.0v 1469.495n 0.0v 1469.505n 0.0v 1479.495n 0.0v 1479.505n 0.0v 1489.495n 0.0v 1489.505n 0.0v 1499.495n 0.0v 1499.505n 1.8v 1509.495n 1.8v 1509.505n 1.8v 1519.495n 1.8v 1519.505n 1.8v 1529.495n 1.8v 1529.505n 1.8v 1539.495n 1.8v 1539.505n 1.8v 1549.495n 1.8v 1549.505n 1.8v 1559.495n 1.8v 1559.505n 1.8v 1569.495n 1.8v 1569.505n 0.0v 1579.495n 0.0v 1579.505n 0.0v 1589.495n 0.0v 1589.505n 0.0v 1599.495n 0.0v 1599.505n 0.0v 1609.495n 0.0v 1609.505n 0.0v 1619.495n 0.0v 1619.505n 0.0v 1629.495n 0.0v 1629.505n 0.0v 1639.495n 0.0v 1639.505n 0.0v 1649.495n 0.0v 1649.505n 0.0v 1659.495n 0.0v 1659.505n 0.0v 1669.495n 0.0v 1669.505n 0.0v 1679.495n 0.0v 1679.505n 0.0v 1689.495n 0.0v 1689.505n 0.0v 1699.495n 0.0v 1699.505n 0.0v 1709.495n 0.0v 1709.505n 1.8v 1719.495n 1.8v 1719.505n 1.8v 1729.495n 1.8v 1729.505n 0.0v 1739.495n 0.0v 1739.505n 0.0v 1749.495n 0.0v 1749.505n 0.0v 1759.495n 0.0v 1759.505n 0.0v 1769.495n 0.0v 1769.505n 0.0v 1779.495n 0.0v 1779.505n 0.0v 1789.495n 0.0v 1789.505n 0.0v 1799.495n 0.0v 1799.505n 0.0v 1809.495n 0.0v 1809.505n 0.0v 1819.495n 0.0v 1819.505n 0.0v 1829.495n 0.0v 1829.505n 0.0v 1839.495n 0.0v 1839.505n 0.0v 1849.495n 0.0v 1849.505n 0.0v 1859.495n 0.0v 1859.505n 0.0v 1869.495n 0.0v 1869.505n 0.0v 1879.495n 0.0v 1879.505n 1.8v 1889.495n 1.8v 1889.505n 1.8v 1899.495n 1.8v 1899.505n 1.8v 1909.495n 1.8v 1909.505n 0.0v 1919.495n 0.0v 1919.505n 0.0v 1929.495n 0.0v 1929.505n 0.0v 1939.495n 0.0v 1939.505n 0.0v 1949.495n 0.0v 1949.505n 0.0v 1959.495n 0.0v 1959.505n 0.0v 1969.495n 0.0v 1969.505n 0.0v 1979.495n 0.0v 1979.505n 0.0v 1989.495n 0.0v 1989.505n 0.0v 1999.495n 0.0v 1999.505n 0.0v 2009.495n 0.0v 2009.505n 0.0v 2019.495n 0.0v 2019.505n 0.0v 2029.495n 0.0v 2029.505n 0.0v 2039.495n 0.0v 2039.505n 0.0v 2049.495n 0.0v 2049.505n 0.0v )
* (time, data): [(0, 0), (10, 0), (20, 1), (30, 0), (40, 0), (50, 0), (60, 1), (70, 1), (80, 1), (90, 1), (100, 1), (110, 1), (120, 1), (130, 1), (140, 1), (150, 0), (160, 0), (170, 0), (180, 0), (190, 0), (200, 0), (210, 0), (220, 0), (230, 0), (240, 0), (250, 0), (260, 1), (270, 1), (280, 1), (290, 1), (300, 1), (310, 1), (320, 1), (330, 1), (340, 1), (350, 1), (360, 1), (370, 1), (380, 1), (390, 1), (400, 0), (410, 0), (420, 0), (430, 0), (440, 0), (450, 0), (460, 0), (470, 1), (480, 1), (490, 1), (500, 0), (510, 0), (520, 0), (530, 0), (540, 0), (550, 0), (560, 0), (570, 0), (580, 0), (590, 0), (600, 0), (610, 0), (620, 0), (630, 0), (640, 0), (650, 0), (660, 0), (670, 0), (680, 0), (690, 0), (700, 0), (710, 1), (720, 1), (730, 1), (740, 1), (750, 1), (760, 1), (770, 0), (780, 0), (790, 0), (800, 0), (810, 0), (820, 0), (830, 0), (840, 0), (850, 0), (860, 0), (870, 0), (880, 0), (890, 1), (900, 1), (910, 1), (920, 1), (930, 0), (940, 0), (950, 0), (960, 1), (970, 1), (980, 1), (990, 1), (1000, 1), (1010, 1), (1020, 1), (1030, 1), (1040, 1), (1050, 1), (1060, 1), (1070, 1), (1080, 0), (1090, 0), (1100, 0), (1110, 0), (1120, 0), (1130, 0), (1140, 0), (1150, 0), (1160, 0), (1170, 0), (1180, 0), (1190, 0), (1200, 0), (1210, 0), (1220, 0), (1230, 0), (1240, 0), (1250, 0), (1260, 1), (1270, 1), (1280, 1), (1290, 1), (1300, 1), (1310, 1), (1320, 1), (1330, 1), (1340, 1), (1350, 1), (1360, 1), (1370, 0), (1380, 0), (1390, 0), (1400, 0), (1410, 0), (1420, 0), (1430, 0), (1440, 0), (1450, 0), (1460, 0), (1470, 0), (1480, 1), (1490, 1), (1500, 1), (1510, 1), (1520, 1), (1530, 1), (1540, 1), (1550, 1), (1560, 1), (1570, 1), (1580, 0), (1590, 1), (1600, 1), (1610, 1), (1620, 0), (1630, 0), (1640, 0), (1650, 0), (1660, 0), (1670, 0), (1680, 0), (1690, 0), (1700, 0), (1710, 0), (1720, 0), (1730, 0), (1740, 0), (1750, 0), (1760, 0), (1770, 0), (1780, 0), (1790, 0), (1800, 0), (1810, 0), (1820, 0), (1830, 0), (1840, 0), (1850, 0), (1860, 1), (1870, 1), (1880, 1), (1890, 1), (1900, 1), (1910, 1), (1920, 1), (1930, 1), (1940, 1), (1950, 1), (1960, 1), (1970, 1), (1980, 1), (1990, 1), (2000, 1), (2010, 1), (2020, 1), (2030, 0), (2040, 0), (2050, 0)]
Vdin0_10  din0_10  0 PWL (0n 0.0v 9.495n 0.0v 9.505n 0.0v 19.495n 0.0v 19.505n 1.8v 29.495n 1.8v 29.505n 0.0v 39.495n 0.0v 39.505n 0.0v 49.495n 0.0v 49.505n 0.0v 59.495n 0.0v 59.505n 1.8v 69.495n 1.8v 69.505n 1.8v 79.495n 1.8v 79.505n 1.8v 89.495n 1.8v 89.505n 1.8v 99.495n 1.8v 99.505n 1.8v 109.495n 1.8v 109.505n 1.8v 119.495n 1.8v 119.505n 1.8v 129.495n 1.8v 129.505n 1.8v 139.495n 1.8v 139.505n 1.8v 149.495n 1.8v 149.505n 0.0v 159.495n 0.0v 159.505n 0.0v 169.495n 0.0v 169.505n 0.0v 179.495n 0.0v 179.505n 0.0v 189.495n 0.0v 189.505n 0.0v 199.495n 0.0v 199.505n 0.0v 209.495n 0.0v 209.505n 0.0v 219.495n 0.0v 219.505n 0.0v 229.495n 0.0v 229.505n 0.0v 239.495n 0.0v 239.505n 0.0v 249.495n 0.0v 249.505n 0.0v 259.495n 0.0v 259.505n 1.8v 269.495n 1.8v 269.505n 1.8v 279.495n 1.8v 279.505n 1.8v 289.495n 1.8v 289.505n 1.8v 299.495n 1.8v 299.505n 1.8v 309.495n 1.8v 309.505n 1.8v 319.495n 1.8v 319.505n 1.8v 329.495n 1.8v 329.505n 1.8v 339.495n 1.8v 339.505n 1.8v 349.495n 1.8v 349.505n 1.8v 359.495n 1.8v 359.505n 1.8v 369.495n 1.8v 369.505n 1.8v 379.495n 1.8v 379.505n 1.8v 389.495n 1.8v 389.505n 1.8v 399.495n 1.8v 399.505n 0.0v 409.495n 0.0v 409.505n 0.0v 419.495n 0.0v 419.505n 0.0v 429.495n 0.0v 429.505n 0.0v 439.495n 0.0v 439.505n 0.0v 449.495n 0.0v 449.505n 0.0v 459.495n 0.0v 459.505n 0.0v 469.495n 0.0v 469.505n 1.8v 479.495n 1.8v 479.505n 1.8v 489.495n 1.8v 489.505n 1.8v 499.495n 1.8v 499.505n 0.0v 509.495n 0.0v 509.505n 0.0v 519.495n 0.0v 519.505n 0.0v 529.495n 0.0v 529.505n 0.0v 539.495n 0.0v 539.505n 0.0v 549.495n 0.0v 549.505n 0.0v 559.495n 0.0v 559.505n 0.0v 569.495n 0.0v 569.505n 0.0v 579.495n 0.0v 579.505n 0.0v 589.495n 0.0v 589.505n 0.0v 599.495n 0.0v 599.505n 0.0v 609.495n 0.0v 609.505n 0.0v 619.495n 0.0v 619.505n 0.0v 629.495n 0.0v 629.505n 0.0v 639.495n 0.0v 639.505n 0.0v 649.495n 0.0v 649.505n 0.0v 659.495n 0.0v 659.505n 0.0v 669.495n 0.0v 669.505n 0.0v 679.495n 0.0v 679.505n 0.0v 689.495n 0.0v 689.505n 0.0v 699.495n 0.0v 699.505n 0.0v 709.495n 0.0v 709.505n 1.8v 719.495n 1.8v 719.505n 1.8v 729.495n 1.8v 729.505n 1.8v 739.495n 1.8v 739.505n 1.8v 749.495n 1.8v 749.505n 1.8v 759.495n 1.8v 759.505n 1.8v 769.495n 1.8v 769.505n 0.0v 779.495n 0.0v 779.505n 0.0v 789.495n 0.0v 789.505n 0.0v 799.495n 0.0v 799.505n 0.0v 809.495n 0.0v 809.505n 0.0v 819.495n 0.0v 819.505n 0.0v 829.495n 0.0v 829.505n 0.0v 839.495n 0.0v 839.505n 0.0v 849.495n 0.0v 849.505n 0.0v 859.495n 0.0v 859.505n 0.0v 869.495n 0.0v 869.505n 0.0v 879.495n 0.0v 879.505n 0.0v 889.495n 0.0v 889.505n 1.8v 899.495n 1.8v 899.505n 1.8v 909.495n 1.8v 909.505n 1.8v 919.495n 1.8v 919.505n 1.8v 929.495n 1.8v 929.505n 0.0v 939.495n 0.0v 939.505n 0.0v 949.495n 0.0v 949.505n 0.0v 959.495n 0.0v 959.505n 1.8v 969.495n 1.8v 969.505n 1.8v 979.495n 1.8v 979.505n 1.8v 989.495n 1.8v 989.505n 1.8v 999.495n 1.8v 999.505n 1.8v 1009.495n 1.8v 1009.505n 1.8v 1019.495n 1.8v 1019.505n 1.8v 1029.495n 1.8v 1029.505n 1.8v 1039.495n 1.8v 1039.505n 1.8v 1049.495n 1.8v 1049.505n 1.8v 1059.495n 1.8v 1059.505n 1.8v 1069.495n 1.8v 1069.505n 1.8v 1079.495n 1.8v 1079.505n 0.0v 1089.495n 0.0v 1089.505n 0.0v 1099.495n 0.0v 1099.505n 0.0v 1109.495n 0.0v 1109.505n 0.0v 1119.495n 0.0v 1119.505n 0.0v 1129.495n 0.0v 1129.505n 0.0v 1139.495n 0.0v 1139.505n 0.0v 1149.495n 0.0v 1149.505n 0.0v 1159.495n 0.0v 1159.505n 0.0v 1169.495n 0.0v 1169.505n 0.0v 1179.495n 0.0v 1179.505n 0.0v 1189.495n 0.0v 1189.505n 0.0v 1199.495n 0.0v 1199.505n 0.0v 1209.495n 0.0v 1209.505n 0.0v 1219.495n 0.0v 1219.505n 0.0v 1229.495n 0.0v 1229.505n 0.0v 1239.495n 0.0v 1239.505n 0.0v 1249.495n 0.0v 1249.505n 0.0v 1259.495n 0.0v 1259.505n 1.8v 1269.495n 1.8v 1269.505n 1.8v 1279.495n 1.8v 1279.505n 1.8v 1289.495n 1.8v 1289.505n 1.8v 1299.495n 1.8v 1299.505n 1.8v 1309.495n 1.8v 1309.505n 1.8v 1319.495n 1.8v 1319.505n 1.8v 1329.495n 1.8v 1329.505n 1.8v 1339.495n 1.8v 1339.505n 1.8v 1349.495n 1.8v 1349.505n 1.8v 1359.495n 1.8v 1359.505n 1.8v 1369.495n 1.8v 1369.505n 0.0v 1379.495n 0.0v 1379.505n 0.0v 1389.495n 0.0v 1389.505n 0.0v 1399.495n 0.0v 1399.505n 0.0v 1409.495n 0.0v 1409.505n 0.0v 1419.495n 0.0v 1419.505n 0.0v 1429.495n 0.0v 1429.505n 0.0v 1439.495n 0.0v 1439.505n 0.0v 1449.495n 0.0v 1449.505n 0.0v 1459.495n 0.0v 1459.505n 0.0v 1469.495n 0.0v 1469.505n 0.0v 1479.495n 0.0v 1479.505n 1.8v 1489.495n 1.8v 1489.505n 1.8v 1499.495n 1.8v 1499.505n 1.8v 1509.495n 1.8v 1509.505n 1.8v 1519.495n 1.8v 1519.505n 1.8v 1529.495n 1.8v 1529.505n 1.8v 1539.495n 1.8v 1539.505n 1.8v 1549.495n 1.8v 1549.505n 1.8v 1559.495n 1.8v 1559.505n 1.8v 1569.495n 1.8v 1569.505n 1.8v 1579.495n 1.8v 1579.505n 0.0v 1589.495n 0.0v 1589.505n 1.8v 1599.495n 1.8v 1599.505n 1.8v 1609.495n 1.8v 1609.505n 1.8v 1619.495n 1.8v 1619.505n 0.0v 1629.495n 0.0v 1629.505n 0.0v 1639.495n 0.0v 1639.505n 0.0v 1649.495n 0.0v 1649.505n 0.0v 1659.495n 0.0v 1659.505n 0.0v 1669.495n 0.0v 1669.505n 0.0v 1679.495n 0.0v 1679.505n 0.0v 1689.495n 0.0v 1689.505n 0.0v 1699.495n 0.0v 1699.505n 0.0v 1709.495n 0.0v 1709.505n 0.0v 1719.495n 0.0v 1719.505n 0.0v 1729.495n 0.0v 1729.505n 0.0v 1739.495n 0.0v 1739.505n 0.0v 1749.495n 0.0v 1749.505n 0.0v 1759.495n 0.0v 1759.505n 0.0v 1769.495n 0.0v 1769.505n 0.0v 1779.495n 0.0v 1779.505n 0.0v 1789.495n 0.0v 1789.505n 0.0v 1799.495n 0.0v 1799.505n 0.0v 1809.495n 0.0v 1809.505n 0.0v 1819.495n 0.0v 1819.505n 0.0v 1829.495n 0.0v 1829.505n 0.0v 1839.495n 0.0v 1839.505n 0.0v 1849.495n 0.0v 1849.505n 0.0v 1859.495n 0.0v 1859.505n 1.8v 1869.495n 1.8v 1869.505n 1.8v 1879.495n 1.8v 1879.505n 1.8v 1889.495n 1.8v 1889.505n 1.8v 1899.495n 1.8v 1899.505n 1.8v 1909.495n 1.8v 1909.505n 1.8v 1919.495n 1.8v 1919.505n 1.8v 1929.495n 1.8v 1929.505n 1.8v 1939.495n 1.8v 1939.505n 1.8v 1949.495n 1.8v 1949.505n 1.8v 1959.495n 1.8v 1959.505n 1.8v 1969.495n 1.8v 1969.505n 1.8v 1979.495n 1.8v 1979.505n 1.8v 1989.495n 1.8v 1989.505n 1.8v 1999.495n 1.8v 1999.505n 1.8v 2009.495n 1.8v 2009.505n 1.8v 2019.495n 1.8v 2019.505n 1.8v 2029.495n 1.8v 2029.505n 0.0v 2039.495n 0.0v 2039.505n 0.0v 2049.495n 0.0v 2049.505n 0.0v )
* (time, data): [(0, 0), (10, 0), (20, 1), (30, 0), (40, 0), (50, 0), (60, 1), (70, 1), (80, 1), (90, 1), (100, 1), (110, 1), (120, 1), (130, 1), (140, 1), (150, 0), (160, 0), (170, 0), (180, 0), (190, 0), (200, 0), (210, 0), (220, 0), (230, 0), (240, 0), (250, 0), (260, 0), (270, 0), (280, 0), (290, 0), (300, 0), (310, 0), (320, 0), (330, 0), (340, 0), (350, 1), (360, 1), (370, 1), (380, 1), (390, 0), (400, 0), (410, 0), (420, 1), (430, 1), (440, 1), (450, 0), (460, 0), (470, 0), (480, 0), (490, 1), (500, 1), (510, 1), (520, 1), (530, 1), (540, 1), (550, 1), (560, 1), (570, 1), (580, 1), (590, 1), (600, 1), (610, 1), (620, 0), (630, 0), (640, 0), (650, 0), (660, 1), (670, 1), (680, 1), (690, 1), (700, 1), (710, 0), (720, 0), (730, 0), (740, 0), (750, 0), (760, 0), (770, 1), (780, 1), (790, 1), (800, 1), (810, 1), (820, 0), (830, 0), (840, 0), (850, 0), (860, 0), (870, 0), (880, 0), (890, 1), (900, 1), (910, 1), (920, 1), (930, 0), (940, 0), (950, 0), (960, 1), (970, 1), (980, 1), (990, 1), (1000, 1), (1010, 1), (1020, 1), (1030, 1), (1040, 1), (1050, 1), (1060, 1), (1070, 1), (1080, 0), (1090, 0), (1100, 0), (1110, 0), (1120, 0), (1130, 1), (1140, 1), (1150, 1), (1160, 1), (1170, 1), (1180, 1), (1190, 1), (1200, 1), (1210, 1), (1220, 1), (1230, 1), (1240, 1), (1250, 1), (1260, 1), (1270, 1), (1280, 0), (1290, 0), (1300, 0), (1310, 0), (1320, 0), (1330, 0), (1340, 0), (1350, 0), (1360, 0), (1370, 0), (1380, 0), (1390, 0), (1400, 0), (1410, 0), (1420, 0), (1430, 0), (1440, 0), (1450, 0), (1460, 0), (1470, 0), (1480, 0), (1490, 0), (1500, 1), (1510, 1), (1520, 1), (1530, 1), (1540, 1), (1550, 1), (1560, 1), (1570, 1), (1580, 1), (1590, 1), (1600, 1), (1610, 1), (1620, 0), (1630, 0), (1640, 0), (1650, 0), (1660, 0), (1670, 0), (1680, 0), (1690, 0), (1700, 0), (1710, 1), (1720, 1), (1730, 0), (1740, 0), (1750, 0), (1760, 0), (1770, 0), (1780, 0), (1790, 1), (1800, 1), (1810, 1), (1820, 1), (1830, 1), (1840, 1), (1850, 1), (1860, 0), (1870, 1), (1880, 0), (1890, 1), (1900, 1), (1910, 1), (1920, 1), (1930, 1), (1940, 1), (1950, 1), (1960, 1), (1970, 1), (1980, 1), (1990, 1), (2000, 1), (2010, 1), (2020, 1), (2030, 1), (2040, 1), (2050, 1)]
Vdin0_11  din0_11  0 PWL (0n 0.0v 9.495n 0.0v 9.505n 0.0v 19.495n 0.0v 19.505n 1.8v 29.495n 1.8v 29.505n 0.0v 39.495n 0.0v 39.505n 0.0v 49.495n 0.0v 49.505n 0.0v 59.495n 0.0v 59.505n 1.8v 69.495n 1.8v 69.505n 1.8v 79.495n 1.8v 79.505n 1.8v 89.495n 1.8v 89.505n 1.8v 99.495n 1.8v 99.505n 1.8v 109.495n 1.8v 109.505n 1.8v 119.495n 1.8v 119.505n 1.8v 129.495n 1.8v 129.505n 1.8v 139.495n 1.8v 139.505n 1.8v 149.495n 1.8v 149.505n 0.0v 159.495n 0.0v 159.505n 0.0v 169.495n 0.0v 169.505n 0.0v 179.495n 0.0v 179.505n 0.0v 189.495n 0.0v 189.505n 0.0v 199.495n 0.0v 199.505n 0.0v 209.495n 0.0v 209.505n 0.0v 219.495n 0.0v 219.505n 0.0v 229.495n 0.0v 229.505n 0.0v 239.495n 0.0v 239.505n 0.0v 249.495n 0.0v 249.505n 0.0v 259.495n 0.0v 259.505n 0.0v 269.495n 0.0v 269.505n 0.0v 279.495n 0.0v 279.505n 0.0v 289.495n 0.0v 289.505n 0.0v 299.495n 0.0v 299.505n 0.0v 309.495n 0.0v 309.505n 0.0v 319.495n 0.0v 319.505n 0.0v 329.495n 0.0v 329.505n 0.0v 339.495n 0.0v 339.505n 0.0v 349.495n 0.0v 349.505n 1.8v 359.495n 1.8v 359.505n 1.8v 369.495n 1.8v 369.505n 1.8v 379.495n 1.8v 379.505n 1.8v 389.495n 1.8v 389.505n 0.0v 399.495n 0.0v 399.505n 0.0v 409.495n 0.0v 409.505n 0.0v 419.495n 0.0v 419.505n 1.8v 429.495n 1.8v 429.505n 1.8v 439.495n 1.8v 439.505n 1.8v 449.495n 1.8v 449.505n 0.0v 459.495n 0.0v 459.505n 0.0v 469.495n 0.0v 469.505n 0.0v 479.495n 0.0v 479.505n 0.0v 489.495n 0.0v 489.505n 1.8v 499.495n 1.8v 499.505n 1.8v 509.495n 1.8v 509.505n 1.8v 519.495n 1.8v 519.505n 1.8v 529.495n 1.8v 529.505n 1.8v 539.495n 1.8v 539.505n 1.8v 549.495n 1.8v 549.505n 1.8v 559.495n 1.8v 559.505n 1.8v 569.495n 1.8v 569.505n 1.8v 579.495n 1.8v 579.505n 1.8v 589.495n 1.8v 589.505n 1.8v 599.495n 1.8v 599.505n 1.8v 609.495n 1.8v 609.505n 1.8v 619.495n 1.8v 619.505n 0.0v 629.495n 0.0v 629.505n 0.0v 639.495n 0.0v 639.505n 0.0v 649.495n 0.0v 649.505n 0.0v 659.495n 0.0v 659.505n 1.8v 669.495n 1.8v 669.505n 1.8v 679.495n 1.8v 679.505n 1.8v 689.495n 1.8v 689.505n 1.8v 699.495n 1.8v 699.505n 1.8v 709.495n 1.8v 709.505n 0.0v 719.495n 0.0v 719.505n 0.0v 729.495n 0.0v 729.505n 0.0v 739.495n 0.0v 739.505n 0.0v 749.495n 0.0v 749.505n 0.0v 759.495n 0.0v 759.505n 0.0v 769.495n 0.0v 769.505n 1.8v 779.495n 1.8v 779.505n 1.8v 789.495n 1.8v 789.505n 1.8v 799.495n 1.8v 799.505n 1.8v 809.495n 1.8v 809.505n 1.8v 819.495n 1.8v 819.505n 0.0v 829.495n 0.0v 829.505n 0.0v 839.495n 0.0v 839.505n 0.0v 849.495n 0.0v 849.505n 0.0v 859.495n 0.0v 859.505n 0.0v 869.495n 0.0v 869.505n 0.0v 879.495n 0.0v 879.505n 0.0v 889.495n 0.0v 889.505n 1.8v 899.495n 1.8v 899.505n 1.8v 909.495n 1.8v 909.505n 1.8v 919.495n 1.8v 919.505n 1.8v 929.495n 1.8v 929.505n 0.0v 939.495n 0.0v 939.505n 0.0v 949.495n 0.0v 949.505n 0.0v 959.495n 0.0v 959.505n 1.8v 969.495n 1.8v 969.505n 1.8v 979.495n 1.8v 979.505n 1.8v 989.495n 1.8v 989.505n 1.8v 999.495n 1.8v 999.505n 1.8v 1009.495n 1.8v 1009.505n 1.8v 1019.495n 1.8v 1019.505n 1.8v 1029.495n 1.8v 1029.505n 1.8v 1039.495n 1.8v 1039.505n 1.8v 1049.495n 1.8v 1049.505n 1.8v 1059.495n 1.8v 1059.505n 1.8v 1069.495n 1.8v 1069.505n 1.8v 1079.495n 1.8v 1079.505n 0.0v 1089.495n 0.0v 1089.505n 0.0v 1099.495n 0.0v 1099.505n 0.0v 1109.495n 0.0v 1109.505n 0.0v 1119.495n 0.0v 1119.505n 0.0v 1129.495n 0.0v 1129.505n 1.8v 1139.495n 1.8v 1139.505n 1.8v 1149.495n 1.8v 1149.505n 1.8v 1159.495n 1.8v 1159.505n 1.8v 1169.495n 1.8v 1169.505n 1.8v 1179.495n 1.8v 1179.505n 1.8v 1189.495n 1.8v 1189.505n 1.8v 1199.495n 1.8v 1199.505n 1.8v 1209.495n 1.8v 1209.505n 1.8v 1219.495n 1.8v 1219.505n 1.8v 1229.495n 1.8v 1229.505n 1.8v 1239.495n 1.8v 1239.505n 1.8v 1249.495n 1.8v 1249.505n 1.8v 1259.495n 1.8v 1259.505n 1.8v 1269.495n 1.8v 1269.505n 1.8v 1279.495n 1.8v 1279.505n 0.0v 1289.495n 0.0v 1289.505n 0.0v 1299.495n 0.0v 1299.505n 0.0v 1309.495n 0.0v 1309.505n 0.0v 1319.495n 0.0v 1319.505n 0.0v 1329.495n 0.0v 1329.505n 0.0v 1339.495n 0.0v 1339.505n 0.0v 1349.495n 0.0v 1349.505n 0.0v 1359.495n 0.0v 1359.505n 0.0v 1369.495n 0.0v 1369.505n 0.0v 1379.495n 0.0v 1379.505n 0.0v 1389.495n 0.0v 1389.505n 0.0v 1399.495n 0.0v 1399.505n 0.0v 1409.495n 0.0v 1409.505n 0.0v 1419.495n 0.0v 1419.505n 0.0v 1429.495n 0.0v 1429.505n 0.0v 1439.495n 0.0v 1439.505n 0.0v 1449.495n 0.0v 1449.505n 0.0v 1459.495n 0.0v 1459.505n 0.0v 1469.495n 0.0v 1469.505n 0.0v 1479.495n 0.0v 1479.505n 0.0v 1489.495n 0.0v 1489.505n 0.0v 1499.495n 0.0v 1499.505n 1.8v 1509.495n 1.8v 1509.505n 1.8v 1519.495n 1.8v 1519.505n 1.8v 1529.495n 1.8v 1529.505n 1.8v 1539.495n 1.8v 1539.505n 1.8v 1549.495n 1.8v 1549.505n 1.8v 1559.495n 1.8v 1559.505n 1.8v 1569.495n 1.8v 1569.505n 1.8v 1579.495n 1.8v 1579.505n 1.8v 1589.495n 1.8v 1589.505n 1.8v 1599.495n 1.8v 1599.505n 1.8v 1609.495n 1.8v 1609.505n 1.8v 1619.495n 1.8v 1619.505n 0.0v 1629.495n 0.0v 1629.505n 0.0v 1639.495n 0.0v 1639.505n 0.0v 1649.495n 0.0v 1649.505n 0.0v 1659.495n 0.0v 1659.505n 0.0v 1669.495n 0.0v 1669.505n 0.0v 1679.495n 0.0v 1679.505n 0.0v 1689.495n 0.0v 1689.505n 0.0v 1699.495n 0.0v 1699.505n 0.0v 1709.495n 0.0v 1709.505n 1.8v 1719.495n 1.8v 1719.505n 1.8v 1729.495n 1.8v 1729.505n 0.0v 1739.495n 0.0v 1739.505n 0.0v 1749.495n 0.0v 1749.505n 0.0v 1759.495n 0.0v 1759.505n 0.0v 1769.495n 0.0v 1769.505n 0.0v 1779.495n 0.0v 1779.505n 0.0v 1789.495n 0.0v 1789.505n 1.8v 1799.495n 1.8v 1799.505n 1.8v 1809.495n 1.8v 1809.505n 1.8v 1819.495n 1.8v 1819.505n 1.8v 1829.495n 1.8v 1829.505n 1.8v 1839.495n 1.8v 1839.505n 1.8v 1849.495n 1.8v 1849.505n 1.8v 1859.495n 1.8v 1859.505n 0.0v 1869.495n 0.0v 1869.505n 1.8v 1879.495n 1.8v 1879.505n 0.0v 1889.495n 0.0v 1889.505n 1.8v 1899.495n 1.8v 1899.505n 1.8v 1909.495n 1.8v 1909.505n 1.8v 1919.495n 1.8v 1919.505n 1.8v 1929.495n 1.8v 1929.505n 1.8v 1939.495n 1.8v 1939.505n 1.8v 1949.495n 1.8v 1949.505n 1.8v 1959.495n 1.8v 1959.505n 1.8v 1969.495n 1.8v 1969.505n 1.8v 1979.495n 1.8v 1979.505n 1.8v 1989.495n 1.8v 1989.505n 1.8v 1999.495n 1.8v 1999.505n 1.8v 2009.495n 1.8v 2009.505n 1.8v 2019.495n 1.8v 2019.505n 1.8v 2029.495n 1.8v 2029.505n 1.8v 2039.495n 1.8v 2039.505n 1.8v 2049.495n 1.8v 2049.505n 1.8v )
* (time, data): [(0, 0), (10, 0), (20, 0), (30, 0), (40, 0), (50, 0), (60, 1), (70, 1), (80, 1), (90, 1), (100, 1), (110, 1), (120, 1), (130, 1), (140, 1), (150, 0), (160, 0), (170, 0), (180, 0), (190, 0), (200, 0), (210, 0), (220, 0), (230, 0), (240, 0), (250, 0), (260, 1), (270, 1), (280, 1), (290, 1), (300, 1), (310, 1), (320, 1), (330, 1), (340, 1), (350, 1), (360, 1), (370, 1), (380, 1), (390, 1), (400, 1), (410, 1), (420, 0), (430, 0), (440, 0), (450, 1), (460, 1), (470, 0), (480, 0), (490, 0), (500, 0), (510, 0), (520, 0), (530, 0), (540, 0), (550, 0), (560, 0), (570, 0), (580, 0), (590, 0), (600, 0), (610, 0), (620, 1), (630, 1), (640, 1), (650, 1), (660, 1), (670, 0), (680, 0), (690, 0), (700, 0), (710, 0), (720, 0), (730, 0), (740, 0), (750, 0), (760, 0), (770, 0), (780, 0), (790, 0), (800, 0), (810, 0), (820, 1), (830, 1), (840, 1), (850, 1), (860, 1), (870, 1), (880, 1), (890, 1), (900, 1), (910, 1), (920, 1), (930, 0), (940, 0), (950, 0), (960, 1), (970, 1), (980, 1), (990, 1), (1000, 1), (1010, 1), (1020, 1), (1030, 1), (1040, 1), (1050, 1), (1060, 1), (1070, 1), (1080, 1), (1090, 1), (1100, 1), (1110, 1), (1120, 1), (1130, 1), (1140, 1), (1150, 1), (1160, 1), (1170, 1), (1180, 1), (1190, 1), (1200, 1), (1210, 1), (1220, 1), (1230, 1), (1240, 1), (1250, 1), (1260, 1), (1270, 1), (1280, 0), (1290, 0), (1300, 0), (1310, 0), (1320, 0), (1330, 0), (1340, 0), (1350, 0), (1360, 0), (1370, 1), (1380, 1), (1390, 1), (1400, 0), (1410, 0), (1420, 0), (1430, 0), (1440, 0), (1450, 0), (1460, 0), (1470, 0), (1480, 1), (1490, 1), (1500, 0), (1510, 0), (1520, 0), (1530, 0), (1540, 0), (1550, 0), (1560, 0), (1570, 1), (1580, 0), (1590, 0), (1600, 0), (1610, 0), (1620, 0), (1630, 0), (1640, 0), (1650, 0), (1660, 0), (1670, 0), (1680, 0), (1690, 1), (1700, 1), (1710, 0), (1720, 0), (1730, 1), (1740, 0), (1750, 0), (1760, 0), (1770, 0), (1780, 0), (1790, 1), (1800, 1), (1810, 1), (1820, 1), (1830, 1), (1840, 1), (1850, 1), (1860, 1), (1870, 1), (1880, 0), (1890, 1), (1900, 1), (1910, 1), (1920, 1), (1930, 1), (1940, 1), (1950, 1), (1960, 1), (1970, 1), (1980, 1), (1990, 1), (2000, 1), (2010, 1), (2020, 1), (2030, 0), (2040, 0), (2050, 0)]
Vdin0_12  din0_12  0 PWL (0n 0.0v 9.495n 0.0v 9.505n 0.0v 19.495n 0.0v 19.505n 0.0v 29.495n 0.0v 29.505n 0.0v 39.495n 0.0v 39.505n 0.0v 49.495n 0.0v 49.505n 0.0v 59.495n 0.0v 59.505n 1.8v 69.495n 1.8v 69.505n 1.8v 79.495n 1.8v 79.505n 1.8v 89.495n 1.8v 89.505n 1.8v 99.495n 1.8v 99.505n 1.8v 109.495n 1.8v 109.505n 1.8v 119.495n 1.8v 119.505n 1.8v 129.495n 1.8v 129.505n 1.8v 139.495n 1.8v 139.505n 1.8v 149.495n 1.8v 149.505n 0.0v 159.495n 0.0v 159.505n 0.0v 169.495n 0.0v 169.505n 0.0v 179.495n 0.0v 179.505n 0.0v 189.495n 0.0v 189.505n 0.0v 199.495n 0.0v 199.505n 0.0v 209.495n 0.0v 209.505n 0.0v 219.495n 0.0v 219.505n 0.0v 229.495n 0.0v 229.505n 0.0v 239.495n 0.0v 239.505n 0.0v 249.495n 0.0v 249.505n 0.0v 259.495n 0.0v 259.505n 1.8v 269.495n 1.8v 269.505n 1.8v 279.495n 1.8v 279.505n 1.8v 289.495n 1.8v 289.505n 1.8v 299.495n 1.8v 299.505n 1.8v 309.495n 1.8v 309.505n 1.8v 319.495n 1.8v 319.505n 1.8v 329.495n 1.8v 329.505n 1.8v 339.495n 1.8v 339.505n 1.8v 349.495n 1.8v 349.505n 1.8v 359.495n 1.8v 359.505n 1.8v 369.495n 1.8v 369.505n 1.8v 379.495n 1.8v 379.505n 1.8v 389.495n 1.8v 389.505n 1.8v 399.495n 1.8v 399.505n 1.8v 409.495n 1.8v 409.505n 1.8v 419.495n 1.8v 419.505n 0.0v 429.495n 0.0v 429.505n 0.0v 439.495n 0.0v 439.505n 0.0v 449.495n 0.0v 449.505n 1.8v 459.495n 1.8v 459.505n 1.8v 469.495n 1.8v 469.505n 0.0v 479.495n 0.0v 479.505n 0.0v 489.495n 0.0v 489.505n 0.0v 499.495n 0.0v 499.505n 0.0v 509.495n 0.0v 509.505n 0.0v 519.495n 0.0v 519.505n 0.0v 529.495n 0.0v 529.505n 0.0v 539.495n 0.0v 539.505n 0.0v 549.495n 0.0v 549.505n 0.0v 559.495n 0.0v 559.505n 0.0v 569.495n 0.0v 569.505n 0.0v 579.495n 0.0v 579.505n 0.0v 589.495n 0.0v 589.505n 0.0v 599.495n 0.0v 599.505n 0.0v 609.495n 0.0v 609.505n 0.0v 619.495n 0.0v 619.505n 1.8v 629.495n 1.8v 629.505n 1.8v 639.495n 1.8v 639.505n 1.8v 649.495n 1.8v 649.505n 1.8v 659.495n 1.8v 659.505n 1.8v 669.495n 1.8v 669.505n 0.0v 679.495n 0.0v 679.505n 0.0v 689.495n 0.0v 689.505n 0.0v 699.495n 0.0v 699.505n 0.0v 709.495n 0.0v 709.505n 0.0v 719.495n 0.0v 719.505n 0.0v 729.495n 0.0v 729.505n 0.0v 739.495n 0.0v 739.505n 0.0v 749.495n 0.0v 749.505n 0.0v 759.495n 0.0v 759.505n 0.0v 769.495n 0.0v 769.505n 0.0v 779.495n 0.0v 779.505n 0.0v 789.495n 0.0v 789.505n 0.0v 799.495n 0.0v 799.505n 0.0v 809.495n 0.0v 809.505n 0.0v 819.495n 0.0v 819.505n 1.8v 829.495n 1.8v 829.505n 1.8v 839.495n 1.8v 839.505n 1.8v 849.495n 1.8v 849.505n 1.8v 859.495n 1.8v 859.505n 1.8v 869.495n 1.8v 869.505n 1.8v 879.495n 1.8v 879.505n 1.8v 889.495n 1.8v 889.505n 1.8v 899.495n 1.8v 899.505n 1.8v 909.495n 1.8v 909.505n 1.8v 919.495n 1.8v 919.505n 1.8v 929.495n 1.8v 929.505n 0.0v 939.495n 0.0v 939.505n 0.0v 949.495n 0.0v 949.505n 0.0v 959.495n 0.0v 959.505n 1.8v 969.495n 1.8v 969.505n 1.8v 979.495n 1.8v 979.505n 1.8v 989.495n 1.8v 989.505n 1.8v 999.495n 1.8v 999.505n 1.8v 1009.495n 1.8v 1009.505n 1.8v 1019.495n 1.8v 1019.505n 1.8v 1029.495n 1.8v 1029.505n 1.8v 1039.495n 1.8v 1039.505n 1.8v 1049.495n 1.8v 1049.505n 1.8v 1059.495n 1.8v 1059.505n 1.8v 1069.495n 1.8v 1069.505n 1.8v 1079.495n 1.8v 1079.505n 1.8v 1089.495n 1.8v 1089.505n 1.8v 1099.495n 1.8v 1099.505n 1.8v 1109.495n 1.8v 1109.505n 1.8v 1119.495n 1.8v 1119.505n 1.8v 1129.495n 1.8v 1129.505n 1.8v 1139.495n 1.8v 1139.505n 1.8v 1149.495n 1.8v 1149.505n 1.8v 1159.495n 1.8v 1159.505n 1.8v 1169.495n 1.8v 1169.505n 1.8v 1179.495n 1.8v 1179.505n 1.8v 1189.495n 1.8v 1189.505n 1.8v 1199.495n 1.8v 1199.505n 1.8v 1209.495n 1.8v 1209.505n 1.8v 1219.495n 1.8v 1219.505n 1.8v 1229.495n 1.8v 1229.505n 1.8v 1239.495n 1.8v 1239.505n 1.8v 1249.495n 1.8v 1249.505n 1.8v 1259.495n 1.8v 1259.505n 1.8v 1269.495n 1.8v 1269.505n 1.8v 1279.495n 1.8v 1279.505n 0.0v 1289.495n 0.0v 1289.505n 0.0v 1299.495n 0.0v 1299.505n 0.0v 1309.495n 0.0v 1309.505n 0.0v 1319.495n 0.0v 1319.505n 0.0v 1329.495n 0.0v 1329.505n 0.0v 1339.495n 0.0v 1339.505n 0.0v 1349.495n 0.0v 1349.505n 0.0v 1359.495n 0.0v 1359.505n 0.0v 1369.495n 0.0v 1369.505n 1.8v 1379.495n 1.8v 1379.505n 1.8v 1389.495n 1.8v 1389.505n 1.8v 1399.495n 1.8v 1399.505n 0.0v 1409.495n 0.0v 1409.505n 0.0v 1419.495n 0.0v 1419.505n 0.0v 1429.495n 0.0v 1429.505n 0.0v 1439.495n 0.0v 1439.505n 0.0v 1449.495n 0.0v 1449.505n 0.0v 1459.495n 0.0v 1459.505n 0.0v 1469.495n 0.0v 1469.505n 0.0v 1479.495n 0.0v 1479.505n 1.8v 1489.495n 1.8v 1489.505n 1.8v 1499.495n 1.8v 1499.505n 0.0v 1509.495n 0.0v 1509.505n 0.0v 1519.495n 0.0v 1519.505n 0.0v 1529.495n 0.0v 1529.505n 0.0v 1539.495n 0.0v 1539.505n 0.0v 1549.495n 0.0v 1549.505n 0.0v 1559.495n 0.0v 1559.505n 0.0v 1569.495n 0.0v 1569.505n 1.8v 1579.495n 1.8v 1579.505n 0.0v 1589.495n 0.0v 1589.505n 0.0v 1599.495n 0.0v 1599.505n 0.0v 1609.495n 0.0v 1609.505n 0.0v 1619.495n 0.0v 1619.505n 0.0v 1629.495n 0.0v 1629.505n 0.0v 1639.495n 0.0v 1639.505n 0.0v 1649.495n 0.0v 1649.505n 0.0v 1659.495n 0.0v 1659.505n 0.0v 1669.495n 0.0v 1669.505n 0.0v 1679.495n 0.0v 1679.505n 0.0v 1689.495n 0.0v 1689.505n 1.8v 1699.495n 1.8v 1699.505n 1.8v 1709.495n 1.8v 1709.505n 0.0v 1719.495n 0.0v 1719.505n 0.0v 1729.495n 0.0v 1729.505n 1.8v 1739.495n 1.8v 1739.505n 0.0v 1749.495n 0.0v 1749.505n 0.0v 1759.495n 0.0v 1759.505n 0.0v 1769.495n 0.0v 1769.505n 0.0v 1779.495n 0.0v 1779.505n 0.0v 1789.495n 0.0v 1789.505n 1.8v 1799.495n 1.8v 1799.505n 1.8v 1809.495n 1.8v 1809.505n 1.8v 1819.495n 1.8v 1819.505n 1.8v 1829.495n 1.8v 1829.505n 1.8v 1839.495n 1.8v 1839.505n 1.8v 1849.495n 1.8v 1849.505n 1.8v 1859.495n 1.8v 1859.505n 1.8v 1869.495n 1.8v 1869.505n 1.8v 1879.495n 1.8v 1879.505n 0.0v 1889.495n 0.0v 1889.505n 1.8v 1899.495n 1.8v 1899.505n 1.8v 1909.495n 1.8v 1909.505n 1.8v 1919.495n 1.8v 1919.505n 1.8v 1929.495n 1.8v 1929.505n 1.8v 1939.495n 1.8v 1939.505n 1.8v 1949.495n 1.8v 1949.505n 1.8v 1959.495n 1.8v 1959.505n 1.8v 1969.495n 1.8v 1969.505n 1.8v 1979.495n 1.8v 1979.505n 1.8v 1989.495n 1.8v 1989.505n 1.8v 1999.495n 1.8v 1999.505n 1.8v 2009.495n 1.8v 2009.505n 1.8v 2019.495n 1.8v 2019.505n 1.8v 2029.495n 1.8v 2029.505n 0.0v 2039.495n 0.0v 2039.505n 0.0v 2049.495n 0.0v 2049.505n 0.0v )
* (time, data): [(0, 0), (10, 0), (20, 0), (30, 1), (40, 1), (50, 1), (60, 1), (70, 1), (80, 1), (90, 1), (100, 1), (110, 1), (120, 1), (130, 1), (140, 1), (150, 1), (160, 1), (170, 1), (180, 1), (190, 1), (200, 1), (210, 1), (220, 1), (230, 1), (240, 1), (250, 1), (260, 1), (270, 1), (280, 1), (290, 1), (300, 1), (310, 1), (320, 1), (330, 1), (340, 1), (350, 1), (360, 1), (370, 1), (380, 1), (390, 1), (400, 1), (410, 1), (420, 1), (430, 1), (440, 1), (450, 1), (460, 1), (470, 1), (480, 1), (490, 1), (500, 1), (510, 1), (520, 1), (530, 1), (540, 1), (550, 1), (560, 1), (570, 1), (580, 1), (590, 1), (600, 1), (610, 1), (620, 1), (630, 1), (640, 1), (650, 1), (660, 0), (670, 1), (680, 1), (690, 1), (700, 1), (710, 0), (720, 0), (730, 0), (740, 0), (750, 0), (760, 0), (770, 1), (780, 1), (790, 1), (800, 1), (810, 1), (820, 0), (830, 0), (840, 0), (850, 0), (860, 0), (870, 0), (880, 0), (890, 1), (900, 1), (910, 1), (920, 1), (930, 0), (940, 0), (950, 0), (960, 1), (970, 1), (980, 1), (990, 1), (1000, 1), (1010, 1), (1020, 1), (1030, 1), (1040, 1), (1050, 1), (1060, 1), (1070, 1), (1080, 0), (1090, 0), (1100, 0), (1110, 0), (1120, 0), (1130, 1), (1140, 1), (1150, 1), (1160, 1), (1170, 1), (1180, 1), (1190, 1), (1200, 1), (1210, 1), (1220, 1), (1230, 1), (1240, 1), (1250, 1), (1260, 1), (1270, 1), (1280, 1), (1290, 1), (1300, 1), (1310, 1), (1320, 1), (1330, 1), (1340, 1), (1350, 1), (1360, 1), (1370, 0), (1380, 0), (1390, 0), (1400, 1), (1410, 1), (1420, 1), (1430, 1), (1440, 1), (1450, 1), (1460, 1), (1470, 1), (1480, 1), (1490, 1), (1500, 0), (1510, 0), (1520, 0), (1530, 0), (1540, 0), (1550, 0), (1560, 0), (1570, 0), (1580, 0), (1590, 0), (1600, 0), (1610, 0), (1620, 1), (1630, 1), (1640, 1), (1650, 1), (1660, 1), (1670, 1), (1680, 1), (1690, 0), (1700, 0), (1710, 1), (1720, 1), (1730, 1), (1740, 1), (1750, 1), (1760, 1), (1770, 1), (1780, 1), (1790, 1), (1800, 1), (1810, 1), (1820, 1), (1830, 1), (1840, 1), (1850, 0), (1860, 0), (1870, 1), (1880, 0), (1890, 0), (1900, 0), (1910, 0), (1920, 0), (1930, 0), (1940, 0), (1950, 0), (1960, 0), (1970, 0), (1980, 0), (1990, 0), (2000, 0), (2010, 0), (2020, 0), (2030, 1), (2040, 1), (2050, 1)]
Vdin0_13  din0_13  0 PWL (0n 0.0v 9.495n 0.0v 9.505n 0.0v 19.495n 0.0v 19.505n 0.0v 29.495n 0.0v 29.505n 1.8v 39.495n 1.8v 39.505n 1.8v 49.495n 1.8v 49.505n 1.8v 59.495n 1.8v 59.505n 1.8v 69.495n 1.8v 69.505n 1.8v 79.495n 1.8v 79.505n 1.8v 89.495n 1.8v 89.505n 1.8v 99.495n 1.8v 99.505n 1.8v 109.495n 1.8v 109.505n 1.8v 119.495n 1.8v 119.505n 1.8v 129.495n 1.8v 129.505n 1.8v 139.495n 1.8v 139.505n 1.8v 149.495n 1.8v 149.505n 1.8v 159.495n 1.8v 159.505n 1.8v 169.495n 1.8v 169.505n 1.8v 179.495n 1.8v 179.505n 1.8v 189.495n 1.8v 189.505n 1.8v 199.495n 1.8v 199.505n 1.8v 209.495n 1.8v 209.505n 1.8v 219.495n 1.8v 219.505n 1.8v 229.495n 1.8v 229.505n 1.8v 239.495n 1.8v 239.505n 1.8v 249.495n 1.8v 249.505n 1.8v 259.495n 1.8v 259.505n 1.8v 269.495n 1.8v 269.505n 1.8v 279.495n 1.8v 279.505n 1.8v 289.495n 1.8v 289.505n 1.8v 299.495n 1.8v 299.505n 1.8v 309.495n 1.8v 309.505n 1.8v 319.495n 1.8v 319.505n 1.8v 329.495n 1.8v 329.505n 1.8v 339.495n 1.8v 339.505n 1.8v 349.495n 1.8v 349.505n 1.8v 359.495n 1.8v 359.505n 1.8v 369.495n 1.8v 369.505n 1.8v 379.495n 1.8v 379.505n 1.8v 389.495n 1.8v 389.505n 1.8v 399.495n 1.8v 399.505n 1.8v 409.495n 1.8v 409.505n 1.8v 419.495n 1.8v 419.505n 1.8v 429.495n 1.8v 429.505n 1.8v 439.495n 1.8v 439.505n 1.8v 449.495n 1.8v 449.505n 1.8v 459.495n 1.8v 459.505n 1.8v 469.495n 1.8v 469.505n 1.8v 479.495n 1.8v 479.505n 1.8v 489.495n 1.8v 489.505n 1.8v 499.495n 1.8v 499.505n 1.8v 509.495n 1.8v 509.505n 1.8v 519.495n 1.8v 519.505n 1.8v 529.495n 1.8v 529.505n 1.8v 539.495n 1.8v 539.505n 1.8v 549.495n 1.8v 549.505n 1.8v 559.495n 1.8v 559.505n 1.8v 569.495n 1.8v 569.505n 1.8v 579.495n 1.8v 579.505n 1.8v 589.495n 1.8v 589.505n 1.8v 599.495n 1.8v 599.505n 1.8v 609.495n 1.8v 609.505n 1.8v 619.495n 1.8v 619.505n 1.8v 629.495n 1.8v 629.505n 1.8v 639.495n 1.8v 639.505n 1.8v 649.495n 1.8v 649.505n 1.8v 659.495n 1.8v 659.505n 0.0v 669.495n 0.0v 669.505n 1.8v 679.495n 1.8v 679.505n 1.8v 689.495n 1.8v 689.505n 1.8v 699.495n 1.8v 699.505n 1.8v 709.495n 1.8v 709.505n 0.0v 719.495n 0.0v 719.505n 0.0v 729.495n 0.0v 729.505n 0.0v 739.495n 0.0v 739.505n 0.0v 749.495n 0.0v 749.505n 0.0v 759.495n 0.0v 759.505n 0.0v 769.495n 0.0v 769.505n 1.8v 779.495n 1.8v 779.505n 1.8v 789.495n 1.8v 789.505n 1.8v 799.495n 1.8v 799.505n 1.8v 809.495n 1.8v 809.505n 1.8v 819.495n 1.8v 819.505n 0.0v 829.495n 0.0v 829.505n 0.0v 839.495n 0.0v 839.505n 0.0v 849.495n 0.0v 849.505n 0.0v 859.495n 0.0v 859.505n 0.0v 869.495n 0.0v 869.505n 0.0v 879.495n 0.0v 879.505n 0.0v 889.495n 0.0v 889.505n 1.8v 899.495n 1.8v 899.505n 1.8v 909.495n 1.8v 909.505n 1.8v 919.495n 1.8v 919.505n 1.8v 929.495n 1.8v 929.505n 0.0v 939.495n 0.0v 939.505n 0.0v 949.495n 0.0v 949.505n 0.0v 959.495n 0.0v 959.505n 1.8v 969.495n 1.8v 969.505n 1.8v 979.495n 1.8v 979.505n 1.8v 989.495n 1.8v 989.505n 1.8v 999.495n 1.8v 999.505n 1.8v 1009.495n 1.8v 1009.505n 1.8v 1019.495n 1.8v 1019.505n 1.8v 1029.495n 1.8v 1029.505n 1.8v 1039.495n 1.8v 1039.505n 1.8v 1049.495n 1.8v 1049.505n 1.8v 1059.495n 1.8v 1059.505n 1.8v 1069.495n 1.8v 1069.505n 1.8v 1079.495n 1.8v 1079.505n 0.0v 1089.495n 0.0v 1089.505n 0.0v 1099.495n 0.0v 1099.505n 0.0v 1109.495n 0.0v 1109.505n 0.0v 1119.495n 0.0v 1119.505n 0.0v 1129.495n 0.0v 1129.505n 1.8v 1139.495n 1.8v 1139.505n 1.8v 1149.495n 1.8v 1149.505n 1.8v 1159.495n 1.8v 1159.505n 1.8v 1169.495n 1.8v 1169.505n 1.8v 1179.495n 1.8v 1179.505n 1.8v 1189.495n 1.8v 1189.505n 1.8v 1199.495n 1.8v 1199.505n 1.8v 1209.495n 1.8v 1209.505n 1.8v 1219.495n 1.8v 1219.505n 1.8v 1229.495n 1.8v 1229.505n 1.8v 1239.495n 1.8v 1239.505n 1.8v 1249.495n 1.8v 1249.505n 1.8v 1259.495n 1.8v 1259.505n 1.8v 1269.495n 1.8v 1269.505n 1.8v 1279.495n 1.8v 1279.505n 1.8v 1289.495n 1.8v 1289.505n 1.8v 1299.495n 1.8v 1299.505n 1.8v 1309.495n 1.8v 1309.505n 1.8v 1319.495n 1.8v 1319.505n 1.8v 1329.495n 1.8v 1329.505n 1.8v 1339.495n 1.8v 1339.505n 1.8v 1349.495n 1.8v 1349.505n 1.8v 1359.495n 1.8v 1359.505n 1.8v 1369.495n 1.8v 1369.505n 0.0v 1379.495n 0.0v 1379.505n 0.0v 1389.495n 0.0v 1389.505n 0.0v 1399.495n 0.0v 1399.505n 1.8v 1409.495n 1.8v 1409.505n 1.8v 1419.495n 1.8v 1419.505n 1.8v 1429.495n 1.8v 1429.505n 1.8v 1439.495n 1.8v 1439.505n 1.8v 1449.495n 1.8v 1449.505n 1.8v 1459.495n 1.8v 1459.505n 1.8v 1469.495n 1.8v 1469.505n 1.8v 1479.495n 1.8v 1479.505n 1.8v 1489.495n 1.8v 1489.505n 1.8v 1499.495n 1.8v 1499.505n 0.0v 1509.495n 0.0v 1509.505n 0.0v 1519.495n 0.0v 1519.505n 0.0v 1529.495n 0.0v 1529.505n 0.0v 1539.495n 0.0v 1539.505n 0.0v 1549.495n 0.0v 1549.505n 0.0v 1559.495n 0.0v 1559.505n 0.0v 1569.495n 0.0v 1569.505n 0.0v 1579.495n 0.0v 1579.505n 0.0v 1589.495n 0.0v 1589.505n 0.0v 1599.495n 0.0v 1599.505n 0.0v 1609.495n 0.0v 1609.505n 0.0v 1619.495n 0.0v 1619.505n 1.8v 1629.495n 1.8v 1629.505n 1.8v 1639.495n 1.8v 1639.505n 1.8v 1649.495n 1.8v 1649.505n 1.8v 1659.495n 1.8v 1659.505n 1.8v 1669.495n 1.8v 1669.505n 1.8v 1679.495n 1.8v 1679.505n 1.8v 1689.495n 1.8v 1689.505n 0.0v 1699.495n 0.0v 1699.505n 0.0v 1709.495n 0.0v 1709.505n 1.8v 1719.495n 1.8v 1719.505n 1.8v 1729.495n 1.8v 1729.505n 1.8v 1739.495n 1.8v 1739.505n 1.8v 1749.495n 1.8v 1749.505n 1.8v 1759.495n 1.8v 1759.505n 1.8v 1769.495n 1.8v 1769.505n 1.8v 1779.495n 1.8v 1779.505n 1.8v 1789.495n 1.8v 1789.505n 1.8v 1799.495n 1.8v 1799.505n 1.8v 1809.495n 1.8v 1809.505n 1.8v 1819.495n 1.8v 1819.505n 1.8v 1829.495n 1.8v 1829.505n 1.8v 1839.495n 1.8v 1839.505n 1.8v 1849.495n 1.8v 1849.505n 0.0v 1859.495n 0.0v 1859.505n 0.0v 1869.495n 0.0v 1869.505n 1.8v 1879.495n 1.8v 1879.505n 0.0v 1889.495n 0.0v 1889.505n 0.0v 1899.495n 0.0v 1899.505n 0.0v 1909.495n 0.0v 1909.505n 0.0v 1919.495n 0.0v 1919.505n 0.0v 1929.495n 0.0v 1929.505n 0.0v 1939.495n 0.0v 1939.505n 0.0v 1949.495n 0.0v 1949.505n 0.0v 1959.495n 0.0v 1959.505n 0.0v 1969.495n 0.0v 1969.505n 0.0v 1979.495n 0.0v 1979.505n 0.0v 1989.495n 0.0v 1989.505n 0.0v 1999.495n 0.0v 1999.505n 0.0v 2009.495n 0.0v 2009.505n 0.0v 2019.495n 0.0v 2019.505n 0.0v 2029.495n 0.0v 2029.505n 1.8v 2039.495n 1.8v 2039.505n 1.8v 2049.495n 1.8v 2049.505n 1.8v )
* (time, data): [(0, 0), (10, 0), (20, 1), (30, 1), (40, 1), (50, 1), (60, 0), (70, 0), (80, 0), (90, 0), (100, 0), (110, 0), (120, 0), (130, 0), (140, 0), (150, 1), (160, 1), (170, 1), (180, 1), (190, 1), (200, 1), (210, 1), (220, 1), (230, 1), (240, 1), (250, 1), (260, 0), (270, 0), (280, 0), (290, 0), (300, 0), (310, 0), (320, 0), (330, 0), (340, 0), (350, 1), (360, 1), (370, 1), (380, 1), (390, 0), (400, 1), (410, 1), (420, 1), (430, 1), (440, 1), (450, 0), (460, 0), (470, 1), (480, 1), (490, 1), (500, 1), (510, 1), (520, 1), (530, 1), (540, 1), (550, 1), (560, 1), (570, 1), (580, 1), (590, 1), (600, 1), (610, 1), (620, 0), (630, 0), (640, 0), (650, 0), (660, 1), (670, 0), (680, 0), (690, 0), (700, 0), (710, 1), (720, 1), (730, 1), (740, 1), (750, 1), (760, 1), (770, 1), (780, 1), (790, 1), (800, 1), (810, 1), (820, 0), (830, 0), (840, 1), (850, 1), (860, 1), (870, 1), (880, 1), (890, 1), (900, 1), (910, 1), (920, 1), (930, 1), (940, 1), (950, 1), (960, 1), (970, 1), (980, 1), (990, 1), (1000, 1), (1010, 1), (1020, 1), (1030, 1), (1040, 1), (1050, 1), (1060, 1), (1070, 1), (1080, 0), (1090, 0), (1100, 0), (1110, 0), (1120, 0), (1130, 1), (1140, 1), (1150, 1), (1160, 1), (1170, 1), (1180, 1), (1190, 1), (1200, 1), (1210, 1), (1220, 1), (1230, 1), (1240, 1), (1250, 1), (1260, 0), (1270, 0), (1280, 1), (1290, 1), (1300, 1), (1310, 1), (1320, 1), (1330, 1), (1340, 1), (1350, 1), (1360, 1), (1370, 1), (1380, 1), (1390, 1), (1400, 0), (1410, 0), (1420, 0), (1430, 0), (1440, 0), (1450, 0), (1460, 0), (1470, 0), (1480, 1), (1490, 1), (1500, 0), (1510, 0), (1520, 0), (1530, 0), (1540, 0), (1550, 0), (1560, 0), (1570, 0), (1580, 1), (1590, 0), (1600, 0), (1610, 0), (1620, 1), (1630, 1), (1640, 1), (1650, 1), (1660, 1), (1670, 1), (1680, 1), (1690, 1), (1700, 1), (1710, 0), (1720, 0), (1730, 1), (1740, 1), (1750, 1), (1760, 1), (1770, 1), (1780, 1), (1790, 0), (1800, 0), (1810, 0), (1820, 0), (1830, 0), (1840, 0), (1850, 1), (1860, 1), (1870, 0), (1880, 0), (1890, 0), (1900, 0), (1910, 0), (1920, 0), (1930, 0), (1940, 0), (1950, 0), (1960, 0), (1970, 0), (1980, 0), (1990, 0), (2000, 0), (2010, 0), (2020, 0), (2030, 1), (2040, 1), (2050, 1)]
Vdin0_14  din0_14  0 PWL (0n 0.0v 9.495n 0.0v 9.505n 0.0v 19.495n 0.0v 19.505n 1.8v 29.495n 1.8v 29.505n 1.8v 39.495n 1.8v 39.505n 1.8v 49.495n 1.8v 49.505n 1.8v 59.495n 1.8v 59.505n 0.0v 69.495n 0.0v 69.505n 0.0v 79.495n 0.0v 79.505n 0.0v 89.495n 0.0v 89.505n 0.0v 99.495n 0.0v 99.505n 0.0v 109.495n 0.0v 109.505n 0.0v 119.495n 0.0v 119.505n 0.0v 129.495n 0.0v 129.505n 0.0v 139.495n 0.0v 139.505n 0.0v 149.495n 0.0v 149.505n 1.8v 159.495n 1.8v 159.505n 1.8v 169.495n 1.8v 169.505n 1.8v 179.495n 1.8v 179.505n 1.8v 189.495n 1.8v 189.505n 1.8v 199.495n 1.8v 199.505n 1.8v 209.495n 1.8v 209.505n 1.8v 219.495n 1.8v 219.505n 1.8v 229.495n 1.8v 229.505n 1.8v 239.495n 1.8v 239.505n 1.8v 249.495n 1.8v 249.505n 1.8v 259.495n 1.8v 259.505n 0.0v 269.495n 0.0v 269.505n 0.0v 279.495n 0.0v 279.505n 0.0v 289.495n 0.0v 289.505n 0.0v 299.495n 0.0v 299.505n 0.0v 309.495n 0.0v 309.505n 0.0v 319.495n 0.0v 319.505n 0.0v 329.495n 0.0v 329.505n 0.0v 339.495n 0.0v 339.505n 0.0v 349.495n 0.0v 349.505n 1.8v 359.495n 1.8v 359.505n 1.8v 369.495n 1.8v 369.505n 1.8v 379.495n 1.8v 379.505n 1.8v 389.495n 1.8v 389.505n 0.0v 399.495n 0.0v 399.505n 1.8v 409.495n 1.8v 409.505n 1.8v 419.495n 1.8v 419.505n 1.8v 429.495n 1.8v 429.505n 1.8v 439.495n 1.8v 439.505n 1.8v 449.495n 1.8v 449.505n 0.0v 459.495n 0.0v 459.505n 0.0v 469.495n 0.0v 469.505n 1.8v 479.495n 1.8v 479.505n 1.8v 489.495n 1.8v 489.505n 1.8v 499.495n 1.8v 499.505n 1.8v 509.495n 1.8v 509.505n 1.8v 519.495n 1.8v 519.505n 1.8v 529.495n 1.8v 529.505n 1.8v 539.495n 1.8v 539.505n 1.8v 549.495n 1.8v 549.505n 1.8v 559.495n 1.8v 559.505n 1.8v 569.495n 1.8v 569.505n 1.8v 579.495n 1.8v 579.505n 1.8v 589.495n 1.8v 589.505n 1.8v 599.495n 1.8v 599.505n 1.8v 609.495n 1.8v 609.505n 1.8v 619.495n 1.8v 619.505n 0.0v 629.495n 0.0v 629.505n 0.0v 639.495n 0.0v 639.505n 0.0v 649.495n 0.0v 649.505n 0.0v 659.495n 0.0v 659.505n 1.8v 669.495n 1.8v 669.505n 0.0v 679.495n 0.0v 679.505n 0.0v 689.495n 0.0v 689.505n 0.0v 699.495n 0.0v 699.505n 0.0v 709.495n 0.0v 709.505n 1.8v 719.495n 1.8v 719.505n 1.8v 729.495n 1.8v 729.505n 1.8v 739.495n 1.8v 739.505n 1.8v 749.495n 1.8v 749.505n 1.8v 759.495n 1.8v 759.505n 1.8v 769.495n 1.8v 769.505n 1.8v 779.495n 1.8v 779.505n 1.8v 789.495n 1.8v 789.505n 1.8v 799.495n 1.8v 799.505n 1.8v 809.495n 1.8v 809.505n 1.8v 819.495n 1.8v 819.505n 0.0v 829.495n 0.0v 829.505n 0.0v 839.495n 0.0v 839.505n 1.8v 849.495n 1.8v 849.505n 1.8v 859.495n 1.8v 859.505n 1.8v 869.495n 1.8v 869.505n 1.8v 879.495n 1.8v 879.505n 1.8v 889.495n 1.8v 889.505n 1.8v 899.495n 1.8v 899.505n 1.8v 909.495n 1.8v 909.505n 1.8v 919.495n 1.8v 919.505n 1.8v 929.495n 1.8v 929.505n 1.8v 939.495n 1.8v 939.505n 1.8v 949.495n 1.8v 949.505n 1.8v 959.495n 1.8v 959.505n 1.8v 969.495n 1.8v 969.505n 1.8v 979.495n 1.8v 979.505n 1.8v 989.495n 1.8v 989.505n 1.8v 999.495n 1.8v 999.505n 1.8v 1009.495n 1.8v 1009.505n 1.8v 1019.495n 1.8v 1019.505n 1.8v 1029.495n 1.8v 1029.505n 1.8v 1039.495n 1.8v 1039.505n 1.8v 1049.495n 1.8v 1049.505n 1.8v 1059.495n 1.8v 1059.505n 1.8v 1069.495n 1.8v 1069.505n 1.8v 1079.495n 1.8v 1079.505n 0.0v 1089.495n 0.0v 1089.505n 0.0v 1099.495n 0.0v 1099.505n 0.0v 1109.495n 0.0v 1109.505n 0.0v 1119.495n 0.0v 1119.505n 0.0v 1129.495n 0.0v 1129.505n 1.8v 1139.495n 1.8v 1139.505n 1.8v 1149.495n 1.8v 1149.505n 1.8v 1159.495n 1.8v 1159.505n 1.8v 1169.495n 1.8v 1169.505n 1.8v 1179.495n 1.8v 1179.505n 1.8v 1189.495n 1.8v 1189.505n 1.8v 1199.495n 1.8v 1199.505n 1.8v 1209.495n 1.8v 1209.505n 1.8v 1219.495n 1.8v 1219.505n 1.8v 1229.495n 1.8v 1229.505n 1.8v 1239.495n 1.8v 1239.505n 1.8v 1249.495n 1.8v 1249.505n 1.8v 1259.495n 1.8v 1259.505n 0.0v 1269.495n 0.0v 1269.505n 0.0v 1279.495n 0.0v 1279.505n 1.8v 1289.495n 1.8v 1289.505n 1.8v 1299.495n 1.8v 1299.505n 1.8v 1309.495n 1.8v 1309.505n 1.8v 1319.495n 1.8v 1319.505n 1.8v 1329.495n 1.8v 1329.505n 1.8v 1339.495n 1.8v 1339.505n 1.8v 1349.495n 1.8v 1349.505n 1.8v 1359.495n 1.8v 1359.505n 1.8v 1369.495n 1.8v 1369.505n 1.8v 1379.495n 1.8v 1379.505n 1.8v 1389.495n 1.8v 1389.505n 1.8v 1399.495n 1.8v 1399.505n 0.0v 1409.495n 0.0v 1409.505n 0.0v 1419.495n 0.0v 1419.505n 0.0v 1429.495n 0.0v 1429.505n 0.0v 1439.495n 0.0v 1439.505n 0.0v 1449.495n 0.0v 1449.505n 0.0v 1459.495n 0.0v 1459.505n 0.0v 1469.495n 0.0v 1469.505n 0.0v 1479.495n 0.0v 1479.505n 1.8v 1489.495n 1.8v 1489.505n 1.8v 1499.495n 1.8v 1499.505n 0.0v 1509.495n 0.0v 1509.505n 0.0v 1519.495n 0.0v 1519.505n 0.0v 1529.495n 0.0v 1529.505n 0.0v 1539.495n 0.0v 1539.505n 0.0v 1549.495n 0.0v 1549.505n 0.0v 1559.495n 0.0v 1559.505n 0.0v 1569.495n 0.0v 1569.505n 0.0v 1579.495n 0.0v 1579.505n 1.8v 1589.495n 1.8v 1589.505n 0.0v 1599.495n 0.0v 1599.505n 0.0v 1609.495n 0.0v 1609.505n 0.0v 1619.495n 0.0v 1619.505n 1.8v 1629.495n 1.8v 1629.505n 1.8v 1639.495n 1.8v 1639.505n 1.8v 1649.495n 1.8v 1649.505n 1.8v 1659.495n 1.8v 1659.505n 1.8v 1669.495n 1.8v 1669.505n 1.8v 1679.495n 1.8v 1679.505n 1.8v 1689.495n 1.8v 1689.505n 1.8v 1699.495n 1.8v 1699.505n 1.8v 1709.495n 1.8v 1709.505n 0.0v 1719.495n 0.0v 1719.505n 0.0v 1729.495n 0.0v 1729.505n 1.8v 1739.495n 1.8v 1739.505n 1.8v 1749.495n 1.8v 1749.505n 1.8v 1759.495n 1.8v 1759.505n 1.8v 1769.495n 1.8v 1769.505n 1.8v 1779.495n 1.8v 1779.505n 1.8v 1789.495n 1.8v 1789.505n 0.0v 1799.495n 0.0v 1799.505n 0.0v 1809.495n 0.0v 1809.505n 0.0v 1819.495n 0.0v 1819.505n 0.0v 1829.495n 0.0v 1829.505n 0.0v 1839.495n 0.0v 1839.505n 0.0v 1849.495n 0.0v 1849.505n 1.8v 1859.495n 1.8v 1859.505n 1.8v 1869.495n 1.8v 1869.505n 0.0v 1879.495n 0.0v 1879.505n 0.0v 1889.495n 0.0v 1889.505n 0.0v 1899.495n 0.0v 1899.505n 0.0v 1909.495n 0.0v 1909.505n 0.0v 1919.495n 0.0v 1919.505n 0.0v 1929.495n 0.0v 1929.505n 0.0v 1939.495n 0.0v 1939.505n 0.0v 1949.495n 0.0v 1949.505n 0.0v 1959.495n 0.0v 1959.505n 0.0v 1969.495n 0.0v 1969.505n 0.0v 1979.495n 0.0v 1979.505n 0.0v 1989.495n 0.0v 1989.505n 0.0v 1999.495n 0.0v 1999.505n 0.0v 2009.495n 0.0v 2009.505n 0.0v 2019.495n 0.0v 2019.505n 0.0v 2029.495n 0.0v 2029.505n 1.8v 2039.495n 1.8v 2039.505n 1.8v 2049.495n 1.8v 2049.505n 1.8v )
* (time, data): [(0, 0), (10, 1), (20, 0), (30, 1), (40, 1), (50, 1), (60, 0), (70, 0), (80, 0), (90, 0), (100, 0), (110, 0), (120, 0), (130, 0), (140, 0), (150, 0), (160, 0), (170, 0), (180, 0), (190, 0), (200, 0), (210, 0), (220, 0), (230, 0), (240, 0), (250, 0), (260, 1), (270, 1), (280, 1), (290, 1), (300, 1), (310, 1), (320, 1), (330, 1), (340, 1), (350, 0), (360, 0), (370, 0), (380, 0), (390, 0), (400, 1), (410, 1), (420, 1), (430, 1), (440, 1), (450, 0), (460, 0), (470, 1), (480, 1), (490, 0), (500, 1), (510, 1), (520, 1), (530, 1), (540, 1), (550, 1), (560, 1), (570, 1), (580, 1), (590, 1), (600, 1), (610, 1), (620, 0), (630, 0), (640, 0), (650, 0), (660, 1), (670, 1), (680, 1), (690, 1), (700, 1), (710, 1), (720, 1), (730, 1), (740, 1), (750, 1), (760, 1), (770, 1), (780, 1), (790, 1), (800, 1), (810, 1), (820, 0), (830, 0), (840, 0), (850, 0), (860, 0), (870, 0), (880, 0), (890, 1), (900, 1), (910, 1), (920, 1), (930, 1), (940, 1), (950, 1), (960, 0), (970, 0), (980, 0), (990, 0), (1000, 0), (1010, 0), (1020, 0), (1030, 0), (1040, 0), (1050, 0), (1060, 0), (1070, 0), (1080, 1), (1090, 1), (1100, 1), (1110, 1), (1120, 1), (1130, 1), (1140, 1), (1150, 1), (1160, 1), (1170, 1), (1180, 1), (1190, 1), (1200, 1), (1210, 1), (1220, 1), (1230, 1), (1240, 1), (1250, 1), (1260, 1), (1270, 1), (1280, 0), (1290, 0), (1300, 0), (1310, 0), (1320, 0), (1330, 0), (1340, 0), (1350, 0), (1360, 0), (1370, 0), (1380, 0), (1390, 0), (1400, 1), (1410, 1), (1420, 1), (1430, 0), (1440, 0), (1450, 0), (1460, 0), (1470, 0), (1480, 0), (1490, 0), (1500, 1), (1510, 1), (1520, 1), (1530, 1), (1540, 1), (1550, 1), (1560, 1), (1570, 0), (1580, 0), (1590, 0), (1600, 0), (1610, 0), (1620, 1), (1630, 1), (1640, 1), (1650, 1), (1660, 1), (1670, 1), (1680, 1), (1690, 0), (1700, 0), (1710, 1), (1720, 1), (1730, 0), (1740, 0), (1750, 0), (1760, 0), (1770, 0), (1780, 0), (1790, 0), (1800, 0), (1810, 0), (1820, 0), (1830, 0), (1840, 0), (1850, 1), (1860, 0), (1870, 1), (1880, 1), (1890, 1), (1900, 1), (1910, 1), (1920, 1), (1930, 1), (1940, 1), (1950, 1), (1960, 1), (1970, 1), (1980, 1), (1990, 1), (2000, 1), (2010, 1), (2020, 1), (2030, 0), (2040, 0), (2050, 0)]
Vdin0_15  din0_15  0 PWL (0n 0.0v 9.495n 0.0v 9.505n 1.8v 19.495n 1.8v 19.505n 0.0v 29.495n 0.0v 29.505n 1.8v 39.495n 1.8v 39.505n 1.8v 49.495n 1.8v 49.505n 1.8v 59.495n 1.8v 59.505n 0.0v 69.495n 0.0v 69.505n 0.0v 79.495n 0.0v 79.505n 0.0v 89.495n 0.0v 89.505n 0.0v 99.495n 0.0v 99.505n 0.0v 109.495n 0.0v 109.505n 0.0v 119.495n 0.0v 119.505n 0.0v 129.495n 0.0v 129.505n 0.0v 139.495n 0.0v 139.505n 0.0v 149.495n 0.0v 149.505n 0.0v 159.495n 0.0v 159.505n 0.0v 169.495n 0.0v 169.505n 0.0v 179.495n 0.0v 179.505n 0.0v 189.495n 0.0v 189.505n 0.0v 199.495n 0.0v 199.505n 0.0v 209.495n 0.0v 209.505n 0.0v 219.495n 0.0v 219.505n 0.0v 229.495n 0.0v 229.505n 0.0v 239.495n 0.0v 239.505n 0.0v 249.495n 0.0v 249.505n 0.0v 259.495n 0.0v 259.505n 1.8v 269.495n 1.8v 269.505n 1.8v 279.495n 1.8v 279.505n 1.8v 289.495n 1.8v 289.505n 1.8v 299.495n 1.8v 299.505n 1.8v 309.495n 1.8v 309.505n 1.8v 319.495n 1.8v 319.505n 1.8v 329.495n 1.8v 329.505n 1.8v 339.495n 1.8v 339.505n 1.8v 349.495n 1.8v 349.505n 0.0v 359.495n 0.0v 359.505n 0.0v 369.495n 0.0v 369.505n 0.0v 379.495n 0.0v 379.505n 0.0v 389.495n 0.0v 389.505n 0.0v 399.495n 0.0v 399.505n 1.8v 409.495n 1.8v 409.505n 1.8v 419.495n 1.8v 419.505n 1.8v 429.495n 1.8v 429.505n 1.8v 439.495n 1.8v 439.505n 1.8v 449.495n 1.8v 449.505n 0.0v 459.495n 0.0v 459.505n 0.0v 469.495n 0.0v 469.505n 1.8v 479.495n 1.8v 479.505n 1.8v 489.495n 1.8v 489.505n 0.0v 499.495n 0.0v 499.505n 1.8v 509.495n 1.8v 509.505n 1.8v 519.495n 1.8v 519.505n 1.8v 529.495n 1.8v 529.505n 1.8v 539.495n 1.8v 539.505n 1.8v 549.495n 1.8v 549.505n 1.8v 559.495n 1.8v 559.505n 1.8v 569.495n 1.8v 569.505n 1.8v 579.495n 1.8v 579.505n 1.8v 589.495n 1.8v 589.505n 1.8v 599.495n 1.8v 599.505n 1.8v 609.495n 1.8v 609.505n 1.8v 619.495n 1.8v 619.505n 0.0v 629.495n 0.0v 629.505n 0.0v 639.495n 0.0v 639.505n 0.0v 649.495n 0.0v 649.505n 0.0v 659.495n 0.0v 659.505n 1.8v 669.495n 1.8v 669.505n 1.8v 679.495n 1.8v 679.505n 1.8v 689.495n 1.8v 689.505n 1.8v 699.495n 1.8v 699.505n 1.8v 709.495n 1.8v 709.505n 1.8v 719.495n 1.8v 719.505n 1.8v 729.495n 1.8v 729.505n 1.8v 739.495n 1.8v 739.505n 1.8v 749.495n 1.8v 749.505n 1.8v 759.495n 1.8v 759.505n 1.8v 769.495n 1.8v 769.505n 1.8v 779.495n 1.8v 779.505n 1.8v 789.495n 1.8v 789.505n 1.8v 799.495n 1.8v 799.505n 1.8v 809.495n 1.8v 809.505n 1.8v 819.495n 1.8v 819.505n 0.0v 829.495n 0.0v 829.505n 0.0v 839.495n 0.0v 839.505n 0.0v 849.495n 0.0v 849.505n 0.0v 859.495n 0.0v 859.505n 0.0v 869.495n 0.0v 869.505n 0.0v 879.495n 0.0v 879.505n 0.0v 889.495n 0.0v 889.505n 1.8v 899.495n 1.8v 899.505n 1.8v 909.495n 1.8v 909.505n 1.8v 919.495n 1.8v 919.505n 1.8v 929.495n 1.8v 929.505n 1.8v 939.495n 1.8v 939.505n 1.8v 949.495n 1.8v 949.505n 1.8v 959.495n 1.8v 959.505n 0.0v 969.495n 0.0v 969.505n 0.0v 979.495n 0.0v 979.505n 0.0v 989.495n 0.0v 989.505n 0.0v 999.495n 0.0v 999.505n 0.0v 1009.495n 0.0v 1009.505n 0.0v 1019.495n 0.0v 1019.505n 0.0v 1029.495n 0.0v 1029.505n 0.0v 1039.495n 0.0v 1039.505n 0.0v 1049.495n 0.0v 1049.505n 0.0v 1059.495n 0.0v 1059.505n 0.0v 1069.495n 0.0v 1069.505n 0.0v 1079.495n 0.0v 1079.505n 1.8v 1089.495n 1.8v 1089.505n 1.8v 1099.495n 1.8v 1099.505n 1.8v 1109.495n 1.8v 1109.505n 1.8v 1119.495n 1.8v 1119.505n 1.8v 1129.495n 1.8v 1129.505n 1.8v 1139.495n 1.8v 1139.505n 1.8v 1149.495n 1.8v 1149.505n 1.8v 1159.495n 1.8v 1159.505n 1.8v 1169.495n 1.8v 1169.505n 1.8v 1179.495n 1.8v 1179.505n 1.8v 1189.495n 1.8v 1189.505n 1.8v 1199.495n 1.8v 1199.505n 1.8v 1209.495n 1.8v 1209.505n 1.8v 1219.495n 1.8v 1219.505n 1.8v 1229.495n 1.8v 1229.505n 1.8v 1239.495n 1.8v 1239.505n 1.8v 1249.495n 1.8v 1249.505n 1.8v 1259.495n 1.8v 1259.505n 1.8v 1269.495n 1.8v 1269.505n 1.8v 1279.495n 1.8v 1279.505n 0.0v 1289.495n 0.0v 1289.505n 0.0v 1299.495n 0.0v 1299.505n 0.0v 1309.495n 0.0v 1309.505n 0.0v 1319.495n 0.0v 1319.505n 0.0v 1329.495n 0.0v 1329.505n 0.0v 1339.495n 0.0v 1339.505n 0.0v 1349.495n 0.0v 1349.505n 0.0v 1359.495n 0.0v 1359.505n 0.0v 1369.495n 0.0v 1369.505n 0.0v 1379.495n 0.0v 1379.505n 0.0v 1389.495n 0.0v 1389.505n 0.0v 1399.495n 0.0v 1399.505n 1.8v 1409.495n 1.8v 1409.505n 1.8v 1419.495n 1.8v 1419.505n 1.8v 1429.495n 1.8v 1429.505n 0.0v 1439.495n 0.0v 1439.505n 0.0v 1449.495n 0.0v 1449.505n 0.0v 1459.495n 0.0v 1459.505n 0.0v 1469.495n 0.0v 1469.505n 0.0v 1479.495n 0.0v 1479.505n 0.0v 1489.495n 0.0v 1489.505n 0.0v 1499.495n 0.0v 1499.505n 1.8v 1509.495n 1.8v 1509.505n 1.8v 1519.495n 1.8v 1519.505n 1.8v 1529.495n 1.8v 1529.505n 1.8v 1539.495n 1.8v 1539.505n 1.8v 1549.495n 1.8v 1549.505n 1.8v 1559.495n 1.8v 1559.505n 1.8v 1569.495n 1.8v 1569.505n 0.0v 1579.495n 0.0v 1579.505n 0.0v 1589.495n 0.0v 1589.505n 0.0v 1599.495n 0.0v 1599.505n 0.0v 1609.495n 0.0v 1609.505n 0.0v 1619.495n 0.0v 1619.505n 1.8v 1629.495n 1.8v 1629.505n 1.8v 1639.495n 1.8v 1639.505n 1.8v 1649.495n 1.8v 1649.505n 1.8v 1659.495n 1.8v 1659.505n 1.8v 1669.495n 1.8v 1669.505n 1.8v 1679.495n 1.8v 1679.505n 1.8v 1689.495n 1.8v 1689.505n 0.0v 1699.495n 0.0v 1699.505n 0.0v 1709.495n 0.0v 1709.505n 1.8v 1719.495n 1.8v 1719.505n 1.8v 1729.495n 1.8v 1729.505n 0.0v 1739.495n 0.0v 1739.505n 0.0v 1749.495n 0.0v 1749.505n 0.0v 1759.495n 0.0v 1759.505n 0.0v 1769.495n 0.0v 1769.505n 0.0v 1779.495n 0.0v 1779.505n 0.0v 1789.495n 0.0v 1789.505n 0.0v 1799.495n 0.0v 1799.505n 0.0v 1809.495n 0.0v 1809.505n 0.0v 1819.495n 0.0v 1819.505n 0.0v 1829.495n 0.0v 1829.505n 0.0v 1839.495n 0.0v 1839.505n 0.0v 1849.495n 0.0v 1849.505n 1.8v 1859.495n 1.8v 1859.505n 0.0v 1869.495n 0.0v 1869.505n 1.8v 1879.495n 1.8v 1879.505n 1.8v 1889.495n 1.8v 1889.505n 1.8v 1899.495n 1.8v 1899.505n 1.8v 1909.495n 1.8v 1909.505n 1.8v 1919.495n 1.8v 1919.505n 1.8v 1929.495n 1.8v 1929.505n 1.8v 1939.495n 1.8v 1939.505n 1.8v 1949.495n 1.8v 1949.505n 1.8v 1959.495n 1.8v 1959.505n 1.8v 1969.495n 1.8v 1969.505n 1.8v 1979.495n 1.8v 1979.505n 1.8v 1989.495n 1.8v 1989.505n 1.8v 1999.495n 1.8v 1999.505n 1.8v 2009.495n 1.8v 2009.505n 1.8v 2019.495n 1.8v 2019.505n 1.8v 2029.495n 1.8v 2029.505n 0.0v 2039.495n 0.0v 2039.505n 0.0v 2049.495n 0.0v 2049.505n 0.0v )
* (time, data): [(0, 0), (10, 0), (20, 0), (30, 1), (40, 1), (50, 1), (60, 1), (70, 1), (80, 1), (90, 1), (100, 1), (110, 1), (120, 1), (130, 1), (140, 1), (150, 0), (160, 0), (170, 0), (180, 0), (190, 0), (200, 0), (210, 0), (220, 0), (230, 0), (240, 0), (250, 0), (260, 0), (270, 0), (280, 0), (290, 0), (300, 0), (310, 1), (320, 1), (330, 1), (340, 1), (350, 0), (360, 0), (370, 0), (380, 0), (390, 1), (400, 1), (410, 1), (420, 0), (430, 0), (440, 0), (450, 0), (460, 0), (470, 1), (480, 1), (490, 1), (500, 1), (510, 1), (520, 1), (530, 1), (540, 1), (550, 1), (560, 1), (570, 1), (580, 1), (590, 1), (600, 1), (610, 1), (620, 0), (630, 0), (640, 0), (650, 0), (660, 0), (670, 1), (680, 1), (690, 1), (700, 1), (710, 1), (720, 1), (730, 1), (740, 1), (750, 1), (760, 1), (770, 0), (780, 0), (790, 0), (800, 0), (810, 0), (820, 1), (830, 1), (840, 0), (850, 0), (860, 0), (870, 0), (880, 0), (890, 0), (900, 0), (910, 0), (920, 0), (930, 0), (940, 0), (950, 0), (960, 1), (970, 1), (980, 1), (990, 1), (1000, 1), (1010, 1), (1020, 1), (1030, 1), (1040, 1), (1050, 1), (1060, 1), (1070, 1), (1080, 0), (1090, 0), (1100, 0), (1110, 0), (1120, 0), (1130, 1), (1140, 1), (1150, 1), (1160, 1), (1170, 1), (1180, 1), (1190, 1), (1200, 1), (1210, 1), (1220, 1), (1230, 1), (1240, 1), (1250, 1), (1260, 1), (1270, 1), (1280, 1), (1290, 1), (1300, 1), (1310, 1), (1320, 1), (1330, 1), (1340, 1), (1350, 1), (1360, 1), (1370, 1), (1380, 1), (1390, 1), (1400, 0), (1410, 0), (1420, 0), (1430, 1), (1440, 1), (1450, 1), (1460, 1), (1470, 1), (1480, 1), (1490, 1), (1500, 1), (1510, 1), (1520, 1), (1530, 1), (1540, 1), (1550, 1), (1560, 1), (1570, 1), (1580, 1), (1590, 0), (1600, 0), (1610, 0), (1620, 1), (1630, 1), (1640, 1), (1650, 1), (1660, 1), (1670, 1), (1680, 1), (1690, 0), (1700, 0), (1710, 0), (1720, 0), (1730, 0), (1740, 0), (1750, 0), (1760, 0), (1770, 0), (1780, 0), (1790, 1), (1800, 1), (1810, 1), (1820, 1), (1830, 1), (1840, 1), (1850, 0), (1860, 1), (1870, 1), (1880, 1), (1890, 0), (1900, 0), (1910, 1), (1920, 1), (1930, 1), (1940, 1), (1950, 1), (1960, 1), (1970, 1), (1980, 1), (1990, 1), (2000, 1), (2010, 1), (2020, 1), (2030, 1), (2040, 1), (2050, 1)]
Vdin0_16  din0_16  0 PWL (0n 0.0v 9.495n 0.0v 9.505n 0.0v 19.495n 0.0v 19.505n 0.0v 29.495n 0.0v 29.505n 1.8v 39.495n 1.8v 39.505n 1.8v 49.495n 1.8v 49.505n 1.8v 59.495n 1.8v 59.505n 1.8v 69.495n 1.8v 69.505n 1.8v 79.495n 1.8v 79.505n 1.8v 89.495n 1.8v 89.505n 1.8v 99.495n 1.8v 99.505n 1.8v 109.495n 1.8v 109.505n 1.8v 119.495n 1.8v 119.505n 1.8v 129.495n 1.8v 129.505n 1.8v 139.495n 1.8v 139.505n 1.8v 149.495n 1.8v 149.505n 0.0v 159.495n 0.0v 159.505n 0.0v 169.495n 0.0v 169.505n 0.0v 179.495n 0.0v 179.505n 0.0v 189.495n 0.0v 189.505n 0.0v 199.495n 0.0v 199.505n 0.0v 209.495n 0.0v 209.505n 0.0v 219.495n 0.0v 219.505n 0.0v 229.495n 0.0v 229.505n 0.0v 239.495n 0.0v 239.505n 0.0v 249.495n 0.0v 249.505n 0.0v 259.495n 0.0v 259.505n 0.0v 269.495n 0.0v 269.505n 0.0v 279.495n 0.0v 279.505n 0.0v 289.495n 0.0v 289.505n 0.0v 299.495n 0.0v 299.505n 0.0v 309.495n 0.0v 309.505n 1.8v 319.495n 1.8v 319.505n 1.8v 329.495n 1.8v 329.505n 1.8v 339.495n 1.8v 339.505n 1.8v 349.495n 1.8v 349.505n 0.0v 359.495n 0.0v 359.505n 0.0v 369.495n 0.0v 369.505n 0.0v 379.495n 0.0v 379.505n 0.0v 389.495n 0.0v 389.505n 1.8v 399.495n 1.8v 399.505n 1.8v 409.495n 1.8v 409.505n 1.8v 419.495n 1.8v 419.505n 0.0v 429.495n 0.0v 429.505n 0.0v 439.495n 0.0v 439.505n 0.0v 449.495n 0.0v 449.505n 0.0v 459.495n 0.0v 459.505n 0.0v 469.495n 0.0v 469.505n 1.8v 479.495n 1.8v 479.505n 1.8v 489.495n 1.8v 489.505n 1.8v 499.495n 1.8v 499.505n 1.8v 509.495n 1.8v 509.505n 1.8v 519.495n 1.8v 519.505n 1.8v 529.495n 1.8v 529.505n 1.8v 539.495n 1.8v 539.505n 1.8v 549.495n 1.8v 549.505n 1.8v 559.495n 1.8v 559.505n 1.8v 569.495n 1.8v 569.505n 1.8v 579.495n 1.8v 579.505n 1.8v 589.495n 1.8v 589.505n 1.8v 599.495n 1.8v 599.505n 1.8v 609.495n 1.8v 609.505n 1.8v 619.495n 1.8v 619.505n 0.0v 629.495n 0.0v 629.505n 0.0v 639.495n 0.0v 639.505n 0.0v 649.495n 0.0v 649.505n 0.0v 659.495n 0.0v 659.505n 0.0v 669.495n 0.0v 669.505n 1.8v 679.495n 1.8v 679.505n 1.8v 689.495n 1.8v 689.505n 1.8v 699.495n 1.8v 699.505n 1.8v 709.495n 1.8v 709.505n 1.8v 719.495n 1.8v 719.505n 1.8v 729.495n 1.8v 729.505n 1.8v 739.495n 1.8v 739.505n 1.8v 749.495n 1.8v 749.505n 1.8v 759.495n 1.8v 759.505n 1.8v 769.495n 1.8v 769.505n 0.0v 779.495n 0.0v 779.505n 0.0v 789.495n 0.0v 789.505n 0.0v 799.495n 0.0v 799.505n 0.0v 809.495n 0.0v 809.505n 0.0v 819.495n 0.0v 819.505n 1.8v 829.495n 1.8v 829.505n 1.8v 839.495n 1.8v 839.505n 0.0v 849.495n 0.0v 849.505n 0.0v 859.495n 0.0v 859.505n 0.0v 869.495n 0.0v 869.505n 0.0v 879.495n 0.0v 879.505n 0.0v 889.495n 0.0v 889.505n 0.0v 899.495n 0.0v 899.505n 0.0v 909.495n 0.0v 909.505n 0.0v 919.495n 0.0v 919.505n 0.0v 929.495n 0.0v 929.505n 0.0v 939.495n 0.0v 939.505n 0.0v 949.495n 0.0v 949.505n 0.0v 959.495n 0.0v 959.505n 1.8v 969.495n 1.8v 969.505n 1.8v 979.495n 1.8v 979.505n 1.8v 989.495n 1.8v 989.505n 1.8v 999.495n 1.8v 999.505n 1.8v 1009.495n 1.8v 1009.505n 1.8v 1019.495n 1.8v 1019.505n 1.8v 1029.495n 1.8v 1029.505n 1.8v 1039.495n 1.8v 1039.505n 1.8v 1049.495n 1.8v 1049.505n 1.8v 1059.495n 1.8v 1059.505n 1.8v 1069.495n 1.8v 1069.505n 1.8v 1079.495n 1.8v 1079.505n 0.0v 1089.495n 0.0v 1089.505n 0.0v 1099.495n 0.0v 1099.505n 0.0v 1109.495n 0.0v 1109.505n 0.0v 1119.495n 0.0v 1119.505n 0.0v 1129.495n 0.0v 1129.505n 1.8v 1139.495n 1.8v 1139.505n 1.8v 1149.495n 1.8v 1149.505n 1.8v 1159.495n 1.8v 1159.505n 1.8v 1169.495n 1.8v 1169.505n 1.8v 1179.495n 1.8v 1179.505n 1.8v 1189.495n 1.8v 1189.505n 1.8v 1199.495n 1.8v 1199.505n 1.8v 1209.495n 1.8v 1209.505n 1.8v 1219.495n 1.8v 1219.505n 1.8v 1229.495n 1.8v 1229.505n 1.8v 1239.495n 1.8v 1239.505n 1.8v 1249.495n 1.8v 1249.505n 1.8v 1259.495n 1.8v 1259.505n 1.8v 1269.495n 1.8v 1269.505n 1.8v 1279.495n 1.8v 1279.505n 1.8v 1289.495n 1.8v 1289.505n 1.8v 1299.495n 1.8v 1299.505n 1.8v 1309.495n 1.8v 1309.505n 1.8v 1319.495n 1.8v 1319.505n 1.8v 1329.495n 1.8v 1329.505n 1.8v 1339.495n 1.8v 1339.505n 1.8v 1349.495n 1.8v 1349.505n 1.8v 1359.495n 1.8v 1359.505n 1.8v 1369.495n 1.8v 1369.505n 1.8v 1379.495n 1.8v 1379.505n 1.8v 1389.495n 1.8v 1389.505n 1.8v 1399.495n 1.8v 1399.505n 0.0v 1409.495n 0.0v 1409.505n 0.0v 1419.495n 0.0v 1419.505n 0.0v 1429.495n 0.0v 1429.505n 1.8v 1439.495n 1.8v 1439.505n 1.8v 1449.495n 1.8v 1449.505n 1.8v 1459.495n 1.8v 1459.505n 1.8v 1469.495n 1.8v 1469.505n 1.8v 1479.495n 1.8v 1479.505n 1.8v 1489.495n 1.8v 1489.505n 1.8v 1499.495n 1.8v 1499.505n 1.8v 1509.495n 1.8v 1509.505n 1.8v 1519.495n 1.8v 1519.505n 1.8v 1529.495n 1.8v 1529.505n 1.8v 1539.495n 1.8v 1539.505n 1.8v 1549.495n 1.8v 1549.505n 1.8v 1559.495n 1.8v 1559.505n 1.8v 1569.495n 1.8v 1569.505n 1.8v 1579.495n 1.8v 1579.505n 1.8v 1589.495n 1.8v 1589.505n 0.0v 1599.495n 0.0v 1599.505n 0.0v 1609.495n 0.0v 1609.505n 0.0v 1619.495n 0.0v 1619.505n 1.8v 1629.495n 1.8v 1629.505n 1.8v 1639.495n 1.8v 1639.505n 1.8v 1649.495n 1.8v 1649.505n 1.8v 1659.495n 1.8v 1659.505n 1.8v 1669.495n 1.8v 1669.505n 1.8v 1679.495n 1.8v 1679.505n 1.8v 1689.495n 1.8v 1689.505n 0.0v 1699.495n 0.0v 1699.505n 0.0v 1709.495n 0.0v 1709.505n 0.0v 1719.495n 0.0v 1719.505n 0.0v 1729.495n 0.0v 1729.505n 0.0v 1739.495n 0.0v 1739.505n 0.0v 1749.495n 0.0v 1749.505n 0.0v 1759.495n 0.0v 1759.505n 0.0v 1769.495n 0.0v 1769.505n 0.0v 1779.495n 0.0v 1779.505n 0.0v 1789.495n 0.0v 1789.505n 1.8v 1799.495n 1.8v 1799.505n 1.8v 1809.495n 1.8v 1809.505n 1.8v 1819.495n 1.8v 1819.505n 1.8v 1829.495n 1.8v 1829.505n 1.8v 1839.495n 1.8v 1839.505n 1.8v 1849.495n 1.8v 1849.505n 0.0v 1859.495n 0.0v 1859.505n 1.8v 1869.495n 1.8v 1869.505n 1.8v 1879.495n 1.8v 1879.505n 1.8v 1889.495n 1.8v 1889.505n 0.0v 1899.495n 0.0v 1899.505n 0.0v 1909.495n 0.0v 1909.505n 1.8v 1919.495n 1.8v 1919.505n 1.8v 1929.495n 1.8v 1929.505n 1.8v 1939.495n 1.8v 1939.505n 1.8v 1949.495n 1.8v 1949.505n 1.8v 1959.495n 1.8v 1959.505n 1.8v 1969.495n 1.8v 1969.505n 1.8v 1979.495n 1.8v 1979.505n 1.8v 1989.495n 1.8v 1989.505n 1.8v 1999.495n 1.8v 1999.505n 1.8v 2009.495n 1.8v 2009.505n 1.8v 2019.495n 1.8v 2019.505n 1.8v 2029.495n 1.8v 2029.505n 1.8v 2039.495n 1.8v 2039.505n 1.8v 2049.495n 1.8v 2049.505n 1.8v )
* (time, data): [(0, 0), (10, 1), (20, 0), (30, 0), (40, 0), (50, 0), (60, 1), (70, 1), (80, 1), (90, 1), (100, 1), (110, 1), (120, 1), (130, 1), (140, 1), (150, 1), (160, 1), (170, 1), (180, 1), (190, 1), (200, 1), (210, 1), (220, 1), (230, 1), (240, 1), (250, 1), (260, 0), (270, 0), (280, 0), (290, 0), (300, 0), (310, 1), (320, 1), (330, 1), (340, 1), (350, 1), (360, 1), (370, 1), (380, 1), (390, 1), (400, 1), (410, 1), (420, 0), (430, 0), (440, 0), (450, 1), (460, 1), (470, 0), (480, 0), (490, 1), (500, 0), (510, 0), (520, 0), (530, 0), (540, 0), (550, 0), (560, 0), (570, 0), (580, 0), (590, 0), (600, 0), (610, 0), (620, 1), (630, 1), (640, 1), (650, 1), (660, 0), (670, 1), (680, 1), (690, 1), (700, 1), (710, 0), (720, 0), (730, 0), (740, 0), (750, 0), (760, 0), (770, 1), (780, 1), (790, 1), (800, 1), (810, 1), (820, 0), (830, 0), (840, 0), (850, 0), (860, 0), (870, 0), (880, 0), (890, 1), (900, 1), (910, 1), (920, 1), (930, 1), (940, 1), (950, 1), (960, 0), (970, 0), (980, 0), (990, 0), (1000, 0), (1010, 0), (1020, 0), (1030, 0), (1040, 0), (1050, 0), (1060, 0), (1070, 0), (1080, 1), (1090, 1), (1100, 1), (1110, 1), (1120, 1), (1130, 0), (1140, 0), (1150, 0), (1160, 0), (1170, 0), (1180, 0), (1190, 0), (1200, 0), (1210, 0), (1220, 0), (1230, 0), (1240, 0), (1250, 0), (1260, 0), (1270, 0), (1280, 0), (1290, 0), (1300, 0), (1310, 0), (1320, 0), (1330, 0), (1340, 0), (1350, 0), (1360, 0), (1370, 1), (1380, 1), (1390, 1), (1400, 0), (1410, 0), (1420, 0), (1430, 1), (1440, 1), (1450, 1), (1460, 1), (1470, 1), (1480, 1), (1490, 1), (1500, 1), (1510, 1), (1520, 1), (1530, 1), (1540, 1), (1550, 1), (1560, 1), (1570, 1), (1580, 0), (1590, 1), (1600, 1), (1610, 1), (1620, 0), (1630, 0), (1640, 0), (1650, 0), (1660, 0), (1670, 0), (1680, 0), (1690, 1), (1700, 1), (1710, 1), (1720, 1), (1730, 0), (1740, 1), (1750, 1), (1760, 1), (1770, 1), (1780, 1), (1790, 0), (1800, 0), (1810, 0), (1820, 0), (1830, 0), (1840, 0), (1850, 1), (1860, 1), (1870, 1), (1880, 0), (1890, 0), (1900, 0), (1910, 1), (1920, 1), (1930, 1), (1940, 1), (1950, 1), (1960, 1), (1970, 1), (1980, 1), (1990, 1), (2000, 1), (2010, 1), (2020, 1), (2030, 1), (2040, 1), (2050, 1)]
Vdin0_17  din0_17  0 PWL (0n 0.0v 9.495n 0.0v 9.505n 1.8v 19.495n 1.8v 19.505n 0.0v 29.495n 0.0v 29.505n 0.0v 39.495n 0.0v 39.505n 0.0v 49.495n 0.0v 49.505n 0.0v 59.495n 0.0v 59.505n 1.8v 69.495n 1.8v 69.505n 1.8v 79.495n 1.8v 79.505n 1.8v 89.495n 1.8v 89.505n 1.8v 99.495n 1.8v 99.505n 1.8v 109.495n 1.8v 109.505n 1.8v 119.495n 1.8v 119.505n 1.8v 129.495n 1.8v 129.505n 1.8v 139.495n 1.8v 139.505n 1.8v 149.495n 1.8v 149.505n 1.8v 159.495n 1.8v 159.505n 1.8v 169.495n 1.8v 169.505n 1.8v 179.495n 1.8v 179.505n 1.8v 189.495n 1.8v 189.505n 1.8v 199.495n 1.8v 199.505n 1.8v 209.495n 1.8v 209.505n 1.8v 219.495n 1.8v 219.505n 1.8v 229.495n 1.8v 229.505n 1.8v 239.495n 1.8v 239.505n 1.8v 249.495n 1.8v 249.505n 1.8v 259.495n 1.8v 259.505n 0.0v 269.495n 0.0v 269.505n 0.0v 279.495n 0.0v 279.505n 0.0v 289.495n 0.0v 289.505n 0.0v 299.495n 0.0v 299.505n 0.0v 309.495n 0.0v 309.505n 1.8v 319.495n 1.8v 319.505n 1.8v 329.495n 1.8v 329.505n 1.8v 339.495n 1.8v 339.505n 1.8v 349.495n 1.8v 349.505n 1.8v 359.495n 1.8v 359.505n 1.8v 369.495n 1.8v 369.505n 1.8v 379.495n 1.8v 379.505n 1.8v 389.495n 1.8v 389.505n 1.8v 399.495n 1.8v 399.505n 1.8v 409.495n 1.8v 409.505n 1.8v 419.495n 1.8v 419.505n 0.0v 429.495n 0.0v 429.505n 0.0v 439.495n 0.0v 439.505n 0.0v 449.495n 0.0v 449.505n 1.8v 459.495n 1.8v 459.505n 1.8v 469.495n 1.8v 469.505n 0.0v 479.495n 0.0v 479.505n 0.0v 489.495n 0.0v 489.505n 1.8v 499.495n 1.8v 499.505n 0.0v 509.495n 0.0v 509.505n 0.0v 519.495n 0.0v 519.505n 0.0v 529.495n 0.0v 529.505n 0.0v 539.495n 0.0v 539.505n 0.0v 549.495n 0.0v 549.505n 0.0v 559.495n 0.0v 559.505n 0.0v 569.495n 0.0v 569.505n 0.0v 579.495n 0.0v 579.505n 0.0v 589.495n 0.0v 589.505n 0.0v 599.495n 0.0v 599.505n 0.0v 609.495n 0.0v 609.505n 0.0v 619.495n 0.0v 619.505n 1.8v 629.495n 1.8v 629.505n 1.8v 639.495n 1.8v 639.505n 1.8v 649.495n 1.8v 649.505n 1.8v 659.495n 1.8v 659.505n 0.0v 669.495n 0.0v 669.505n 1.8v 679.495n 1.8v 679.505n 1.8v 689.495n 1.8v 689.505n 1.8v 699.495n 1.8v 699.505n 1.8v 709.495n 1.8v 709.505n 0.0v 719.495n 0.0v 719.505n 0.0v 729.495n 0.0v 729.505n 0.0v 739.495n 0.0v 739.505n 0.0v 749.495n 0.0v 749.505n 0.0v 759.495n 0.0v 759.505n 0.0v 769.495n 0.0v 769.505n 1.8v 779.495n 1.8v 779.505n 1.8v 789.495n 1.8v 789.505n 1.8v 799.495n 1.8v 799.505n 1.8v 809.495n 1.8v 809.505n 1.8v 819.495n 1.8v 819.505n 0.0v 829.495n 0.0v 829.505n 0.0v 839.495n 0.0v 839.505n 0.0v 849.495n 0.0v 849.505n 0.0v 859.495n 0.0v 859.505n 0.0v 869.495n 0.0v 869.505n 0.0v 879.495n 0.0v 879.505n 0.0v 889.495n 0.0v 889.505n 1.8v 899.495n 1.8v 899.505n 1.8v 909.495n 1.8v 909.505n 1.8v 919.495n 1.8v 919.505n 1.8v 929.495n 1.8v 929.505n 1.8v 939.495n 1.8v 939.505n 1.8v 949.495n 1.8v 949.505n 1.8v 959.495n 1.8v 959.505n 0.0v 969.495n 0.0v 969.505n 0.0v 979.495n 0.0v 979.505n 0.0v 989.495n 0.0v 989.505n 0.0v 999.495n 0.0v 999.505n 0.0v 1009.495n 0.0v 1009.505n 0.0v 1019.495n 0.0v 1019.505n 0.0v 1029.495n 0.0v 1029.505n 0.0v 1039.495n 0.0v 1039.505n 0.0v 1049.495n 0.0v 1049.505n 0.0v 1059.495n 0.0v 1059.505n 0.0v 1069.495n 0.0v 1069.505n 0.0v 1079.495n 0.0v 1079.505n 1.8v 1089.495n 1.8v 1089.505n 1.8v 1099.495n 1.8v 1099.505n 1.8v 1109.495n 1.8v 1109.505n 1.8v 1119.495n 1.8v 1119.505n 1.8v 1129.495n 1.8v 1129.505n 0.0v 1139.495n 0.0v 1139.505n 0.0v 1149.495n 0.0v 1149.505n 0.0v 1159.495n 0.0v 1159.505n 0.0v 1169.495n 0.0v 1169.505n 0.0v 1179.495n 0.0v 1179.505n 0.0v 1189.495n 0.0v 1189.505n 0.0v 1199.495n 0.0v 1199.505n 0.0v 1209.495n 0.0v 1209.505n 0.0v 1219.495n 0.0v 1219.505n 0.0v 1229.495n 0.0v 1229.505n 0.0v 1239.495n 0.0v 1239.505n 0.0v 1249.495n 0.0v 1249.505n 0.0v 1259.495n 0.0v 1259.505n 0.0v 1269.495n 0.0v 1269.505n 0.0v 1279.495n 0.0v 1279.505n 0.0v 1289.495n 0.0v 1289.505n 0.0v 1299.495n 0.0v 1299.505n 0.0v 1309.495n 0.0v 1309.505n 0.0v 1319.495n 0.0v 1319.505n 0.0v 1329.495n 0.0v 1329.505n 0.0v 1339.495n 0.0v 1339.505n 0.0v 1349.495n 0.0v 1349.505n 0.0v 1359.495n 0.0v 1359.505n 0.0v 1369.495n 0.0v 1369.505n 1.8v 1379.495n 1.8v 1379.505n 1.8v 1389.495n 1.8v 1389.505n 1.8v 1399.495n 1.8v 1399.505n 0.0v 1409.495n 0.0v 1409.505n 0.0v 1419.495n 0.0v 1419.505n 0.0v 1429.495n 0.0v 1429.505n 1.8v 1439.495n 1.8v 1439.505n 1.8v 1449.495n 1.8v 1449.505n 1.8v 1459.495n 1.8v 1459.505n 1.8v 1469.495n 1.8v 1469.505n 1.8v 1479.495n 1.8v 1479.505n 1.8v 1489.495n 1.8v 1489.505n 1.8v 1499.495n 1.8v 1499.505n 1.8v 1509.495n 1.8v 1509.505n 1.8v 1519.495n 1.8v 1519.505n 1.8v 1529.495n 1.8v 1529.505n 1.8v 1539.495n 1.8v 1539.505n 1.8v 1549.495n 1.8v 1549.505n 1.8v 1559.495n 1.8v 1559.505n 1.8v 1569.495n 1.8v 1569.505n 1.8v 1579.495n 1.8v 1579.505n 0.0v 1589.495n 0.0v 1589.505n 1.8v 1599.495n 1.8v 1599.505n 1.8v 1609.495n 1.8v 1609.505n 1.8v 1619.495n 1.8v 1619.505n 0.0v 1629.495n 0.0v 1629.505n 0.0v 1639.495n 0.0v 1639.505n 0.0v 1649.495n 0.0v 1649.505n 0.0v 1659.495n 0.0v 1659.505n 0.0v 1669.495n 0.0v 1669.505n 0.0v 1679.495n 0.0v 1679.505n 0.0v 1689.495n 0.0v 1689.505n 1.8v 1699.495n 1.8v 1699.505n 1.8v 1709.495n 1.8v 1709.505n 1.8v 1719.495n 1.8v 1719.505n 1.8v 1729.495n 1.8v 1729.505n 0.0v 1739.495n 0.0v 1739.505n 1.8v 1749.495n 1.8v 1749.505n 1.8v 1759.495n 1.8v 1759.505n 1.8v 1769.495n 1.8v 1769.505n 1.8v 1779.495n 1.8v 1779.505n 1.8v 1789.495n 1.8v 1789.505n 0.0v 1799.495n 0.0v 1799.505n 0.0v 1809.495n 0.0v 1809.505n 0.0v 1819.495n 0.0v 1819.505n 0.0v 1829.495n 0.0v 1829.505n 0.0v 1839.495n 0.0v 1839.505n 0.0v 1849.495n 0.0v 1849.505n 1.8v 1859.495n 1.8v 1859.505n 1.8v 1869.495n 1.8v 1869.505n 1.8v 1879.495n 1.8v 1879.505n 0.0v 1889.495n 0.0v 1889.505n 0.0v 1899.495n 0.0v 1899.505n 0.0v 1909.495n 0.0v 1909.505n 1.8v 1919.495n 1.8v 1919.505n 1.8v 1929.495n 1.8v 1929.505n 1.8v 1939.495n 1.8v 1939.505n 1.8v 1949.495n 1.8v 1949.505n 1.8v 1959.495n 1.8v 1959.505n 1.8v 1969.495n 1.8v 1969.505n 1.8v 1979.495n 1.8v 1979.505n 1.8v 1989.495n 1.8v 1989.505n 1.8v 1999.495n 1.8v 1999.505n 1.8v 2009.495n 1.8v 2009.505n 1.8v 2019.495n 1.8v 2019.505n 1.8v 2029.495n 1.8v 2029.505n 1.8v 2039.495n 1.8v 2039.505n 1.8v 2049.495n 1.8v 2049.505n 1.8v )
* (time, data): [(0, 0), (10, 0), (20, 0), (30, 0), (40, 0), (50, 0), (60, 0), (70, 0), (80, 0), (90, 0), (100, 0), (110, 0), (120, 0), (130, 0), (140, 0), (150, 0), (160, 0), (170, 0), (180, 0), (190, 0), (200, 0), (210, 0), (220, 0), (230, 0), (240, 0), (250, 0), (260, 1), (270, 1), (280, 1), (290, 1), (300, 1), (310, 0), (320, 0), (330, 0), (340, 0), (350, 1), (360, 1), (370, 1), (380, 1), (390, 1), (400, 0), (410, 0), (420, 1), (430, 1), (440, 1), (450, 1), (460, 1), (470, 0), (480, 0), (490, 1), (500, 1), (510, 1), (520, 1), (530, 1), (540, 1), (550, 1), (560, 1), (570, 1), (580, 1), (590, 1), (600, 1), (610, 1), (620, 0), (630, 0), (640, 0), (650, 0), (660, 1), (670, 0), (680, 0), (690, 0), (700, 0), (710, 0), (720, 0), (730, 0), (740, 0), (750, 0), (760, 0), (770, 1), (780, 1), (790, 1), (800, 1), (810, 1), (820, 1), (830, 1), (840, 1), (850, 1), (860, 1), (870, 1), (880, 1), (890, 0), (900, 0), (910, 0), (920, 0), (930, 1), (940, 1), (950, 1), (960, 0), (970, 0), (980, 0), (990, 0), (1000, 0), (1010, 0), (1020, 0), (1030, 0), (1040, 0), (1050, 0), (1060, 0), (1070, 0), (1080, 0), (1090, 0), (1100, 0), (1110, 0), (1120, 0), (1130, 0), (1140, 0), (1150, 0), (1160, 0), (1170, 0), (1180, 0), (1190, 0), (1200, 0), (1210, 0), (1220, 0), (1230, 0), (1240, 0), (1250, 0), (1260, 1), (1270, 1), (1280, 1), (1290, 1), (1300, 1), (1310, 1), (1320, 1), (1330, 1), (1340, 1), (1350, 1), (1360, 1), (1370, 1), (1380, 1), (1390, 1), (1400, 0), (1410, 0), (1420, 0), (1430, 0), (1440, 0), (1450, 0), (1460, 0), (1470, 0), (1480, 0), (1490, 0), (1500, 0), (1510, 0), (1520, 0), (1530, 0), (1540, 0), (1550, 0), (1560, 0), (1570, 1), (1580, 0), (1590, 1), (1600, 1), (1610, 1), (1620, 0), (1630, 0), (1640, 0), (1650, 0), (1660, 0), (1670, 0), (1680, 0), (1690, 0), (1700, 0), (1710, 1), (1720, 1), (1730, 1), (1740, 0), (1750, 0), (1760, 0), (1770, 0), (1780, 0), (1790, 0), (1800, 0), (1810, 0), (1820, 0), (1830, 0), (1840, 0), (1850, 1), (1860, 0), (1870, 1), (1880, 0), (1890, 0), (1900, 0), (1910, 0), (1920, 0), (1930, 0), (1940, 0), (1950, 0), (1960, 0), (1970, 0), (1980, 0), (1990, 0), (2000, 0), (2010, 0), (2020, 0), (2030, 0), (2040, 0), (2050, 0)]
Vdin0_18  din0_18  0 PWL (0n 0.0v 9.495n 0.0v 9.505n 0.0v 19.495n 0.0v 19.505n 0.0v 29.495n 0.0v 29.505n 0.0v 39.495n 0.0v 39.505n 0.0v 49.495n 0.0v 49.505n 0.0v 59.495n 0.0v 59.505n 0.0v 69.495n 0.0v 69.505n 0.0v 79.495n 0.0v 79.505n 0.0v 89.495n 0.0v 89.505n 0.0v 99.495n 0.0v 99.505n 0.0v 109.495n 0.0v 109.505n 0.0v 119.495n 0.0v 119.505n 0.0v 129.495n 0.0v 129.505n 0.0v 139.495n 0.0v 139.505n 0.0v 149.495n 0.0v 149.505n 0.0v 159.495n 0.0v 159.505n 0.0v 169.495n 0.0v 169.505n 0.0v 179.495n 0.0v 179.505n 0.0v 189.495n 0.0v 189.505n 0.0v 199.495n 0.0v 199.505n 0.0v 209.495n 0.0v 209.505n 0.0v 219.495n 0.0v 219.505n 0.0v 229.495n 0.0v 229.505n 0.0v 239.495n 0.0v 239.505n 0.0v 249.495n 0.0v 249.505n 0.0v 259.495n 0.0v 259.505n 1.8v 269.495n 1.8v 269.505n 1.8v 279.495n 1.8v 279.505n 1.8v 289.495n 1.8v 289.505n 1.8v 299.495n 1.8v 299.505n 1.8v 309.495n 1.8v 309.505n 0.0v 319.495n 0.0v 319.505n 0.0v 329.495n 0.0v 329.505n 0.0v 339.495n 0.0v 339.505n 0.0v 349.495n 0.0v 349.505n 1.8v 359.495n 1.8v 359.505n 1.8v 369.495n 1.8v 369.505n 1.8v 379.495n 1.8v 379.505n 1.8v 389.495n 1.8v 389.505n 1.8v 399.495n 1.8v 399.505n 0.0v 409.495n 0.0v 409.505n 0.0v 419.495n 0.0v 419.505n 1.8v 429.495n 1.8v 429.505n 1.8v 439.495n 1.8v 439.505n 1.8v 449.495n 1.8v 449.505n 1.8v 459.495n 1.8v 459.505n 1.8v 469.495n 1.8v 469.505n 0.0v 479.495n 0.0v 479.505n 0.0v 489.495n 0.0v 489.505n 1.8v 499.495n 1.8v 499.505n 1.8v 509.495n 1.8v 509.505n 1.8v 519.495n 1.8v 519.505n 1.8v 529.495n 1.8v 529.505n 1.8v 539.495n 1.8v 539.505n 1.8v 549.495n 1.8v 549.505n 1.8v 559.495n 1.8v 559.505n 1.8v 569.495n 1.8v 569.505n 1.8v 579.495n 1.8v 579.505n 1.8v 589.495n 1.8v 589.505n 1.8v 599.495n 1.8v 599.505n 1.8v 609.495n 1.8v 609.505n 1.8v 619.495n 1.8v 619.505n 0.0v 629.495n 0.0v 629.505n 0.0v 639.495n 0.0v 639.505n 0.0v 649.495n 0.0v 649.505n 0.0v 659.495n 0.0v 659.505n 1.8v 669.495n 1.8v 669.505n 0.0v 679.495n 0.0v 679.505n 0.0v 689.495n 0.0v 689.505n 0.0v 699.495n 0.0v 699.505n 0.0v 709.495n 0.0v 709.505n 0.0v 719.495n 0.0v 719.505n 0.0v 729.495n 0.0v 729.505n 0.0v 739.495n 0.0v 739.505n 0.0v 749.495n 0.0v 749.505n 0.0v 759.495n 0.0v 759.505n 0.0v 769.495n 0.0v 769.505n 1.8v 779.495n 1.8v 779.505n 1.8v 789.495n 1.8v 789.505n 1.8v 799.495n 1.8v 799.505n 1.8v 809.495n 1.8v 809.505n 1.8v 819.495n 1.8v 819.505n 1.8v 829.495n 1.8v 829.505n 1.8v 839.495n 1.8v 839.505n 1.8v 849.495n 1.8v 849.505n 1.8v 859.495n 1.8v 859.505n 1.8v 869.495n 1.8v 869.505n 1.8v 879.495n 1.8v 879.505n 1.8v 889.495n 1.8v 889.505n 0.0v 899.495n 0.0v 899.505n 0.0v 909.495n 0.0v 909.505n 0.0v 919.495n 0.0v 919.505n 0.0v 929.495n 0.0v 929.505n 1.8v 939.495n 1.8v 939.505n 1.8v 949.495n 1.8v 949.505n 1.8v 959.495n 1.8v 959.505n 0.0v 969.495n 0.0v 969.505n 0.0v 979.495n 0.0v 979.505n 0.0v 989.495n 0.0v 989.505n 0.0v 999.495n 0.0v 999.505n 0.0v 1009.495n 0.0v 1009.505n 0.0v 1019.495n 0.0v 1019.505n 0.0v 1029.495n 0.0v 1029.505n 0.0v 1039.495n 0.0v 1039.505n 0.0v 1049.495n 0.0v 1049.505n 0.0v 1059.495n 0.0v 1059.505n 0.0v 1069.495n 0.0v 1069.505n 0.0v 1079.495n 0.0v 1079.505n 0.0v 1089.495n 0.0v 1089.505n 0.0v 1099.495n 0.0v 1099.505n 0.0v 1109.495n 0.0v 1109.505n 0.0v 1119.495n 0.0v 1119.505n 0.0v 1129.495n 0.0v 1129.505n 0.0v 1139.495n 0.0v 1139.505n 0.0v 1149.495n 0.0v 1149.505n 0.0v 1159.495n 0.0v 1159.505n 0.0v 1169.495n 0.0v 1169.505n 0.0v 1179.495n 0.0v 1179.505n 0.0v 1189.495n 0.0v 1189.505n 0.0v 1199.495n 0.0v 1199.505n 0.0v 1209.495n 0.0v 1209.505n 0.0v 1219.495n 0.0v 1219.505n 0.0v 1229.495n 0.0v 1229.505n 0.0v 1239.495n 0.0v 1239.505n 0.0v 1249.495n 0.0v 1249.505n 0.0v 1259.495n 0.0v 1259.505n 1.8v 1269.495n 1.8v 1269.505n 1.8v 1279.495n 1.8v 1279.505n 1.8v 1289.495n 1.8v 1289.505n 1.8v 1299.495n 1.8v 1299.505n 1.8v 1309.495n 1.8v 1309.505n 1.8v 1319.495n 1.8v 1319.505n 1.8v 1329.495n 1.8v 1329.505n 1.8v 1339.495n 1.8v 1339.505n 1.8v 1349.495n 1.8v 1349.505n 1.8v 1359.495n 1.8v 1359.505n 1.8v 1369.495n 1.8v 1369.505n 1.8v 1379.495n 1.8v 1379.505n 1.8v 1389.495n 1.8v 1389.505n 1.8v 1399.495n 1.8v 1399.505n 0.0v 1409.495n 0.0v 1409.505n 0.0v 1419.495n 0.0v 1419.505n 0.0v 1429.495n 0.0v 1429.505n 0.0v 1439.495n 0.0v 1439.505n 0.0v 1449.495n 0.0v 1449.505n 0.0v 1459.495n 0.0v 1459.505n 0.0v 1469.495n 0.0v 1469.505n 0.0v 1479.495n 0.0v 1479.505n 0.0v 1489.495n 0.0v 1489.505n 0.0v 1499.495n 0.0v 1499.505n 0.0v 1509.495n 0.0v 1509.505n 0.0v 1519.495n 0.0v 1519.505n 0.0v 1529.495n 0.0v 1529.505n 0.0v 1539.495n 0.0v 1539.505n 0.0v 1549.495n 0.0v 1549.505n 0.0v 1559.495n 0.0v 1559.505n 0.0v 1569.495n 0.0v 1569.505n 1.8v 1579.495n 1.8v 1579.505n 0.0v 1589.495n 0.0v 1589.505n 1.8v 1599.495n 1.8v 1599.505n 1.8v 1609.495n 1.8v 1609.505n 1.8v 1619.495n 1.8v 1619.505n 0.0v 1629.495n 0.0v 1629.505n 0.0v 1639.495n 0.0v 1639.505n 0.0v 1649.495n 0.0v 1649.505n 0.0v 1659.495n 0.0v 1659.505n 0.0v 1669.495n 0.0v 1669.505n 0.0v 1679.495n 0.0v 1679.505n 0.0v 1689.495n 0.0v 1689.505n 0.0v 1699.495n 0.0v 1699.505n 0.0v 1709.495n 0.0v 1709.505n 1.8v 1719.495n 1.8v 1719.505n 1.8v 1729.495n 1.8v 1729.505n 1.8v 1739.495n 1.8v 1739.505n 0.0v 1749.495n 0.0v 1749.505n 0.0v 1759.495n 0.0v 1759.505n 0.0v 1769.495n 0.0v 1769.505n 0.0v 1779.495n 0.0v 1779.505n 0.0v 1789.495n 0.0v 1789.505n 0.0v 1799.495n 0.0v 1799.505n 0.0v 1809.495n 0.0v 1809.505n 0.0v 1819.495n 0.0v 1819.505n 0.0v 1829.495n 0.0v 1829.505n 0.0v 1839.495n 0.0v 1839.505n 0.0v 1849.495n 0.0v 1849.505n 1.8v 1859.495n 1.8v 1859.505n 0.0v 1869.495n 0.0v 1869.505n 1.8v 1879.495n 1.8v 1879.505n 0.0v 1889.495n 0.0v 1889.505n 0.0v 1899.495n 0.0v 1899.505n 0.0v 1909.495n 0.0v 1909.505n 0.0v 1919.495n 0.0v 1919.505n 0.0v 1929.495n 0.0v 1929.505n 0.0v 1939.495n 0.0v 1939.505n 0.0v 1949.495n 0.0v 1949.505n 0.0v 1959.495n 0.0v 1959.505n 0.0v 1969.495n 0.0v 1969.505n 0.0v 1979.495n 0.0v 1979.505n 0.0v 1989.495n 0.0v 1989.505n 0.0v 1999.495n 0.0v 1999.505n 0.0v 2009.495n 0.0v 2009.505n 0.0v 2019.495n 0.0v 2019.505n 0.0v 2029.495n 0.0v 2029.505n 0.0v 2039.495n 0.0v 2039.505n 0.0v 2049.495n 0.0v 2049.505n 0.0v )
* (time, data): [(0, 0), (10, 0), (20, 0), (30, 0), (40, 0), (50, 0), (60, 1), (70, 1), (80, 1), (90, 1), (100, 1), (110, 1), (120, 1), (130, 1), (140, 1), (150, 0), (160, 0), (170, 0), (180, 0), (190, 0), (200, 0), (210, 0), (220, 0), (230, 0), (240, 0), (250, 0), (260, 1), (270, 1), (280, 1), (290, 1), (300, 1), (310, 0), (320, 0), (330, 0), (340, 0), (350, 0), (360, 0), (370, 0), (380, 0), (390, 1), (400, 0), (410, 0), (420, 0), (430, 0), (440, 0), (450, 1), (460, 1), (470, 1), (480, 1), (490, 1), (500, 1), (510, 1), (520, 1), (530, 1), (540, 1), (550, 1), (560, 1), (570, 1), (580, 1), (590, 1), (600, 1), (610, 1), (620, 0), (630, 0), (640, 0), (650, 0), (660, 1), (670, 0), (680, 0), (690, 0), (700, 0), (710, 1), (720, 1), (730, 1), (740, 1), (750, 1), (760, 1), (770, 0), (780, 0), (790, 0), (800, 0), (810, 0), (820, 1), (830, 1), (840, 0), (850, 0), (860, 0), (870, 0), (880, 0), (890, 0), (900, 0), (910, 0), (920, 0), (930, 1), (940, 1), (950, 1), (960, 0), (970, 0), (980, 0), (990, 0), (1000, 0), (1010, 0), (1020, 0), (1030, 0), (1040, 0), (1050, 0), (1060, 0), (1070, 0), (1080, 0), (1090, 0), (1100, 0), (1110, 0), (1120, 0), (1130, 0), (1140, 0), (1150, 0), (1160, 0), (1170, 0), (1180, 0), (1190, 0), (1200, 0), (1210, 0), (1220, 0), (1230, 0), (1240, 0), (1250, 0), (1260, 0), (1270, 0), (1280, 1), (1290, 1), (1300, 1), (1310, 1), (1320, 1), (1330, 1), (1340, 1), (1350, 1), (1360, 1), (1370, 1), (1380, 1), (1390, 1), (1400, 1), (1410, 1), (1420, 1), (1430, 1), (1440, 1), (1450, 1), (1460, 1), (1470, 1), (1480, 0), (1490, 0), (1500, 1), (1510, 1), (1520, 1), (1530, 1), (1540, 1), (1550, 1), (1560, 1), (1570, 0), (1580, 1), (1590, 1), (1600, 1), (1610, 1), (1620, 0), (1630, 0), (1640, 0), (1650, 0), (1660, 0), (1670, 0), (1680, 0), (1690, 1), (1700, 1), (1710, 0), (1720, 0), (1730, 1), (1740, 0), (1750, 0), (1760, 0), (1770, 0), (1780, 0), (1790, 1), (1800, 1), (1810, 1), (1820, 1), (1830, 1), (1840, 1), (1850, 0), (1860, 1), (1870, 1), (1880, 1), (1890, 0), (1900, 0), (1910, 1), (1920, 1), (1930, 1), (1940, 1), (1950, 1), (1960, 1), (1970, 1), (1980, 1), (1990, 1), (2000, 1), (2010, 1), (2020, 1), (2030, 0), (2040, 0), (2050, 0)]
Vdin0_19  din0_19  0 PWL (0n 0.0v 9.495n 0.0v 9.505n 0.0v 19.495n 0.0v 19.505n 0.0v 29.495n 0.0v 29.505n 0.0v 39.495n 0.0v 39.505n 0.0v 49.495n 0.0v 49.505n 0.0v 59.495n 0.0v 59.505n 1.8v 69.495n 1.8v 69.505n 1.8v 79.495n 1.8v 79.505n 1.8v 89.495n 1.8v 89.505n 1.8v 99.495n 1.8v 99.505n 1.8v 109.495n 1.8v 109.505n 1.8v 119.495n 1.8v 119.505n 1.8v 129.495n 1.8v 129.505n 1.8v 139.495n 1.8v 139.505n 1.8v 149.495n 1.8v 149.505n 0.0v 159.495n 0.0v 159.505n 0.0v 169.495n 0.0v 169.505n 0.0v 179.495n 0.0v 179.505n 0.0v 189.495n 0.0v 189.505n 0.0v 199.495n 0.0v 199.505n 0.0v 209.495n 0.0v 209.505n 0.0v 219.495n 0.0v 219.505n 0.0v 229.495n 0.0v 229.505n 0.0v 239.495n 0.0v 239.505n 0.0v 249.495n 0.0v 249.505n 0.0v 259.495n 0.0v 259.505n 1.8v 269.495n 1.8v 269.505n 1.8v 279.495n 1.8v 279.505n 1.8v 289.495n 1.8v 289.505n 1.8v 299.495n 1.8v 299.505n 1.8v 309.495n 1.8v 309.505n 0.0v 319.495n 0.0v 319.505n 0.0v 329.495n 0.0v 329.505n 0.0v 339.495n 0.0v 339.505n 0.0v 349.495n 0.0v 349.505n 0.0v 359.495n 0.0v 359.505n 0.0v 369.495n 0.0v 369.505n 0.0v 379.495n 0.0v 379.505n 0.0v 389.495n 0.0v 389.505n 1.8v 399.495n 1.8v 399.505n 0.0v 409.495n 0.0v 409.505n 0.0v 419.495n 0.0v 419.505n 0.0v 429.495n 0.0v 429.505n 0.0v 439.495n 0.0v 439.505n 0.0v 449.495n 0.0v 449.505n 1.8v 459.495n 1.8v 459.505n 1.8v 469.495n 1.8v 469.505n 1.8v 479.495n 1.8v 479.505n 1.8v 489.495n 1.8v 489.505n 1.8v 499.495n 1.8v 499.505n 1.8v 509.495n 1.8v 509.505n 1.8v 519.495n 1.8v 519.505n 1.8v 529.495n 1.8v 529.505n 1.8v 539.495n 1.8v 539.505n 1.8v 549.495n 1.8v 549.505n 1.8v 559.495n 1.8v 559.505n 1.8v 569.495n 1.8v 569.505n 1.8v 579.495n 1.8v 579.505n 1.8v 589.495n 1.8v 589.505n 1.8v 599.495n 1.8v 599.505n 1.8v 609.495n 1.8v 609.505n 1.8v 619.495n 1.8v 619.505n 0.0v 629.495n 0.0v 629.505n 0.0v 639.495n 0.0v 639.505n 0.0v 649.495n 0.0v 649.505n 0.0v 659.495n 0.0v 659.505n 1.8v 669.495n 1.8v 669.505n 0.0v 679.495n 0.0v 679.505n 0.0v 689.495n 0.0v 689.505n 0.0v 699.495n 0.0v 699.505n 0.0v 709.495n 0.0v 709.505n 1.8v 719.495n 1.8v 719.505n 1.8v 729.495n 1.8v 729.505n 1.8v 739.495n 1.8v 739.505n 1.8v 749.495n 1.8v 749.505n 1.8v 759.495n 1.8v 759.505n 1.8v 769.495n 1.8v 769.505n 0.0v 779.495n 0.0v 779.505n 0.0v 789.495n 0.0v 789.505n 0.0v 799.495n 0.0v 799.505n 0.0v 809.495n 0.0v 809.505n 0.0v 819.495n 0.0v 819.505n 1.8v 829.495n 1.8v 829.505n 1.8v 839.495n 1.8v 839.505n 0.0v 849.495n 0.0v 849.505n 0.0v 859.495n 0.0v 859.505n 0.0v 869.495n 0.0v 869.505n 0.0v 879.495n 0.0v 879.505n 0.0v 889.495n 0.0v 889.505n 0.0v 899.495n 0.0v 899.505n 0.0v 909.495n 0.0v 909.505n 0.0v 919.495n 0.0v 919.505n 0.0v 929.495n 0.0v 929.505n 1.8v 939.495n 1.8v 939.505n 1.8v 949.495n 1.8v 949.505n 1.8v 959.495n 1.8v 959.505n 0.0v 969.495n 0.0v 969.505n 0.0v 979.495n 0.0v 979.505n 0.0v 989.495n 0.0v 989.505n 0.0v 999.495n 0.0v 999.505n 0.0v 1009.495n 0.0v 1009.505n 0.0v 1019.495n 0.0v 1019.505n 0.0v 1029.495n 0.0v 1029.505n 0.0v 1039.495n 0.0v 1039.505n 0.0v 1049.495n 0.0v 1049.505n 0.0v 1059.495n 0.0v 1059.505n 0.0v 1069.495n 0.0v 1069.505n 0.0v 1079.495n 0.0v 1079.505n 0.0v 1089.495n 0.0v 1089.505n 0.0v 1099.495n 0.0v 1099.505n 0.0v 1109.495n 0.0v 1109.505n 0.0v 1119.495n 0.0v 1119.505n 0.0v 1129.495n 0.0v 1129.505n 0.0v 1139.495n 0.0v 1139.505n 0.0v 1149.495n 0.0v 1149.505n 0.0v 1159.495n 0.0v 1159.505n 0.0v 1169.495n 0.0v 1169.505n 0.0v 1179.495n 0.0v 1179.505n 0.0v 1189.495n 0.0v 1189.505n 0.0v 1199.495n 0.0v 1199.505n 0.0v 1209.495n 0.0v 1209.505n 0.0v 1219.495n 0.0v 1219.505n 0.0v 1229.495n 0.0v 1229.505n 0.0v 1239.495n 0.0v 1239.505n 0.0v 1249.495n 0.0v 1249.505n 0.0v 1259.495n 0.0v 1259.505n 0.0v 1269.495n 0.0v 1269.505n 0.0v 1279.495n 0.0v 1279.505n 1.8v 1289.495n 1.8v 1289.505n 1.8v 1299.495n 1.8v 1299.505n 1.8v 1309.495n 1.8v 1309.505n 1.8v 1319.495n 1.8v 1319.505n 1.8v 1329.495n 1.8v 1329.505n 1.8v 1339.495n 1.8v 1339.505n 1.8v 1349.495n 1.8v 1349.505n 1.8v 1359.495n 1.8v 1359.505n 1.8v 1369.495n 1.8v 1369.505n 1.8v 1379.495n 1.8v 1379.505n 1.8v 1389.495n 1.8v 1389.505n 1.8v 1399.495n 1.8v 1399.505n 1.8v 1409.495n 1.8v 1409.505n 1.8v 1419.495n 1.8v 1419.505n 1.8v 1429.495n 1.8v 1429.505n 1.8v 1439.495n 1.8v 1439.505n 1.8v 1449.495n 1.8v 1449.505n 1.8v 1459.495n 1.8v 1459.505n 1.8v 1469.495n 1.8v 1469.505n 1.8v 1479.495n 1.8v 1479.505n 0.0v 1489.495n 0.0v 1489.505n 0.0v 1499.495n 0.0v 1499.505n 1.8v 1509.495n 1.8v 1509.505n 1.8v 1519.495n 1.8v 1519.505n 1.8v 1529.495n 1.8v 1529.505n 1.8v 1539.495n 1.8v 1539.505n 1.8v 1549.495n 1.8v 1549.505n 1.8v 1559.495n 1.8v 1559.505n 1.8v 1569.495n 1.8v 1569.505n 0.0v 1579.495n 0.0v 1579.505n 1.8v 1589.495n 1.8v 1589.505n 1.8v 1599.495n 1.8v 1599.505n 1.8v 1609.495n 1.8v 1609.505n 1.8v 1619.495n 1.8v 1619.505n 0.0v 1629.495n 0.0v 1629.505n 0.0v 1639.495n 0.0v 1639.505n 0.0v 1649.495n 0.0v 1649.505n 0.0v 1659.495n 0.0v 1659.505n 0.0v 1669.495n 0.0v 1669.505n 0.0v 1679.495n 0.0v 1679.505n 0.0v 1689.495n 0.0v 1689.505n 1.8v 1699.495n 1.8v 1699.505n 1.8v 1709.495n 1.8v 1709.505n 0.0v 1719.495n 0.0v 1719.505n 0.0v 1729.495n 0.0v 1729.505n 1.8v 1739.495n 1.8v 1739.505n 0.0v 1749.495n 0.0v 1749.505n 0.0v 1759.495n 0.0v 1759.505n 0.0v 1769.495n 0.0v 1769.505n 0.0v 1779.495n 0.0v 1779.505n 0.0v 1789.495n 0.0v 1789.505n 1.8v 1799.495n 1.8v 1799.505n 1.8v 1809.495n 1.8v 1809.505n 1.8v 1819.495n 1.8v 1819.505n 1.8v 1829.495n 1.8v 1829.505n 1.8v 1839.495n 1.8v 1839.505n 1.8v 1849.495n 1.8v 1849.505n 0.0v 1859.495n 0.0v 1859.505n 1.8v 1869.495n 1.8v 1869.505n 1.8v 1879.495n 1.8v 1879.505n 1.8v 1889.495n 1.8v 1889.505n 0.0v 1899.495n 0.0v 1899.505n 0.0v 1909.495n 0.0v 1909.505n 1.8v 1919.495n 1.8v 1919.505n 1.8v 1929.495n 1.8v 1929.505n 1.8v 1939.495n 1.8v 1939.505n 1.8v 1949.495n 1.8v 1949.505n 1.8v 1959.495n 1.8v 1959.505n 1.8v 1969.495n 1.8v 1969.505n 1.8v 1979.495n 1.8v 1979.505n 1.8v 1989.495n 1.8v 1989.505n 1.8v 1999.495n 1.8v 1999.505n 1.8v 2009.495n 1.8v 2009.505n 1.8v 2019.495n 1.8v 2019.505n 1.8v 2029.495n 1.8v 2029.505n 0.0v 2039.495n 0.0v 2039.505n 0.0v 2049.495n 0.0v 2049.505n 0.0v )
* (time, data): [(0, 0), (10, 1), (20, 1), (30, 0), (40, 0), (50, 0), (60, 0), (70, 0), (80, 0), (90, 0), (100, 0), (110, 0), (120, 0), (130, 0), (140, 0), (150, 0), (160, 0), (170, 0), (180, 0), (190, 0), (200, 0), (210, 0), (220, 0), (230, 0), (240, 0), (250, 0), (260, 1), (270, 1), (280, 1), (290, 1), (300, 1), (310, 0), (320, 0), (330, 0), (340, 0), (350, 1), (360, 1), (370, 1), (380, 1), (390, 1), (400, 0), (410, 0), (420, 1), (430, 1), (440, 1), (450, 1), (460, 1), (470, 1), (480, 1), (490, 1), (500, 0), (510, 0), (520, 0), (530, 0), (540, 0), (550, 0), (560, 0), (570, 0), (580, 0), (590, 0), (600, 0), (610, 0), (620, 0), (630, 0), (640, 0), (650, 0), (660, 0), (670, 0), (680, 0), (690, 0), (700, 0), (710, 0), (720, 0), (730, 0), (740, 0), (750, 0), (760, 0), (770, 1), (780, 1), (790, 1), (800, 1), (810, 1), (820, 0), (830, 0), (840, 0), (850, 0), (860, 0), (870, 0), (880, 0), (890, 0), (900, 0), (910, 0), (920, 0), (930, 1), (940, 1), (950, 1), (960, 1), (970, 1), (980, 1), (990, 1), (1000, 1), (1010, 1), (1020, 1), (1030, 1), (1040, 1), (1050, 1), (1060, 1), (1070, 1), (1080, 1), (1090, 1), (1100, 1), (1110, 1), (1120, 1), (1130, 1), (1140, 1), (1150, 1), (1160, 1), (1170, 1), (1180, 1), (1190, 1), (1200, 1), (1210, 1), (1220, 1), (1230, 1), (1240, 1), (1250, 1), (1260, 0), (1270, 0), (1280, 0), (1290, 0), (1300, 0), (1310, 0), (1320, 0), (1330, 0), (1340, 0), (1350, 0), (1360, 0), (1370, 0), (1380, 0), (1390, 0), (1400, 1), (1410, 1), (1420, 1), (1430, 1), (1440, 1), (1450, 1), (1460, 1), (1470, 1), (1480, 0), (1490, 0), (1500, 1), (1510, 1), (1520, 1), (1530, 1), (1540, 1), (1550, 1), (1560, 1), (1570, 0), (1580, 1), (1590, 1), (1600, 1), (1610, 1), (1620, 1), (1630, 1), (1640, 1), (1650, 1), (1660, 1), (1670, 1), (1680, 1), (1690, 0), (1700, 0), (1710, 0), (1720, 0), (1730, 0), (1740, 0), (1750, 0), (1760, 0), (1770, 0), (1780, 0), (1790, 1), (1800, 1), (1810, 1), (1820, 1), (1830, 1), (1840, 1), (1850, 0), (1860, 0), (1870, 1), (1880, 1), (1890, 0), (1900, 0), (1910, 1), (1920, 1), (1930, 1), (1940, 1), (1950, 1), (1960, 1), (1970, 1), (1980, 1), (1990, 1), (2000, 1), (2010, 1), (2020, 1), (2030, 1), (2040, 1), (2050, 1)]
Vdin0_20  din0_20  0 PWL (0n 0.0v 9.495n 0.0v 9.505n 1.8v 19.495n 1.8v 19.505n 1.8v 29.495n 1.8v 29.505n 0.0v 39.495n 0.0v 39.505n 0.0v 49.495n 0.0v 49.505n 0.0v 59.495n 0.0v 59.505n 0.0v 69.495n 0.0v 69.505n 0.0v 79.495n 0.0v 79.505n 0.0v 89.495n 0.0v 89.505n 0.0v 99.495n 0.0v 99.505n 0.0v 109.495n 0.0v 109.505n 0.0v 119.495n 0.0v 119.505n 0.0v 129.495n 0.0v 129.505n 0.0v 139.495n 0.0v 139.505n 0.0v 149.495n 0.0v 149.505n 0.0v 159.495n 0.0v 159.505n 0.0v 169.495n 0.0v 169.505n 0.0v 179.495n 0.0v 179.505n 0.0v 189.495n 0.0v 189.505n 0.0v 199.495n 0.0v 199.505n 0.0v 209.495n 0.0v 209.505n 0.0v 219.495n 0.0v 219.505n 0.0v 229.495n 0.0v 229.505n 0.0v 239.495n 0.0v 239.505n 0.0v 249.495n 0.0v 249.505n 0.0v 259.495n 0.0v 259.505n 1.8v 269.495n 1.8v 269.505n 1.8v 279.495n 1.8v 279.505n 1.8v 289.495n 1.8v 289.505n 1.8v 299.495n 1.8v 299.505n 1.8v 309.495n 1.8v 309.505n 0.0v 319.495n 0.0v 319.505n 0.0v 329.495n 0.0v 329.505n 0.0v 339.495n 0.0v 339.505n 0.0v 349.495n 0.0v 349.505n 1.8v 359.495n 1.8v 359.505n 1.8v 369.495n 1.8v 369.505n 1.8v 379.495n 1.8v 379.505n 1.8v 389.495n 1.8v 389.505n 1.8v 399.495n 1.8v 399.505n 0.0v 409.495n 0.0v 409.505n 0.0v 419.495n 0.0v 419.505n 1.8v 429.495n 1.8v 429.505n 1.8v 439.495n 1.8v 439.505n 1.8v 449.495n 1.8v 449.505n 1.8v 459.495n 1.8v 459.505n 1.8v 469.495n 1.8v 469.505n 1.8v 479.495n 1.8v 479.505n 1.8v 489.495n 1.8v 489.505n 1.8v 499.495n 1.8v 499.505n 0.0v 509.495n 0.0v 509.505n 0.0v 519.495n 0.0v 519.505n 0.0v 529.495n 0.0v 529.505n 0.0v 539.495n 0.0v 539.505n 0.0v 549.495n 0.0v 549.505n 0.0v 559.495n 0.0v 559.505n 0.0v 569.495n 0.0v 569.505n 0.0v 579.495n 0.0v 579.505n 0.0v 589.495n 0.0v 589.505n 0.0v 599.495n 0.0v 599.505n 0.0v 609.495n 0.0v 609.505n 0.0v 619.495n 0.0v 619.505n 0.0v 629.495n 0.0v 629.505n 0.0v 639.495n 0.0v 639.505n 0.0v 649.495n 0.0v 649.505n 0.0v 659.495n 0.0v 659.505n 0.0v 669.495n 0.0v 669.505n 0.0v 679.495n 0.0v 679.505n 0.0v 689.495n 0.0v 689.505n 0.0v 699.495n 0.0v 699.505n 0.0v 709.495n 0.0v 709.505n 0.0v 719.495n 0.0v 719.505n 0.0v 729.495n 0.0v 729.505n 0.0v 739.495n 0.0v 739.505n 0.0v 749.495n 0.0v 749.505n 0.0v 759.495n 0.0v 759.505n 0.0v 769.495n 0.0v 769.505n 1.8v 779.495n 1.8v 779.505n 1.8v 789.495n 1.8v 789.505n 1.8v 799.495n 1.8v 799.505n 1.8v 809.495n 1.8v 809.505n 1.8v 819.495n 1.8v 819.505n 0.0v 829.495n 0.0v 829.505n 0.0v 839.495n 0.0v 839.505n 0.0v 849.495n 0.0v 849.505n 0.0v 859.495n 0.0v 859.505n 0.0v 869.495n 0.0v 869.505n 0.0v 879.495n 0.0v 879.505n 0.0v 889.495n 0.0v 889.505n 0.0v 899.495n 0.0v 899.505n 0.0v 909.495n 0.0v 909.505n 0.0v 919.495n 0.0v 919.505n 0.0v 929.495n 0.0v 929.505n 1.8v 939.495n 1.8v 939.505n 1.8v 949.495n 1.8v 949.505n 1.8v 959.495n 1.8v 959.505n 1.8v 969.495n 1.8v 969.505n 1.8v 979.495n 1.8v 979.505n 1.8v 989.495n 1.8v 989.505n 1.8v 999.495n 1.8v 999.505n 1.8v 1009.495n 1.8v 1009.505n 1.8v 1019.495n 1.8v 1019.505n 1.8v 1029.495n 1.8v 1029.505n 1.8v 1039.495n 1.8v 1039.505n 1.8v 1049.495n 1.8v 1049.505n 1.8v 1059.495n 1.8v 1059.505n 1.8v 1069.495n 1.8v 1069.505n 1.8v 1079.495n 1.8v 1079.505n 1.8v 1089.495n 1.8v 1089.505n 1.8v 1099.495n 1.8v 1099.505n 1.8v 1109.495n 1.8v 1109.505n 1.8v 1119.495n 1.8v 1119.505n 1.8v 1129.495n 1.8v 1129.505n 1.8v 1139.495n 1.8v 1139.505n 1.8v 1149.495n 1.8v 1149.505n 1.8v 1159.495n 1.8v 1159.505n 1.8v 1169.495n 1.8v 1169.505n 1.8v 1179.495n 1.8v 1179.505n 1.8v 1189.495n 1.8v 1189.505n 1.8v 1199.495n 1.8v 1199.505n 1.8v 1209.495n 1.8v 1209.505n 1.8v 1219.495n 1.8v 1219.505n 1.8v 1229.495n 1.8v 1229.505n 1.8v 1239.495n 1.8v 1239.505n 1.8v 1249.495n 1.8v 1249.505n 1.8v 1259.495n 1.8v 1259.505n 0.0v 1269.495n 0.0v 1269.505n 0.0v 1279.495n 0.0v 1279.505n 0.0v 1289.495n 0.0v 1289.505n 0.0v 1299.495n 0.0v 1299.505n 0.0v 1309.495n 0.0v 1309.505n 0.0v 1319.495n 0.0v 1319.505n 0.0v 1329.495n 0.0v 1329.505n 0.0v 1339.495n 0.0v 1339.505n 0.0v 1349.495n 0.0v 1349.505n 0.0v 1359.495n 0.0v 1359.505n 0.0v 1369.495n 0.0v 1369.505n 0.0v 1379.495n 0.0v 1379.505n 0.0v 1389.495n 0.0v 1389.505n 0.0v 1399.495n 0.0v 1399.505n 1.8v 1409.495n 1.8v 1409.505n 1.8v 1419.495n 1.8v 1419.505n 1.8v 1429.495n 1.8v 1429.505n 1.8v 1439.495n 1.8v 1439.505n 1.8v 1449.495n 1.8v 1449.505n 1.8v 1459.495n 1.8v 1459.505n 1.8v 1469.495n 1.8v 1469.505n 1.8v 1479.495n 1.8v 1479.505n 0.0v 1489.495n 0.0v 1489.505n 0.0v 1499.495n 0.0v 1499.505n 1.8v 1509.495n 1.8v 1509.505n 1.8v 1519.495n 1.8v 1519.505n 1.8v 1529.495n 1.8v 1529.505n 1.8v 1539.495n 1.8v 1539.505n 1.8v 1549.495n 1.8v 1549.505n 1.8v 1559.495n 1.8v 1559.505n 1.8v 1569.495n 1.8v 1569.505n 0.0v 1579.495n 0.0v 1579.505n 1.8v 1589.495n 1.8v 1589.505n 1.8v 1599.495n 1.8v 1599.505n 1.8v 1609.495n 1.8v 1609.505n 1.8v 1619.495n 1.8v 1619.505n 1.8v 1629.495n 1.8v 1629.505n 1.8v 1639.495n 1.8v 1639.505n 1.8v 1649.495n 1.8v 1649.505n 1.8v 1659.495n 1.8v 1659.505n 1.8v 1669.495n 1.8v 1669.505n 1.8v 1679.495n 1.8v 1679.505n 1.8v 1689.495n 1.8v 1689.505n 0.0v 1699.495n 0.0v 1699.505n 0.0v 1709.495n 0.0v 1709.505n 0.0v 1719.495n 0.0v 1719.505n 0.0v 1729.495n 0.0v 1729.505n 0.0v 1739.495n 0.0v 1739.505n 0.0v 1749.495n 0.0v 1749.505n 0.0v 1759.495n 0.0v 1759.505n 0.0v 1769.495n 0.0v 1769.505n 0.0v 1779.495n 0.0v 1779.505n 0.0v 1789.495n 0.0v 1789.505n 1.8v 1799.495n 1.8v 1799.505n 1.8v 1809.495n 1.8v 1809.505n 1.8v 1819.495n 1.8v 1819.505n 1.8v 1829.495n 1.8v 1829.505n 1.8v 1839.495n 1.8v 1839.505n 1.8v 1849.495n 1.8v 1849.505n 0.0v 1859.495n 0.0v 1859.505n 0.0v 1869.495n 0.0v 1869.505n 1.8v 1879.495n 1.8v 1879.505n 1.8v 1889.495n 1.8v 1889.505n 0.0v 1899.495n 0.0v 1899.505n 0.0v 1909.495n 0.0v 1909.505n 1.8v 1919.495n 1.8v 1919.505n 1.8v 1929.495n 1.8v 1929.505n 1.8v 1939.495n 1.8v 1939.505n 1.8v 1949.495n 1.8v 1949.505n 1.8v 1959.495n 1.8v 1959.505n 1.8v 1969.495n 1.8v 1969.505n 1.8v 1979.495n 1.8v 1979.505n 1.8v 1989.495n 1.8v 1989.505n 1.8v 1999.495n 1.8v 1999.505n 1.8v 2009.495n 1.8v 2009.505n 1.8v 2019.495n 1.8v 2019.505n 1.8v 2029.495n 1.8v 2029.505n 1.8v 2039.495n 1.8v 2039.505n 1.8v 2049.495n 1.8v 2049.505n 1.8v )
* (time, data): [(0, 0), (10, 0), (20, 1), (30, 0), (40, 0), (50, 0), (60, 1), (70, 1), (80, 1), (90, 1), (100, 1), (110, 1), (120, 1), (130, 1), (140, 1), (150, 1), (160, 1), (170, 1), (180, 1), (190, 1), (200, 1), (210, 1), (220, 1), (230, 1), (240, 1), (250, 1), (260, 0), (270, 0), (280, 0), (290, 0), (300, 0), (310, 0), (320, 0), (330, 0), (340, 0), (350, 0), (360, 0), (370, 0), (380, 0), (390, 1), (400, 0), (410, 0), (420, 1), (430, 1), (440, 1), (450, 1), (460, 1), (470, 1), (480, 1), (490, 1), (500, 0), (510, 0), (520, 0), (530, 0), (540, 0), (550, 0), (560, 0), (570, 0), (580, 0), (590, 0), (600, 0), (610, 0), (620, 1), (630, 1), (640, 1), (650, 1), (660, 1), (670, 1), (680, 1), (690, 1), (700, 1), (710, 0), (720, 0), (730, 0), (740, 0), (750, 0), (760, 0), (770, 1), (780, 1), (790, 1), (800, 1), (810, 1), (820, 0), (830, 0), (840, 1), (850, 1), (860, 1), (870, 1), (880, 1), (890, 0), (900, 0), (910, 0), (920, 0), (930, 0), (940, 0), (950, 0), (960, 0), (970, 0), (980, 0), (990, 0), (1000, 0), (1010, 0), (1020, 0), (1030, 0), (1040, 0), (1050, 0), (1060, 0), (1070, 0), (1080, 1), (1090, 1), (1100, 1), (1110, 1), (1120, 1), (1130, 0), (1140, 0), (1150, 0), (1160, 0), (1170, 0), (1180, 0), (1190, 0), (1200, 0), (1210, 0), (1220, 0), (1230, 0), (1240, 0), (1250, 0), (1260, 1), (1270, 1), (1280, 0), (1290, 0), (1300, 0), (1310, 0), (1320, 0), (1330, 0), (1340, 0), (1350, 0), (1360, 0), (1370, 0), (1380, 0), (1390, 0), (1400, 1), (1410, 1), (1420, 1), (1430, 1), (1440, 1), (1450, 1), (1460, 1), (1470, 1), (1480, 1), (1490, 1), (1500, 1), (1510, 1), (1520, 1), (1530, 1), (1540, 1), (1550, 1), (1560, 1), (1570, 0), (1580, 0), (1590, 1), (1600, 1), (1610, 1), (1620, 0), (1630, 0), (1640, 0), (1650, 0), (1660, 0), (1670, 0), (1680, 0), (1690, 1), (1700, 1), (1710, 0), (1720, 0), (1730, 0), (1740, 1), (1750, 1), (1760, 1), (1770, 1), (1780, 1), (1790, 0), (1800, 0), (1810, 0), (1820, 0), (1830, 0), (1840, 0), (1850, 1), (1860, 0), (1870, 1), (1880, 0), (1890, 1), (1900, 1), (1910, 1), (1920, 1), (1930, 1), (1940, 1), (1950, 1), (1960, 1), (1970, 1), (1980, 1), (1990, 1), (2000, 1), (2010, 1), (2020, 1), (2030, 0), (2040, 0), (2050, 0)]
Vdin0_21  din0_21  0 PWL (0n 0.0v 9.495n 0.0v 9.505n 0.0v 19.495n 0.0v 19.505n 1.8v 29.495n 1.8v 29.505n 0.0v 39.495n 0.0v 39.505n 0.0v 49.495n 0.0v 49.505n 0.0v 59.495n 0.0v 59.505n 1.8v 69.495n 1.8v 69.505n 1.8v 79.495n 1.8v 79.505n 1.8v 89.495n 1.8v 89.505n 1.8v 99.495n 1.8v 99.505n 1.8v 109.495n 1.8v 109.505n 1.8v 119.495n 1.8v 119.505n 1.8v 129.495n 1.8v 129.505n 1.8v 139.495n 1.8v 139.505n 1.8v 149.495n 1.8v 149.505n 1.8v 159.495n 1.8v 159.505n 1.8v 169.495n 1.8v 169.505n 1.8v 179.495n 1.8v 179.505n 1.8v 189.495n 1.8v 189.505n 1.8v 199.495n 1.8v 199.505n 1.8v 209.495n 1.8v 209.505n 1.8v 219.495n 1.8v 219.505n 1.8v 229.495n 1.8v 229.505n 1.8v 239.495n 1.8v 239.505n 1.8v 249.495n 1.8v 249.505n 1.8v 259.495n 1.8v 259.505n 0.0v 269.495n 0.0v 269.505n 0.0v 279.495n 0.0v 279.505n 0.0v 289.495n 0.0v 289.505n 0.0v 299.495n 0.0v 299.505n 0.0v 309.495n 0.0v 309.505n 0.0v 319.495n 0.0v 319.505n 0.0v 329.495n 0.0v 329.505n 0.0v 339.495n 0.0v 339.505n 0.0v 349.495n 0.0v 349.505n 0.0v 359.495n 0.0v 359.505n 0.0v 369.495n 0.0v 369.505n 0.0v 379.495n 0.0v 379.505n 0.0v 389.495n 0.0v 389.505n 1.8v 399.495n 1.8v 399.505n 0.0v 409.495n 0.0v 409.505n 0.0v 419.495n 0.0v 419.505n 1.8v 429.495n 1.8v 429.505n 1.8v 439.495n 1.8v 439.505n 1.8v 449.495n 1.8v 449.505n 1.8v 459.495n 1.8v 459.505n 1.8v 469.495n 1.8v 469.505n 1.8v 479.495n 1.8v 479.505n 1.8v 489.495n 1.8v 489.505n 1.8v 499.495n 1.8v 499.505n 0.0v 509.495n 0.0v 509.505n 0.0v 519.495n 0.0v 519.505n 0.0v 529.495n 0.0v 529.505n 0.0v 539.495n 0.0v 539.505n 0.0v 549.495n 0.0v 549.505n 0.0v 559.495n 0.0v 559.505n 0.0v 569.495n 0.0v 569.505n 0.0v 579.495n 0.0v 579.505n 0.0v 589.495n 0.0v 589.505n 0.0v 599.495n 0.0v 599.505n 0.0v 609.495n 0.0v 609.505n 0.0v 619.495n 0.0v 619.505n 1.8v 629.495n 1.8v 629.505n 1.8v 639.495n 1.8v 639.505n 1.8v 649.495n 1.8v 649.505n 1.8v 659.495n 1.8v 659.505n 1.8v 669.495n 1.8v 669.505n 1.8v 679.495n 1.8v 679.505n 1.8v 689.495n 1.8v 689.505n 1.8v 699.495n 1.8v 699.505n 1.8v 709.495n 1.8v 709.505n 0.0v 719.495n 0.0v 719.505n 0.0v 729.495n 0.0v 729.505n 0.0v 739.495n 0.0v 739.505n 0.0v 749.495n 0.0v 749.505n 0.0v 759.495n 0.0v 759.505n 0.0v 769.495n 0.0v 769.505n 1.8v 779.495n 1.8v 779.505n 1.8v 789.495n 1.8v 789.505n 1.8v 799.495n 1.8v 799.505n 1.8v 809.495n 1.8v 809.505n 1.8v 819.495n 1.8v 819.505n 0.0v 829.495n 0.0v 829.505n 0.0v 839.495n 0.0v 839.505n 1.8v 849.495n 1.8v 849.505n 1.8v 859.495n 1.8v 859.505n 1.8v 869.495n 1.8v 869.505n 1.8v 879.495n 1.8v 879.505n 1.8v 889.495n 1.8v 889.505n 0.0v 899.495n 0.0v 899.505n 0.0v 909.495n 0.0v 909.505n 0.0v 919.495n 0.0v 919.505n 0.0v 929.495n 0.0v 929.505n 0.0v 939.495n 0.0v 939.505n 0.0v 949.495n 0.0v 949.505n 0.0v 959.495n 0.0v 959.505n 0.0v 969.495n 0.0v 969.505n 0.0v 979.495n 0.0v 979.505n 0.0v 989.495n 0.0v 989.505n 0.0v 999.495n 0.0v 999.505n 0.0v 1009.495n 0.0v 1009.505n 0.0v 1019.495n 0.0v 1019.505n 0.0v 1029.495n 0.0v 1029.505n 0.0v 1039.495n 0.0v 1039.505n 0.0v 1049.495n 0.0v 1049.505n 0.0v 1059.495n 0.0v 1059.505n 0.0v 1069.495n 0.0v 1069.505n 0.0v 1079.495n 0.0v 1079.505n 1.8v 1089.495n 1.8v 1089.505n 1.8v 1099.495n 1.8v 1099.505n 1.8v 1109.495n 1.8v 1109.505n 1.8v 1119.495n 1.8v 1119.505n 1.8v 1129.495n 1.8v 1129.505n 0.0v 1139.495n 0.0v 1139.505n 0.0v 1149.495n 0.0v 1149.505n 0.0v 1159.495n 0.0v 1159.505n 0.0v 1169.495n 0.0v 1169.505n 0.0v 1179.495n 0.0v 1179.505n 0.0v 1189.495n 0.0v 1189.505n 0.0v 1199.495n 0.0v 1199.505n 0.0v 1209.495n 0.0v 1209.505n 0.0v 1219.495n 0.0v 1219.505n 0.0v 1229.495n 0.0v 1229.505n 0.0v 1239.495n 0.0v 1239.505n 0.0v 1249.495n 0.0v 1249.505n 0.0v 1259.495n 0.0v 1259.505n 1.8v 1269.495n 1.8v 1269.505n 1.8v 1279.495n 1.8v 1279.505n 0.0v 1289.495n 0.0v 1289.505n 0.0v 1299.495n 0.0v 1299.505n 0.0v 1309.495n 0.0v 1309.505n 0.0v 1319.495n 0.0v 1319.505n 0.0v 1329.495n 0.0v 1329.505n 0.0v 1339.495n 0.0v 1339.505n 0.0v 1349.495n 0.0v 1349.505n 0.0v 1359.495n 0.0v 1359.505n 0.0v 1369.495n 0.0v 1369.505n 0.0v 1379.495n 0.0v 1379.505n 0.0v 1389.495n 0.0v 1389.505n 0.0v 1399.495n 0.0v 1399.505n 1.8v 1409.495n 1.8v 1409.505n 1.8v 1419.495n 1.8v 1419.505n 1.8v 1429.495n 1.8v 1429.505n 1.8v 1439.495n 1.8v 1439.505n 1.8v 1449.495n 1.8v 1449.505n 1.8v 1459.495n 1.8v 1459.505n 1.8v 1469.495n 1.8v 1469.505n 1.8v 1479.495n 1.8v 1479.505n 1.8v 1489.495n 1.8v 1489.505n 1.8v 1499.495n 1.8v 1499.505n 1.8v 1509.495n 1.8v 1509.505n 1.8v 1519.495n 1.8v 1519.505n 1.8v 1529.495n 1.8v 1529.505n 1.8v 1539.495n 1.8v 1539.505n 1.8v 1549.495n 1.8v 1549.505n 1.8v 1559.495n 1.8v 1559.505n 1.8v 1569.495n 1.8v 1569.505n 0.0v 1579.495n 0.0v 1579.505n 0.0v 1589.495n 0.0v 1589.505n 1.8v 1599.495n 1.8v 1599.505n 1.8v 1609.495n 1.8v 1609.505n 1.8v 1619.495n 1.8v 1619.505n 0.0v 1629.495n 0.0v 1629.505n 0.0v 1639.495n 0.0v 1639.505n 0.0v 1649.495n 0.0v 1649.505n 0.0v 1659.495n 0.0v 1659.505n 0.0v 1669.495n 0.0v 1669.505n 0.0v 1679.495n 0.0v 1679.505n 0.0v 1689.495n 0.0v 1689.505n 1.8v 1699.495n 1.8v 1699.505n 1.8v 1709.495n 1.8v 1709.505n 0.0v 1719.495n 0.0v 1719.505n 0.0v 1729.495n 0.0v 1729.505n 0.0v 1739.495n 0.0v 1739.505n 1.8v 1749.495n 1.8v 1749.505n 1.8v 1759.495n 1.8v 1759.505n 1.8v 1769.495n 1.8v 1769.505n 1.8v 1779.495n 1.8v 1779.505n 1.8v 1789.495n 1.8v 1789.505n 0.0v 1799.495n 0.0v 1799.505n 0.0v 1809.495n 0.0v 1809.505n 0.0v 1819.495n 0.0v 1819.505n 0.0v 1829.495n 0.0v 1829.505n 0.0v 1839.495n 0.0v 1839.505n 0.0v 1849.495n 0.0v 1849.505n 1.8v 1859.495n 1.8v 1859.505n 0.0v 1869.495n 0.0v 1869.505n 1.8v 1879.495n 1.8v 1879.505n 0.0v 1889.495n 0.0v 1889.505n 1.8v 1899.495n 1.8v 1899.505n 1.8v 1909.495n 1.8v 1909.505n 1.8v 1919.495n 1.8v 1919.505n 1.8v 1929.495n 1.8v 1929.505n 1.8v 1939.495n 1.8v 1939.505n 1.8v 1949.495n 1.8v 1949.505n 1.8v 1959.495n 1.8v 1959.505n 1.8v 1969.495n 1.8v 1969.505n 1.8v 1979.495n 1.8v 1979.505n 1.8v 1989.495n 1.8v 1989.505n 1.8v 1999.495n 1.8v 1999.505n 1.8v 2009.495n 1.8v 2009.505n 1.8v 2019.495n 1.8v 2019.505n 1.8v 2029.495n 1.8v 2029.505n 0.0v 2039.495n 0.0v 2039.505n 0.0v 2049.495n 0.0v 2049.505n 0.0v )
* (time, data): [(0, 0), (10, 1), (20, 1), (30, 1), (40, 1), (50, 1), (60, 1), (70, 1), (80, 1), (90, 1), (100, 1), (110, 1), (120, 1), (130, 1), (140, 1), (150, 0), (160, 0), (170, 0), (180, 0), (190, 0), (200, 0), (210, 0), (220, 0), (230, 0), (240, 0), (250, 0), (260, 0), (270, 0), (280, 0), (290, 0), (300, 0), (310, 1), (320, 1), (330, 1), (340, 1), (350, 0), (360, 0), (370, 0), (380, 0), (390, 0), (400, 1), (410, 1), (420, 1), (430, 1), (440, 1), (450, 0), (460, 0), (470, 0), (480, 0), (490, 0), (500, 1), (510, 1), (520, 1), (530, 1), (540, 1), (550, 1), (560, 1), (570, 1), (580, 1), (590, 1), (600, 1), (610, 1), (620, 1), (630, 1), (640, 1), (650, 1), (660, 0), (670, 1), (680, 1), (690, 1), (700, 1), (710, 0), (720, 0), (730, 0), (740, 0), (750, 0), (760, 0), (770, 0), (780, 0), (790, 0), (800, 0), (810, 0), (820, 0), (830, 0), (840, 1), (850, 1), (860, 1), (870, 1), (880, 1), (890, 0), (900, 0), (910, 0), (920, 0), (930, 1), (940, 1), (950, 1), (960, 0), (970, 0), (980, 0), (990, 0), (1000, 0), (1010, 0), (1020, 0), (1030, 0), (1040, 0), (1050, 0), (1060, 0), (1070, 0), (1080, 1), (1090, 1), (1100, 1), (1110, 1), (1120, 1), (1130, 1), (1140, 1), (1150, 1), (1160, 1), (1170, 1), (1180, 1), (1190, 1), (1200, 1), (1210, 1), (1220, 1), (1230, 1), (1240, 1), (1250, 1), (1260, 1), (1270, 1), (1280, 1), (1290, 1), (1300, 1), (1310, 1), (1320, 1), (1330, 1), (1340, 1), (1350, 1), (1360, 1), (1370, 0), (1380, 0), (1390, 0), (1400, 1), (1410, 1), (1420, 1), (1430, 0), (1440, 0), (1450, 0), (1460, 0), (1470, 0), (1480, 0), (1490, 0), (1500, 1), (1510, 1), (1520, 1), (1530, 1), (1540, 1), (1550, 1), (1560, 1), (1570, 0), (1580, 0), (1590, 1), (1600, 1), (1610, 1), (1620, 0), (1630, 0), (1640, 0), (1650, 0), (1660, 0), (1670, 0), (1680, 0), (1690, 1), (1700, 1), (1710, 0), (1720, 0), (1730, 0), (1740, 1), (1750, 1), (1760, 1), (1770, 1), (1780, 1), (1790, 1), (1800, 1), (1810, 1), (1820, 1), (1830, 1), (1840, 1), (1850, 0), (1860, 0), (1870, 1), (1880, 1), (1890, 0), (1900, 0), (1910, 0), (1920, 0), (1930, 0), (1940, 0), (1950, 0), (1960, 0), (1970, 0), (1980, 0), (1990, 0), (2000, 0), (2010, 0), (2020, 0), (2030, 1), (2040, 1), (2050, 1)]
Vdin0_22  din0_22  0 PWL (0n 0.0v 9.495n 0.0v 9.505n 1.8v 19.495n 1.8v 19.505n 1.8v 29.495n 1.8v 29.505n 1.8v 39.495n 1.8v 39.505n 1.8v 49.495n 1.8v 49.505n 1.8v 59.495n 1.8v 59.505n 1.8v 69.495n 1.8v 69.505n 1.8v 79.495n 1.8v 79.505n 1.8v 89.495n 1.8v 89.505n 1.8v 99.495n 1.8v 99.505n 1.8v 109.495n 1.8v 109.505n 1.8v 119.495n 1.8v 119.505n 1.8v 129.495n 1.8v 129.505n 1.8v 139.495n 1.8v 139.505n 1.8v 149.495n 1.8v 149.505n 0.0v 159.495n 0.0v 159.505n 0.0v 169.495n 0.0v 169.505n 0.0v 179.495n 0.0v 179.505n 0.0v 189.495n 0.0v 189.505n 0.0v 199.495n 0.0v 199.505n 0.0v 209.495n 0.0v 209.505n 0.0v 219.495n 0.0v 219.505n 0.0v 229.495n 0.0v 229.505n 0.0v 239.495n 0.0v 239.505n 0.0v 249.495n 0.0v 249.505n 0.0v 259.495n 0.0v 259.505n 0.0v 269.495n 0.0v 269.505n 0.0v 279.495n 0.0v 279.505n 0.0v 289.495n 0.0v 289.505n 0.0v 299.495n 0.0v 299.505n 0.0v 309.495n 0.0v 309.505n 1.8v 319.495n 1.8v 319.505n 1.8v 329.495n 1.8v 329.505n 1.8v 339.495n 1.8v 339.505n 1.8v 349.495n 1.8v 349.505n 0.0v 359.495n 0.0v 359.505n 0.0v 369.495n 0.0v 369.505n 0.0v 379.495n 0.0v 379.505n 0.0v 389.495n 0.0v 389.505n 0.0v 399.495n 0.0v 399.505n 1.8v 409.495n 1.8v 409.505n 1.8v 419.495n 1.8v 419.505n 1.8v 429.495n 1.8v 429.505n 1.8v 439.495n 1.8v 439.505n 1.8v 449.495n 1.8v 449.505n 0.0v 459.495n 0.0v 459.505n 0.0v 469.495n 0.0v 469.505n 0.0v 479.495n 0.0v 479.505n 0.0v 489.495n 0.0v 489.505n 0.0v 499.495n 0.0v 499.505n 1.8v 509.495n 1.8v 509.505n 1.8v 519.495n 1.8v 519.505n 1.8v 529.495n 1.8v 529.505n 1.8v 539.495n 1.8v 539.505n 1.8v 549.495n 1.8v 549.505n 1.8v 559.495n 1.8v 559.505n 1.8v 569.495n 1.8v 569.505n 1.8v 579.495n 1.8v 579.505n 1.8v 589.495n 1.8v 589.505n 1.8v 599.495n 1.8v 599.505n 1.8v 609.495n 1.8v 609.505n 1.8v 619.495n 1.8v 619.505n 1.8v 629.495n 1.8v 629.505n 1.8v 639.495n 1.8v 639.505n 1.8v 649.495n 1.8v 649.505n 1.8v 659.495n 1.8v 659.505n 0.0v 669.495n 0.0v 669.505n 1.8v 679.495n 1.8v 679.505n 1.8v 689.495n 1.8v 689.505n 1.8v 699.495n 1.8v 699.505n 1.8v 709.495n 1.8v 709.505n 0.0v 719.495n 0.0v 719.505n 0.0v 729.495n 0.0v 729.505n 0.0v 739.495n 0.0v 739.505n 0.0v 749.495n 0.0v 749.505n 0.0v 759.495n 0.0v 759.505n 0.0v 769.495n 0.0v 769.505n 0.0v 779.495n 0.0v 779.505n 0.0v 789.495n 0.0v 789.505n 0.0v 799.495n 0.0v 799.505n 0.0v 809.495n 0.0v 809.505n 0.0v 819.495n 0.0v 819.505n 0.0v 829.495n 0.0v 829.505n 0.0v 839.495n 0.0v 839.505n 1.8v 849.495n 1.8v 849.505n 1.8v 859.495n 1.8v 859.505n 1.8v 869.495n 1.8v 869.505n 1.8v 879.495n 1.8v 879.505n 1.8v 889.495n 1.8v 889.505n 0.0v 899.495n 0.0v 899.505n 0.0v 909.495n 0.0v 909.505n 0.0v 919.495n 0.0v 919.505n 0.0v 929.495n 0.0v 929.505n 1.8v 939.495n 1.8v 939.505n 1.8v 949.495n 1.8v 949.505n 1.8v 959.495n 1.8v 959.505n 0.0v 969.495n 0.0v 969.505n 0.0v 979.495n 0.0v 979.505n 0.0v 989.495n 0.0v 989.505n 0.0v 999.495n 0.0v 999.505n 0.0v 1009.495n 0.0v 1009.505n 0.0v 1019.495n 0.0v 1019.505n 0.0v 1029.495n 0.0v 1029.505n 0.0v 1039.495n 0.0v 1039.505n 0.0v 1049.495n 0.0v 1049.505n 0.0v 1059.495n 0.0v 1059.505n 0.0v 1069.495n 0.0v 1069.505n 0.0v 1079.495n 0.0v 1079.505n 1.8v 1089.495n 1.8v 1089.505n 1.8v 1099.495n 1.8v 1099.505n 1.8v 1109.495n 1.8v 1109.505n 1.8v 1119.495n 1.8v 1119.505n 1.8v 1129.495n 1.8v 1129.505n 1.8v 1139.495n 1.8v 1139.505n 1.8v 1149.495n 1.8v 1149.505n 1.8v 1159.495n 1.8v 1159.505n 1.8v 1169.495n 1.8v 1169.505n 1.8v 1179.495n 1.8v 1179.505n 1.8v 1189.495n 1.8v 1189.505n 1.8v 1199.495n 1.8v 1199.505n 1.8v 1209.495n 1.8v 1209.505n 1.8v 1219.495n 1.8v 1219.505n 1.8v 1229.495n 1.8v 1229.505n 1.8v 1239.495n 1.8v 1239.505n 1.8v 1249.495n 1.8v 1249.505n 1.8v 1259.495n 1.8v 1259.505n 1.8v 1269.495n 1.8v 1269.505n 1.8v 1279.495n 1.8v 1279.505n 1.8v 1289.495n 1.8v 1289.505n 1.8v 1299.495n 1.8v 1299.505n 1.8v 1309.495n 1.8v 1309.505n 1.8v 1319.495n 1.8v 1319.505n 1.8v 1329.495n 1.8v 1329.505n 1.8v 1339.495n 1.8v 1339.505n 1.8v 1349.495n 1.8v 1349.505n 1.8v 1359.495n 1.8v 1359.505n 1.8v 1369.495n 1.8v 1369.505n 0.0v 1379.495n 0.0v 1379.505n 0.0v 1389.495n 0.0v 1389.505n 0.0v 1399.495n 0.0v 1399.505n 1.8v 1409.495n 1.8v 1409.505n 1.8v 1419.495n 1.8v 1419.505n 1.8v 1429.495n 1.8v 1429.505n 0.0v 1439.495n 0.0v 1439.505n 0.0v 1449.495n 0.0v 1449.505n 0.0v 1459.495n 0.0v 1459.505n 0.0v 1469.495n 0.0v 1469.505n 0.0v 1479.495n 0.0v 1479.505n 0.0v 1489.495n 0.0v 1489.505n 0.0v 1499.495n 0.0v 1499.505n 1.8v 1509.495n 1.8v 1509.505n 1.8v 1519.495n 1.8v 1519.505n 1.8v 1529.495n 1.8v 1529.505n 1.8v 1539.495n 1.8v 1539.505n 1.8v 1549.495n 1.8v 1549.505n 1.8v 1559.495n 1.8v 1559.505n 1.8v 1569.495n 1.8v 1569.505n 0.0v 1579.495n 0.0v 1579.505n 0.0v 1589.495n 0.0v 1589.505n 1.8v 1599.495n 1.8v 1599.505n 1.8v 1609.495n 1.8v 1609.505n 1.8v 1619.495n 1.8v 1619.505n 0.0v 1629.495n 0.0v 1629.505n 0.0v 1639.495n 0.0v 1639.505n 0.0v 1649.495n 0.0v 1649.505n 0.0v 1659.495n 0.0v 1659.505n 0.0v 1669.495n 0.0v 1669.505n 0.0v 1679.495n 0.0v 1679.505n 0.0v 1689.495n 0.0v 1689.505n 1.8v 1699.495n 1.8v 1699.505n 1.8v 1709.495n 1.8v 1709.505n 0.0v 1719.495n 0.0v 1719.505n 0.0v 1729.495n 0.0v 1729.505n 0.0v 1739.495n 0.0v 1739.505n 1.8v 1749.495n 1.8v 1749.505n 1.8v 1759.495n 1.8v 1759.505n 1.8v 1769.495n 1.8v 1769.505n 1.8v 1779.495n 1.8v 1779.505n 1.8v 1789.495n 1.8v 1789.505n 1.8v 1799.495n 1.8v 1799.505n 1.8v 1809.495n 1.8v 1809.505n 1.8v 1819.495n 1.8v 1819.505n 1.8v 1829.495n 1.8v 1829.505n 1.8v 1839.495n 1.8v 1839.505n 1.8v 1849.495n 1.8v 1849.505n 0.0v 1859.495n 0.0v 1859.505n 0.0v 1869.495n 0.0v 1869.505n 1.8v 1879.495n 1.8v 1879.505n 1.8v 1889.495n 1.8v 1889.505n 0.0v 1899.495n 0.0v 1899.505n 0.0v 1909.495n 0.0v 1909.505n 0.0v 1919.495n 0.0v 1919.505n 0.0v 1929.495n 0.0v 1929.505n 0.0v 1939.495n 0.0v 1939.505n 0.0v 1949.495n 0.0v 1949.505n 0.0v 1959.495n 0.0v 1959.505n 0.0v 1969.495n 0.0v 1969.505n 0.0v 1979.495n 0.0v 1979.505n 0.0v 1989.495n 0.0v 1989.505n 0.0v 1999.495n 0.0v 1999.505n 0.0v 2009.495n 0.0v 2009.505n 0.0v 2019.495n 0.0v 2019.505n 0.0v 2029.495n 0.0v 2029.505n 1.8v 2039.495n 1.8v 2039.505n 1.8v 2049.495n 1.8v 2049.505n 1.8v )
* (time, data): [(0, 0), (10, 1), (20, 1), (30, 1), (40, 1), (50, 1), (60, 0), (70, 0), (80, 0), (90, 0), (100, 0), (110, 0), (120, 0), (130, 0), (140, 0), (150, 0), (160, 0), (170, 0), (180, 0), (190, 0), (200, 0), (210, 0), (220, 0), (230, 0), (240, 0), (250, 0), (260, 0), (270, 0), (280, 0), (290, 0), (300, 0), (310, 1), (320, 1), (330, 1), (340, 1), (350, 1), (360, 1), (370, 1), (380, 1), (390, 0), (400, 1), (410, 1), (420, 1), (430, 1), (440, 1), (450, 1), (460, 1), (470, 1), (480, 1), (490, 1), (500, 0), (510, 0), (520, 0), (530, 0), (540, 0), (550, 0), (560, 0), (570, 0), (580, 0), (590, 0), (600, 0), (610, 0), (620, 0), (630, 0), (640, 0), (650, 0), (660, 0), (670, 1), (680, 1), (690, 1), (700, 1), (710, 0), (720, 0), (730, 0), (740, 0), (750, 0), (760, 0), (770, 1), (780, 1), (790, 1), (800, 1), (810, 1), (820, 1), (830, 1), (840, 1), (850, 1), (860, 1), (870, 1), (880, 1), (890, 1), (900, 1), (910, 1), (920, 1), (930, 0), (940, 0), (950, 0), (960, 1), (970, 1), (980, 1), (990, 1), (1000, 1), (1010, 1), (1020, 1), (1030, 1), (1040, 1), (1050, 1), (1060, 1), (1070, 1), (1080, 0), (1090, 0), (1100, 0), (1110, 0), (1120, 0), (1130, 0), (1140, 0), (1150, 0), (1160, 0), (1170, 0), (1180, 0), (1190, 0), (1200, 0), (1210, 0), (1220, 0), (1230, 0), (1240, 0), (1250, 0), (1260, 0), (1270, 0), (1280, 0), (1290, 0), (1300, 0), (1310, 0), (1320, 0), (1330, 0), (1340, 0), (1350, 0), (1360, 0), (1370, 0), (1380, 0), (1390, 0), (1400, 0), (1410, 0), (1420, 0), (1430, 1), (1440, 1), (1450, 1), (1460, 1), (1470, 1), (1480, 1), (1490, 1), (1500, 0), (1510, 0), (1520, 0), (1530, 0), (1540, 0), (1550, 0), (1560, 0), (1570, 0), (1580, 1), (1590, 0), (1600, 0), (1610, 0), (1620, 1), (1630, 1), (1640, 1), (1650, 1), (1660, 1), (1670, 1), (1680, 1), (1690, 0), (1700, 0), (1710, 0), (1720, 0), (1730, 0), (1740, 0), (1750, 0), (1760, 0), (1770, 0), (1780, 0), (1790, 0), (1800, 0), (1810, 0), (1820, 0), (1830, 0), (1840, 0), (1850, 1), (1860, 0), (1870, 1), (1880, 0), (1890, 1), (1900, 1), (1910, 1), (1920, 1), (1930, 1), (1940, 1), (1950, 1), (1960, 1), (1970, 1), (1980, 1), (1990, 1), (2000, 1), (2010, 1), (2020, 1), (2030, 0), (2040, 0), (2050, 0)]
Vdin0_23  din0_23  0 PWL (0n 0.0v 9.495n 0.0v 9.505n 1.8v 19.495n 1.8v 19.505n 1.8v 29.495n 1.8v 29.505n 1.8v 39.495n 1.8v 39.505n 1.8v 49.495n 1.8v 49.505n 1.8v 59.495n 1.8v 59.505n 0.0v 69.495n 0.0v 69.505n 0.0v 79.495n 0.0v 79.505n 0.0v 89.495n 0.0v 89.505n 0.0v 99.495n 0.0v 99.505n 0.0v 109.495n 0.0v 109.505n 0.0v 119.495n 0.0v 119.505n 0.0v 129.495n 0.0v 129.505n 0.0v 139.495n 0.0v 139.505n 0.0v 149.495n 0.0v 149.505n 0.0v 159.495n 0.0v 159.505n 0.0v 169.495n 0.0v 169.505n 0.0v 179.495n 0.0v 179.505n 0.0v 189.495n 0.0v 189.505n 0.0v 199.495n 0.0v 199.505n 0.0v 209.495n 0.0v 209.505n 0.0v 219.495n 0.0v 219.505n 0.0v 229.495n 0.0v 229.505n 0.0v 239.495n 0.0v 239.505n 0.0v 249.495n 0.0v 249.505n 0.0v 259.495n 0.0v 259.505n 0.0v 269.495n 0.0v 269.505n 0.0v 279.495n 0.0v 279.505n 0.0v 289.495n 0.0v 289.505n 0.0v 299.495n 0.0v 299.505n 0.0v 309.495n 0.0v 309.505n 1.8v 319.495n 1.8v 319.505n 1.8v 329.495n 1.8v 329.505n 1.8v 339.495n 1.8v 339.505n 1.8v 349.495n 1.8v 349.505n 1.8v 359.495n 1.8v 359.505n 1.8v 369.495n 1.8v 369.505n 1.8v 379.495n 1.8v 379.505n 1.8v 389.495n 1.8v 389.505n 0.0v 399.495n 0.0v 399.505n 1.8v 409.495n 1.8v 409.505n 1.8v 419.495n 1.8v 419.505n 1.8v 429.495n 1.8v 429.505n 1.8v 439.495n 1.8v 439.505n 1.8v 449.495n 1.8v 449.505n 1.8v 459.495n 1.8v 459.505n 1.8v 469.495n 1.8v 469.505n 1.8v 479.495n 1.8v 479.505n 1.8v 489.495n 1.8v 489.505n 1.8v 499.495n 1.8v 499.505n 0.0v 509.495n 0.0v 509.505n 0.0v 519.495n 0.0v 519.505n 0.0v 529.495n 0.0v 529.505n 0.0v 539.495n 0.0v 539.505n 0.0v 549.495n 0.0v 549.505n 0.0v 559.495n 0.0v 559.505n 0.0v 569.495n 0.0v 569.505n 0.0v 579.495n 0.0v 579.505n 0.0v 589.495n 0.0v 589.505n 0.0v 599.495n 0.0v 599.505n 0.0v 609.495n 0.0v 609.505n 0.0v 619.495n 0.0v 619.505n 0.0v 629.495n 0.0v 629.505n 0.0v 639.495n 0.0v 639.505n 0.0v 649.495n 0.0v 649.505n 0.0v 659.495n 0.0v 659.505n 0.0v 669.495n 0.0v 669.505n 1.8v 679.495n 1.8v 679.505n 1.8v 689.495n 1.8v 689.505n 1.8v 699.495n 1.8v 699.505n 1.8v 709.495n 1.8v 709.505n 0.0v 719.495n 0.0v 719.505n 0.0v 729.495n 0.0v 729.505n 0.0v 739.495n 0.0v 739.505n 0.0v 749.495n 0.0v 749.505n 0.0v 759.495n 0.0v 759.505n 0.0v 769.495n 0.0v 769.505n 1.8v 779.495n 1.8v 779.505n 1.8v 789.495n 1.8v 789.505n 1.8v 799.495n 1.8v 799.505n 1.8v 809.495n 1.8v 809.505n 1.8v 819.495n 1.8v 819.505n 1.8v 829.495n 1.8v 829.505n 1.8v 839.495n 1.8v 839.505n 1.8v 849.495n 1.8v 849.505n 1.8v 859.495n 1.8v 859.505n 1.8v 869.495n 1.8v 869.505n 1.8v 879.495n 1.8v 879.505n 1.8v 889.495n 1.8v 889.505n 1.8v 899.495n 1.8v 899.505n 1.8v 909.495n 1.8v 909.505n 1.8v 919.495n 1.8v 919.505n 1.8v 929.495n 1.8v 929.505n 0.0v 939.495n 0.0v 939.505n 0.0v 949.495n 0.0v 949.505n 0.0v 959.495n 0.0v 959.505n 1.8v 969.495n 1.8v 969.505n 1.8v 979.495n 1.8v 979.505n 1.8v 989.495n 1.8v 989.505n 1.8v 999.495n 1.8v 999.505n 1.8v 1009.495n 1.8v 1009.505n 1.8v 1019.495n 1.8v 1019.505n 1.8v 1029.495n 1.8v 1029.505n 1.8v 1039.495n 1.8v 1039.505n 1.8v 1049.495n 1.8v 1049.505n 1.8v 1059.495n 1.8v 1059.505n 1.8v 1069.495n 1.8v 1069.505n 1.8v 1079.495n 1.8v 1079.505n 0.0v 1089.495n 0.0v 1089.505n 0.0v 1099.495n 0.0v 1099.505n 0.0v 1109.495n 0.0v 1109.505n 0.0v 1119.495n 0.0v 1119.505n 0.0v 1129.495n 0.0v 1129.505n 0.0v 1139.495n 0.0v 1139.505n 0.0v 1149.495n 0.0v 1149.505n 0.0v 1159.495n 0.0v 1159.505n 0.0v 1169.495n 0.0v 1169.505n 0.0v 1179.495n 0.0v 1179.505n 0.0v 1189.495n 0.0v 1189.505n 0.0v 1199.495n 0.0v 1199.505n 0.0v 1209.495n 0.0v 1209.505n 0.0v 1219.495n 0.0v 1219.505n 0.0v 1229.495n 0.0v 1229.505n 0.0v 1239.495n 0.0v 1239.505n 0.0v 1249.495n 0.0v 1249.505n 0.0v 1259.495n 0.0v 1259.505n 0.0v 1269.495n 0.0v 1269.505n 0.0v 1279.495n 0.0v 1279.505n 0.0v 1289.495n 0.0v 1289.505n 0.0v 1299.495n 0.0v 1299.505n 0.0v 1309.495n 0.0v 1309.505n 0.0v 1319.495n 0.0v 1319.505n 0.0v 1329.495n 0.0v 1329.505n 0.0v 1339.495n 0.0v 1339.505n 0.0v 1349.495n 0.0v 1349.505n 0.0v 1359.495n 0.0v 1359.505n 0.0v 1369.495n 0.0v 1369.505n 0.0v 1379.495n 0.0v 1379.505n 0.0v 1389.495n 0.0v 1389.505n 0.0v 1399.495n 0.0v 1399.505n 0.0v 1409.495n 0.0v 1409.505n 0.0v 1419.495n 0.0v 1419.505n 0.0v 1429.495n 0.0v 1429.505n 1.8v 1439.495n 1.8v 1439.505n 1.8v 1449.495n 1.8v 1449.505n 1.8v 1459.495n 1.8v 1459.505n 1.8v 1469.495n 1.8v 1469.505n 1.8v 1479.495n 1.8v 1479.505n 1.8v 1489.495n 1.8v 1489.505n 1.8v 1499.495n 1.8v 1499.505n 0.0v 1509.495n 0.0v 1509.505n 0.0v 1519.495n 0.0v 1519.505n 0.0v 1529.495n 0.0v 1529.505n 0.0v 1539.495n 0.0v 1539.505n 0.0v 1549.495n 0.0v 1549.505n 0.0v 1559.495n 0.0v 1559.505n 0.0v 1569.495n 0.0v 1569.505n 0.0v 1579.495n 0.0v 1579.505n 1.8v 1589.495n 1.8v 1589.505n 0.0v 1599.495n 0.0v 1599.505n 0.0v 1609.495n 0.0v 1609.505n 0.0v 1619.495n 0.0v 1619.505n 1.8v 1629.495n 1.8v 1629.505n 1.8v 1639.495n 1.8v 1639.505n 1.8v 1649.495n 1.8v 1649.505n 1.8v 1659.495n 1.8v 1659.505n 1.8v 1669.495n 1.8v 1669.505n 1.8v 1679.495n 1.8v 1679.505n 1.8v 1689.495n 1.8v 1689.505n 0.0v 1699.495n 0.0v 1699.505n 0.0v 1709.495n 0.0v 1709.505n 0.0v 1719.495n 0.0v 1719.505n 0.0v 1729.495n 0.0v 1729.505n 0.0v 1739.495n 0.0v 1739.505n 0.0v 1749.495n 0.0v 1749.505n 0.0v 1759.495n 0.0v 1759.505n 0.0v 1769.495n 0.0v 1769.505n 0.0v 1779.495n 0.0v 1779.505n 0.0v 1789.495n 0.0v 1789.505n 0.0v 1799.495n 0.0v 1799.505n 0.0v 1809.495n 0.0v 1809.505n 0.0v 1819.495n 0.0v 1819.505n 0.0v 1829.495n 0.0v 1829.505n 0.0v 1839.495n 0.0v 1839.505n 0.0v 1849.495n 0.0v 1849.505n 1.8v 1859.495n 1.8v 1859.505n 0.0v 1869.495n 0.0v 1869.505n 1.8v 1879.495n 1.8v 1879.505n 0.0v 1889.495n 0.0v 1889.505n 1.8v 1899.495n 1.8v 1899.505n 1.8v 1909.495n 1.8v 1909.505n 1.8v 1919.495n 1.8v 1919.505n 1.8v 1929.495n 1.8v 1929.505n 1.8v 1939.495n 1.8v 1939.505n 1.8v 1949.495n 1.8v 1949.505n 1.8v 1959.495n 1.8v 1959.505n 1.8v 1969.495n 1.8v 1969.505n 1.8v 1979.495n 1.8v 1979.505n 1.8v 1989.495n 1.8v 1989.505n 1.8v 1999.495n 1.8v 1999.505n 1.8v 2009.495n 1.8v 2009.505n 1.8v 2019.495n 1.8v 2019.505n 1.8v 2029.495n 1.8v 2029.505n 0.0v 2039.495n 0.0v 2039.505n 0.0v 2049.495n 0.0v 2049.505n 0.0v )
* (time, data): [(0, 0), (10, 0), (20, 0), (30, 0), (40, 0), (50, 0), (60, 0), (70, 0), (80, 0), (90, 0), (100, 0), (110, 0), (120, 0), (130, 0), (140, 0), (150, 1), (160, 1), (170, 1), (180, 1), (190, 1), (200, 1), (210, 1), (220, 1), (230, 1), (240, 1), (250, 1), (260, 1), (270, 1), (280, 1), (290, 1), (300, 1), (310, 0), (320, 0), (330, 0), (340, 0), (350, 1), (360, 1), (370, 1), (380, 1), (390, 0), (400, 1), (410, 1), (420, 0), (430, 0), (440, 0), (450, 1), (460, 1), (470, 1), (480, 1), (490, 1), (500, 1), (510, 1), (520, 1), (530, 1), (540, 1), (550, 1), (560, 1), (570, 1), (580, 1), (590, 1), (600, 1), (610, 1), (620, 0), (630, 0), (640, 0), (650, 0), (660, 1), (670, 0), (680, 0), (690, 0), (700, 0), (710, 1), (720, 1), (730, 1), (740, 1), (750, 1), (760, 1), (770, 1), (780, 1), (790, 1), (800, 1), (810, 1), (820, 0), (830, 0), (840, 0), (850, 0), (860, 0), (870, 0), (880, 0), (890, 0), (900, 0), (910, 0), (920, 0), (930, 0), (940, 0), (950, 0), (960, 0), (970, 0), (980, 0), (990, 0), (1000, 0), (1010, 0), (1020, 0), (1030, 0), (1040, 0), (1050, 0), (1060, 0), (1070, 0), (1080, 0), (1090, 0), (1100, 0), (1110, 0), (1120, 0), (1130, 0), (1140, 0), (1150, 0), (1160, 0), (1170, 0), (1180, 0), (1190, 0), (1200, 0), (1210, 0), (1220, 0), (1230, 0), (1240, 0), (1250, 0), (1260, 1), (1270, 1), (1280, 0), (1290, 0), (1300, 0), (1310, 0), (1320, 0), (1330, 0), (1340, 0), (1350, 0), (1360, 0), (1370, 0), (1380, 0), (1390, 0), (1400, 1), (1410, 1), (1420, 1), (1430, 0), (1440, 0), (1450, 0), (1460, 0), (1470, 0), (1480, 0), (1490, 0), (1500, 1), (1510, 1), (1520, 1), (1530, 1), (1540, 1), (1550, 1), (1560, 1), (1570, 0), (1580, 0), (1590, 0), (1600, 0), (1610, 0), (1620, 0), (1630, 0), (1640, 0), (1650, 0), (1660, 0), (1670, 0), (1680, 0), (1690, 1), (1700, 1), (1710, 0), (1720, 0), (1730, 1), (1740, 0), (1750, 0), (1760, 0), (1770, 0), (1780, 0), (1790, 0), (1800, 0), (1810, 0), (1820, 0), (1830, 0), (1840, 0), (1850, 1), (1860, 1), (1870, 1), (1880, 0), (1890, 0), (1900, 0), (1910, 0), (1920, 0), (1930, 0), (1940, 0), (1950, 0), (1960, 0), (1970, 0), (1980, 0), (1990, 0), (2000, 0), (2010, 0), (2020, 0), (2030, 1), (2040, 1), (2050, 1)]
Vdin0_24  din0_24  0 PWL (0n 0.0v 9.495n 0.0v 9.505n 0.0v 19.495n 0.0v 19.505n 0.0v 29.495n 0.0v 29.505n 0.0v 39.495n 0.0v 39.505n 0.0v 49.495n 0.0v 49.505n 0.0v 59.495n 0.0v 59.505n 0.0v 69.495n 0.0v 69.505n 0.0v 79.495n 0.0v 79.505n 0.0v 89.495n 0.0v 89.505n 0.0v 99.495n 0.0v 99.505n 0.0v 109.495n 0.0v 109.505n 0.0v 119.495n 0.0v 119.505n 0.0v 129.495n 0.0v 129.505n 0.0v 139.495n 0.0v 139.505n 0.0v 149.495n 0.0v 149.505n 1.8v 159.495n 1.8v 159.505n 1.8v 169.495n 1.8v 169.505n 1.8v 179.495n 1.8v 179.505n 1.8v 189.495n 1.8v 189.505n 1.8v 199.495n 1.8v 199.505n 1.8v 209.495n 1.8v 209.505n 1.8v 219.495n 1.8v 219.505n 1.8v 229.495n 1.8v 229.505n 1.8v 239.495n 1.8v 239.505n 1.8v 249.495n 1.8v 249.505n 1.8v 259.495n 1.8v 259.505n 1.8v 269.495n 1.8v 269.505n 1.8v 279.495n 1.8v 279.505n 1.8v 289.495n 1.8v 289.505n 1.8v 299.495n 1.8v 299.505n 1.8v 309.495n 1.8v 309.505n 0.0v 319.495n 0.0v 319.505n 0.0v 329.495n 0.0v 329.505n 0.0v 339.495n 0.0v 339.505n 0.0v 349.495n 0.0v 349.505n 1.8v 359.495n 1.8v 359.505n 1.8v 369.495n 1.8v 369.505n 1.8v 379.495n 1.8v 379.505n 1.8v 389.495n 1.8v 389.505n 0.0v 399.495n 0.0v 399.505n 1.8v 409.495n 1.8v 409.505n 1.8v 419.495n 1.8v 419.505n 0.0v 429.495n 0.0v 429.505n 0.0v 439.495n 0.0v 439.505n 0.0v 449.495n 0.0v 449.505n 1.8v 459.495n 1.8v 459.505n 1.8v 469.495n 1.8v 469.505n 1.8v 479.495n 1.8v 479.505n 1.8v 489.495n 1.8v 489.505n 1.8v 499.495n 1.8v 499.505n 1.8v 509.495n 1.8v 509.505n 1.8v 519.495n 1.8v 519.505n 1.8v 529.495n 1.8v 529.505n 1.8v 539.495n 1.8v 539.505n 1.8v 549.495n 1.8v 549.505n 1.8v 559.495n 1.8v 559.505n 1.8v 569.495n 1.8v 569.505n 1.8v 579.495n 1.8v 579.505n 1.8v 589.495n 1.8v 589.505n 1.8v 599.495n 1.8v 599.505n 1.8v 609.495n 1.8v 609.505n 1.8v 619.495n 1.8v 619.505n 0.0v 629.495n 0.0v 629.505n 0.0v 639.495n 0.0v 639.505n 0.0v 649.495n 0.0v 649.505n 0.0v 659.495n 0.0v 659.505n 1.8v 669.495n 1.8v 669.505n 0.0v 679.495n 0.0v 679.505n 0.0v 689.495n 0.0v 689.505n 0.0v 699.495n 0.0v 699.505n 0.0v 709.495n 0.0v 709.505n 1.8v 719.495n 1.8v 719.505n 1.8v 729.495n 1.8v 729.505n 1.8v 739.495n 1.8v 739.505n 1.8v 749.495n 1.8v 749.505n 1.8v 759.495n 1.8v 759.505n 1.8v 769.495n 1.8v 769.505n 1.8v 779.495n 1.8v 779.505n 1.8v 789.495n 1.8v 789.505n 1.8v 799.495n 1.8v 799.505n 1.8v 809.495n 1.8v 809.505n 1.8v 819.495n 1.8v 819.505n 0.0v 829.495n 0.0v 829.505n 0.0v 839.495n 0.0v 839.505n 0.0v 849.495n 0.0v 849.505n 0.0v 859.495n 0.0v 859.505n 0.0v 869.495n 0.0v 869.505n 0.0v 879.495n 0.0v 879.505n 0.0v 889.495n 0.0v 889.505n 0.0v 899.495n 0.0v 899.505n 0.0v 909.495n 0.0v 909.505n 0.0v 919.495n 0.0v 919.505n 0.0v 929.495n 0.0v 929.505n 0.0v 939.495n 0.0v 939.505n 0.0v 949.495n 0.0v 949.505n 0.0v 959.495n 0.0v 959.505n 0.0v 969.495n 0.0v 969.505n 0.0v 979.495n 0.0v 979.505n 0.0v 989.495n 0.0v 989.505n 0.0v 999.495n 0.0v 999.505n 0.0v 1009.495n 0.0v 1009.505n 0.0v 1019.495n 0.0v 1019.505n 0.0v 1029.495n 0.0v 1029.505n 0.0v 1039.495n 0.0v 1039.505n 0.0v 1049.495n 0.0v 1049.505n 0.0v 1059.495n 0.0v 1059.505n 0.0v 1069.495n 0.0v 1069.505n 0.0v 1079.495n 0.0v 1079.505n 0.0v 1089.495n 0.0v 1089.505n 0.0v 1099.495n 0.0v 1099.505n 0.0v 1109.495n 0.0v 1109.505n 0.0v 1119.495n 0.0v 1119.505n 0.0v 1129.495n 0.0v 1129.505n 0.0v 1139.495n 0.0v 1139.505n 0.0v 1149.495n 0.0v 1149.505n 0.0v 1159.495n 0.0v 1159.505n 0.0v 1169.495n 0.0v 1169.505n 0.0v 1179.495n 0.0v 1179.505n 0.0v 1189.495n 0.0v 1189.505n 0.0v 1199.495n 0.0v 1199.505n 0.0v 1209.495n 0.0v 1209.505n 0.0v 1219.495n 0.0v 1219.505n 0.0v 1229.495n 0.0v 1229.505n 0.0v 1239.495n 0.0v 1239.505n 0.0v 1249.495n 0.0v 1249.505n 0.0v 1259.495n 0.0v 1259.505n 1.8v 1269.495n 1.8v 1269.505n 1.8v 1279.495n 1.8v 1279.505n 0.0v 1289.495n 0.0v 1289.505n 0.0v 1299.495n 0.0v 1299.505n 0.0v 1309.495n 0.0v 1309.505n 0.0v 1319.495n 0.0v 1319.505n 0.0v 1329.495n 0.0v 1329.505n 0.0v 1339.495n 0.0v 1339.505n 0.0v 1349.495n 0.0v 1349.505n 0.0v 1359.495n 0.0v 1359.505n 0.0v 1369.495n 0.0v 1369.505n 0.0v 1379.495n 0.0v 1379.505n 0.0v 1389.495n 0.0v 1389.505n 0.0v 1399.495n 0.0v 1399.505n 1.8v 1409.495n 1.8v 1409.505n 1.8v 1419.495n 1.8v 1419.505n 1.8v 1429.495n 1.8v 1429.505n 0.0v 1439.495n 0.0v 1439.505n 0.0v 1449.495n 0.0v 1449.505n 0.0v 1459.495n 0.0v 1459.505n 0.0v 1469.495n 0.0v 1469.505n 0.0v 1479.495n 0.0v 1479.505n 0.0v 1489.495n 0.0v 1489.505n 0.0v 1499.495n 0.0v 1499.505n 1.8v 1509.495n 1.8v 1509.505n 1.8v 1519.495n 1.8v 1519.505n 1.8v 1529.495n 1.8v 1529.505n 1.8v 1539.495n 1.8v 1539.505n 1.8v 1549.495n 1.8v 1549.505n 1.8v 1559.495n 1.8v 1559.505n 1.8v 1569.495n 1.8v 1569.505n 0.0v 1579.495n 0.0v 1579.505n 0.0v 1589.495n 0.0v 1589.505n 0.0v 1599.495n 0.0v 1599.505n 0.0v 1609.495n 0.0v 1609.505n 0.0v 1619.495n 0.0v 1619.505n 0.0v 1629.495n 0.0v 1629.505n 0.0v 1639.495n 0.0v 1639.505n 0.0v 1649.495n 0.0v 1649.505n 0.0v 1659.495n 0.0v 1659.505n 0.0v 1669.495n 0.0v 1669.505n 0.0v 1679.495n 0.0v 1679.505n 0.0v 1689.495n 0.0v 1689.505n 1.8v 1699.495n 1.8v 1699.505n 1.8v 1709.495n 1.8v 1709.505n 0.0v 1719.495n 0.0v 1719.505n 0.0v 1729.495n 0.0v 1729.505n 1.8v 1739.495n 1.8v 1739.505n 0.0v 1749.495n 0.0v 1749.505n 0.0v 1759.495n 0.0v 1759.505n 0.0v 1769.495n 0.0v 1769.505n 0.0v 1779.495n 0.0v 1779.505n 0.0v 1789.495n 0.0v 1789.505n 0.0v 1799.495n 0.0v 1799.505n 0.0v 1809.495n 0.0v 1809.505n 0.0v 1819.495n 0.0v 1819.505n 0.0v 1829.495n 0.0v 1829.505n 0.0v 1839.495n 0.0v 1839.505n 0.0v 1849.495n 0.0v 1849.505n 1.8v 1859.495n 1.8v 1859.505n 1.8v 1869.495n 1.8v 1869.505n 1.8v 1879.495n 1.8v 1879.505n 0.0v 1889.495n 0.0v 1889.505n 0.0v 1899.495n 0.0v 1899.505n 0.0v 1909.495n 0.0v 1909.505n 0.0v 1919.495n 0.0v 1919.505n 0.0v 1929.495n 0.0v 1929.505n 0.0v 1939.495n 0.0v 1939.505n 0.0v 1949.495n 0.0v 1949.505n 0.0v 1959.495n 0.0v 1959.505n 0.0v 1969.495n 0.0v 1969.505n 0.0v 1979.495n 0.0v 1979.505n 0.0v 1989.495n 0.0v 1989.505n 0.0v 1999.495n 0.0v 1999.505n 0.0v 2009.495n 0.0v 2009.505n 0.0v 2019.495n 0.0v 2019.505n 0.0v 2029.495n 0.0v 2029.505n 1.8v 2039.495n 1.8v 2039.505n 1.8v 2049.495n 1.8v 2049.505n 1.8v )
* (time, data): [(0, 0), (10, 0), (20, 0), (30, 0), (40, 0), (50, 0), (60, 1), (70, 1), (80, 1), (90, 1), (100, 1), (110, 1), (120, 1), (130, 1), (140, 1), (150, 1), (160, 1), (170, 1), (180, 1), (190, 1), (200, 1), (210, 1), (220, 1), (230, 1), (240, 1), (250, 1), (260, 0), (270, 0), (280, 0), (290, 0), (300, 0), (310, 0), (320, 0), (330, 0), (340, 0), (350, 0), (360, 0), (370, 0), (380, 0), (390, 0), (400, 0), (410, 0), (420, 1), (430, 1), (440, 1), (450, 0), (460, 0), (470, 0), (480, 0), (490, 0), (500, 0), (510, 0), (520, 0), (530, 0), (540, 0), (550, 0), (560, 0), (570, 0), (580, 0), (590, 0), (600, 0), (610, 0), (620, 0), (630, 0), (640, 0), (650, 0), (660, 0), (670, 0), (680, 0), (690, 0), (700, 0), (710, 0), (720, 0), (730, 0), (740, 0), (750, 0), (760, 0), (770, 1), (780, 1), (790, 1), (800, 1), (810, 1), (820, 0), (830, 0), (840, 0), (850, 0), (860, 0), (870, 0), (880, 0), (890, 0), (900, 0), (910, 0), (920, 0), (930, 0), (940, 0), (950, 0), (960, 0), (970, 0), (980, 0), (990, 0), (1000, 0), (1010, 0), (1020, 0), (1030, 0), (1040, 0), (1050, 0), (1060, 0), (1070, 0), (1080, 0), (1090, 0), (1100, 0), (1110, 0), (1120, 0), (1130, 1), (1140, 1), (1150, 1), (1160, 1), (1170, 1), (1180, 1), (1190, 1), (1200, 1), (1210, 1), (1220, 1), (1230, 1), (1240, 1), (1250, 1), (1260, 1), (1270, 1), (1280, 1), (1290, 1), (1300, 1), (1310, 1), (1320, 1), (1330, 1), (1340, 1), (1350, 1), (1360, 1), (1370, 1), (1380, 1), (1390, 1), (1400, 0), (1410, 0), (1420, 0), (1430, 0), (1440, 0), (1450, 0), (1460, 0), (1470, 0), (1480, 1), (1490, 1), (1500, 0), (1510, 0), (1520, 0), (1530, 0), (1540, 0), (1550, 0), (1560, 0), (1570, 1), (1580, 1), (1590, 1), (1600, 1), (1610, 1), (1620, 0), (1630, 0), (1640, 0), (1650, 0), (1660, 0), (1670, 0), (1680, 0), (1690, 0), (1700, 0), (1710, 1), (1720, 1), (1730, 0), (1740, 0), (1750, 0), (1760, 0), (1770, 0), (1780, 0), (1790, 0), (1800, 0), (1810, 0), (1820, 0), (1830, 0), (1840, 0), (1850, 1), (1860, 1), (1870, 1), (1880, 0), (1890, 0), (1900, 0), (1910, 1), (1920, 1), (1930, 1), (1940, 1), (1950, 1), (1960, 1), (1970, 1), (1980, 1), (1990, 1), (2000, 1), (2010, 1), (2020, 1), (2030, 0), (2040, 0), (2050, 0)]
Vdin0_25  din0_25  0 PWL (0n 0.0v 9.495n 0.0v 9.505n 0.0v 19.495n 0.0v 19.505n 0.0v 29.495n 0.0v 29.505n 0.0v 39.495n 0.0v 39.505n 0.0v 49.495n 0.0v 49.505n 0.0v 59.495n 0.0v 59.505n 1.8v 69.495n 1.8v 69.505n 1.8v 79.495n 1.8v 79.505n 1.8v 89.495n 1.8v 89.505n 1.8v 99.495n 1.8v 99.505n 1.8v 109.495n 1.8v 109.505n 1.8v 119.495n 1.8v 119.505n 1.8v 129.495n 1.8v 129.505n 1.8v 139.495n 1.8v 139.505n 1.8v 149.495n 1.8v 149.505n 1.8v 159.495n 1.8v 159.505n 1.8v 169.495n 1.8v 169.505n 1.8v 179.495n 1.8v 179.505n 1.8v 189.495n 1.8v 189.505n 1.8v 199.495n 1.8v 199.505n 1.8v 209.495n 1.8v 209.505n 1.8v 219.495n 1.8v 219.505n 1.8v 229.495n 1.8v 229.505n 1.8v 239.495n 1.8v 239.505n 1.8v 249.495n 1.8v 249.505n 1.8v 259.495n 1.8v 259.505n 0.0v 269.495n 0.0v 269.505n 0.0v 279.495n 0.0v 279.505n 0.0v 289.495n 0.0v 289.505n 0.0v 299.495n 0.0v 299.505n 0.0v 309.495n 0.0v 309.505n 0.0v 319.495n 0.0v 319.505n 0.0v 329.495n 0.0v 329.505n 0.0v 339.495n 0.0v 339.505n 0.0v 349.495n 0.0v 349.505n 0.0v 359.495n 0.0v 359.505n 0.0v 369.495n 0.0v 369.505n 0.0v 379.495n 0.0v 379.505n 0.0v 389.495n 0.0v 389.505n 0.0v 399.495n 0.0v 399.505n 0.0v 409.495n 0.0v 409.505n 0.0v 419.495n 0.0v 419.505n 1.8v 429.495n 1.8v 429.505n 1.8v 439.495n 1.8v 439.505n 1.8v 449.495n 1.8v 449.505n 0.0v 459.495n 0.0v 459.505n 0.0v 469.495n 0.0v 469.505n 0.0v 479.495n 0.0v 479.505n 0.0v 489.495n 0.0v 489.505n 0.0v 499.495n 0.0v 499.505n 0.0v 509.495n 0.0v 509.505n 0.0v 519.495n 0.0v 519.505n 0.0v 529.495n 0.0v 529.505n 0.0v 539.495n 0.0v 539.505n 0.0v 549.495n 0.0v 549.505n 0.0v 559.495n 0.0v 559.505n 0.0v 569.495n 0.0v 569.505n 0.0v 579.495n 0.0v 579.505n 0.0v 589.495n 0.0v 589.505n 0.0v 599.495n 0.0v 599.505n 0.0v 609.495n 0.0v 609.505n 0.0v 619.495n 0.0v 619.505n 0.0v 629.495n 0.0v 629.505n 0.0v 639.495n 0.0v 639.505n 0.0v 649.495n 0.0v 649.505n 0.0v 659.495n 0.0v 659.505n 0.0v 669.495n 0.0v 669.505n 0.0v 679.495n 0.0v 679.505n 0.0v 689.495n 0.0v 689.505n 0.0v 699.495n 0.0v 699.505n 0.0v 709.495n 0.0v 709.505n 0.0v 719.495n 0.0v 719.505n 0.0v 729.495n 0.0v 729.505n 0.0v 739.495n 0.0v 739.505n 0.0v 749.495n 0.0v 749.505n 0.0v 759.495n 0.0v 759.505n 0.0v 769.495n 0.0v 769.505n 1.8v 779.495n 1.8v 779.505n 1.8v 789.495n 1.8v 789.505n 1.8v 799.495n 1.8v 799.505n 1.8v 809.495n 1.8v 809.505n 1.8v 819.495n 1.8v 819.505n 0.0v 829.495n 0.0v 829.505n 0.0v 839.495n 0.0v 839.505n 0.0v 849.495n 0.0v 849.505n 0.0v 859.495n 0.0v 859.505n 0.0v 869.495n 0.0v 869.505n 0.0v 879.495n 0.0v 879.505n 0.0v 889.495n 0.0v 889.505n 0.0v 899.495n 0.0v 899.505n 0.0v 909.495n 0.0v 909.505n 0.0v 919.495n 0.0v 919.505n 0.0v 929.495n 0.0v 929.505n 0.0v 939.495n 0.0v 939.505n 0.0v 949.495n 0.0v 949.505n 0.0v 959.495n 0.0v 959.505n 0.0v 969.495n 0.0v 969.505n 0.0v 979.495n 0.0v 979.505n 0.0v 989.495n 0.0v 989.505n 0.0v 999.495n 0.0v 999.505n 0.0v 1009.495n 0.0v 1009.505n 0.0v 1019.495n 0.0v 1019.505n 0.0v 1029.495n 0.0v 1029.505n 0.0v 1039.495n 0.0v 1039.505n 0.0v 1049.495n 0.0v 1049.505n 0.0v 1059.495n 0.0v 1059.505n 0.0v 1069.495n 0.0v 1069.505n 0.0v 1079.495n 0.0v 1079.505n 0.0v 1089.495n 0.0v 1089.505n 0.0v 1099.495n 0.0v 1099.505n 0.0v 1109.495n 0.0v 1109.505n 0.0v 1119.495n 0.0v 1119.505n 0.0v 1129.495n 0.0v 1129.505n 1.8v 1139.495n 1.8v 1139.505n 1.8v 1149.495n 1.8v 1149.505n 1.8v 1159.495n 1.8v 1159.505n 1.8v 1169.495n 1.8v 1169.505n 1.8v 1179.495n 1.8v 1179.505n 1.8v 1189.495n 1.8v 1189.505n 1.8v 1199.495n 1.8v 1199.505n 1.8v 1209.495n 1.8v 1209.505n 1.8v 1219.495n 1.8v 1219.505n 1.8v 1229.495n 1.8v 1229.505n 1.8v 1239.495n 1.8v 1239.505n 1.8v 1249.495n 1.8v 1249.505n 1.8v 1259.495n 1.8v 1259.505n 1.8v 1269.495n 1.8v 1269.505n 1.8v 1279.495n 1.8v 1279.505n 1.8v 1289.495n 1.8v 1289.505n 1.8v 1299.495n 1.8v 1299.505n 1.8v 1309.495n 1.8v 1309.505n 1.8v 1319.495n 1.8v 1319.505n 1.8v 1329.495n 1.8v 1329.505n 1.8v 1339.495n 1.8v 1339.505n 1.8v 1349.495n 1.8v 1349.505n 1.8v 1359.495n 1.8v 1359.505n 1.8v 1369.495n 1.8v 1369.505n 1.8v 1379.495n 1.8v 1379.505n 1.8v 1389.495n 1.8v 1389.505n 1.8v 1399.495n 1.8v 1399.505n 0.0v 1409.495n 0.0v 1409.505n 0.0v 1419.495n 0.0v 1419.505n 0.0v 1429.495n 0.0v 1429.505n 0.0v 1439.495n 0.0v 1439.505n 0.0v 1449.495n 0.0v 1449.505n 0.0v 1459.495n 0.0v 1459.505n 0.0v 1469.495n 0.0v 1469.505n 0.0v 1479.495n 0.0v 1479.505n 1.8v 1489.495n 1.8v 1489.505n 1.8v 1499.495n 1.8v 1499.505n 0.0v 1509.495n 0.0v 1509.505n 0.0v 1519.495n 0.0v 1519.505n 0.0v 1529.495n 0.0v 1529.505n 0.0v 1539.495n 0.0v 1539.505n 0.0v 1549.495n 0.0v 1549.505n 0.0v 1559.495n 0.0v 1559.505n 0.0v 1569.495n 0.0v 1569.505n 1.8v 1579.495n 1.8v 1579.505n 1.8v 1589.495n 1.8v 1589.505n 1.8v 1599.495n 1.8v 1599.505n 1.8v 1609.495n 1.8v 1609.505n 1.8v 1619.495n 1.8v 1619.505n 0.0v 1629.495n 0.0v 1629.505n 0.0v 1639.495n 0.0v 1639.505n 0.0v 1649.495n 0.0v 1649.505n 0.0v 1659.495n 0.0v 1659.505n 0.0v 1669.495n 0.0v 1669.505n 0.0v 1679.495n 0.0v 1679.505n 0.0v 1689.495n 0.0v 1689.505n 0.0v 1699.495n 0.0v 1699.505n 0.0v 1709.495n 0.0v 1709.505n 1.8v 1719.495n 1.8v 1719.505n 1.8v 1729.495n 1.8v 1729.505n 0.0v 1739.495n 0.0v 1739.505n 0.0v 1749.495n 0.0v 1749.505n 0.0v 1759.495n 0.0v 1759.505n 0.0v 1769.495n 0.0v 1769.505n 0.0v 1779.495n 0.0v 1779.505n 0.0v 1789.495n 0.0v 1789.505n 0.0v 1799.495n 0.0v 1799.505n 0.0v 1809.495n 0.0v 1809.505n 0.0v 1819.495n 0.0v 1819.505n 0.0v 1829.495n 0.0v 1829.505n 0.0v 1839.495n 0.0v 1839.505n 0.0v 1849.495n 0.0v 1849.505n 1.8v 1859.495n 1.8v 1859.505n 1.8v 1869.495n 1.8v 1869.505n 1.8v 1879.495n 1.8v 1879.505n 0.0v 1889.495n 0.0v 1889.505n 0.0v 1899.495n 0.0v 1899.505n 0.0v 1909.495n 0.0v 1909.505n 1.8v 1919.495n 1.8v 1919.505n 1.8v 1929.495n 1.8v 1929.505n 1.8v 1939.495n 1.8v 1939.505n 1.8v 1949.495n 1.8v 1949.505n 1.8v 1959.495n 1.8v 1959.505n 1.8v 1969.495n 1.8v 1969.505n 1.8v 1979.495n 1.8v 1979.505n 1.8v 1989.495n 1.8v 1989.505n 1.8v 1999.495n 1.8v 1999.505n 1.8v 2009.495n 1.8v 2009.505n 1.8v 2019.495n 1.8v 2019.505n 1.8v 2029.495n 1.8v 2029.505n 0.0v 2039.495n 0.0v 2039.505n 0.0v 2049.495n 0.0v 2049.505n 0.0v )
* (time, data): [(0, 0), (10, 1), (20, 1), (30, 0), (40, 0), (50, 0), (60, 1), (70, 1), (80, 1), (90, 1), (100, 1), (110, 1), (120, 1), (130, 1), (140, 1), (150, 0), (160, 0), (170, 0), (180, 0), (190, 0), (200, 0), (210, 0), (220, 0), (230, 0), (240, 0), (250, 0), (260, 1), (270, 1), (280, 1), (290, 1), (300, 1), (310, 0), (320, 0), (330, 0), (340, 0), (350, 0), (360, 0), (370, 0), (380, 0), (390, 1), (400, 1), (410, 1), (420, 1), (430, 1), (440, 1), (450, 0), (460, 0), (470, 0), (480, 0), (490, 0), (500, 0), (510, 0), (520, 0), (530, 0), (540, 0), (550, 0), (560, 0), (570, 0), (580, 0), (590, 0), (600, 0), (610, 0), (620, 1), (630, 1), (640, 1), (650, 1), (660, 1), (670, 1), (680, 1), (690, 1), (700, 1), (710, 0), (720, 0), (730, 0), (740, 0), (750, 0), (760, 0), (770, 1), (780, 1), (790, 1), (800, 1), (810, 1), (820, 0), (830, 0), (840, 0), (850, 0), (860, 0), (870, 0), (880, 0), (890, 0), (900, 0), (910, 0), (920, 0), (930, 1), (940, 1), (950, 1), (960, 1), (970, 1), (980, 1), (990, 1), (1000, 1), (1010, 1), (1020, 1), (1030, 1), (1040, 1), (1050, 1), (1060, 1), (1070, 1), (1080, 0), (1090, 0), (1100, 0), (1110, 0), (1120, 0), (1130, 1), (1140, 1), (1150, 1), (1160, 1), (1170, 1), (1180, 1), (1190, 1), (1200, 1), (1210, 1), (1220, 1), (1230, 1), (1240, 1), (1250, 1), (1260, 1), (1270, 1), (1280, 0), (1290, 0), (1300, 0), (1310, 0), (1320, 0), (1330, 0), (1340, 0), (1350, 0), (1360, 0), (1370, 1), (1380, 1), (1390, 1), (1400, 0), (1410, 0), (1420, 0), (1430, 1), (1440, 1), (1450, 1), (1460, 1), (1470, 1), (1480, 0), (1490, 0), (1500, 1), (1510, 1), (1520, 1), (1530, 1), (1540, 1), (1550, 1), (1560, 1), (1570, 1), (1580, 0), (1590, 1), (1600, 1), (1610, 1), (1620, 0), (1630, 0), (1640, 0), (1650, 0), (1660, 0), (1670, 0), (1680, 0), (1690, 0), (1700, 0), (1710, 1), (1720, 1), (1730, 1), (1740, 1), (1750, 1), (1760, 1), (1770, 1), (1780, 1), (1790, 1), (1800, 1), (1810, 1), (1820, 1), (1830, 1), (1840, 1), (1850, 0), (1860, 1), (1870, 1), (1880, 0), (1890, 1), (1900, 1), (1910, 0), (1920, 0), (1930, 0), (1940, 0), (1950, 0), (1960, 0), (1970, 0), (1980, 0), (1990, 0), (2000, 0), (2010, 0), (2020, 0), (2030, 0), (2040, 0), (2050, 0)]
Vdin0_26  din0_26  0 PWL (0n 0.0v 9.495n 0.0v 9.505n 1.8v 19.495n 1.8v 19.505n 1.8v 29.495n 1.8v 29.505n 0.0v 39.495n 0.0v 39.505n 0.0v 49.495n 0.0v 49.505n 0.0v 59.495n 0.0v 59.505n 1.8v 69.495n 1.8v 69.505n 1.8v 79.495n 1.8v 79.505n 1.8v 89.495n 1.8v 89.505n 1.8v 99.495n 1.8v 99.505n 1.8v 109.495n 1.8v 109.505n 1.8v 119.495n 1.8v 119.505n 1.8v 129.495n 1.8v 129.505n 1.8v 139.495n 1.8v 139.505n 1.8v 149.495n 1.8v 149.505n 0.0v 159.495n 0.0v 159.505n 0.0v 169.495n 0.0v 169.505n 0.0v 179.495n 0.0v 179.505n 0.0v 189.495n 0.0v 189.505n 0.0v 199.495n 0.0v 199.505n 0.0v 209.495n 0.0v 209.505n 0.0v 219.495n 0.0v 219.505n 0.0v 229.495n 0.0v 229.505n 0.0v 239.495n 0.0v 239.505n 0.0v 249.495n 0.0v 249.505n 0.0v 259.495n 0.0v 259.505n 1.8v 269.495n 1.8v 269.505n 1.8v 279.495n 1.8v 279.505n 1.8v 289.495n 1.8v 289.505n 1.8v 299.495n 1.8v 299.505n 1.8v 309.495n 1.8v 309.505n 0.0v 319.495n 0.0v 319.505n 0.0v 329.495n 0.0v 329.505n 0.0v 339.495n 0.0v 339.505n 0.0v 349.495n 0.0v 349.505n 0.0v 359.495n 0.0v 359.505n 0.0v 369.495n 0.0v 369.505n 0.0v 379.495n 0.0v 379.505n 0.0v 389.495n 0.0v 389.505n 1.8v 399.495n 1.8v 399.505n 1.8v 409.495n 1.8v 409.505n 1.8v 419.495n 1.8v 419.505n 1.8v 429.495n 1.8v 429.505n 1.8v 439.495n 1.8v 439.505n 1.8v 449.495n 1.8v 449.505n 0.0v 459.495n 0.0v 459.505n 0.0v 469.495n 0.0v 469.505n 0.0v 479.495n 0.0v 479.505n 0.0v 489.495n 0.0v 489.505n 0.0v 499.495n 0.0v 499.505n 0.0v 509.495n 0.0v 509.505n 0.0v 519.495n 0.0v 519.505n 0.0v 529.495n 0.0v 529.505n 0.0v 539.495n 0.0v 539.505n 0.0v 549.495n 0.0v 549.505n 0.0v 559.495n 0.0v 559.505n 0.0v 569.495n 0.0v 569.505n 0.0v 579.495n 0.0v 579.505n 0.0v 589.495n 0.0v 589.505n 0.0v 599.495n 0.0v 599.505n 0.0v 609.495n 0.0v 609.505n 0.0v 619.495n 0.0v 619.505n 1.8v 629.495n 1.8v 629.505n 1.8v 639.495n 1.8v 639.505n 1.8v 649.495n 1.8v 649.505n 1.8v 659.495n 1.8v 659.505n 1.8v 669.495n 1.8v 669.505n 1.8v 679.495n 1.8v 679.505n 1.8v 689.495n 1.8v 689.505n 1.8v 699.495n 1.8v 699.505n 1.8v 709.495n 1.8v 709.505n 0.0v 719.495n 0.0v 719.505n 0.0v 729.495n 0.0v 729.505n 0.0v 739.495n 0.0v 739.505n 0.0v 749.495n 0.0v 749.505n 0.0v 759.495n 0.0v 759.505n 0.0v 769.495n 0.0v 769.505n 1.8v 779.495n 1.8v 779.505n 1.8v 789.495n 1.8v 789.505n 1.8v 799.495n 1.8v 799.505n 1.8v 809.495n 1.8v 809.505n 1.8v 819.495n 1.8v 819.505n 0.0v 829.495n 0.0v 829.505n 0.0v 839.495n 0.0v 839.505n 0.0v 849.495n 0.0v 849.505n 0.0v 859.495n 0.0v 859.505n 0.0v 869.495n 0.0v 869.505n 0.0v 879.495n 0.0v 879.505n 0.0v 889.495n 0.0v 889.505n 0.0v 899.495n 0.0v 899.505n 0.0v 909.495n 0.0v 909.505n 0.0v 919.495n 0.0v 919.505n 0.0v 929.495n 0.0v 929.505n 1.8v 939.495n 1.8v 939.505n 1.8v 949.495n 1.8v 949.505n 1.8v 959.495n 1.8v 959.505n 1.8v 969.495n 1.8v 969.505n 1.8v 979.495n 1.8v 979.505n 1.8v 989.495n 1.8v 989.505n 1.8v 999.495n 1.8v 999.505n 1.8v 1009.495n 1.8v 1009.505n 1.8v 1019.495n 1.8v 1019.505n 1.8v 1029.495n 1.8v 1029.505n 1.8v 1039.495n 1.8v 1039.505n 1.8v 1049.495n 1.8v 1049.505n 1.8v 1059.495n 1.8v 1059.505n 1.8v 1069.495n 1.8v 1069.505n 1.8v 1079.495n 1.8v 1079.505n 0.0v 1089.495n 0.0v 1089.505n 0.0v 1099.495n 0.0v 1099.505n 0.0v 1109.495n 0.0v 1109.505n 0.0v 1119.495n 0.0v 1119.505n 0.0v 1129.495n 0.0v 1129.505n 1.8v 1139.495n 1.8v 1139.505n 1.8v 1149.495n 1.8v 1149.505n 1.8v 1159.495n 1.8v 1159.505n 1.8v 1169.495n 1.8v 1169.505n 1.8v 1179.495n 1.8v 1179.505n 1.8v 1189.495n 1.8v 1189.505n 1.8v 1199.495n 1.8v 1199.505n 1.8v 1209.495n 1.8v 1209.505n 1.8v 1219.495n 1.8v 1219.505n 1.8v 1229.495n 1.8v 1229.505n 1.8v 1239.495n 1.8v 1239.505n 1.8v 1249.495n 1.8v 1249.505n 1.8v 1259.495n 1.8v 1259.505n 1.8v 1269.495n 1.8v 1269.505n 1.8v 1279.495n 1.8v 1279.505n 0.0v 1289.495n 0.0v 1289.505n 0.0v 1299.495n 0.0v 1299.505n 0.0v 1309.495n 0.0v 1309.505n 0.0v 1319.495n 0.0v 1319.505n 0.0v 1329.495n 0.0v 1329.505n 0.0v 1339.495n 0.0v 1339.505n 0.0v 1349.495n 0.0v 1349.505n 0.0v 1359.495n 0.0v 1359.505n 0.0v 1369.495n 0.0v 1369.505n 1.8v 1379.495n 1.8v 1379.505n 1.8v 1389.495n 1.8v 1389.505n 1.8v 1399.495n 1.8v 1399.505n 0.0v 1409.495n 0.0v 1409.505n 0.0v 1419.495n 0.0v 1419.505n 0.0v 1429.495n 0.0v 1429.505n 1.8v 1439.495n 1.8v 1439.505n 1.8v 1449.495n 1.8v 1449.505n 1.8v 1459.495n 1.8v 1459.505n 1.8v 1469.495n 1.8v 1469.505n 1.8v 1479.495n 1.8v 1479.505n 0.0v 1489.495n 0.0v 1489.505n 0.0v 1499.495n 0.0v 1499.505n 1.8v 1509.495n 1.8v 1509.505n 1.8v 1519.495n 1.8v 1519.505n 1.8v 1529.495n 1.8v 1529.505n 1.8v 1539.495n 1.8v 1539.505n 1.8v 1549.495n 1.8v 1549.505n 1.8v 1559.495n 1.8v 1559.505n 1.8v 1569.495n 1.8v 1569.505n 1.8v 1579.495n 1.8v 1579.505n 0.0v 1589.495n 0.0v 1589.505n 1.8v 1599.495n 1.8v 1599.505n 1.8v 1609.495n 1.8v 1609.505n 1.8v 1619.495n 1.8v 1619.505n 0.0v 1629.495n 0.0v 1629.505n 0.0v 1639.495n 0.0v 1639.505n 0.0v 1649.495n 0.0v 1649.505n 0.0v 1659.495n 0.0v 1659.505n 0.0v 1669.495n 0.0v 1669.505n 0.0v 1679.495n 0.0v 1679.505n 0.0v 1689.495n 0.0v 1689.505n 0.0v 1699.495n 0.0v 1699.505n 0.0v 1709.495n 0.0v 1709.505n 1.8v 1719.495n 1.8v 1719.505n 1.8v 1729.495n 1.8v 1729.505n 1.8v 1739.495n 1.8v 1739.505n 1.8v 1749.495n 1.8v 1749.505n 1.8v 1759.495n 1.8v 1759.505n 1.8v 1769.495n 1.8v 1769.505n 1.8v 1779.495n 1.8v 1779.505n 1.8v 1789.495n 1.8v 1789.505n 1.8v 1799.495n 1.8v 1799.505n 1.8v 1809.495n 1.8v 1809.505n 1.8v 1819.495n 1.8v 1819.505n 1.8v 1829.495n 1.8v 1829.505n 1.8v 1839.495n 1.8v 1839.505n 1.8v 1849.495n 1.8v 1849.505n 0.0v 1859.495n 0.0v 1859.505n 1.8v 1869.495n 1.8v 1869.505n 1.8v 1879.495n 1.8v 1879.505n 0.0v 1889.495n 0.0v 1889.505n 1.8v 1899.495n 1.8v 1899.505n 1.8v 1909.495n 1.8v 1909.505n 0.0v 1919.495n 0.0v 1919.505n 0.0v 1929.495n 0.0v 1929.505n 0.0v 1939.495n 0.0v 1939.505n 0.0v 1949.495n 0.0v 1949.505n 0.0v 1959.495n 0.0v 1959.505n 0.0v 1969.495n 0.0v 1969.505n 0.0v 1979.495n 0.0v 1979.505n 0.0v 1989.495n 0.0v 1989.505n 0.0v 1999.495n 0.0v 1999.505n 0.0v 2009.495n 0.0v 2009.505n 0.0v 2019.495n 0.0v 2019.505n 0.0v 2029.495n 0.0v 2029.505n 0.0v 2039.495n 0.0v 2039.505n 0.0v 2049.495n 0.0v 2049.505n 0.0v )
* (time, data): [(0, 0), (10, 0), (20, 0), (30, 1), (40, 1), (50, 1), (60, 0), (70, 0), (80, 0), (90, 0), (100, 0), (110, 0), (120, 0), (130, 0), (140, 0), (150, 1), (160, 1), (170, 1), (180, 1), (190, 1), (200, 1), (210, 1), (220, 1), (230, 1), (240, 1), (250, 1), (260, 0), (270, 0), (280, 0), (290, 0), (300, 0), (310, 0), (320, 0), (330, 0), (340, 0), (350, 1), (360, 1), (370, 1), (380, 1), (390, 0), (400, 1), (410, 1), (420, 1), (430, 1), (440, 1), (450, 1), (460, 1), (470, 0), (480, 0), (490, 1), (500, 0), (510, 0), (520, 0), (530, 0), (540, 0), (550, 0), (560, 0), (570, 0), (580, 0), (590, 0), (600, 0), (610, 0), (620, 0), (630, 0), (640, 0), (650, 0), (660, 0), (670, 1), (680, 1), (690, 1), (700, 1), (710, 1), (720, 1), (730, 1), (740, 1), (750, 1), (760, 1), (770, 1), (780, 1), (790, 1), (800, 1), (810, 1), (820, 0), (830, 0), (840, 1), (850, 1), (860, 1), (870, 1), (880, 1), (890, 0), (900, 0), (910, 0), (920, 0), (930, 1), (940, 1), (950, 1), (960, 1), (970, 1), (980, 1), (990, 1), (1000, 1), (1010, 1), (1020, 1), (1030, 1), (1040, 1), (1050, 1), (1060, 1), (1070, 1), (1080, 0), (1090, 0), (1100, 0), (1110, 0), (1120, 0), (1130, 0), (1140, 0), (1150, 0), (1160, 0), (1170, 0), (1180, 0), (1190, 0), (1200, 0), (1210, 0), (1220, 0), (1230, 0), (1240, 0), (1250, 0), (1260, 1), (1270, 1), (1280, 1), (1290, 1), (1300, 1), (1310, 1), (1320, 1), (1330, 1), (1340, 1), (1350, 1), (1360, 1), (1370, 0), (1380, 0), (1390, 0), (1400, 0), (1410, 0), (1420, 0), (1430, 0), (1440, 0), (1450, 0), (1460, 0), (1470, 0), (1480, 1), (1490, 1), (1500, 1), (1510, 1), (1520, 1), (1530, 1), (1540, 1), (1550, 1), (1560, 1), (1570, 1), (1580, 1), (1590, 1), (1600, 1), (1610, 1), (1620, 0), (1630, 0), (1640, 0), (1650, 0), (1660, 0), (1670, 0), (1680, 0), (1690, 0), (1700, 0), (1710, 1), (1720, 1), (1730, 1), (1740, 0), (1750, 0), (1760, 0), (1770, 0), (1780, 0), (1790, 0), (1800, 0), (1810, 0), (1820, 0), (1830, 0), (1840, 0), (1850, 1), (1860, 0), (1870, 1), (1880, 0), (1890, 0), (1900, 0), (1910, 1), (1920, 1), (1930, 1), (1940, 1), (1950, 1), (1960, 1), (1970, 1), (1980, 1), (1990, 1), (2000, 1), (2010, 1), (2020, 1), (2030, 0), (2040, 0), (2050, 0)]
Vdin0_27  din0_27  0 PWL (0n 0.0v 9.495n 0.0v 9.505n 0.0v 19.495n 0.0v 19.505n 0.0v 29.495n 0.0v 29.505n 1.8v 39.495n 1.8v 39.505n 1.8v 49.495n 1.8v 49.505n 1.8v 59.495n 1.8v 59.505n 0.0v 69.495n 0.0v 69.505n 0.0v 79.495n 0.0v 79.505n 0.0v 89.495n 0.0v 89.505n 0.0v 99.495n 0.0v 99.505n 0.0v 109.495n 0.0v 109.505n 0.0v 119.495n 0.0v 119.505n 0.0v 129.495n 0.0v 129.505n 0.0v 139.495n 0.0v 139.505n 0.0v 149.495n 0.0v 149.505n 1.8v 159.495n 1.8v 159.505n 1.8v 169.495n 1.8v 169.505n 1.8v 179.495n 1.8v 179.505n 1.8v 189.495n 1.8v 189.505n 1.8v 199.495n 1.8v 199.505n 1.8v 209.495n 1.8v 209.505n 1.8v 219.495n 1.8v 219.505n 1.8v 229.495n 1.8v 229.505n 1.8v 239.495n 1.8v 239.505n 1.8v 249.495n 1.8v 249.505n 1.8v 259.495n 1.8v 259.505n 0.0v 269.495n 0.0v 269.505n 0.0v 279.495n 0.0v 279.505n 0.0v 289.495n 0.0v 289.505n 0.0v 299.495n 0.0v 299.505n 0.0v 309.495n 0.0v 309.505n 0.0v 319.495n 0.0v 319.505n 0.0v 329.495n 0.0v 329.505n 0.0v 339.495n 0.0v 339.505n 0.0v 349.495n 0.0v 349.505n 1.8v 359.495n 1.8v 359.505n 1.8v 369.495n 1.8v 369.505n 1.8v 379.495n 1.8v 379.505n 1.8v 389.495n 1.8v 389.505n 0.0v 399.495n 0.0v 399.505n 1.8v 409.495n 1.8v 409.505n 1.8v 419.495n 1.8v 419.505n 1.8v 429.495n 1.8v 429.505n 1.8v 439.495n 1.8v 439.505n 1.8v 449.495n 1.8v 449.505n 1.8v 459.495n 1.8v 459.505n 1.8v 469.495n 1.8v 469.505n 0.0v 479.495n 0.0v 479.505n 0.0v 489.495n 0.0v 489.505n 1.8v 499.495n 1.8v 499.505n 0.0v 509.495n 0.0v 509.505n 0.0v 519.495n 0.0v 519.505n 0.0v 529.495n 0.0v 529.505n 0.0v 539.495n 0.0v 539.505n 0.0v 549.495n 0.0v 549.505n 0.0v 559.495n 0.0v 559.505n 0.0v 569.495n 0.0v 569.505n 0.0v 579.495n 0.0v 579.505n 0.0v 589.495n 0.0v 589.505n 0.0v 599.495n 0.0v 599.505n 0.0v 609.495n 0.0v 609.505n 0.0v 619.495n 0.0v 619.505n 0.0v 629.495n 0.0v 629.505n 0.0v 639.495n 0.0v 639.505n 0.0v 649.495n 0.0v 649.505n 0.0v 659.495n 0.0v 659.505n 0.0v 669.495n 0.0v 669.505n 1.8v 679.495n 1.8v 679.505n 1.8v 689.495n 1.8v 689.505n 1.8v 699.495n 1.8v 699.505n 1.8v 709.495n 1.8v 709.505n 1.8v 719.495n 1.8v 719.505n 1.8v 729.495n 1.8v 729.505n 1.8v 739.495n 1.8v 739.505n 1.8v 749.495n 1.8v 749.505n 1.8v 759.495n 1.8v 759.505n 1.8v 769.495n 1.8v 769.505n 1.8v 779.495n 1.8v 779.505n 1.8v 789.495n 1.8v 789.505n 1.8v 799.495n 1.8v 799.505n 1.8v 809.495n 1.8v 809.505n 1.8v 819.495n 1.8v 819.505n 0.0v 829.495n 0.0v 829.505n 0.0v 839.495n 0.0v 839.505n 1.8v 849.495n 1.8v 849.505n 1.8v 859.495n 1.8v 859.505n 1.8v 869.495n 1.8v 869.505n 1.8v 879.495n 1.8v 879.505n 1.8v 889.495n 1.8v 889.505n 0.0v 899.495n 0.0v 899.505n 0.0v 909.495n 0.0v 909.505n 0.0v 919.495n 0.0v 919.505n 0.0v 929.495n 0.0v 929.505n 1.8v 939.495n 1.8v 939.505n 1.8v 949.495n 1.8v 949.505n 1.8v 959.495n 1.8v 959.505n 1.8v 969.495n 1.8v 969.505n 1.8v 979.495n 1.8v 979.505n 1.8v 989.495n 1.8v 989.505n 1.8v 999.495n 1.8v 999.505n 1.8v 1009.495n 1.8v 1009.505n 1.8v 1019.495n 1.8v 1019.505n 1.8v 1029.495n 1.8v 1029.505n 1.8v 1039.495n 1.8v 1039.505n 1.8v 1049.495n 1.8v 1049.505n 1.8v 1059.495n 1.8v 1059.505n 1.8v 1069.495n 1.8v 1069.505n 1.8v 1079.495n 1.8v 1079.505n 0.0v 1089.495n 0.0v 1089.505n 0.0v 1099.495n 0.0v 1099.505n 0.0v 1109.495n 0.0v 1109.505n 0.0v 1119.495n 0.0v 1119.505n 0.0v 1129.495n 0.0v 1129.505n 0.0v 1139.495n 0.0v 1139.505n 0.0v 1149.495n 0.0v 1149.505n 0.0v 1159.495n 0.0v 1159.505n 0.0v 1169.495n 0.0v 1169.505n 0.0v 1179.495n 0.0v 1179.505n 0.0v 1189.495n 0.0v 1189.505n 0.0v 1199.495n 0.0v 1199.505n 0.0v 1209.495n 0.0v 1209.505n 0.0v 1219.495n 0.0v 1219.505n 0.0v 1229.495n 0.0v 1229.505n 0.0v 1239.495n 0.0v 1239.505n 0.0v 1249.495n 0.0v 1249.505n 0.0v 1259.495n 0.0v 1259.505n 1.8v 1269.495n 1.8v 1269.505n 1.8v 1279.495n 1.8v 1279.505n 1.8v 1289.495n 1.8v 1289.505n 1.8v 1299.495n 1.8v 1299.505n 1.8v 1309.495n 1.8v 1309.505n 1.8v 1319.495n 1.8v 1319.505n 1.8v 1329.495n 1.8v 1329.505n 1.8v 1339.495n 1.8v 1339.505n 1.8v 1349.495n 1.8v 1349.505n 1.8v 1359.495n 1.8v 1359.505n 1.8v 1369.495n 1.8v 1369.505n 0.0v 1379.495n 0.0v 1379.505n 0.0v 1389.495n 0.0v 1389.505n 0.0v 1399.495n 0.0v 1399.505n 0.0v 1409.495n 0.0v 1409.505n 0.0v 1419.495n 0.0v 1419.505n 0.0v 1429.495n 0.0v 1429.505n 0.0v 1439.495n 0.0v 1439.505n 0.0v 1449.495n 0.0v 1449.505n 0.0v 1459.495n 0.0v 1459.505n 0.0v 1469.495n 0.0v 1469.505n 0.0v 1479.495n 0.0v 1479.505n 1.8v 1489.495n 1.8v 1489.505n 1.8v 1499.495n 1.8v 1499.505n 1.8v 1509.495n 1.8v 1509.505n 1.8v 1519.495n 1.8v 1519.505n 1.8v 1529.495n 1.8v 1529.505n 1.8v 1539.495n 1.8v 1539.505n 1.8v 1549.495n 1.8v 1549.505n 1.8v 1559.495n 1.8v 1559.505n 1.8v 1569.495n 1.8v 1569.505n 1.8v 1579.495n 1.8v 1579.505n 1.8v 1589.495n 1.8v 1589.505n 1.8v 1599.495n 1.8v 1599.505n 1.8v 1609.495n 1.8v 1609.505n 1.8v 1619.495n 1.8v 1619.505n 0.0v 1629.495n 0.0v 1629.505n 0.0v 1639.495n 0.0v 1639.505n 0.0v 1649.495n 0.0v 1649.505n 0.0v 1659.495n 0.0v 1659.505n 0.0v 1669.495n 0.0v 1669.505n 0.0v 1679.495n 0.0v 1679.505n 0.0v 1689.495n 0.0v 1689.505n 0.0v 1699.495n 0.0v 1699.505n 0.0v 1709.495n 0.0v 1709.505n 1.8v 1719.495n 1.8v 1719.505n 1.8v 1729.495n 1.8v 1729.505n 1.8v 1739.495n 1.8v 1739.505n 0.0v 1749.495n 0.0v 1749.505n 0.0v 1759.495n 0.0v 1759.505n 0.0v 1769.495n 0.0v 1769.505n 0.0v 1779.495n 0.0v 1779.505n 0.0v 1789.495n 0.0v 1789.505n 0.0v 1799.495n 0.0v 1799.505n 0.0v 1809.495n 0.0v 1809.505n 0.0v 1819.495n 0.0v 1819.505n 0.0v 1829.495n 0.0v 1829.505n 0.0v 1839.495n 0.0v 1839.505n 0.0v 1849.495n 0.0v 1849.505n 1.8v 1859.495n 1.8v 1859.505n 0.0v 1869.495n 0.0v 1869.505n 1.8v 1879.495n 1.8v 1879.505n 0.0v 1889.495n 0.0v 1889.505n 0.0v 1899.495n 0.0v 1899.505n 0.0v 1909.495n 0.0v 1909.505n 1.8v 1919.495n 1.8v 1919.505n 1.8v 1929.495n 1.8v 1929.505n 1.8v 1939.495n 1.8v 1939.505n 1.8v 1949.495n 1.8v 1949.505n 1.8v 1959.495n 1.8v 1959.505n 1.8v 1969.495n 1.8v 1969.505n 1.8v 1979.495n 1.8v 1979.505n 1.8v 1989.495n 1.8v 1989.505n 1.8v 1999.495n 1.8v 1999.505n 1.8v 2009.495n 1.8v 2009.505n 1.8v 2019.495n 1.8v 2019.505n 1.8v 2029.495n 1.8v 2029.505n 0.0v 2039.495n 0.0v 2039.505n 0.0v 2049.495n 0.0v 2049.505n 0.0v )
* (time, data): [(0, 0), (10, 0), (20, 0), (30, 1), (40, 1), (50, 1), (60, 1), (70, 1), (80, 1), (90, 1), (100, 1), (110, 1), (120, 1), (130, 1), (140, 1), (150, 1), (160, 1), (170, 1), (180, 1), (190, 1), (200, 1), (210, 1), (220, 1), (230, 1), (240, 1), (250, 1), (260, 0), (270, 0), (280, 0), (290, 0), (300, 0), (310, 1), (320, 1), (330, 1), (340, 1), (350, 1), (360, 1), (370, 1), (380, 1), (390, 0), (400, 1), (410, 1), (420, 1), (430, 1), (440, 1), (450, 0), (460, 0), (470, 0), (480, 0), (490, 0), (500, 1), (510, 1), (520, 1), (530, 1), (540, 1), (550, 1), (560, 1), (570, 1), (580, 1), (590, 1), (600, 1), (610, 1), (620, 0), (630, 0), (640, 0), (650, 0), (660, 1), (670, 0), (680, 0), (690, 0), (700, 0), (710, 0), (720, 0), (730, 0), (740, 0), (750, 0), (760, 0), (770, 1), (780, 1), (790, 1), (800, 1), (810, 1), (820, 0), (830, 0), (840, 0), (850, 0), (860, 0), (870, 0), (880, 0), (890, 1), (900, 1), (910, 1), (920, 1), (930, 0), (940, 0), (950, 0), (960, 1), (970, 1), (980, 1), (990, 1), (1000, 1), (1010, 1), (1020, 1), (1030, 1), (1040, 1), (1050, 1), (1060, 1), (1070, 1), (1080, 0), (1090, 0), (1100, 0), (1110, 0), (1120, 0), (1130, 0), (1140, 0), (1150, 0), (1160, 0), (1170, 0), (1180, 0), (1190, 0), (1200, 0), (1210, 0), (1220, 0), (1230, 0), (1240, 0), (1250, 0), (1260, 0), (1270, 0), (1280, 0), (1290, 0), (1300, 0), (1310, 0), (1320, 0), (1330, 0), (1340, 0), (1350, 0), (1360, 0), (1370, 0), (1380, 0), (1390, 0), (1400, 0), (1410, 0), (1420, 0), (1430, 1), (1440, 1), (1450, 1), (1460, 1), (1470, 1), (1480, 0), (1490, 0), (1500, 1), (1510, 1), (1520, 1), (1530, 1), (1540, 1), (1550, 1), (1560, 1), (1570, 1), (1580, 0), (1590, 1), (1600, 1), (1610, 1), (1620, 0), (1630, 0), (1640, 0), (1650, 0), (1660, 0), (1670, 0), (1680, 0), (1690, 0), (1700, 0), (1710, 1), (1720, 1), (1730, 1), (1740, 0), (1750, 0), (1760, 0), (1770, 0), (1780, 0), (1790, 1), (1800, 1), (1810, 1), (1820, 1), (1830, 1), (1840, 1), (1850, 1), (1860, 1), (1870, 0), (1880, 1), (1890, 1), (1900, 1), (1910, 0), (1920, 0), (1930, 0), (1940, 0), (1950, 0), (1960, 0), (1970, 0), (1980, 0), (1990, 0), (2000, 0), (2010, 0), (2020, 0), (2030, 1), (2040, 1), (2050, 1)]
Vdin0_28  din0_28  0 PWL (0n 0.0v 9.495n 0.0v 9.505n 0.0v 19.495n 0.0v 19.505n 0.0v 29.495n 0.0v 29.505n 1.8v 39.495n 1.8v 39.505n 1.8v 49.495n 1.8v 49.505n 1.8v 59.495n 1.8v 59.505n 1.8v 69.495n 1.8v 69.505n 1.8v 79.495n 1.8v 79.505n 1.8v 89.495n 1.8v 89.505n 1.8v 99.495n 1.8v 99.505n 1.8v 109.495n 1.8v 109.505n 1.8v 119.495n 1.8v 119.505n 1.8v 129.495n 1.8v 129.505n 1.8v 139.495n 1.8v 139.505n 1.8v 149.495n 1.8v 149.505n 1.8v 159.495n 1.8v 159.505n 1.8v 169.495n 1.8v 169.505n 1.8v 179.495n 1.8v 179.505n 1.8v 189.495n 1.8v 189.505n 1.8v 199.495n 1.8v 199.505n 1.8v 209.495n 1.8v 209.505n 1.8v 219.495n 1.8v 219.505n 1.8v 229.495n 1.8v 229.505n 1.8v 239.495n 1.8v 239.505n 1.8v 249.495n 1.8v 249.505n 1.8v 259.495n 1.8v 259.505n 0.0v 269.495n 0.0v 269.505n 0.0v 279.495n 0.0v 279.505n 0.0v 289.495n 0.0v 289.505n 0.0v 299.495n 0.0v 299.505n 0.0v 309.495n 0.0v 309.505n 1.8v 319.495n 1.8v 319.505n 1.8v 329.495n 1.8v 329.505n 1.8v 339.495n 1.8v 339.505n 1.8v 349.495n 1.8v 349.505n 1.8v 359.495n 1.8v 359.505n 1.8v 369.495n 1.8v 369.505n 1.8v 379.495n 1.8v 379.505n 1.8v 389.495n 1.8v 389.505n 0.0v 399.495n 0.0v 399.505n 1.8v 409.495n 1.8v 409.505n 1.8v 419.495n 1.8v 419.505n 1.8v 429.495n 1.8v 429.505n 1.8v 439.495n 1.8v 439.505n 1.8v 449.495n 1.8v 449.505n 0.0v 459.495n 0.0v 459.505n 0.0v 469.495n 0.0v 469.505n 0.0v 479.495n 0.0v 479.505n 0.0v 489.495n 0.0v 489.505n 0.0v 499.495n 0.0v 499.505n 1.8v 509.495n 1.8v 509.505n 1.8v 519.495n 1.8v 519.505n 1.8v 529.495n 1.8v 529.505n 1.8v 539.495n 1.8v 539.505n 1.8v 549.495n 1.8v 549.505n 1.8v 559.495n 1.8v 559.505n 1.8v 569.495n 1.8v 569.505n 1.8v 579.495n 1.8v 579.505n 1.8v 589.495n 1.8v 589.505n 1.8v 599.495n 1.8v 599.505n 1.8v 609.495n 1.8v 609.505n 1.8v 619.495n 1.8v 619.505n 0.0v 629.495n 0.0v 629.505n 0.0v 639.495n 0.0v 639.505n 0.0v 649.495n 0.0v 649.505n 0.0v 659.495n 0.0v 659.505n 1.8v 669.495n 1.8v 669.505n 0.0v 679.495n 0.0v 679.505n 0.0v 689.495n 0.0v 689.505n 0.0v 699.495n 0.0v 699.505n 0.0v 709.495n 0.0v 709.505n 0.0v 719.495n 0.0v 719.505n 0.0v 729.495n 0.0v 729.505n 0.0v 739.495n 0.0v 739.505n 0.0v 749.495n 0.0v 749.505n 0.0v 759.495n 0.0v 759.505n 0.0v 769.495n 0.0v 769.505n 1.8v 779.495n 1.8v 779.505n 1.8v 789.495n 1.8v 789.505n 1.8v 799.495n 1.8v 799.505n 1.8v 809.495n 1.8v 809.505n 1.8v 819.495n 1.8v 819.505n 0.0v 829.495n 0.0v 829.505n 0.0v 839.495n 0.0v 839.505n 0.0v 849.495n 0.0v 849.505n 0.0v 859.495n 0.0v 859.505n 0.0v 869.495n 0.0v 869.505n 0.0v 879.495n 0.0v 879.505n 0.0v 889.495n 0.0v 889.505n 1.8v 899.495n 1.8v 899.505n 1.8v 909.495n 1.8v 909.505n 1.8v 919.495n 1.8v 919.505n 1.8v 929.495n 1.8v 929.505n 0.0v 939.495n 0.0v 939.505n 0.0v 949.495n 0.0v 949.505n 0.0v 959.495n 0.0v 959.505n 1.8v 969.495n 1.8v 969.505n 1.8v 979.495n 1.8v 979.505n 1.8v 989.495n 1.8v 989.505n 1.8v 999.495n 1.8v 999.505n 1.8v 1009.495n 1.8v 1009.505n 1.8v 1019.495n 1.8v 1019.505n 1.8v 1029.495n 1.8v 1029.505n 1.8v 1039.495n 1.8v 1039.505n 1.8v 1049.495n 1.8v 1049.505n 1.8v 1059.495n 1.8v 1059.505n 1.8v 1069.495n 1.8v 1069.505n 1.8v 1079.495n 1.8v 1079.505n 0.0v 1089.495n 0.0v 1089.505n 0.0v 1099.495n 0.0v 1099.505n 0.0v 1109.495n 0.0v 1109.505n 0.0v 1119.495n 0.0v 1119.505n 0.0v 1129.495n 0.0v 1129.505n 0.0v 1139.495n 0.0v 1139.505n 0.0v 1149.495n 0.0v 1149.505n 0.0v 1159.495n 0.0v 1159.505n 0.0v 1169.495n 0.0v 1169.505n 0.0v 1179.495n 0.0v 1179.505n 0.0v 1189.495n 0.0v 1189.505n 0.0v 1199.495n 0.0v 1199.505n 0.0v 1209.495n 0.0v 1209.505n 0.0v 1219.495n 0.0v 1219.505n 0.0v 1229.495n 0.0v 1229.505n 0.0v 1239.495n 0.0v 1239.505n 0.0v 1249.495n 0.0v 1249.505n 0.0v 1259.495n 0.0v 1259.505n 0.0v 1269.495n 0.0v 1269.505n 0.0v 1279.495n 0.0v 1279.505n 0.0v 1289.495n 0.0v 1289.505n 0.0v 1299.495n 0.0v 1299.505n 0.0v 1309.495n 0.0v 1309.505n 0.0v 1319.495n 0.0v 1319.505n 0.0v 1329.495n 0.0v 1329.505n 0.0v 1339.495n 0.0v 1339.505n 0.0v 1349.495n 0.0v 1349.505n 0.0v 1359.495n 0.0v 1359.505n 0.0v 1369.495n 0.0v 1369.505n 0.0v 1379.495n 0.0v 1379.505n 0.0v 1389.495n 0.0v 1389.505n 0.0v 1399.495n 0.0v 1399.505n 0.0v 1409.495n 0.0v 1409.505n 0.0v 1419.495n 0.0v 1419.505n 0.0v 1429.495n 0.0v 1429.505n 1.8v 1439.495n 1.8v 1439.505n 1.8v 1449.495n 1.8v 1449.505n 1.8v 1459.495n 1.8v 1459.505n 1.8v 1469.495n 1.8v 1469.505n 1.8v 1479.495n 1.8v 1479.505n 0.0v 1489.495n 0.0v 1489.505n 0.0v 1499.495n 0.0v 1499.505n 1.8v 1509.495n 1.8v 1509.505n 1.8v 1519.495n 1.8v 1519.505n 1.8v 1529.495n 1.8v 1529.505n 1.8v 1539.495n 1.8v 1539.505n 1.8v 1549.495n 1.8v 1549.505n 1.8v 1559.495n 1.8v 1559.505n 1.8v 1569.495n 1.8v 1569.505n 1.8v 1579.495n 1.8v 1579.505n 0.0v 1589.495n 0.0v 1589.505n 1.8v 1599.495n 1.8v 1599.505n 1.8v 1609.495n 1.8v 1609.505n 1.8v 1619.495n 1.8v 1619.505n 0.0v 1629.495n 0.0v 1629.505n 0.0v 1639.495n 0.0v 1639.505n 0.0v 1649.495n 0.0v 1649.505n 0.0v 1659.495n 0.0v 1659.505n 0.0v 1669.495n 0.0v 1669.505n 0.0v 1679.495n 0.0v 1679.505n 0.0v 1689.495n 0.0v 1689.505n 0.0v 1699.495n 0.0v 1699.505n 0.0v 1709.495n 0.0v 1709.505n 1.8v 1719.495n 1.8v 1719.505n 1.8v 1729.495n 1.8v 1729.505n 1.8v 1739.495n 1.8v 1739.505n 0.0v 1749.495n 0.0v 1749.505n 0.0v 1759.495n 0.0v 1759.505n 0.0v 1769.495n 0.0v 1769.505n 0.0v 1779.495n 0.0v 1779.505n 0.0v 1789.495n 0.0v 1789.505n 1.8v 1799.495n 1.8v 1799.505n 1.8v 1809.495n 1.8v 1809.505n 1.8v 1819.495n 1.8v 1819.505n 1.8v 1829.495n 1.8v 1829.505n 1.8v 1839.495n 1.8v 1839.505n 1.8v 1849.495n 1.8v 1849.505n 1.8v 1859.495n 1.8v 1859.505n 1.8v 1869.495n 1.8v 1869.505n 0.0v 1879.495n 0.0v 1879.505n 1.8v 1889.495n 1.8v 1889.505n 1.8v 1899.495n 1.8v 1899.505n 1.8v 1909.495n 1.8v 1909.505n 0.0v 1919.495n 0.0v 1919.505n 0.0v 1929.495n 0.0v 1929.505n 0.0v 1939.495n 0.0v 1939.505n 0.0v 1949.495n 0.0v 1949.505n 0.0v 1959.495n 0.0v 1959.505n 0.0v 1969.495n 0.0v 1969.505n 0.0v 1979.495n 0.0v 1979.505n 0.0v 1989.495n 0.0v 1989.505n 0.0v 1999.495n 0.0v 1999.505n 0.0v 2009.495n 0.0v 2009.505n 0.0v 2019.495n 0.0v 2019.505n 0.0v 2029.495n 0.0v 2029.505n 1.8v 2039.495n 1.8v 2039.505n 1.8v 2049.495n 1.8v 2049.505n 1.8v )
* (time, data): [(0, 0), (10, 0), (20, 0), (30, 0), (40, 0), (50, 0), (60, 1), (70, 1), (80, 1), (90, 1), (100, 1), (110, 1), (120, 1), (130, 1), (140, 1), (150, 1), (160, 1), (170, 1), (180, 1), (190, 1), (200, 1), (210, 1), (220, 1), (230, 1), (240, 1), (250, 1), (260, 0), (270, 0), (280, 0), (290, 0), (300, 0), (310, 1), (320, 1), (330, 1), (340, 1), (350, 0), (360, 0), (370, 0), (380, 0), (390, 0), (400, 0), (410, 0), (420, 0), (430, 0), (440, 0), (450, 0), (460, 0), (470, 0), (480, 0), (490, 0), (500, 1), (510, 1), (520, 1), (530, 1), (540, 1), (550, 1), (560, 1), (570, 1), (580, 1), (590, 1), (600, 1), (610, 1), (620, 1), (630, 1), (640, 1), (650, 1), (660, 1), (670, 1), (680, 1), (690, 1), (700, 1), (710, 0), (720, 0), (730, 0), (740, 0), (750, 0), (760, 0), (770, 0), (780, 0), (790, 0), (800, 0), (810, 0), (820, 0), (830, 0), (840, 1), (850, 1), (860, 1), (870, 1), (880, 1), (890, 0), (900, 0), (910, 0), (920, 0), (930, 0), (940, 0), (950, 0), (960, 0), (970, 0), (980, 0), (990, 0), (1000, 0), (1010, 0), (1020, 0), (1030, 0), (1040, 0), (1050, 0), (1060, 0), (1070, 0), (1080, 1), (1090, 1), (1100, 1), (1110, 1), (1120, 1), (1130, 0), (1140, 0), (1150, 0), (1160, 0), (1170, 0), (1180, 0), (1190, 0), (1200, 0), (1210, 0), (1220, 0), (1230, 0), (1240, 0), (1250, 0), (1260, 0), (1270, 0), (1280, 0), (1290, 0), (1300, 0), (1310, 0), (1320, 0), (1330, 0), (1340, 0), (1350, 0), (1360, 0), (1370, 1), (1380, 1), (1390, 1), (1400, 0), (1410, 0), (1420, 0), (1430, 0), (1440, 0), (1450, 0), (1460, 0), (1470, 0), (1480, 1), (1490, 1), (1500, 1), (1510, 1), (1520, 1), (1530, 1), (1540, 1), (1550, 1), (1560, 1), (1570, 1), (1580, 0), (1590, 0), (1600, 0), (1610, 0), (1620, 0), (1630, 0), (1640, 0), (1650, 0), (1660, 0), (1670, 0), (1680, 0), (1690, 0), (1700, 0), (1710, 1), (1720, 1), (1730, 1), (1740, 0), (1750, 0), (1760, 0), (1770, 0), (1780, 0), (1790, 0), (1800, 0), (1810, 0), (1820, 0), (1830, 0), (1840, 0), (1850, 1), (1860, 1), (1870, 1), (1880, 0), (1890, 1), (1900, 1), (1910, 0), (1920, 0), (1930, 0), (1940, 0), (1950, 0), (1960, 0), (1970, 0), (1980, 0), (1990, 0), (2000, 0), (2010, 0), (2020, 0), (2030, 0), (2040, 0), (2050, 0)]
Vdin0_29  din0_29  0 PWL (0n 0.0v 9.495n 0.0v 9.505n 0.0v 19.495n 0.0v 19.505n 0.0v 29.495n 0.0v 29.505n 0.0v 39.495n 0.0v 39.505n 0.0v 49.495n 0.0v 49.505n 0.0v 59.495n 0.0v 59.505n 1.8v 69.495n 1.8v 69.505n 1.8v 79.495n 1.8v 79.505n 1.8v 89.495n 1.8v 89.505n 1.8v 99.495n 1.8v 99.505n 1.8v 109.495n 1.8v 109.505n 1.8v 119.495n 1.8v 119.505n 1.8v 129.495n 1.8v 129.505n 1.8v 139.495n 1.8v 139.505n 1.8v 149.495n 1.8v 149.505n 1.8v 159.495n 1.8v 159.505n 1.8v 169.495n 1.8v 169.505n 1.8v 179.495n 1.8v 179.505n 1.8v 189.495n 1.8v 189.505n 1.8v 199.495n 1.8v 199.505n 1.8v 209.495n 1.8v 209.505n 1.8v 219.495n 1.8v 219.505n 1.8v 229.495n 1.8v 229.505n 1.8v 239.495n 1.8v 239.505n 1.8v 249.495n 1.8v 249.505n 1.8v 259.495n 1.8v 259.505n 0.0v 269.495n 0.0v 269.505n 0.0v 279.495n 0.0v 279.505n 0.0v 289.495n 0.0v 289.505n 0.0v 299.495n 0.0v 299.505n 0.0v 309.495n 0.0v 309.505n 1.8v 319.495n 1.8v 319.505n 1.8v 329.495n 1.8v 329.505n 1.8v 339.495n 1.8v 339.505n 1.8v 349.495n 1.8v 349.505n 0.0v 359.495n 0.0v 359.505n 0.0v 369.495n 0.0v 369.505n 0.0v 379.495n 0.0v 379.505n 0.0v 389.495n 0.0v 389.505n 0.0v 399.495n 0.0v 399.505n 0.0v 409.495n 0.0v 409.505n 0.0v 419.495n 0.0v 419.505n 0.0v 429.495n 0.0v 429.505n 0.0v 439.495n 0.0v 439.505n 0.0v 449.495n 0.0v 449.505n 0.0v 459.495n 0.0v 459.505n 0.0v 469.495n 0.0v 469.505n 0.0v 479.495n 0.0v 479.505n 0.0v 489.495n 0.0v 489.505n 0.0v 499.495n 0.0v 499.505n 1.8v 509.495n 1.8v 509.505n 1.8v 519.495n 1.8v 519.505n 1.8v 529.495n 1.8v 529.505n 1.8v 539.495n 1.8v 539.505n 1.8v 549.495n 1.8v 549.505n 1.8v 559.495n 1.8v 559.505n 1.8v 569.495n 1.8v 569.505n 1.8v 579.495n 1.8v 579.505n 1.8v 589.495n 1.8v 589.505n 1.8v 599.495n 1.8v 599.505n 1.8v 609.495n 1.8v 609.505n 1.8v 619.495n 1.8v 619.505n 1.8v 629.495n 1.8v 629.505n 1.8v 639.495n 1.8v 639.505n 1.8v 649.495n 1.8v 649.505n 1.8v 659.495n 1.8v 659.505n 1.8v 669.495n 1.8v 669.505n 1.8v 679.495n 1.8v 679.505n 1.8v 689.495n 1.8v 689.505n 1.8v 699.495n 1.8v 699.505n 1.8v 709.495n 1.8v 709.505n 0.0v 719.495n 0.0v 719.505n 0.0v 729.495n 0.0v 729.505n 0.0v 739.495n 0.0v 739.505n 0.0v 749.495n 0.0v 749.505n 0.0v 759.495n 0.0v 759.505n 0.0v 769.495n 0.0v 769.505n 0.0v 779.495n 0.0v 779.505n 0.0v 789.495n 0.0v 789.505n 0.0v 799.495n 0.0v 799.505n 0.0v 809.495n 0.0v 809.505n 0.0v 819.495n 0.0v 819.505n 0.0v 829.495n 0.0v 829.505n 0.0v 839.495n 0.0v 839.505n 1.8v 849.495n 1.8v 849.505n 1.8v 859.495n 1.8v 859.505n 1.8v 869.495n 1.8v 869.505n 1.8v 879.495n 1.8v 879.505n 1.8v 889.495n 1.8v 889.505n 0.0v 899.495n 0.0v 899.505n 0.0v 909.495n 0.0v 909.505n 0.0v 919.495n 0.0v 919.505n 0.0v 929.495n 0.0v 929.505n 0.0v 939.495n 0.0v 939.505n 0.0v 949.495n 0.0v 949.505n 0.0v 959.495n 0.0v 959.505n 0.0v 969.495n 0.0v 969.505n 0.0v 979.495n 0.0v 979.505n 0.0v 989.495n 0.0v 989.505n 0.0v 999.495n 0.0v 999.505n 0.0v 1009.495n 0.0v 1009.505n 0.0v 1019.495n 0.0v 1019.505n 0.0v 1029.495n 0.0v 1029.505n 0.0v 1039.495n 0.0v 1039.505n 0.0v 1049.495n 0.0v 1049.505n 0.0v 1059.495n 0.0v 1059.505n 0.0v 1069.495n 0.0v 1069.505n 0.0v 1079.495n 0.0v 1079.505n 1.8v 1089.495n 1.8v 1089.505n 1.8v 1099.495n 1.8v 1099.505n 1.8v 1109.495n 1.8v 1109.505n 1.8v 1119.495n 1.8v 1119.505n 1.8v 1129.495n 1.8v 1129.505n 0.0v 1139.495n 0.0v 1139.505n 0.0v 1149.495n 0.0v 1149.505n 0.0v 1159.495n 0.0v 1159.505n 0.0v 1169.495n 0.0v 1169.505n 0.0v 1179.495n 0.0v 1179.505n 0.0v 1189.495n 0.0v 1189.505n 0.0v 1199.495n 0.0v 1199.505n 0.0v 1209.495n 0.0v 1209.505n 0.0v 1219.495n 0.0v 1219.505n 0.0v 1229.495n 0.0v 1229.505n 0.0v 1239.495n 0.0v 1239.505n 0.0v 1249.495n 0.0v 1249.505n 0.0v 1259.495n 0.0v 1259.505n 0.0v 1269.495n 0.0v 1269.505n 0.0v 1279.495n 0.0v 1279.505n 0.0v 1289.495n 0.0v 1289.505n 0.0v 1299.495n 0.0v 1299.505n 0.0v 1309.495n 0.0v 1309.505n 0.0v 1319.495n 0.0v 1319.505n 0.0v 1329.495n 0.0v 1329.505n 0.0v 1339.495n 0.0v 1339.505n 0.0v 1349.495n 0.0v 1349.505n 0.0v 1359.495n 0.0v 1359.505n 0.0v 1369.495n 0.0v 1369.505n 1.8v 1379.495n 1.8v 1379.505n 1.8v 1389.495n 1.8v 1389.505n 1.8v 1399.495n 1.8v 1399.505n 0.0v 1409.495n 0.0v 1409.505n 0.0v 1419.495n 0.0v 1419.505n 0.0v 1429.495n 0.0v 1429.505n 0.0v 1439.495n 0.0v 1439.505n 0.0v 1449.495n 0.0v 1449.505n 0.0v 1459.495n 0.0v 1459.505n 0.0v 1469.495n 0.0v 1469.505n 0.0v 1479.495n 0.0v 1479.505n 1.8v 1489.495n 1.8v 1489.505n 1.8v 1499.495n 1.8v 1499.505n 1.8v 1509.495n 1.8v 1509.505n 1.8v 1519.495n 1.8v 1519.505n 1.8v 1529.495n 1.8v 1529.505n 1.8v 1539.495n 1.8v 1539.505n 1.8v 1549.495n 1.8v 1549.505n 1.8v 1559.495n 1.8v 1559.505n 1.8v 1569.495n 1.8v 1569.505n 1.8v 1579.495n 1.8v 1579.505n 0.0v 1589.495n 0.0v 1589.505n 0.0v 1599.495n 0.0v 1599.505n 0.0v 1609.495n 0.0v 1609.505n 0.0v 1619.495n 0.0v 1619.505n 0.0v 1629.495n 0.0v 1629.505n 0.0v 1639.495n 0.0v 1639.505n 0.0v 1649.495n 0.0v 1649.505n 0.0v 1659.495n 0.0v 1659.505n 0.0v 1669.495n 0.0v 1669.505n 0.0v 1679.495n 0.0v 1679.505n 0.0v 1689.495n 0.0v 1689.505n 0.0v 1699.495n 0.0v 1699.505n 0.0v 1709.495n 0.0v 1709.505n 1.8v 1719.495n 1.8v 1719.505n 1.8v 1729.495n 1.8v 1729.505n 1.8v 1739.495n 1.8v 1739.505n 0.0v 1749.495n 0.0v 1749.505n 0.0v 1759.495n 0.0v 1759.505n 0.0v 1769.495n 0.0v 1769.505n 0.0v 1779.495n 0.0v 1779.505n 0.0v 1789.495n 0.0v 1789.505n 0.0v 1799.495n 0.0v 1799.505n 0.0v 1809.495n 0.0v 1809.505n 0.0v 1819.495n 0.0v 1819.505n 0.0v 1829.495n 0.0v 1829.505n 0.0v 1839.495n 0.0v 1839.505n 0.0v 1849.495n 0.0v 1849.505n 1.8v 1859.495n 1.8v 1859.505n 1.8v 1869.495n 1.8v 1869.505n 1.8v 1879.495n 1.8v 1879.505n 0.0v 1889.495n 0.0v 1889.505n 1.8v 1899.495n 1.8v 1899.505n 1.8v 1909.495n 1.8v 1909.505n 0.0v 1919.495n 0.0v 1919.505n 0.0v 1929.495n 0.0v 1929.505n 0.0v 1939.495n 0.0v 1939.505n 0.0v 1949.495n 0.0v 1949.505n 0.0v 1959.495n 0.0v 1959.505n 0.0v 1969.495n 0.0v 1969.505n 0.0v 1979.495n 0.0v 1979.505n 0.0v 1989.495n 0.0v 1989.505n 0.0v 1999.495n 0.0v 1999.505n 0.0v 2009.495n 0.0v 2009.505n 0.0v 2019.495n 0.0v 2019.505n 0.0v 2029.495n 0.0v 2029.505n 0.0v 2039.495n 0.0v 2039.505n 0.0v 2049.495n 0.0v 2049.505n 0.0v )
* (time, data): [(0, 0), (10, 1), (20, 1), (30, 0), (40, 0), (50, 0), (60, 0), (70, 0), (80, 0), (90, 0), (100, 0), (110, 0), (120, 0), (130, 0), (140, 0), (150, 0), (160, 0), (170, 0), (180, 0), (190, 0), (200, 0), (210, 0), (220, 0), (230, 0), (240, 0), (250, 0), (260, 1), (270, 1), (280, 1), (290, 1), (300, 1), (310, 0), (320, 0), (330, 0), (340, 0), (350, 1), (360, 1), (370, 1), (380, 1), (390, 1), (400, 1), (410, 1), (420, 1), (430, 1), (440, 1), (450, 1), (460, 1), (470, 1), (480, 1), (490, 1), (500, 0), (510, 0), (520, 0), (530, 0), (540, 0), (550, 0), (560, 0), (570, 0), (580, 0), (590, 0), (600, 0), (610, 0), (620, 0), (630, 0), (640, 0), (650, 0), (660, 1), (670, 1), (680, 1), (690, 1), (700, 1), (710, 1), (720, 1), (730, 1), (740, 1), (750, 1), (760, 1), (770, 0), (780, 0), (790, 0), (800, 0), (810, 0), (820, 1), (830, 1), (840, 0), (850, 0), (860, 0), (870, 0), (880, 0), (890, 1), (900, 1), (910, 1), (920, 1), (930, 0), (940, 0), (950, 0), (960, 1), (970, 1), (980, 1), (990, 1), (1000, 1), (1010, 1), (1020, 1), (1030, 1), (1040, 1), (1050, 1), (1060, 1), (1070, 1), (1080, 0), (1090, 0), (1100, 0), (1110, 0), (1120, 0), (1130, 1), (1140, 1), (1150, 1), (1160, 1), (1170, 1), (1180, 1), (1190, 1), (1200, 1), (1210, 1), (1220, 1), (1230, 1), (1240, 1), (1250, 1), (1260, 1), (1270, 1), (1280, 1), (1290, 1), (1300, 1), (1310, 1), (1320, 1), (1330, 1), (1340, 1), (1350, 1), (1360, 1), (1370, 1), (1380, 1), (1390, 1), (1400, 0), (1410, 0), (1420, 0), (1430, 1), (1440, 1), (1450, 1), (1460, 1), (1470, 1), (1480, 0), (1490, 0), (1500, 0), (1510, 0), (1520, 0), (1530, 0), (1540, 0), (1550, 0), (1560, 0), (1570, 1), (1580, 0), (1590, 1), (1600, 1), (1610, 1), (1620, 1), (1630, 1), (1640, 1), (1650, 1), (1660, 1), (1670, 1), (1680, 1), (1690, 0), (1700, 0), (1710, 0), (1720, 0), (1730, 0), (1740, 1), (1750, 1), (1760, 1), (1770, 1), (1780, 1), (1790, 0), (1800, 0), (1810, 0), (1820, 0), (1830, 0), (1840, 0), (1850, 1), (1860, 1), (1870, 0), (1880, 0), (1890, 0), (1900, 0), (1910, 0), (1920, 0), (1930, 0), (1940, 0), (1950, 0), (1960, 0), (1970, 0), (1980, 0), (1990, 0), (2000, 0), (2010, 0), (2020, 0), (2030, 1), (2040, 1), (2050, 1)]
Vdin0_30  din0_30  0 PWL (0n 0.0v 9.495n 0.0v 9.505n 1.8v 19.495n 1.8v 19.505n 1.8v 29.495n 1.8v 29.505n 0.0v 39.495n 0.0v 39.505n 0.0v 49.495n 0.0v 49.505n 0.0v 59.495n 0.0v 59.505n 0.0v 69.495n 0.0v 69.505n 0.0v 79.495n 0.0v 79.505n 0.0v 89.495n 0.0v 89.505n 0.0v 99.495n 0.0v 99.505n 0.0v 109.495n 0.0v 109.505n 0.0v 119.495n 0.0v 119.505n 0.0v 129.495n 0.0v 129.505n 0.0v 139.495n 0.0v 139.505n 0.0v 149.495n 0.0v 149.505n 0.0v 159.495n 0.0v 159.505n 0.0v 169.495n 0.0v 169.505n 0.0v 179.495n 0.0v 179.505n 0.0v 189.495n 0.0v 189.505n 0.0v 199.495n 0.0v 199.505n 0.0v 209.495n 0.0v 209.505n 0.0v 219.495n 0.0v 219.505n 0.0v 229.495n 0.0v 229.505n 0.0v 239.495n 0.0v 239.505n 0.0v 249.495n 0.0v 249.505n 0.0v 259.495n 0.0v 259.505n 1.8v 269.495n 1.8v 269.505n 1.8v 279.495n 1.8v 279.505n 1.8v 289.495n 1.8v 289.505n 1.8v 299.495n 1.8v 299.505n 1.8v 309.495n 1.8v 309.505n 0.0v 319.495n 0.0v 319.505n 0.0v 329.495n 0.0v 329.505n 0.0v 339.495n 0.0v 339.505n 0.0v 349.495n 0.0v 349.505n 1.8v 359.495n 1.8v 359.505n 1.8v 369.495n 1.8v 369.505n 1.8v 379.495n 1.8v 379.505n 1.8v 389.495n 1.8v 389.505n 1.8v 399.495n 1.8v 399.505n 1.8v 409.495n 1.8v 409.505n 1.8v 419.495n 1.8v 419.505n 1.8v 429.495n 1.8v 429.505n 1.8v 439.495n 1.8v 439.505n 1.8v 449.495n 1.8v 449.505n 1.8v 459.495n 1.8v 459.505n 1.8v 469.495n 1.8v 469.505n 1.8v 479.495n 1.8v 479.505n 1.8v 489.495n 1.8v 489.505n 1.8v 499.495n 1.8v 499.505n 0.0v 509.495n 0.0v 509.505n 0.0v 519.495n 0.0v 519.505n 0.0v 529.495n 0.0v 529.505n 0.0v 539.495n 0.0v 539.505n 0.0v 549.495n 0.0v 549.505n 0.0v 559.495n 0.0v 559.505n 0.0v 569.495n 0.0v 569.505n 0.0v 579.495n 0.0v 579.505n 0.0v 589.495n 0.0v 589.505n 0.0v 599.495n 0.0v 599.505n 0.0v 609.495n 0.0v 609.505n 0.0v 619.495n 0.0v 619.505n 0.0v 629.495n 0.0v 629.505n 0.0v 639.495n 0.0v 639.505n 0.0v 649.495n 0.0v 649.505n 0.0v 659.495n 0.0v 659.505n 1.8v 669.495n 1.8v 669.505n 1.8v 679.495n 1.8v 679.505n 1.8v 689.495n 1.8v 689.505n 1.8v 699.495n 1.8v 699.505n 1.8v 709.495n 1.8v 709.505n 1.8v 719.495n 1.8v 719.505n 1.8v 729.495n 1.8v 729.505n 1.8v 739.495n 1.8v 739.505n 1.8v 749.495n 1.8v 749.505n 1.8v 759.495n 1.8v 759.505n 1.8v 769.495n 1.8v 769.505n 0.0v 779.495n 0.0v 779.505n 0.0v 789.495n 0.0v 789.505n 0.0v 799.495n 0.0v 799.505n 0.0v 809.495n 0.0v 809.505n 0.0v 819.495n 0.0v 819.505n 1.8v 829.495n 1.8v 829.505n 1.8v 839.495n 1.8v 839.505n 0.0v 849.495n 0.0v 849.505n 0.0v 859.495n 0.0v 859.505n 0.0v 869.495n 0.0v 869.505n 0.0v 879.495n 0.0v 879.505n 0.0v 889.495n 0.0v 889.505n 1.8v 899.495n 1.8v 899.505n 1.8v 909.495n 1.8v 909.505n 1.8v 919.495n 1.8v 919.505n 1.8v 929.495n 1.8v 929.505n 0.0v 939.495n 0.0v 939.505n 0.0v 949.495n 0.0v 949.505n 0.0v 959.495n 0.0v 959.505n 1.8v 969.495n 1.8v 969.505n 1.8v 979.495n 1.8v 979.505n 1.8v 989.495n 1.8v 989.505n 1.8v 999.495n 1.8v 999.505n 1.8v 1009.495n 1.8v 1009.505n 1.8v 1019.495n 1.8v 1019.505n 1.8v 1029.495n 1.8v 1029.505n 1.8v 1039.495n 1.8v 1039.505n 1.8v 1049.495n 1.8v 1049.505n 1.8v 1059.495n 1.8v 1059.505n 1.8v 1069.495n 1.8v 1069.505n 1.8v 1079.495n 1.8v 1079.505n 0.0v 1089.495n 0.0v 1089.505n 0.0v 1099.495n 0.0v 1099.505n 0.0v 1109.495n 0.0v 1109.505n 0.0v 1119.495n 0.0v 1119.505n 0.0v 1129.495n 0.0v 1129.505n 1.8v 1139.495n 1.8v 1139.505n 1.8v 1149.495n 1.8v 1149.505n 1.8v 1159.495n 1.8v 1159.505n 1.8v 1169.495n 1.8v 1169.505n 1.8v 1179.495n 1.8v 1179.505n 1.8v 1189.495n 1.8v 1189.505n 1.8v 1199.495n 1.8v 1199.505n 1.8v 1209.495n 1.8v 1209.505n 1.8v 1219.495n 1.8v 1219.505n 1.8v 1229.495n 1.8v 1229.505n 1.8v 1239.495n 1.8v 1239.505n 1.8v 1249.495n 1.8v 1249.505n 1.8v 1259.495n 1.8v 1259.505n 1.8v 1269.495n 1.8v 1269.505n 1.8v 1279.495n 1.8v 1279.505n 1.8v 1289.495n 1.8v 1289.505n 1.8v 1299.495n 1.8v 1299.505n 1.8v 1309.495n 1.8v 1309.505n 1.8v 1319.495n 1.8v 1319.505n 1.8v 1329.495n 1.8v 1329.505n 1.8v 1339.495n 1.8v 1339.505n 1.8v 1349.495n 1.8v 1349.505n 1.8v 1359.495n 1.8v 1359.505n 1.8v 1369.495n 1.8v 1369.505n 1.8v 1379.495n 1.8v 1379.505n 1.8v 1389.495n 1.8v 1389.505n 1.8v 1399.495n 1.8v 1399.505n 0.0v 1409.495n 0.0v 1409.505n 0.0v 1419.495n 0.0v 1419.505n 0.0v 1429.495n 0.0v 1429.505n 1.8v 1439.495n 1.8v 1439.505n 1.8v 1449.495n 1.8v 1449.505n 1.8v 1459.495n 1.8v 1459.505n 1.8v 1469.495n 1.8v 1469.505n 1.8v 1479.495n 1.8v 1479.505n 0.0v 1489.495n 0.0v 1489.505n 0.0v 1499.495n 0.0v 1499.505n 0.0v 1509.495n 0.0v 1509.505n 0.0v 1519.495n 0.0v 1519.505n 0.0v 1529.495n 0.0v 1529.505n 0.0v 1539.495n 0.0v 1539.505n 0.0v 1549.495n 0.0v 1549.505n 0.0v 1559.495n 0.0v 1559.505n 0.0v 1569.495n 0.0v 1569.505n 1.8v 1579.495n 1.8v 1579.505n 0.0v 1589.495n 0.0v 1589.505n 1.8v 1599.495n 1.8v 1599.505n 1.8v 1609.495n 1.8v 1609.505n 1.8v 1619.495n 1.8v 1619.505n 1.8v 1629.495n 1.8v 1629.505n 1.8v 1639.495n 1.8v 1639.505n 1.8v 1649.495n 1.8v 1649.505n 1.8v 1659.495n 1.8v 1659.505n 1.8v 1669.495n 1.8v 1669.505n 1.8v 1679.495n 1.8v 1679.505n 1.8v 1689.495n 1.8v 1689.505n 0.0v 1699.495n 0.0v 1699.505n 0.0v 1709.495n 0.0v 1709.505n 0.0v 1719.495n 0.0v 1719.505n 0.0v 1729.495n 0.0v 1729.505n 0.0v 1739.495n 0.0v 1739.505n 1.8v 1749.495n 1.8v 1749.505n 1.8v 1759.495n 1.8v 1759.505n 1.8v 1769.495n 1.8v 1769.505n 1.8v 1779.495n 1.8v 1779.505n 1.8v 1789.495n 1.8v 1789.505n 0.0v 1799.495n 0.0v 1799.505n 0.0v 1809.495n 0.0v 1809.505n 0.0v 1819.495n 0.0v 1819.505n 0.0v 1829.495n 0.0v 1829.505n 0.0v 1839.495n 0.0v 1839.505n 0.0v 1849.495n 0.0v 1849.505n 1.8v 1859.495n 1.8v 1859.505n 1.8v 1869.495n 1.8v 1869.505n 0.0v 1879.495n 0.0v 1879.505n 0.0v 1889.495n 0.0v 1889.505n 0.0v 1899.495n 0.0v 1899.505n 0.0v 1909.495n 0.0v 1909.505n 0.0v 1919.495n 0.0v 1919.505n 0.0v 1929.495n 0.0v 1929.505n 0.0v 1939.495n 0.0v 1939.505n 0.0v 1949.495n 0.0v 1949.505n 0.0v 1959.495n 0.0v 1959.505n 0.0v 1969.495n 0.0v 1969.505n 0.0v 1979.495n 0.0v 1979.505n 0.0v 1989.495n 0.0v 1989.505n 0.0v 1999.495n 0.0v 1999.505n 0.0v 2009.495n 0.0v 2009.505n 0.0v 2019.495n 0.0v 2019.505n 0.0v 2029.495n 0.0v 2029.505n 1.8v 2039.495n 1.8v 2039.505n 1.8v 2049.495n 1.8v 2049.505n 1.8v )
* (time, data): [(0, 0), (10, 1), (20, 0), (30, 0), (40, 0), (50, 0), (60, 0), (70, 0), (80, 0), (90, 0), (100, 0), (110, 0), (120, 0), (130, 0), (140, 0), (150, 1), (160, 1), (170, 1), (180, 1), (190, 1), (200, 1), (210, 1), (220, 1), (230, 1), (240, 1), (250, 1), (260, 0), (270, 0), (280, 0), (290, 0), (300, 0), (310, 0), (320, 0), (330, 0), (340, 0), (350, 0), (360, 0), (370, 0), (380, 0), (390, 1), (400, 1), (410, 1), (420, 0), (430, 0), (440, 0), (450, 0), (460, 0), (470, 1), (480, 1), (490, 1), (500, 1), (510, 1), (520, 1), (530, 1), (540, 1), (550, 1), (560, 1), (570, 1), (580, 1), (590, 1), (600, 1), (610, 1), (620, 1), (630, 1), (640, 1), (650, 1), (660, 1), (670, 1), (680, 1), (690, 1), (700, 1), (710, 1), (720, 1), (730, 1), (740, 1), (750, 1), (760, 1), (770, 1), (780, 1), (790, 1), (800, 1), (810, 1), (820, 0), (830, 0), (840, 0), (850, 0), (860, 0), (870, 0), (880, 0), (890, 0), (900, 0), (910, 0), (920, 0), (930, 0), (940, 0), (950, 0), (960, 0), (970, 0), (980, 0), (990, 0), (1000, 0), (1010, 0), (1020, 0), (1030, 0), (1040, 0), (1050, 0), (1060, 0), (1070, 0), (1080, 0), (1090, 0), (1100, 0), (1110, 0), (1120, 0), (1130, 0), (1140, 0), (1150, 0), (1160, 0), (1170, 0), (1180, 0), (1190, 0), (1200, 0), (1210, 0), (1220, 0), (1230, 0), (1240, 0), (1250, 0), (1260, 1), (1270, 1), (1280, 1), (1290, 1), (1300, 1), (1310, 1), (1320, 1), (1330, 1), (1340, 1), (1350, 1), (1360, 1), (1370, 1), (1380, 1), (1390, 1), (1400, 1), (1410, 1), (1420, 1), (1430, 0), (1440, 0), (1450, 0), (1460, 0), (1470, 0), (1480, 0), (1490, 0), (1500, 0), (1510, 0), (1520, 0), (1530, 0), (1540, 0), (1550, 0), (1560, 0), (1570, 1), (1580, 1), (1590, 1), (1600, 1), (1610, 1), (1620, 0), (1630, 0), (1640, 0), (1650, 0), (1660, 0), (1670, 0), (1680, 0), (1690, 0), (1700, 0), (1710, 1), (1720, 1), (1730, 0), (1740, 0), (1750, 0), (1760, 0), (1770, 0), (1780, 0), (1790, 0), (1800, 0), (1810, 0), (1820, 0), (1830, 0), (1840, 0), (1850, 0), (1860, 1), (1870, 1), (1880, 0), (1890, 1), (1900, 1), (1910, 0), (1920, 0), (1930, 0), (1940, 0), (1950, 0), (1960, 0), (1970, 0), (1980, 0), (1990, 0), (2000, 0), (2010, 0), (2020, 0), (2030, 0), (2040, 0), (2050, 0)]
Vdin0_31  din0_31  0 PWL (0n 0.0v 9.495n 0.0v 9.505n 1.8v 19.495n 1.8v 19.505n 0.0v 29.495n 0.0v 29.505n 0.0v 39.495n 0.0v 39.505n 0.0v 49.495n 0.0v 49.505n 0.0v 59.495n 0.0v 59.505n 0.0v 69.495n 0.0v 69.505n 0.0v 79.495n 0.0v 79.505n 0.0v 89.495n 0.0v 89.505n 0.0v 99.495n 0.0v 99.505n 0.0v 109.495n 0.0v 109.505n 0.0v 119.495n 0.0v 119.505n 0.0v 129.495n 0.0v 129.505n 0.0v 139.495n 0.0v 139.505n 0.0v 149.495n 0.0v 149.505n 1.8v 159.495n 1.8v 159.505n 1.8v 169.495n 1.8v 169.505n 1.8v 179.495n 1.8v 179.505n 1.8v 189.495n 1.8v 189.505n 1.8v 199.495n 1.8v 199.505n 1.8v 209.495n 1.8v 209.505n 1.8v 219.495n 1.8v 219.505n 1.8v 229.495n 1.8v 229.505n 1.8v 239.495n 1.8v 239.505n 1.8v 249.495n 1.8v 249.505n 1.8v 259.495n 1.8v 259.505n 0.0v 269.495n 0.0v 269.505n 0.0v 279.495n 0.0v 279.505n 0.0v 289.495n 0.0v 289.505n 0.0v 299.495n 0.0v 299.505n 0.0v 309.495n 0.0v 309.505n 0.0v 319.495n 0.0v 319.505n 0.0v 329.495n 0.0v 329.505n 0.0v 339.495n 0.0v 339.505n 0.0v 349.495n 0.0v 349.505n 0.0v 359.495n 0.0v 359.505n 0.0v 369.495n 0.0v 369.505n 0.0v 379.495n 0.0v 379.505n 0.0v 389.495n 0.0v 389.505n 1.8v 399.495n 1.8v 399.505n 1.8v 409.495n 1.8v 409.505n 1.8v 419.495n 1.8v 419.505n 0.0v 429.495n 0.0v 429.505n 0.0v 439.495n 0.0v 439.505n 0.0v 449.495n 0.0v 449.505n 0.0v 459.495n 0.0v 459.505n 0.0v 469.495n 0.0v 469.505n 1.8v 479.495n 1.8v 479.505n 1.8v 489.495n 1.8v 489.505n 1.8v 499.495n 1.8v 499.505n 1.8v 509.495n 1.8v 509.505n 1.8v 519.495n 1.8v 519.505n 1.8v 529.495n 1.8v 529.505n 1.8v 539.495n 1.8v 539.505n 1.8v 549.495n 1.8v 549.505n 1.8v 559.495n 1.8v 559.505n 1.8v 569.495n 1.8v 569.505n 1.8v 579.495n 1.8v 579.505n 1.8v 589.495n 1.8v 589.505n 1.8v 599.495n 1.8v 599.505n 1.8v 609.495n 1.8v 609.505n 1.8v 619.495n 1.8v 619.505n 1.8v 629.495n 1.8v 629.505n 1.8v 639.495n 1.8v 639.505n 1.8v 649.495n 1.8v 649.505n 1.8v 659.495n 1.8v 659.505n 1.8v 669.495n 1.8v 669.505n 1.8v 679.495n 1.8v 679.505n 1.8v 689.495n 1.8v 689.505n 1.8v 699.495n 1.8v 699.505n 1.8v 709.495n 1.8v 709.505n 1.8v 719.495n 1.8v 719.505n 1.8v 729.495n 1.8v 729.505n 1.8v 739.495n 1.8v 739.505n 1.8v 749.495n 1.8v 749.505n 1.8v 759.495n 1.8v 759.505n 1.8v 769.495n 1.8v 769.505n 1.8v 779.495n 1.8v 779.505n 1.8v 789.495n 1.8v 789.505n 1.8v 799.495n 1.8v 799.505n 1.8v 809.495n 1.8v 809.505n 1.8v 819.495n 1.8v 819.505n 0.0v 829.495n 0.0v 829.505n 0.0v 839.495n 0.0v 839.505n 0.0v 849.495n 0.0v 849.505n 0.0v 859.495n 0.0v 859.505n 0.0v 869.495n 0.0v 869.505n 0.0v 879.495n 0.0v 879.505n 0.0v 889.495n 0.0v 889.505n 0.0v 899.495n 0.0v 899.505n 0.0v 909.495n 0.0v 909.505n 0.0v 919.495n 0.0v 919.505n 0.0v 929.495n 0.0v 929.505n 0.0v 939.495n 0.0v 939.505n 0.0v 949.495n 0.0v 949.505n 0.0v 959.495n 0.0v 959.505n 0.0v 969.495n 0.0v 969.505n 0.0v 979.495n 0.0v 979.505n 0.0v 989.495n 0.0v 989.505n 0.0v 999.495n 0.0v 999.505n 0.0v 1009.495n 0.0v 1009.505n 0.0v 1019.495n 0.0v 1019.505n 0.0v 1029.495n 0.0v 1029.505n 0.0v 1039.495n 0.0v 1039.505n 0.0v 1049.495n 0.0v 1049.505n 0.0v 1059.495n 0.0v 1059.505n 0.0v 1069.495n 0.0v 1069.505n 0.0v 1079.495n 0.0v 1079.505n 0.0v 1089.495n 0.0v 1089.505n 0.0v 1099.495n 0.0v 1099.505n 0.0v 1109.495n 0.0v 1109.505n 0.0v 1119.495n 0.0v 1119.505n 0.0v 1129.495n 0.0v 1129.505n 0.0v 1139.495n 0.0v 1139.505n 0.0v 1149.495n 0.0v 1149.505n 0.0v 1159.495n 0.0v 1159.505n 0.0v 1169.495n 0.0v 1169.505n 0.0v 1179.495n 0.0v 1179.505n 0.0v 1189.495n 0.0v 1189.505n 0.0v 1199.495n 0.0v 1199.505n 0.0v 1209.495n 0.0v 1209.505n 0.0v 1219.495n 0.0v 1219.505n 0.0v 1229.495n 0.0v 1229.505n 0.0v 1239.495n 0.0v 1239.505n 0.0v 1249.495n 0.0v 1249.505n 0.0v 1259.495n 0.0v 1259.505n 1.8v 1269.495n 1.8v 1269.505n 1.8v 1279.495n 1.8v 1279.505n 1.8v 1289.495n 1.8v 1289.505n 1.8v 1299.495n 1.8v 1299.505n 1.8v 1309.495n 1.8v 1309.505n 1.8v 1319.495n 1.8v 1319.505n 1.8v 1329.495n 1.8v 1329.505n 1.8v 1339.495n 1.8v 1339.505n 1.8v 1349.495n 1.8v 1349.505n 1.8v 1359.495n 1.8v 1359.505n 1.8v 1369.495n 1.8v 1369.505n 1.8v 1379.495n 1.8v 1379.505n 1.8v 1389.495n 1.8v 1389.505n 1.8v 1399.495n 1.8v 1399.505n 1.8v 1409.495n 1.8v 1409.505n 1.8v 1419.495n 1.8v 1419.505n 1.8v 1429.495n 1.8v 1429.505n 0.0v 1439.495n 0.0v 1439.505n 0.0v 1449.495n 0.0v 1449.505n 0.0v 1459.495n 0.0v 1459.505n 0.0v 1469.495n 0.0v 1469.505n 0.0v 1479.495n 0.0v 1479.505n 0.0v 1489.495n 0.0v 1489.505n 0.0v 1499.495n 0.0v 1499.505n 0.0v 1509.495n 0.0v 1509.505n 0.0v 1519.495n 0.0v 1519.505n 0.0v 1529.495n 0.0v 1529.505n 0.0v 1539.495n 0.0v 1539.505n 0.0v 1549.495n 0.0v 1549.505n 0.0v 1559.495n 0.0v 1559.505n 0.0v 1569.495n 0.0v 1569.505n 1.8v 1579.495n 1.8v 1579.505n 1.8v 1589.495n 1.8v 1589.505n 1.8v 1599.495n 1.8v 1599.505n 1.8v 1609.495n 1.8v 1609.505n 1.8v 1619.495n 1.8v 1619.505n 0.0v 1629.495n 0.0v 1629.505n 0.0v 1639.495n 0.0v 1639.505n 0.0v 1649.495n 0.0v 1649.505n 0.0v 1659.495n 0.0v 1659.505n 0.0v 1669.495n 0.0v 1669.505n 0.0v 1679.495n 0.0v 1679.505n 0.0v 1689.495n 0.0v 1689.505n 0.0v 1699.495n 0.0v 1699.505n 0.0v 1709.495n 0.0v 1709.505n 1.8v 1719.495n 1.8v 1719.505n 1.8v 1729.495n 1.8v 1729.505n 0.0v 1739.495n 0.0v 1739.505n 0.0v 1749.495n 0.0v 1749.505n 0.0v 1759.495n 0.0v 1759.505n 0.0v 1769.495n 0.0v 1769.505n 0.0v 1779.495n 0.0v 1779.505n 0.0v 1789.495n 0.0v 1789.505n 0.0v 1799.495n 0.0v 1799.505n 0.0v 1809.495n 0.0v 1809.505n 0.0v 1819.495n 0.0v 1819.505n 0.0v 1829.495n 0.0v 1829.505n 0.0v 1839.495n 0.0v 1839.505n 0.0v 1849.495n 0.0v 1849.505n 0.0v 1859.495n 0.0v 1859.505n 1.8v 1869.495n 1.8v 1869.505n 1.8v 1879.495n 1.8v 1879.505n 0.0v 1889.495n 0.0v 1889.505n 1.8v 1899.495n 1.8v 1899.505n 1.8v 1909.495n 1.8v 1909.505n 0.0v 1919.495n 0.0v 1919.505n 0.0v 1929.495n 0.0v 1929.505n 0.0v 1939.495n 0.0v 1939.505n 0.0v 1949.495n 0.0v 1949.505n 0.0v 1959.495n 0.0v 1959.505n 0.0v 1969.495n 0.0v 1969.505n 0.0v 1979.495n 0.0v 1979.505n 0.0v 1989.495n 0.0v 1989.505n 0.0v 1999.495n 0.0v 1999.505n 0.0v 2009.495n 0.0v 2009.505n 0.0v 2019.495n 0.0v 2019.505n 0.0v 2029.495n 0.0v 2029.505n 0.0v 2039.495n 0.0v 2039.505n 0.0v 2049.495n 0.0v 2049.505n 0.0v )
* (time, data): [(0, 0), (10, 0), (20, 1), (30, 1), (40, 1), (50, 1), (60, 1), (70, 1), (80, 1), (90, 1), (100, 1), (110, 1), (120, 1), (130, 1), (140, 1), (150, 1), (160, 1), (170, 1), (180, 1), (190, 1), (200, 1), (210, 1), (220, 1), (230, 1), (240, 1), (250, 1), (260, 0), (270, 0), (280, 0), (290, 0), (300, 0), (310, 0), (320, 0), (330, 0), (340, 0), (350, 0), (360, 0), (370, 0), (380, 0), (390, 1), (400, 1), (410, 1), (420, 0), (430, 0), (440, 0), (450, 0), (460, 0), (470, 1), (480, 1), (490, 0), (500, 1), (510, 1), (520, 1), (530, 1), (540, 1), (550, 1), (560, 1), (570, 1), (580, 1), (590, 1), (600, 1), (610, 1), (620, 1), (630, 1), (640, 1), (650, 1), (660, 0), (670, 0), (680, 0), (690, 0), (700, 0), (710, 0), (720, 0), (730, 0), (740, 0), (750, 0), (760, 0), (770, 0), (780, 0), (790, 0), (800, 0), (810, 0), (820, 1), (830, 1), (840, 0), (850, 0), (860, 0), (870, 0), (880, 0), (890, 0), (900, 0), (910, 0), (920, 0), (930, 1), (940, 1), (950, 1), (960, 0), (970, 0), (980, 0), (990, 0), (1000, 0), (1010, 0), (1020, 0), (1030, 0), (1040, 0), (1050, 0), (1060, 0), (1070, 0), (1080, 0), (1090, 0), (1100, 0), (1110, 0), (1120, 0), (1130, 0), (1140, 0), (1150, 0), (1160, 0), (1170, 0), (1180, 0), (1190, 0), (1200, 0), (1210, 0), (1220, 0), (1230, 0), (1240, 0), (1250, 0), (1260, 1), (1270, 1), (1280, 1), (1290, 1), (1300, 1), (1310, 1), (1320, 1), (1330, 1), (1340, 1), (1350, 1), (1360, 1), (1370, 0), (1380, 0), (1390, 0), (1400, 1), (1410, 1), (1420, 1), (1430, 0), (1440, 0), (1450, 0), (1460, 0), (1470, 0), (1480, 1), (1490, 1), (1500, 0), (1510, 0), (1520, 0), (1530, 0), (1540, 0), (1550, 0), (1560, 0), (1570, 0), (1580, 0), (1590, 0), (1600, 0), (1610, 0), (1620, 0), (1630, 0), (1640, 0), (1650, 0), (1660, 0), (1670, 0), (1680, 0), (1690, 0), (1700, 0), (1710, 0), (1720, 0), (1730, 0), (1740, 1), (1750, 1), (1760, 1), (1770, 1), (1780, 1), (1790, 1), (1800, 1), (1810, 1), (1820, 1), (1830, 1), (1840, 1), (1850, 0), (1860, 1), (1870, 0), (1880, 1), (1890, 1), (1900, 1), (1910, 0), (1920, 0), (1930, 0), (1940, 0), (1950, 0), (1960, 0), (1970, 0), (1980, 0), (1990, 0), (2000, 0), (2010, 0), (2020, 0), (2030, 1), (2040, 1), (2050, 1)]
Vdin0_32  din0_32  0 PWL (0n 0.0v 9.495n 0.0v 9.505n 0.0v 19.495n 0.0v 19.505n 1.8v 29.495n 1.8v 29.505n 1.8v 39.495n 1.8v 39.505n 1.8v 49.495n 1.8v 49.505n 1.8v 59.495n 1.8v 59.505n 1.8v 69.495n 1.8v 69.505n 1.8v 79.495n 1.8v 79.505n 1.8v 89.495n 1.8v 89.505n 1.8v 99.495n 1.8v 99.505n 1.8v 109.495n 1.8v 109.505n 1.8v 119.495n 1.8v 119.505n 1.8v 129.495n 1.8v 129.505n 1.8v 139.495n 1.8v 139.505n 1.8v 149.495n 1.8v 149.505n 1.8v 159.495n 1.8v 159.505n 1.8v 169.495n 1.8v 169.505n 1.8v 179.495n 1.8v 179.505n 1.8v 189.495n 1.8v 189.505n 1.8v 199.495n 1.8v 199.505n 1.8v 209.495n 1.8v 209.505n 1.8v 219.495n 1.8v 219.505n 1.8v 229.495n 1.8v 229.505n 1.8v 239.495n 1.8v 239.505n 1.8v 249.495n 1.8v 249.505n 1.8v 259.495n 1.8v 259.505n 0.0v 269.495n 0.0v 269.505n 0.0v 279.495n 0.0v 279.505n 0.0v 289.495n 0.0v 289.505n 0.0v 299.495n 0.0v 299.505n 0.0v 309.495n 0.0v 309.505n 0.0v 319.495n 0.0v 319.505n 0.0v 329.495n 0.0v 329.505n 0.0v 339.495n 0.0v 339.505n 0.0v 349.495n 0.0v 349.505n 0.0v 359.495n 0.0v 359.505n 0.0v 369.495n 0.0v 369.505n 0.0v 379.495n 0.0v 379.505n 0.0v 389.495n 0.0v 389.505n 1.8v 399.495n 1.8v 399.505n 1.8v 409.495n 1.8v 409.505n 1.8v 419.495n 1.8v 419.505n 0.0v 429.495n 0.0v 429.505n 0.0v 439.495n 0.0v 439.505n 0.0v 449.495n 0.0v 449.505n 0.0v 459.495n 0.0v 459.505n 0.0v 469.495n 0.0v 469.505n 1.8v 479.495n 1.8v 479.505n 1.8v 489.495n 1.8v 489.505n 0.0v 499.495n 0.0v 499.505n 1.8v 509.495n 1.8v 509.505n 1.8v 519.495n 1.8v 519.505n 1.8v 529.495n 1.8v 529.505n 1.8v 539.495n 1.8v 539.505n 1.8v 549.495n 1.8v 549.505n 1.8v 559.495n 1.8v 559.505n 1.8v 569.495n 1.8v 569.505n 1.8v 579.495n 1.8v 579.505n 1.8v 589.495n 1.8v 589.505n 1.8v 599.495n 1.8v 599.505n 1.8v 609.495n 1.8v 609.505n 1.8v 619.495n 1.8v 619.505n 1.8v 629.495n 1.8v 629.505n 1.8v 639.495n 1.8v 639.505n 1.8v 649.495n 1.8v 649.505n 1.8v 659.495n 1.8v 659.505n 0.0v 669.495n 0.0v 669.505n 0.0v 679.495n 0.0v 679.505n 0.0v 689.495n 0.0v 689.505n 0.0v 699.495n 0.0v 699.505n 0.0v 709.495n 0.0v 709.505n 0.0v 719.495n 0.0v 719.505n 0.0v 729.495n 0.0v 729.505n 0.0v 739.495n 0.0v 739.505n 0.0v 749.495n 0.0v 749.505n 0.0v 759.495n 0.0v 759.505n 0.0v 769.495n 0.0v 769.505n 0.0v 779.495n 0.0v 779.505n 0.0v 789.495n 0.0v 789.505n 0.0v 799.495n 0.0v 799.505n 0.0v 809.495n 0.0v 809.505n 0.0v 819.495n 0.0v 819.505n 1.8v 829.495n 1.8v 829.505n 1.8v 839.495n 1.8v 839.505n 0.0v 849.495n 0.0v 849.505n 0.0v 859.495n 0.0v 859.505n 0.0v 869.495n 0.0v 869.505n 0.0v 879.495n 0.0v 879.505n 0.0v 889.495n 0.0v 889.505n 0.0v 899.495n 0.0v 899.505n 0.0v 909.495n 0.0v 909.505n 0.0v 919.495n 0.0v 919.505n 0.0v 929.495n 0.0v 929.505n 1.8v 939.495n 1.8v 939.505n 1.8v 949.495n 1.8v 949.505n 1.8v 959.495n 1.8v 959.505n 0.0v 969.495n 0.0v 969.505n 0.0v 979.495n 0.0v 979.505n 0.0v 989.495n 0.0v 989.505n 0.0v 999.495n 0.0v 999.505n 0.0v 1009.495n 0.0v 1009.505n 0.0v 1019.495n 0.0v 1019.505n 0.0v 1029.495n 0.0v 1029.505n 0.0v 1039.495n 0.0v 1039.505n 0.0v 1049.495n 0.0v 1049.505n 0.0v 1059.495n 0.0v 1059.505n 0.0v 1069.495n 0.0v 1069.505n 0.0v 1079.495n 0.0v 1079.505n 0.0v 1089.495n 0.0v 1089.505n 0.0v 1099.495n 0.0v 1099.505n 0.0v 1109.495n 0.0v 1109.505n 0.0v 1119.495n 0.0v 1119.505n 0.0v 1129.495n 0.0v 1129.505n 0.0v 1139.495n 0.0v 1139.505n 0.0v 1149.495n 0.0v 1149.505n 0.0v 1159.495n 0.0v 1159.505n 0.0v 1169.495n 0.0v 1169.505n 0.0v 1179.495n 0.0v 1179.505n 0.0v 1189.495n 0.0v 1189.505n 0.0v 1199.495n 0.0v 1199.505n 0.0v 1209.495n 0.0v 1209.505n 0.0v 1219.495n 0.0v 1219.505n 0.0v 1229.495n 0.0v 1229.505n 0.0v 1239.495n 0.0v 1239.505n 0.0v 1249.495n 0.0v 1249.505n 0.0v 1259.495n 0.0v 1259.505n 1.8v 1269.495n 1.8v 1269.505n 1.8v 1279.495n 1.8v 1279.505n 1.8v 1289.495n 1.8v 1289.505n 1.8v 1299.495n 1.8v 1299.505n 1.8v 1309.495n 1.8v 1309.505n 1.8v 1319.495n 1.8v 1319.505n 1.8v 1329.495n 1.8v 1329.505n 1.8v 1339.495n 1.8v 1339.505n 1.8v 1349.495n 1.8v 1349.505n 1.8v 1359.495n 1.8v 1359.505n 1.8v 1369.495n 1.8v 1369.505n 0.0v 1379.495n 0.0v 1379.505n 0.0v 1389.495n 0.0v 1389.505n 0.0v 1399.495n 0.0v 1399.505n 1.8v 1409.495n 1.8v 1409.505n 1.8v 1419.495n 1.8v 1419.505n 1.8v 1429.495n 1.8v 1429.505n 0.0v 1439.495n 0.0v 1439.505n 0.0v 1449.495n 0.0v 1449.505n 0.0v 1459.495n 0.0v 1459.505n 0.0v 1469.495n 0.0v 1469.505n 0.0v 1479.495n 0.0v 1479.505n 1.8v 1489.495n 1.8v 1489.505n 1.8v 1499.495n 1.8v 1499.505n 0.0v 1509.495n 0.0v 1509.505n 0.0v 1519.495n 0.0v 1519.505n 0.0v 1529.495n 0.0v 1529.505n 0.0v 1539.495n 0.0v 1539.505n 0.0v 1549.495n 0.0v 1549.505n 0.0v 1559.495n 0.0v 1559.505n 0.0v 1569.495n 0.0v 1569.505n 0.0v 1579.495n 0.0v 1579.505n 0.0v 1589.495n 0.0v 1589.505n 0.0v 1599.495n 0.0v 1599.505n 0.0v 1609.495n 0.0v 1609.505n 0.0v 1619.495n 0.0v 1619.505n 0.0v 1629.495n 0.0v 1629.505n 0.0v 1639.495n 0.0v 1639.505n 0.0v 1649.495n 0.0v 1649.505n 0.0v 1659.495n 0.0v 1659.505n 0.0v 1669.495n 0.0v 1669.505n 0.0v 1679.495n 0.0v 1679.505n 0.0v 1689.495n 0.0v 1689.505n 0.0v 1699.495n 0.0v 1699.505n 0.0v 1709.495n 0.0v 1709.505n 0.0v 1719.495n 0.0v 1719.505n 0.0v 1729.495n 0.0v 1729.505n 0.0v 1739.495n 0.0v 1739.505n 1.8v 1749.495n 1.8v 1749.505n 1.8v 1759.495n 1.8v 1759.505n 1.8v 1769.495n 1.8v 1769.505n 1.8v 1779.495n 1.8v 1779.505n 1.8v 1789.495n 1.8v 1789.505n 1.8v 1799.495n 1.8v 1799.505n 1.8v 1809.495n 1.8v 1809.505n 1.8v 1819.495n 1.8v 1819.505n 1.8v 1829.495n 1.8v 1829.505n 1.8v 1839.495n 1.8v 1839.505n 1.8v 1849.495n 1.8v 1849.505n 0.0v 1859.495n 0.0v 1859.505n 1.8v 1869.495n 1.8v 1869.505n 0.0v 1879.495n 0.0v 1879.505n 1.8v 1889.495n 1.8v 1889.505n 1.8v 1899.495n 1.8v 1899.505n 1.8v 1909.495n 1.8v 1909.505n 0.0v 1919.495n 0.0v 1919.505n 0.0v 1929.495n 0.0v 1929.505n 0.0v 1939.495n 0.0v 1939.505n 0.0v 1949.495n 0.0v 1949.505n 0.0v 1959.495n 0.0v 1959.505n 0.0v 1969.495n 0.0v 1969.505n 0.0v 1979.495n 0.0v 1979.505n 0.0v 1989.495n 0.0v 1989.505n 0.0v 1999.495n 0.0v 1999.505n 0.0v 2009.495n 0.0v 2009.505n 0.0v 2019.495n 0.0v 2019.505n 0.0v 2029.495n 0.0v 2029.505n 1.8v 2039.495n 1.8v 2039.505n 1.8v 2049.495n 1.8v 2049.505n 1.8v )
* (time, data): [(0, 0), (10, 1), (20, 0), (30, 1), (40, 1), (50, 1), (60, 1), (70, 1), (80, 1), (90, 1), (100, 1), (110, 1), (120, 1), (130, 1), (140, 1), (150, 0), (160, 0), (170, 0), (180, 0), (190, 0), (200, 0), (210, 0), (220, 0), (230, 0), (240, 0), (250, 0), (260, 0), (270, 0), (280, 0), (290, 0), (300, 0), (310, 1), (320, 1), (330, 1), (340, 1), (350, 1), (360, 1), (370, 1), (380, 1), (390, 1), (400, 1), (410, 1), (420, 0), (430, 0), (440, 0), (450, 0), (460, 0), (470, 0), (480, 0), (490, 0), (500, 0), (510, 0), (520, 0), (530, 0), (540, 0), (550, 0), (560, 0), (570, 0), (580, 0), (590, 0), (600, 0), (610, 0), (620, 1), (630, 1), (640, 1), (650, 1), (660, 0), (670, 0), (680, 0), (690, 0), (700, 0), (710, 1), (720, 1), (730, 1), (740, 1), (750, 1), (760, 1), (770, 1), (780, 1), (790, 1), (800, 1), (810, 1), (820, 1), (830, 1), (840, 0), (850, 0), (860, 0), (870, 0), (880, 0), (890, 0), (900, 0), (910, 0), (920, 0), (930, 1), (940, 1), (950, 1), (960, 1), (970, 1), (980, 1), (990, 1), (1000, 1), (1010, 1), (1020, 1), (1030, 1), (1040, 1), (1050, 1), (1060, 1), (1070, 1), (1080, 1), (1090, 1), (1100, 1), (1110, 1), (1120, 1), (1130, 0), (1140, 0), (1150, 0), (1160, 0), (1170, 0), (1180, 0), (1190, 0), (1200, 0), (1210, 0), (1220, 0), (1230, 0), (1240, 0), (1250, 0), (1260, 1), (1270, 1), (1280, 1), (1290, 1), (1300, 1), (1310, 1), (1320, 1), (1330, 1), (1340, 1), (1350, 1), (1360, 1), (1370, 0), (1380, 0), (1390, 0), (1400, 0), (1410, 0), (1420, 0), (1430, 0), (1440, 0), (1450, 0), (1460, 0), (1470, 0), (1480, 0), (1490, 0), (1500, 0), (1510, 0), (1520, 0), (1530, 0), (1540, 0), (1550, 0), (1560, 0), (1570, 0), (1580, 1), (1590, 0), (1600, 0), (1610, 0), (1620, 1), (1630, 1), (1640, 1), (1650, 1), (1660, 1), (1670, 1), (1680, 1), (1690, 0), (1700, 0), (1710, 1), (1720, 1), (1730, 1), (1740, 0), (1750, 0), (1760, 0), (1770, 0), (1780, 0), (1790, 0), (1800, 0), (1810, 0), (1820, 0), (1830, 0), (1840, 0), (1850, 1), (1860, 0), (1870, 0), (1880, 0), (1890, 0), (1900, 0), (1910, 0), (1920, 0), (1930, 0), (1940, 0), (1950, 0), (1960, 0), (1970, 0), (1980, 0), (1990, 0), (2000, 0), (2010, 0), (2020, 0), (2030, 0), (2040, 0), (2050, 0)]
Vdin0_33  din0_33  0 PWL (0n 0.0v 9.495n 0.0v 9.505n 1.8v 19.495n 1.8v 19.505n 0.0v 29.495n 0.0v 29.505n 1.8v 39.495n 1.8v 39.505n 1.8v 49.495n 1.8v 49.505n 1.8v 59.495n 1.8v 59.505n 1.8v 69.495n 1.8v 69.505n 1.8v 79.495n 1.8v 79.505n 1.8v 89.495n 1.8v 89.505n 1.8v 99.495n 1.8v 99.505n 1.8v 109.495n 1.8v 109.505n 1.8v 119.495n 1.8v 119.505n 1.8v 129.495n 1.8v 129.505n 1.8v 139.495n 1.8v 139.505n 1.8v 149.495n 1.8v 149.505n 0.0v 159.495n 0.0v 159.505n 0.0v 169.495n 0.0v 169.505n 0.0v 179.495n 0.0v 179.505n 0.0v 189.495n 0.0v 189.505n 0.0v 199.495n 0.0v 199.505n 0.0v 209.495n 0.0v 209.505n 0.0v 219.495n 0.0v 219.505n 0.0v 229.495n 0.0v 229.505n 0.0v 239.495n 0.0v 239.505n 0.0v 249.495n 0.0v 249.505n 0.0v 259.495n 0.0v 259.505n 0.0v 269.495n 0.0v 269.505n 0.0v 279.495n 0.0v 279.505n 0.0v 289.495n 0.0v 289.505n 0.0v 299.495n 0.0v 299.505n 0.0v 309.495n 0.0v 309.505n 1.8v 319.495n 1.8v 319.505n 1.8v 329.495n 1.8v 329.505n 1.8v 339.495n 1.8v 339.505n 1.8v 349.495n 1.8v 349.505n 1.8v 359.495n 1.8v 359.505n 1.8v 369.495n 1.8v 369.505n 1.8v 379.495n 1.8v 379.505n 1.8v 389.495n 1.8v 389.505n 1.8v 399.495n 1.8v 399.505n 1.8v 409.495n 1.8v 409.505n 1.8v 419.495n 1.8v 419.505n 0.0v 429.495n 0.0v 429.505n 0.0v 439.495n 0.0v 439.505n 0.0v 449.495n 0.0v 449.505n 0.0v 459.495n 0.0v 459.505n 0.0v 469.495n 0.0v 469.505n 0.0v 479.495n 0.0v 479.505n 0.0v 489.495n 0.0v 489.505n 0.0v 499.495n 0.0v 499.505n 0.0v 509.495n 0.0v 509.505n 0.0v 519.495n 0.0v 519.505n 0.0v 529.495n 0.0v 529.505n 0.0v 539.495n 0.0v 539.505n 0.0v 549.495n 0.0v 549.505n 0.0v 559.495n 0.0v 559.505n 0.0v 569.495n 0.0v 569.505n 0.0v 579.495n 0.0v 579.505n 0.0v 589.495n 0.0v 589.505n 0.0v 599.495n 0.0v 599.505n 0.0v 609.495n 0.0v 609.505n 0.0v 619.495n 0.0v 619.505n 1.8v 629.495n 1.8v 629.505n 1.8v 639.495n 1.8v 639.505n 1.8v 649.495n 1.8v 649.505n 1.8v 659.495n 1.8v 659.505n 0.0v 669.495n 0.0v 669.505n 0.0v 679.495n 0.0v 679.505n 0.0v 689.495n 0.0v 689.505n 0.0v 699.495n 0.0v 699.505n 0.0v 709.495n 0.0v 709.505n 1.8v 719.495n 1.8v 719.505n 1.8v 729.495n 1.8v 729.505n 1.8v 739.495n 1.8v 739.505n 1.8v 749.495n 1.8v 749.505n 1.8v 759.495n 1.8v 759.505n 1.8v 769.495n 1.8v 769.505n 1.8v 779.495n 1.8v 779.505n 1.8v 789.495n 1.8v 789.505n 1.8v 799.495n 1.8v 799.505n 1.8v 809.495n 1.8v 809.505n 1.8v 819.495n 1.8v 819.505n 1.8v 829.495n 1.8v 829.505n 1.8v 839.495n 1.8v 839.505n 0.0v 849.495n 0.0v 849.505n 0.0v 859.495n 0.0v 859.505n 0.0v 869.495n 0.0v 869.505n 0.0v 879.495n 0.0v 879.505n 0.0v 889.495n 0.0v 889.505n 0.0v 899.495n 0.0v 899.505n 0.0v 909.495n 0.0v 909.505n 0.0v 919.495n 0.0v 919.505n 0.0v 929.495n 0.0v 929.505n 1.8v 939.495n 1.8v 939.505n 1.8v 949.495n 1.8v 949.505n 1.8v 959.495n 1.8v 959.505n 1.8v 969.495n 1.8v 969.505n 1.8v 979.495n 1.8v 979.505n 1.8v 989.495n 1.8v 989.505n 1.8v 999.495n 1.8v 999.505n 1.8v 1009.495n 1.8v 1009.505n 1.8v 1019.495n 1.8v 1019.505n 1.8v 1029.495n 1.8v 1029.505n 1.8v 1039.495n 1.8v 1039.505n 1.8v 1049.495n 1.8v 1049.505n 1.8v 1059.495n 1.8v 1059.505n 1.8v 1069.495n 1.8v 1069.505n 1.8v 1079.495n 1.8v 1079.505n 1.8v 1089.495n 1.8v 1089.505n 1.8v 1099.495n 1.8v 1099.505n 1.8v 1109.495n 1.8v 1109.505n 1.8v 1119.495n 1.8v 1119.505n 1.8v 1129.495n 1.8v 1129.505n 0.0v 1139.495n 0.0v 1139.505n 0.0v 1149.495n 0.0v 1149.505n 0.0v 1159.495n 0.0v 1159.505n 0.0v 1169.495n 0.0v 1169.505n 0.0v 1179.495n 0.0v 1179.505n 0.0v 1189.495n 0.0v 1189.505n 0.0v 1199.495n 0.0v 1199.505n 0.0v 1209.495n 0.0v 1209.505n 0.0v 1219.495n 0.0v 1219.505n 0.0v 1229.495n 0.0v 1229.505n 0.0v 1239.495n 0.0v 1239.505n 0.0v 1249.495n 0.0v 1249.505n 0.0v 1259.495n 0.0v 1259.505n 1.8v 1269.495n 1.8v 1269.505n 1.8v 1279.495n 1.8v 1279.505n 1.8v 1289.495n 1.8v 1289.505n 1.8v 1299.495n 1.8v 1299.505n 1.8v 1309.495n 1.8v 1309.505n 1.8v 1319.495n 1.8v 1319.505n 1.8v 1329.495n 1.8v 1329.505n 1.8v 1339.495n 1.8v 1339.505n 1.8v 1349.495n 1.8v 1349.505n 1.8v 1359.495n 1.8v 1359.505n 1.8v 1369.495n 1.8v 1369.505n 0.0v 1379.495n 0.0v 1379.505n 0.0v 1389.495n 0.0v 1389.505n 0.0v 1399.495n 0.0v 1399.505n 0.0v 1409.495n 0.0v 1409.505n 0.0v 1419.495n 0.0v 1419.505n 0.0v 1429.495n 0.0v 1429.505n 0.0v 1439.495n 0.0v 1439.505n 0.0v 1449.495n 0.0v 1449.505n 0.0v 1459.495n 0.0v 1459.505n 0.0v 1469.495n 0.0v 1469.505n 0.0v 1479.495n 0.0v 1479.505n 0.0v 1489.495n 0.0v 1489.505n 0.0v 1499.495n 0.0v 1499.505n 0.0v 1509.495n 0.0v 1509.505n 0.0v 1519.495n 0.0v 1519.505n 0.0v 1529.495n 0.0v 1529.505n 0.0v 1539.495n 0.0v 1539.505n 0.0v 1549.495n 0.0v 1549.505n 0.0v 1559.495n 0.0v 1559.505n 0.0v 1569.495n 0.0v 1569.505n 0.0v 1579.495n 0.0v 1579.505n 1.8v 1589.495n 1.8v 1589.505n 0.0v 1599.495n 0.0v 1599.505n 0.0v 1609.495n 0.0v 1609.505n 0.0v 1619.495n 0.0v 1619.505n 1.8v 1629.495n 1.8v 1629.505n 1.8v 1639.495n 1.8v 1639.505n 1.8v 1649.495n 1.8v 1649.505n 1.8v 1659.495n 1.8v 1659.505n 1.8v 1669.495n 1.8v 1669.505n 1.8v 1679.495n 1.8v 1679.505n 1.8v 1689.495n 1.8v 1689.505n 0.0v 1699.495n 0.0v 1699.505n 0.0v 1709.495n 0.0v 1709.505n 1.8v 1719.495n 1.8v 1719.505n 1.8v 1729.495n 1.8v 1729.505n 1.8v 1739.495n 1.8v 1739.505n 0.0v 1749.495n 0.0v 1749.505n 0.0v 1759.495n 0.0v 1759.505n 0.0v 1769.495n 0.0v 1769.505n 0.0v 1779.495n 0.0v 1779.505n 0.0v 1789.495n 0.0v 1789.505n 0.0v 1799.495n 0.0v 1799.505n 0.0v 1809.495n 0.0v 1809.505n 0.0v 1819.495n 0.0v 1819.505n 0.0v 1829.495n 0.0v 1829.505n 0.0v 1839.495n 0.0v 1839.505n 0.0v 1849.495n 0.0v 1849.505n 1.8v 1859.495n 1.8v 1859.505n 0.0v 1869.495n 0.0v 1869.505n 0.0v 1879.495n 0.0v 1879.505n 0.0v 1889.495n 0.0v 1889.505n 0.0v 1899.495n 0.0v 1899.505n 0.0v 1909.495n 0.0v 1909.505n 0.0v 1919.495n 0.0v 1919.505n 0.0v 1929.495n 0.0v 1929.505n 0.0v 1939.495n 0.0v 1939.505n 0.0v 1949.495n 0.0v 1949.505n 0.0v 1959.495n 0.0v 1959.505n 0.0v 1969.495n 0.0v 1969.505n 0.0v 1979.495n 0.0v 1979.505n 0.0v 1989.495n 0.0v 1989.505n 0.0v 1999.495n 0.0v 1999.505n 0.0v 2009.495n 0.0v 2009.505n 0.0v 2019.495n 0.0v 2019.505n 0.0v 2029.495n 0.0v 2029.505n 0.0v 2039.495n 0.0v 2039.505n 0.0v 2049.495n 0.0v 2049.505n 0.0v )
* (time, data): [(0, 0), (10, 0), (20, 1), (30, 1), (40, 1), (50, 1), (60, 1), (70, 1), (80, 1), (90, 1), (100, 1), (110, 1), (120, 1), (130, 1), (140, 1), (150, 0), (160, 0), (170, 0), (180, 0), (190, 0), (200, 0), (210, 0), (220, 0), (230, 0), (240, 0), (250, 0), (260, 1), (270, 1), (280, 1), (290, 1), (300, 1), (310, 1), (320, 1), (330, 1), (340, 1), (350, 1), (360, 1), (370, 1), (380, 1), (390, 0), (400, 1), (410, 1), (420, 1), (430, 1), (440, 1), (450, 0), (460, 0), (470, 1), (480, 1), (490, 1), (500, 0), (510, 0), (520, 0), (530, 0), (540, 0), (550, 0), (560, 0), (570, 0), (580, 0), (590, 0), (600, 0), (610, 0), (620, 1), (630, 1), (640, 1), (650, 1), (660, 0), (670, 0), (680, 0), (690, 0), (700, 0), (710, 1), (720, 1), (730, 1), (740, 1), (750, 1), (760, 1), (770, 1), (780, 1), (790, 1), (800, 1), (810, 1), (820, 1), (830, 1), (840, 0), (850, 0), (860, 0), (870, 0), (880, 0), (890, 0), (900, 0), (910, 0), (920, 0), (930, 1), (940, 1), (950, 1), (960, 0), (970, 0), (980, 0), (990, 0), (1000, 0), (1010, 0), (1020, 0), (1030, 0), (1040, 0), (1050, 0), (1060, 0), (1070, 0), (1080, 1), (1090, 1), (1100, 1), (1110, 1), (1120, 1), (1130, 1), (1140, 1), (1150, 1), (1160, 1), (1170, 1), (1180, 1), (1190, 1), (1200, 1), (1210, 1), (1220, 1), (1230, 1), (1240, 1), (1250, 1), (1260, 0), (1270, 0), (1280, 0), (1290, 0), (1300, 0), (1310, 0), (1320, 0), (1330, 0), (1340, 0), (1350, 0), (1360, 0), (1370, 1), (1380, 1), (1390, 1), (1400, 1), (1410, 1), (1420, 1), (1430, 0), (1440, 0), (1450, 0), (1460, 0), (1470, 0), (1480, 1), (1490, 1), (1500, 1), (1510, 1), (1520, 1), (1530, 1), (1540, 1), (1550, 1), (1560, 1), (1570, 0), (1580, 1), (1590, 0), (1600, 0), (1610, 0), (1620, 1), (1630, 1), (1640, 1), (1650, 1), (1660, 1), (1670, 1), (1680, 1), (1690, 0), (1700, 0), (1710, 1), (1720, 1), (1730, 1), (1740, 0), (1750, 0), (1760, 0), (1770, 0), (1780, 0), (1790, 1), (1800, 1), (1810, 1), (1820, 1), (1830, 1), (1840, 1), (1850, 1), (1860, 1), (1870, 0), (1880, 1), (1890, 1), (1900, 1), (1910, 1), (1920, 1), (1930, 1), (1940, 1), (1950, 1), (1960, 1), (1970, 1), (1980, 1), (1990, 1), (2000, 1), (2010, 1), (2020, 1), (2030, 1), (2040, 1), (2050, 1)]
Vdin0_34  din0_34  0 PWL (0n 0.0v 9.495n 0.0v 9.505n 0.0v 19.495n 0.0v 19.505n 1.8v 29.495n 1.8v 29.505n 1.8v 39.495n 1.8v 39.505n 1.8v 49.495n 1.8v 49.505n 1.8v 59.495n 1.8v 59.505n 1.8v 69.495n 1.8v 69.505n 1.8v 79.495n 1.8v 79.505n 1.8v 89.495n 1.8v 89.505n 1.8v 99.495n 1.8v 99.505n 1.8v 109.495n 1.8v 109.505n 1.8v 119.495n 1.8v 119.505n 1.8v 129.495n 1.8v 129.505n 1.8v 139.495n 1.8v 139.505n 1.8v 149.495n 1.8v 149.505n 0.0v 159.495n 0.0v 159.505n 0.0v 169.495n 0.0v 169.505n 0.0v 179.495n 0.0v 179.505n 0.0v 189.495n 0.0v 189.505n 0.0v 199.495n 0.0v 199.505n 0.0v 209.495n 0.0v 209.505n 0.0v 219.495n 0.0v 219.505n 0.0v 229.495n 0.0v 229.505n 0.0v 239.495n 0.0v 239.505n 0.0v 249.495n 0.0v 249.505n 0.0v 259.495n 0.0v 259.505n 1.8v 269.495n 1.8v 269.505n 1.8v 279.495n 1.8v 279.505n 1.8v 289.495n 1.8v 289.505n 1.8v 299.495n 1.8v 299.505n 1.8v 309.495n 1.8v 309.505n 1.8v 319.495n 1.8v 319.505n 1.8v 329.495n 1.8v 329.505n 1.8v 339.495n 1.8v 339.505n 1.8v 349.495n 1.8v 349.505n 1.8v 359.495n 1.8v 359.505n 1.8v 369.495n 1.8v 369.505n 1.8v 379.495n 1.8v 379.505n 1.8v 389.495n 1.8v 389.505n 0.0v 399.495n 0.0v 399.505n 1.8v 409.495n 1.8v 409.505n 1.8v 419.495n 1.8v 419.505n 1.8v 429.495n 1.8v 429.505n 1.8v 439.495n 1.8v 439.505n 1.8v 449.495n 1.8v 449.505n 0.0v 459.495n 0.0v 459.505n 0.0v 469.495n 0.0v 469.505n 1.8v 479.495n 1.8v 479.505n 1.8v 489.495n 1.8v 489.505n 1.8v 499.495n 1.8v 499.505n 0.0v 509.495n 0.0v 509.505n 0.0v 519.495n 0.0v 519.505n 0.0v 529.495n 0.0v 529.505n 0.0v 539.495n 0.0v 539.505n 0.0v 549.495n 0.0v 549.505n 0.0v 559.495n 0.0v 559.505n 0.0v 569.495n 0.0v 569.505n 0.0v 579.495n 0.0v 579.505n 0.0v 589.495n 0.0v 589.505n 0.0v 599.495n 0.0v 599.505n 0.0v 609.495n 0.0v 609.505n 0.0v 619.495n 0.0v 619.505n 1.8v 629.495n 1.8v 629.505n 1.8v 639.495n 1.8v 639.505n 1.8v 649.495n 1.8v 649.505n 1.8v 659.495n 1.8v 659.505n 0.0v 669.495n 0.0v 669.505n 0.0v 679.495n 0.0v 679.505n 0.0v 689.495n 0.0v 689.505n 0.0v 699.495n 0.0v 699.505n 0.0v 709.495n 0.0v 709.505n 1.8v 719.495n 1.8v 719.505n 1.8v 729.495n 1.8v 729.505n 1.8v 739.495n 1.8v 739.505n 1.8v 749.495n 1.8v 749.505n 1.8v 759.495n 1.8v 759.505n 1.8v 769.495n 1.8v 769.505n 1.8v 779.495n 1.8v 779.505n 1.8v 789.495n 1.8v 789.505n 1.8v 799.495n 1.8v 799.505n 1.8v 809.495n 1.8v 809.505n 1.8v 819.495n 1.8v 819.505n 1.8v 829.495n 1.8v 829.505n 1.8v 839.495n 1.8v 839.505n 0.0v 849.495n 0.0v 849.505n 0.0v 859.495n 0.0v 859.505n 0.0v 869.495n 0.0v 869.505n 0.0v 879.495n 0.0v 879.505n 0.0v 889.495n 0.0v 889.505n 0.0v 899.495n 0.0v 899.505n 0.0v 909.495n 0.0v 909.505n 0.0v 919.495n 0.0v 919.505n 0.0v 929.495n 0.0v 929.505n 1.8v 939.495n 1.8v 939.505n 1.8v 949.495n 1.8v 949.505n 1.8v 959.495n 1.8v 959.505n 0.0v 969.495n 0.0v 969.505n 0.0v 979.495n 0.0v 979.505n 0.0v 989.495n 0.0v 989.505n 0.0v 999.495n 0.0v 999.505n 0.0v 1009.495n 0.0v 1009.505n 0.0v 1019.495n 0.0v 1019.505n 0.0v 1029.495n 0.0v 1029.505n 0.0v 1039.495n 0.0v 1039.505n 0.0v 1049.495n 0.0v 1049.505n 0.0v 1059.495n 0.0v 1059.505n 0.0v 1069.495n 0.0v 1069.505n 0.0v 1079.495n 0.0v 1079.505n 1.8v 1089.495n 1.8v 1089.505n 1.8v 1099.495n 1.8v 1099.505n 1.8v 1109.495n 1.8v 1109.505n 1.8v 1119.495n 1.8v 1119.505n 1.8v 1129.495n 1.8v 1129.505n 1.8v 1139.495n 1.8v 1139.505n 1.8v 1149.495n 1.8v 1149.505n 1.8v 1159.495n 1.8v 1159.505n 1.8v 1169.495n 1.8v 1169.505n 1.8v 1179.495n 1.8v 1179.505n 1.8v 1189.495n 1.8v 1189.505n 1.8v 1199.495n 1.8v 1199.505n 1.8v 1209.495n 1.8v 1209.505n 1.8v 1219.495n 1.8v 1219.505n 1.8v 1229.495n 1.8v 1229.505n 1.8v 1239.495n 1.8v 1239.505n 1.8v 1249.495n 1.8v 1249.505n 1.8v 1259.495n 1.8v 1259.505n 0.0v 1269.495n 0.0v 1269.505n 0.0v 1279.495n 0.0v 1279.505n 0.0v 1289.495n 0.0v 1289.505n 0.0v 1299.495n 0.0v 1299.505n 0.0v 1309.495n 0.0v 1309.505n 0.0v 1319.495n 0.0v 1319.505n 0.0v 1329.495n 0.0v 1329.505n 0.0v 1339.495n 0.0v 1339.505n 0.0v 1349.495n 0.0v 1349.505n 0.0v 1359.495n 0.0v 1359.505n 0.0v 1369.495n 0.0v 1369.505n 1.8v 1379.495n 1.8v 1379.505n 1.8v 1389.495n 1.8v 1389.505n 1.8v 1399.495n 1.8v 1399.505n 1.8v 1409.495n 1.8v 1409.505n 1.8v 1419.495n 1.8v 1419.505n 1.8v 1429.495n 1.8v 1429.505n 0.0v 1439.495n 0.0v 1439.505n 0.0v 1449.495n 0.0v 1449.505n 0.0v 1459.495n 0.0v 1459.505n 0.0v 1469.495n 0.0v 1469.505n 0.0v 1479.495n 0.0v 1479.505n 1.8v 1489.495n 1.8v 1489.505n 1.8v 1499.495n 1.8v 1499.505n 1.8v 1509.495n 1.8v 1509.505n 1.8v 1519.495n 1.8v 1519.505n 1.8v 1529.495n 1.8v 1529.505n 1.8v 1539.495n 1.8v 1539.505n 1.8v 1549.495n 1.8v 1549.505n 1.8v 1559.495n 1.8v 1559.505n 1.8v 1569.495n 1.8v 1569.505n 0.0v 1579.495n 0.0v 1579.505n 1.8v 1589.495n 1.8v 1589.505n 0.0v 1599.495n 0.0v 1599.505n 0.0v 1609.495n 0.0v 1609.505n 0.0v 1619.495n 0.0v 1619.505n 1.8v 1629.495n 1.8v 1629.505n 1.8v 1639.495n 1.8v 1639.505n 1.8v 1649.495n 1.8v 1649.505n 1.8v 1659.495n 1.8v 1659.505n 1.8v 1669.495n 1.8v 1669.505n 1.8v 1679.495n 1.8v 1679.505n 1.8v 1689.495n 1.8v 1689.505n 0.0v 1699.495n 0.0v 1699.505n 0.0v 1709.495n 0.0v 1709.505n 1.8v 1719.495n 1.8v 1719.505n 1.8v 1729.495n 1.8v 1729.505n 1.8v 1739.495n 1.8v 1739.505n 0.0v 1749.495n 0.0v 1749.505n 0.0v 1759.495n 0.0v 1759.505n 0.0v 1769.495n 0.0v 1769.505n 0.0v 1779.495n 0.0v 1779.505n 0.0v 1789.495n 0.0v 1789.505n 1.8v 1799.495n 1.8v 1799.505n 1.8v 1809.495n 1.8v 1809.505n 1.8v 1819.495n 1.8v 1819.505n 1.8v 1829.495n 1.8v 1829.505n 1.8v 1839.495n 1.8v 1839.505n 1.8v 1849.495n 1.8v 1849.505n 1.8v 1859.495n 1.8v 1859.505n 1.8v 1869.495n 1.8v 1869.505n 0.0v 1879.495n 0.0v 1879.505n 1.8v 1889.495n 1.8v 1889.505n 1.8v 1899.495n 1.8v 1899.505n 1.8v 1909.495n 1.8v 1909.505n 1.8v 1919.495n 1.8v 1919.505n 1.8v 1929.495n 1.8v 1929.505n 1.8v 1939.495n 1.8v 1939.505n 1.8v 1949.495n 1.8v 1949.505n 1.8v 1959.495n 1.8v 1959.505n 1.8v 1969.495n 1.8v 1969.505n 1.8v 1979.495n 1.8v 1979.505n 1.8v 1989.495n 1.8v 1989.505n 1.8v 1999.495n 1.8v 1999.505n 1.8v 2009.495n 1.8v 2009.505n 1.8v 2019.495n 1.8v 2019.505n 1.8v 2029.495n 1.8v 2029.505n 1.8v 2039.495n 1.8v 2039.505n 1.8v 2049.495n 1.8v 2049.505n 1.8v )
* (time, data): [(0, 0), (10, 0), (20, 0), (30, 0), (40, 0), (50, 0), (60, 1), (70, 1), (80, 1), (90, 1), (100, 1), (110, 1), (120, 1), (130, 1), (140, 1), (150, 0), (160, 0), (170, 0), (180, 0), (190, 0), (200, 0), (210, 0), (220, 0), (230, 0), (240, 0), (250, 0), (260, 1), (270, 1), (280, 1), (290, 1), (300, 1), (310, 1), (320, 1), (330, 1), (340, 1), (350, 0), (360, 0), (370, 0), (380, 0), (390, 1), (400, 0), (410, 0), (420, 1), (430, 1), (440, 1), (450, 0), (460, 0), (470, 1), (480, 1), (490, 0), (500, 1), (510, 1), (520, 1), (530, 1), (540, 1), (550, 1), (560, 1), (570, 1), (580, 1), (590, 1), (600, 1), (610, 1), (620, 0), (630, 0), (640, 0), (650, 0), (660, 1), (670, 0), (680, 0), (690, 0), (700, 0), (710, 0), (720, 0), (730, 0), (740, 0), (750, 0), (760, 0), (770, 0), (780, 0), (790, 0), (800, 0), (810, 0), (820, 0), (830, 0), (840, 1), (850, 1), (860, 1), (870, 1), (880, 1), (890, 1), (900, 1), (910, 1), (920, 1), (930, 1), (940, 1), (950, 1), (960, 0), (970, 0), (980, 0), (990, 0), (1000, 0), (1010, 0), (1020, 0), (1030, 0), (1040, 0), (1050, 0), (1060, 0), (1070, 0), (1080, 0), (1090, 0), (1100, 0), (1110, 0), (1120, 0), (1130, 0), (1140, 0), (1150, 0), (1160, 0), (1170, 0), (1180, 0), (1190, 0), (1200, 0), (1210, 0), (1220, 0), (1230, 0), (1240, 0), (1250, 0), (1260, 1), (1270, 1), (1280, 1), (1290, 1), (1300, 1), (1310, 1), (1320, 1), (1330, 1), (1340, 1), (1350, 1), (1360, 1), (1370, 1), (1380, 1), (1390, 1), (1400, 0), (1410, 0), (1420, 0), (1430, 1), (1440, 1), (1450, 1), (1460, 1), (1470, 1), (1480, 0), (1490, 0), (1500, 1), (1510, 1), (1520, 1), (1530, 1), (1540, 1), (1550, 1), (1560, 1), (1570, 1), (1580, 0), (1590, 0), (1600, 0), (1610, 0), (1620, 0), (1630, 0), (1640, 0), (1650, 0), (1660, 0), (1670, 0), (1680, 0), (1690, 1), (1700, 1), (1710, 0), (1720, 0), (1730, 1), (1740, 1), (1750, 1), (1760, 1), (1770, 1), (1780, 1), (1790, 1), (1800, 1), (1810, 1), (1820, 1), (1830, 1), (1840, 1), (1850, 1), (1860, 1), (1870, 1), (1880, 1), (1890, 0), (1900, 0), (1910, 0), (1920, 0), (1930, 0), (1940, 0), (1950, 0), (1960, 0), (1970, 0), (1980, 0), (1990, 0), (2000, 0), (2010, 0), (2020, 0), (2030, 0), (2040, 0), (2050, 0)]
Vdin0_35  din0_35  0 PWL (0n 0.0v 9.495n 0.0v 9.505n 0.0v 19.495n 0.0v 19.505n 0.0v 29.495n 0.0v 29.505n 0.0v 39.495n 0.0v 39.505n 0.0v 49.495n 0.0v 49.505n 0.0v 59.495n 0.0v 59.505n 1.8v 69.495n 1.8v 69.505n 1.8v 79.495n 1.8v 79.505n 1.8v 89.495n 1.8v 89.505n 1.8v 99.495n 1.8v 99.505n 1.8v 109.495n 1.8v 109.505n 1.8v 119.495n 1.8v 119.505n 1.8v 129.495n 1.8v 129.505n 1.8v 139.495n 1.8v 139.505n 1.8v 149.495n 1.8v 149.505n 0.0v 159.495n 0.0v 159.505n 0.0v 169.495n 0.0v 169.505n 0.0v 179.495n 0.0v 179.505n 0.0v 189.495n 0.0v 189.505n 0.0v 199.495n 0.0v 199.505n 0.0v 209.495n 0.0v 209.505n 0.0v 219.495n 0.0v 219.505n 0.0v 229.495n 0.0v 229.505n 0.0v 239.495n 0.0v 239.505n 0.0v 249.495n 0.0v 249.505n 0.0v 259.495n 0.0v 259.505n 1.8v 269.495n 1.8v 269.505n 1.8v 279.495n 1.8v 279.505n 1.8v 289.495n 1.8v 289.505n 1.8v 299.495n 1.8v 299.505n 1.8v 309.495n 1.8v 309.505n 1.8v 319.495n 1.8v 319.505n 1.8v 329.495n 1.8v 329.505n 1.8v 339.495n 1.8v 339.505n 1.8v 349.495n 1.8v 349.505n 0.0v 359.495n 0.0v 359.505n 0.0v 369.495n 0.0v 369.505n 0.0v 379.495n 0.0v 379.505n 0.0v 389.495n 0.0v 389.505n 1.8v 399.495n 1.8v 399.505n 0.0v 409.495n 0.0v 409.505n 0.0v 419.495n 0.0v 419.505n 1.8v 429.495n 1.8v 429.505n 1.8v 439.495n 1.8v 439.505n 1.8v 449.495n 1.8v 449.505n 0.0v 459.495n 0.0v 459.505n 0.0v 469.495n 0.0v 469.505n 1.8v 479.495n 1.8v 479.505n 1.8v 489.495n 1.8v 489.505n 0.0v 499.495n 0.0v 499.505n 1.8v 509.495n 1.8v 509.505n 1.8v 519.495n 1.8v 519.505n 1.8v 529.495n 1.8v 529.505n 1.8v 539.495n 1.8v 539.505n 1.8v 549.495n 1.8v 549.505n 1.8v 559.495n 1.8v 559.505n 1.8v 569.495n 1.8v 569.505n 1.8v 579.495n 1.8v 579.505n 1.8v 589.495n 1.8v 589.505n 1.8v 599.495n 1.8v 599.505n 1.8v 609.495n 1.8v 609.505n 1.8v 619.495n 1.8v 619.505n 0.0v 629.495n 0.0v 629.505n 0.0v 639.495n 0.0v 639.505n 0.0v 649.495n 0.0v 649.505n 0.0v 659.495n 0.0v 659.505n 1.8v 669.495n 1.8v 669.505n 0.0v 679.495n 0.0v 679.505n 0.0v 689.495n 0.0v 689.505n 0.0v 699.495n 0.0v 699.505n 0.0v 709.495n 0.0v 709.505n 0.0v 719.495n 0.0v 719.505n 0.0v 729.495n 0.0v 729.505n 0.0v 739.495n 0.0v 739.505n 0.0v 749.495n 0.0v 749.505n 0.0v 759.495n 0.0v 759.505n 0.0v 769.495n 0.0v 769.505n 0.0v 779.495n 0.0v 779.505n 0.0v 789.495n 0.0v 789.505n 0.0v 799.495n 0.0v 799.505n 0.0v 809.495n 0.0v 809.505n 0.0v 819.495n 0.0v 819.505n 0.0v 829.495n 0.0v 829.505n 0.0v 839.495n 0.0v 839.505n 1.8v 849.495n 1.8v 849.505n 1.8v 859.495n 1.8v 859.505n 1.8v 869.495n 1.8v 869.505n 1.8v 879.495n 1.8v 879.505n 1.8v 889.495n 1.8v 889.505n 1.8v 899.495n 1.8v 899.505n 1.8v 909.495n 1.8v 909.505n 1.8v 919.495n 1.8v 919.505n 1.8v 929.495n 1.8v 929.505n 1.8v 939.495n 1.8v 939.505n 1.8v 949.495n 1.8v 949.505n 1.8v 959.495n 1.8v 959.505n 0.0v 969.495n 0.0v 969.505n 0.0v 979.495n 0.0v 979.505n 0.0v 989.495n 0.0v 989.505n 0.0v 999.495n 0.0v 999.505n 0.0v 1009.495n 0.0v 1009.505n 0.0v 1019.495n 0.0v 1019.505n 0.0v 1029.495n 0.0v 1029.505n 0.0v 1039.495n 0.0v 1039.505n 0.0v 1049.495n 0.0v 1049.505n 0.0v 1059.495n 0.0v 1059.505n 0.0v 1069.495n 0.0v 1069.505n 0.0v 1079.495n 0.0v 1079.505n 0.0v 1089.495n 0.0v 1089.505n 0.0v 1099.495n 0.0v 1099.505n 0.0v 1109.495n 0.0v 1109.505n 0.0v 1119.495n 0.0v 1119.505n 0.0v 1129.495n 0.0v 1129.505n 0.0v 1139.495n 0.0v 1139.505n 0.0v 1149.495n 0.0v 1149.505n 0.0v 1159.495n 0.0v 1159.505n 0.0v 1169.495n 0.0v 1169.505n 0.0v 1179.495n 0.0v 1179.505n 0.0v 1189.495n 0.0v 1189.505n 0.0v 1199.495n 0.0v 1199.505n 0.0v 1209.495n 0.0v 1209.505n 0.0v 1219.495n 0.0v 1219.505n 0.0v 1229.495n 0.0v 1229.505n 0.0v 1239.495n 0.0v 1239.505n 0.0v 1249.495n 0.0v 1249.505n 0.0v 1259.495n 0.0v 1259.505n 1.8v 1269.495n 1.8v 1269.505n 1.8v 1279.495n 1.8v 1279.505n 1.8v 1289.495n 1.8v 1289.505n 1.8v 1299.495n 1.8v 1299.505n 1.8v 1309.495n 1.8v 1309.505n 1.8v 1319.495n 1.8v 1319.505n 1.8v 1329.495n 1.8v 1329.505n 1.8v 1339.495n 1.8v 1339.505n 1.8v 1349.495n 1.8v 1349.505n 1.8v 1359.495n 1.8v 1359.505n 1.8v 1369.495n 1.8v 1369.505n 1.8v 1379.495n 1.8v 1379.505n 1.8v 1389.495n 1.8v 1389.505n 1.8v 1399.495n 1.8v 1399.505n 0.0v 1409.495n 0.0v 1409.505n 0.0v 1419.495n 0.0v 1419.505n 0.0v 1429.495n 0.0v 1429.505n 1.8v 1439.495n 1.8v 1439.505n 1.8v 1449.495n 1.8v 1449.505n 1.8v 1459.495n 1.8v 1459.505n 1.8v 1469.495n 1.8v 1469.505n 1.8v 1479.495n 1.8v 1479.505n 0.0v 1489.495n 0.0v 1489.505n 0.0v 1499.495n 0.0v 1499.505n 1.8v 1509.495n 1.8v 1509.505n 1.8v 1519.495n 1.8v 1519.505n 1.8v 1529.495n 1.8v 1529.505n 1.8v 1539.495n 1.8v 1539.505n 1.8v 1549.495n 1.8v 1549.505n 1.8v 1559.495n 1.8v 1559.505n 1.8v 1569.495n 1.8v 1569.505n 1.8v 1579.495n 1.8v 1579.505n 0.0v 1589.495n 0.0v 1589.505n 0.0v 1599.495n 0.0v 1599.505n 0.0v 1609.495n 0.0v 1609.505n 0.0v 1619.495n 0.0v 1619.505n 0.0v 1629.495n 0.0v 1629.505n 0.0v 1639.495n 0.0v 1639.505n 0.0v 1649.495n 0.0v 1649.505n 0.0v 1659.495n 0.0v 1659.505n 0.0v 1669.495n 0.0v 1669.505n 0.0v 1679.495n 0.0v 1679.505n 0.0v 1689.495n 0.0v 1689.505n 1.8v 1699.495n 1.8v 1699.505n 1.8v 1709.495n 1.8v 1709.505n 0.0v 1719.495n 0.0v 1719.505n 0.0v 1729.495n 0.0v 1729.505n 1.8v 1739.495n 1.8v 1739.505n 1.8v 1749.495n 1.8v 1749.505n 1.8v 1759.495n 1.8v 1759.505n 1.8v 1769.495n 1.8v 1769.505n 1.8v 1779.495n 1.8v 1779.505n 1.8v 1789.495n 1.8v 1789.505n 1.8v 1799.495n 1.8v 1799.505n 1.8v 1809.495n 1.8v 1809.505n 1.8v 1819.495n 1.8v 1819.505n 1.8v 1829.495n 1.8v 1829.505n 1.8v 1839.495n 1.8v 1839.505n 1.8v 1849.495n 1.8v 1849.505n 1.8v 1859.495n 1.8v 1859.505n 1.8v 1869.495n 1.8v 1869.505n 1.8v 1879.495n 1.8v 1879.505n 1.8v 1889.495n 1.8v 1889.505n 0.0v 1899.495n 0.0v 1899.505n 0.0v 1909.495n 0.0v 1909.505n 0.0v 1919.495n 0.0v 1919.505n 0.0v 1929.495n 0.0v 1929.505n 0.0v 1939.495n 0.0v 1939.505n 0.0v 1949.495n 0.0v 1949.505n 0.0v 1959.495n 0.0v 1959.505n 0.0v 1969.495n 0.0v 1969.505n 0.0v 1979.495n 0.0v 1979.505n 0.0v 1989.495n 0.0v 1989.505n 0.0v 1999.495n 0.0v 1999.505n 0.0v 2009.495n 0.0v 2009.505n 0.0v 2019.495n 0.0v 2019.505n 0.0v 2029.495n 0.0v 2029.505n 0.0v 2039.495n 0.0v 2039.505n 0.0v 2049.495n 0.0v 2049.505n 0.0v )
* (time, data): [(0, 0), (10, 1), (20, 1), (30, 1), (40, 1), (50, 1), (60, 0), (70, 0), (80, 0), (90, 0), (100, 0), (110, 0), (120, 0), (130, 0), (140, 0), (150, 1), (160, 1), (170, 1), (180, 1), (190, 1), (200, 1), (210, 1), (220, 1), (230, 1), (240, 1), (250, 1), (260, 0), (270, 0), (280, 0), (290, 0), (300, 0), (310, 0), (320, 0), (330, 0), (340, 0), (350, 0), (360, 0), (370, 0), (380, 0), (390, 1), (400, 1), (410, 1), (420, 0), (430, 0), (440, 0), (450, 1), (460, 1), (470, 1), (480, 1), (490, 0), (500, 0), (510, 0), (520, 0), (530, 0), (540, 0), (550, 0), (560, 0), (570, 0), (580, 0), (590, 0), (600, 0), (610, 0), (620, 0), (630, 0), (640, 0), (650, 0), (660, 1), (670, 1), (680, 1), (690, 1), (700, 1), (710, 1), (720, 1), (730, 1), (740, 1), (750, 1), (760, 1), (770, 0), (780, 0), (790, 0), (800, 0), (810, 0), (820, 0), (830, 0), (840, 0), (850, 0), (860, 0), (870, 0), (880, 0), (890, 1), (900, 1), (910, 1), (920, 1), (930, 1), (940, 1), (950, 1), (960, 1), (970, 1), (980, 1), (990, 1), (1000, 1), (1010, 1), (1020, 1), (1030, 1), (1040, 1), (1050, 1), (1060, 1), (1070, 1), (1080, 0), (1090, 0), (1100, 0), (1110, 0), (1120, 0), (1130, 0), (1140, 0), (1150, 0), (1160, 0), (1170, 0), (1180, 0), (1190, 0), (1200, 0), (1210, 0), (1220, 0), (1230, 0), (1240, 0), (1250, 0), (1260, 1), (1270, 1), (1280, 1), (1290, 1), (1300, 1), (1310, 1), (1320, 1), (1330, 1), (1340, 1), (1350, 1), (1360, 1), (1370, 1), (1380, 1), (1390, 1), (1400, 1), (1410, 1), (1420, 1), (1430, 0), (1440, 0), (1450, 0), (1460, 0), (1470, 0), (1480, 1), (1490, 1), (1500, 1), (1510, 1), (1520, 1), (1530, 1), (1540, 1), (1550, 1), (1560, 1), (1570, 1), (1580, 0), (1590, 1), (1600, 1), (1610, 1), (1620, 1), (1630, 1), (1640, 1), (1650, 1), (1660, 1), (1670, 1), (1680, 1), (1690, 0), (1700, 0), (1710, 1), (1720, 1), (1730, 1), (1740, 1), (1750, 1), (1760, 1), (1770, 1), (1780, 1), (1790, 1), (1800, 1), (1810, 1), (1820, 1), (1830, 1), (1840, 1), (1850, 0), (1860, 0), (1870, 0), (1880, 0), (1890, 1), (1900, 1), (1910, 0), (1920, 0), (1930, 0), (1940, 0), (1950, 0), (1960, 0), (1970, 0), (1980, 0), (1990, 0), (2000, 0), (2010, 0), (2020, 0), (2030, 1), (2040, 1), (2050, 1)]
Vdin0_36  din0_36  0 PWL (0n 0.0v 9.495n 0.0v 9.505n 1.8v 19.495n 1.8v 19.505n 1.8v 29.495n 1.8v 29.505n 1.8v 39.495n 1.8v 39.505n 1.8v 49.495n 1.8v 49.505n 1.8v 59.495n 1.8v 59.505n 0.0v 69.495n 0.0v 69.505n 0.0v 79.495n 0.0v 79.505n 0.0v 89.495n 0.0v 89.505n 0.0v 99.495n 0.0v 99.505n 0.0v 109.495n 0.0v 109.505n 0.0v 119.495n 0.0v 119.505n 0.0v 129.495n 0.0v 129.505n 0.0v 139.495n 0.0v 139.505n 0.0v 149.495n 0.0v 149.505n 1.8v 159.495n 1.8v 159.505n 1.8v 169.495n 1.8v 169.505n 1.8v 179.495n 1.8v 179.505n 1.8v 189.495n 1.8v 189.505n 1.8v 199.495n 1.8v 199.505n 1.8v 209.495n 1.8v 209.505n 1.8v 219.495n 1.8v 219.505n 1.8v 229.495n 1.8v 229.505n 1.8v 239.495n 1.8v 239.505n 1.8v 249.495n 1.8v 249.505n 1.8v 259.495n 1.8v 259.505n 0.0v 269.495n 0.0v 269.505n 0.0v 279.495n 0.0v 279.505n 0.0v 289.495n 0.0v 289.505n 0.0v 299.495n 0.0v 299.505n 0.0v 309.495n 0.0v 309.505n 0.0v 319.495n 0.0v 319.505n 0.0v 329.495n 0.0v 329.505n 0.0v 339.495n 0.0v 339.505n 0.0v 349.495n 0.0v 349.505n 0.0v 359.495n 0.0v 359.505n 0.0v 369.495n 0.0v 369.505n 0.0v 379.495n 0.0v 379.505n 0.0v 389.495n 0.0v 389.505n 1.8v 399.495n 1.8v 399.505n 1.8v 409.495n 1.8v 409.505n 1.8v 419.495n 1.8v 419.505n 0.0v 429.495n 0.0v 429.505n 0.0v 439.495n 0.0v 439.505n 0.0v 449.495n 0.0v 449.505n 1.8v 459.495n 1.8v 459.505n 1.8v 469.495n 1.8v 469.505n 1.8v 479.495n 1.8v 479.505n 1.8v 489.495n 1.8v 489.505n 0.0v 499.495n 0.0v 499.505n 0.0v 509.495n 0.0v 509.505n 0.0v 519.495n 0.0v 519.505n 0.0v 529.495n 0.0v 529.505n 0.0v 539.495n 0.0v 539.505n 0.0v 549.495n 0.0v 549.505n 0.0v 559.495n 0.0v 559.505n 0.0v 569.495n 0.0v 569.505n 0.0v 579.495n 0.0v 579.505n 0.0v 589.495n 0.0v 589.505n 0.0v 599.495n 0.0v 599.505n 0.0v 609.495n 0.0v 609.505n 0.0v 619.495n 0.0v 619.505n 0.0v 629.495n 0.0v 629.505n 0.0v 639.495n 0.0v 639.505n 0.0v 649.495n 0.0v 649.505n 0.0v 659.495n 0.0v 659.505n 1.8v 669.495n 1.8v 669.505n 1.8v 679.495n 1.8v 679.505n 1.8v 689.495n 1.8v 689.505n 1.8v 699.495n 1.8v 699.505n 1.8v 709.495n 1.8v 709.505n 1.8v 719.495n 1.8v 719.505n 1.8v 729.495n 1.8v 729.505n 1.8v 739.495n 1.8v 739.505n 1.8v 749.495n 1.8v 749.505n 1.8v 759.495n 1.8v 759.505n 1.8v 769.495n 1.8v 769.505n 0.0v 779.495n 0.0v 779.505n 0.0v 789.495n 0.0v 789.505n 0.0v 799.495n 0.0v 799.505n 0.0v 809.495n 0.0v 809.505n 0.0v 819.495n 0.0v 819.505n 0.0v 829.495n 0.0v 829.505n 0.0v 839.495n 0.0v 839.505n 0.0v 849.495n 0.0v 849.505n 0.0v 859.495n 0.0v 859.505n 0.0v 869.495n 0.0v 869.505n 0.0v 879.495n 0.0v 879.505n 0.0v 889.495n 0.0v 889.505n 1.8v 899.495n 1.8v 899.505n 1.8v 909.495n 1.8v 909.505n 1.8v 919.495n 1.8v 919.505n 1.8v 929.495n 1.8v 929.505n 1.8v 939.495n 1.8v 939.505n 1.8v 949.495n 1.8v 949.505n 1.8v 959.495n 1.8v 959.505n 1.8v 969.495n 1.8v 969.505n 1.8v 979.495n 1.8v 979.505n 1.8v 989.495n 1.8v 989.505n 1.8v 999.495n 1.8v 999.505n 1.8v 1009.495n 1.8v 1009.505n 1.8v 1019.495n 1.8v 1019.505n 1.8v 1029.495n 1.8v 1029.505n 1.8v 1039.495n 1.8v 1039.505n 1.8v 1049.495n 1.8v 1049.505n 1.8v 1059.495n 1.8v 1059.505n 1.8v 1069.495n 1.8v 1069.505n 1.8v 1079.495n 1.8v 1079.505n 0.0v 1089.495n 0.0v 1089.505n 0.0v 1099.495n 0.0v 1099.505n 0.0v 1109.495n 0.0v 1109.505n 0.0v 1119.495n 0.0v 1119.505n 0.0v 1129.495n 0.0v 1129.505n 0.0v 1139.495n 0.0v 1139.505n 0.0v 1149.495n 0.0v 1149.505n 0.0v 1159.495n 0.0v 1159.505n 0.0v 1169.495n 0.0v 1169.505n 0.0v 1179.495n 0.0v 1179.505n 0.0v 1189.495n 0.0v 1189.505n 0.0v 1199.495n 0.0v 1199.505n 0.0v 1209.495n 0.0v 1209.505n 0.0v 1219.495n 0.0v 1219.505n 0.0v 1229.495n 0.0v 1229.505n 0.0v 1239.495n 0.0v 1239.505n 0.0v 1249.495n 0.0v 1249.505n 0.0v 1259.495n 0.0v 1259.505n 1.8v 1269.495n 1.8v 1269.505n 1.8v 1279.495n 1.8v 1279.505n 1.8v 1289.495n 1.8v 1289.505n 1.8v 1299.495n 1.8v 1299.505n 1.8v 1309.495n 1.8v 1309.505n 1.8v 1319.495n 1.8v 1319.505n 1.8v 1329.495n 1.8v 1329.505n 1.8v 1339.495n 1.8v 1339.505n 1.8v 1349.495n 1.8v 1349.505n 1.8v 1359.495n 1.8v 1359.505n 1.8v 1369.495n 1.8v 1369.505n 1.8v 1379.495n 1.8v 1379.505n 1.8v 1389.495n 1.8v 1389.505n 1.8v 1399.495n 1.8v 1399.505n 1.8v 1409.495n 1.8v 1409.505n 1.8v 1419.495n 1.8v 1419.505n 1.8v 1429.495n 1.8v 1429.505n 0.0v 1439.495n 0.0v 1439.505n 0.0v 1449.495n 0.0v 1449.505n 0.0v 1459.495n 0.0v 1459.505n 0.0v 1469.495n 0.0v 1469.505n 0.0v 1479.495n 0.0v 1479.505n 1.8v 1489.495n 1.8v 1489.505n 1.8v 1499.495n 1.8v 1499.505n 1.8v 1509.495n 1.8v 1509.505n 1.8v 1519.495n 1.8v 1519.505n 1.8v 1529.495n 1.8v 1529.505n 1.8v 1539.495n 1.8v 1539.505n 1.8v 1549.495n 1.8v 1549.505n 1.8v 1559.495n 1.8v 1559.505n 1.8v 1569.495n 1.8v 1569.505n 1.8v 1579.495n 1.8v 1579.505n 0.0v 1589.495n 0.0v 1589.505n 1.8v 1599.495n 1.8v 1599.505n 1.8v 1609.495n 1.8v 1609.505n 1.8v 1619.495n 1.8v 1619.505n 1.8v 1629.495n 1.8v 1629.505n 1.8v 1639.495n 1.8v 1639.505n 1.8v 1649.495n 1.8v 1649.505n 1.8v 1659.495n 1.8v 1659.505n 1.8v 1669.495n 1.8v 1669.505n 1.8v 1679.495n 1.8v 1679.505n 1.8v 1689.495n 1.8v 1689.505n 0.0v 1699.495n 0.0v 1699.505n 0.0v 1709.495n 0.0v 1709.505n 1.8v 1719.495n 1.8v 1719.505n 1.8v 1729.495n 1.8v 1729.505n 1.8v 1739.495n 1.8v 1739.505n 1.8v 1749.495n 1.8v 1749.505n 1.8v 1759.495n 1.8v 1759.505n 1.8v 1769.495n 1.8v 1769.505n 1.8v 1779.495n 1.8v 1779.505n 1.8v 1789.495n 1.8v 1789.505n 1.8v 1799.495n 1.8v 1799.505n 1.8v 1809.495n 1.8v 1809.505n 1.8v 1819.495n 1.8v 1819.505n 1.8v 1829.495n 1.8v 1829.505n 1.8v 1839.495n 1.8v 1839.505n 1.8v 1849.495n 1.8v 1849.505n 0.0v 1859.495n 0.0v 1859.505n 0.0v 1869.495n 0.0v 1869.505n 0.0v 1879.495n 0.0v 1879.505n 0.0v 1889.495n 0.0v 1889.505n 1.8v 1899.495n 1.8v 1899.505n 1.8v 1909.495n 1.8v 1909.505n 0.0v 1919.495n 0.0v 1919.505n 0.0v 1929.495n 0.0v 1929.505n 0.0v 1939.495n 0.0v 1939.505n 0.0v 1949.495n 0.0v 1949.505n 0.0v 1959.495n 0.0v 1959.505n 0.0v 1969.495n 0.0v 1969.505n 0.0v 1979.495n 0.0v 1979.505n 0.0v 1989.495n 0.0v 1989.505n 0.0v 1999.495n 0.0v 1999.505n 0.0v 2009.495n 0.0v 2009.505n 0.0v 2019.495n 0.0v 2019.505n 0.0v 2029.495n 0.0v 2029.505n 1.8v 2039.495n 1.8v 2039.505n 1.8v 2049.495n 1.8v 2049.505n 1.8v )
* (time, data): [(0, 0), (10, 1), (20, 1), (30, 1), (40, 1), (50, 1), (60, 0), (70, 0), (80, 0), (90, 0), (100, 0), (110, 0), (120, 0), (130, 0), (140, 0), (150, 1), (160, 1), (170, 1), (180, 1), (190, 1), (200, 1), (210, 1), (220, 1), (230, 1), (240, 1), (250, 1), (260, 1), (270, 1), (280, 1), (290, 1), (300, 1), (310, 1), (320, 1), (330, 1), (340, 1), (350, 1), (360, 1), (370, 1), (380, 1), (390, 1), (400, 1), (410, 1), (420, 0), (430, 0), (440, 0), (450, 1), (460, 1), (470, 1), (480, 1), (490, 1), (500, 1), (510, 1), (520, 1), (530, 1), (540, 1), (550, 1), (560, 1), (570, 1), (580, 1), (590, 1), (600, 1), (610, 1), (620, 0), (630, 0), (640, 0), (650, 0), (660, 0), (670, 1), (680, 1), (690, 1), (700, 1), (710, 0), (720, 0), (730, 0), (740, 0), (750, 0), (760, 0), (770, 1), (780, 1), (790, 1), (800, 1), (810, 1), (820, 1), (830, 1), (840, 1), (850, 1), (860, 1), (870, 1), (880, 1), (890, 0), (900, 0), (910, 0), (920, 0), (930, 0), (940, 0), (950, 0), (960, 1), (970, 1), (980, 1), (990, 1), (1000, 1), (1010, 1), (1020, 1), (1030, 1), (1040, 1), (1050, 1), (1060, 1), (1070, 1), (1080, 0), (1090, 0), (1100, 0), (1110, 0), (1120, 0), (1130, 0), (1140, 0), (1150, 0), (1160, 0), (1170, 0), (1180, 0), (1190, 0), (1200, 0), (1210, 0), (1220, 0), (1230, 0), (1240, 0), (1250, 0), (1260, 1), (1270, 1), (1280, 0), (1290, 0), (1300, 0), (1310, 0), (1320, 0), (1330, 0), (1340, 0), (1350, 0), (1360, 0), (1370, 1), (1380, 1), (1390, 1), (1400, 1), (1410, 1), (1420, 1), (1430, 0), (1440, 0), (1450, 0), (1460, 0), (1470, 0), (1480, 0), (1490, 0), (1500, 1), (1510, 1), (1520, 1), (1530, 1), (1540, 1), (1550, 1), (1560, 1), (1570, 1), (1580, 0), (1590, 0), (1600, 0), (1610, 0), (1620, 0), (1630, 0), (1640, 0), (1650, 0), (1660, 0), (1670, 0), (1680, 0), (1690, 0), (1700, 0), (1710, 1), (1720, 1), (1730, 1), (1740, 0), (1750, 0), (1760, 0), (1770, 0), (1780, 0), (1790, 1), (1800, 1), (1810, 1), (1820, 1), (1830, 1), (1840, 1), (1850, 0), (1860, 1), (1870, 1), (1880, 0), (1890, 0), (1900, 0), (1910, 1), (1920, 1), (1930, 1), (1940, 1), (1950, 1), (1960, 1), (1970, 1), (1980, 1), (1990, 1), (2000, 1), (2010, 1), (2020, 1), (2030, 0), (2040, 0), (2050, 0)]
Vdin0_37  din0_37  0 PWL (0n 0.0v 9.495n 0.0v 9.505n 1.8v 19.495n 1.8v 19.505n 1.8v 29.495n 1.8v 29.505n 1.8v 39.495n 1.8v 39.505n 1.8v 49.495n 1.8v 49.505n 1.8v 59.495n 1.8v 59.505n 0.0v 69.495n 0.0v 69.505n 0.0v 79.495n 0.0v 79.505n 0.0v 89.495n 0.0v 89.505n 0.0v 99.495n 0.0v 99.505n 0.0v 109.495n 0.0v 109.505n 0.0v 119.495n 0.0v 119.505n 0.0v 129.495n 0.0v 129.505n 0.0v 139.495n 0.0v 139.505n 0.0v 149.495n 0.0v 149.505n 1.8v 159.495n 1.8v 159.505n 1.8v 169.495n 1.8v 169.505n 1.8v 179.495n 1.8v 179.505n 1.8v 189.495n 1.8v 189.505n 1.8v 199.495n 1.8v 199.505n 1.8v 209.495n 1.8v 209.505n 1.8v 219.495n 1.8v 219.505n 1.8v 229.495n 1.8v 229.505n 1.8v 239.495n 1.8v 239.505n 1.8v 249.495n 1.8v 249.505n 1.8v 259.495n 1.8v 259.505n 1.8v 269.495n 1.8v 269.505n 1.8v 279.495n 1.8v 279.505n 1.8v 289.495n 1.8v 289.505n 1.8v 299.495n 1.8v 299.505n 1.8v 309.495n 1.8v 309.505n 1.8v 319.495n 1.8v 319.505n 1.8v 329.495n 1.8v 329.505n 1.8v 339.495n 1.8v 339.505n 1.8v 349.495n 1.8v 349.505n 1.8v 359.495n 1.8v 359.505n 1.8v 369.495n 1.8v 369.505n 1.8v 379.495n 1.8v 379.505n 1.8v 389.495n 1.8v 389.505n 1.8v 399.495n 1.8v 399.505n 1.8v 409.495n 1.8v 409.505n 1.8v 419.495n 1.8v 419.505n 0.0v 429.495n 0.0v 429.505n 0.0v 439.495n 0.0v 439.505n 0.0v 449.495n 0.0v 449.505n 1.8v 459.495n 1.8v 459.505n 1.8v 469.495n 1.8v 469.505n 1.8v 479.495n 1.8v 479.505n 1.8v 489.495n 1.8v 489.505n 1.8v 499.495n 1.8v 499.505n 1.8v 509.495n 1.8v 509.505n 1.8v 519.495n 1.8v 519.505n 1.8v 529.495n 1.8v 529.505n 1.8v 539.495n 1.8v 539.505n 1.8v 549.495n 1.8v 549.505n 1.8v 559.495n 1.8v 559.505n 1.8v 569.495n 1.8v 569.505n 1.8v 579.495n 1.8v 579.505n 1.8v 589.495n 1.8v 589.505n 1.8v 599.495n 1.8v 599.505n 1.8v 609.495n 1.8v 609.505n 1.8v 619.495n 1.8v 619.505n 0.0v 629.495n 0.0v 629.505n 0.0v 639.495n 0.0v 639.505n 0.0v 649.495n 0.0v 649.505n 0.0v 659.495n 0.0v 659.505n 0.0v 669.495n 0.0v 669.505n 1.8v 679.495n 1.8v 679.505n 1.8v 689.495n 1.8v 689.505n 1.8v 699.495n 1.8v 699.505n 1.8v 709.495n 1.8v 709.505n 0.0v 719.495n 0.0v 719.505n 0.0v 729.495n 0.0v 729.505n 0.0v 739.495n 0.0v 739.505n 0.0v 749.495n 0.0v 749.505n 0.0v 759.495n 0.0v 759.505n 0.0v 769.495n 0.0v 769.505n 1.8v 779.495n 1.8v 779.505n 1.8v 789.495n 1.8v 789.505n 1.8v 799.495n 1.8v 799.505n 1.8v 809.495n 1.8v 809.505n 1.8v 819.495n 1.8v 819.505n 1.8v 829.495n 1.8v 829.505n 1.8v 839.495n 1.8v 839.505n 1.8v 849.495n 1.8v 849.505n 1.8v 859.495n 1.8v 859.505n 1.8v 869.495n 1.8v 869.505n 1.8v 879.495n 1.8v 879.505n 1.8v 889.495n 1.8v 889.505n 0.0v 899.495n 0.0v 899.505n 0.0v 909.495n 0.0v 909.505n 0.0v 919.495n 0.0v 919.505n 0.0v 929.495n 0.0v 929.505n 0.0v 939.495n 0.0v 939.505n 0.0v 949.495n 0.0v 949.505n 0.0v 959.495n 0.0v 959.505n 1.8v 969.495n 1.8v 969.505n 1.8v 979.495n 1.8v 979.505n 1.8v 989.495n 1.8v 989.505n 1.8v 999.495n 1.8v 999.505n 1.8v 1009.495n 1.8v 1009.505n 1.8v 1019.495n 1.8v 1019.505n 1.8v 1029.495n 1.8v 1029.505n 1.8v 1039.495n 1.8v 1039.505n 1.8v 1049.495n 1.8v 1049.505n 1.8v 1059.495n 1.8v 1059.505n 1.8v 1069.495n 1.8v 1069.505n 1.8v 1079.495n 1.8v 1079.505n 0.0v 1089.495n 0.0v 1089.505n 0.0v 1099.495n 0.0v 1099.505n 0.0v 1109.495n 0.0v 1109.505n 0.0v 1119.495n 0.0v 1119.505n 0.0v 1129.495n 0.0v 1129.505n 0.0v 1139.495n 0.0v 1139.505n 0.0v 1149.495n 0.0v 1149.505n 0.0v 1159.495n 0.0v 1159.505n 0.0v 1169.495n 0.0v 1169.505n 0.0v 1179.495n 0.0v 1179.505n 0.0v 1189.495n 0.0v 1189.505n 0.0v 1199.495n 0.0v 1199.505n 0.0v 1209.495n 0.0v 1209.505n 0.0v 1219.495n 0.0v 1219.505n 0.0v 1229.495n 0.0v 1229.505n 0.0v 1239.495n 0.0v 1239.505n 0.0v 1249.495n 0.0v 1249.505n 0.0v 1259.495n 0.0v 1259.505n 1.8v 1269.495n 1.8v 1269.505n 1.8v 1279.495n 1.8v 1279.505n 0.0v 1289.495n 0.0v 1289.505n 0.0v 1299.495n 0.0v 1299.505n 0.0v 1309.495n 0.0v 1309.505n 0.0v 1319.495n 0.0v 1319.505n 0.0v 1329.495n 0.0v 1329.505n 0.0v 1339.495n 0.0v 1339.505n 0.0v 1349.495n 0.0v 1349.505n 0.0v 1359.495n 0.0v 1359.505n 0.0v 1369.495n 0.0v 1369.505n 1.8v 1379.495n 1.8v 1379.505n 1.8v 1389.495n 1.8v 1389.505n 1.8v 1399.495n 1.8v 1399.505n 1.8v 1409.495n 1.8v 1409.505n 1.8v 1419.495n 1.8v 1419.505n 1.8v 1429.495n 1.8v 1429.505n 0.0v 1439.495n 0.0v 1439.505n 0.0v 1449.495n 0.0v 1449.505n 0.0v 1459.495n 0.0v 1459.505n 0.0v 1469.495n 0.0v 1469.505n 0.0v 1479.495n 0.0v 1479.505n 0.0v 1489.495n 0.0v 1489.505n 0.0v 1499.495n 0.0v 1499.505n 1.8v 1509.495n 1.8v 1509.505n 1.8v 1519.495n 1.8v 1519.505n 1.8v 1529.495n 1.8v 1529.505n 1.8v 1539.495n 1.8v 1539.505n 1.8v 1549.495n 1.8v 1549.505n 1.8v 1559.495n 1.8v 1559.505n 1.8v 1569.495n 1.8v 1569.505n 1.8v 1579.495n 1.8v 1579.505n 0.0v 1589.495n 0.0v 1589.505n 0.0v 1599.495n 0.0v 1599.505n 0.0v 1609.495n 0.0v 1609.505n 0.0v 1619.495n 0.0v 1619.505n 0.0v 1629.495n 0.0v 1629.505n 0.0v 1639.495n 0.0v 1639.505n 0.0v 1649.495n 0.0v 1649.505n 0.0v 1659.495n 0.0v 1659.505n 0.0v 1669.495n 0.0v 1669.505n 0.0v 1679.495n 0.0v 1679.505n 0.0v 1689.495n 0.0v 1689.505n 0.0v 1699.495n 0.0v 1699.505n 0.0v 1709.495n 0.0v 1709.505n 1.8v 1719.495n 1.8v 1719.505n 1.8v 1729.495n 1.8v 1729.505n 1.8v 1739.495n 1.8v 1739.505n 0.0v 1749.495n 0.0v 1749.505n 0.0v 1759.495n 0.0v 1759.505n 0.0v 1769.495n 0.0v 1769.505n 0.0v 1779.495n 0.0v 1779.505n 0.0v 1789.495n 0.0v 1789.505n 1.8v 1799.495n 1.8v 1799.505n 1.8v 1809.495n 1.8v 1809.505n 1.8v 1819.495n 1.8v 1819.505n 1.8v 1829.495n 1.8v 1829.505n 1.8v 1839.495n 1.8v 1839.505n 1.8v 1849.495n 1.8v 1849.505n 0.0v 1859.495n 0.0v 1859.505n 1.8v 1869.495n 1.8v 1869.505n 1.8v 1879.495n 1.8v 1879.505n 0.0v 1889.495n 0.0v 1889.505n 0.0v 1899.495n 0.0v 1899.505n 0.0v 1909.495n 0.0v 1909.505n 1.8v 1919.495n 1.8v 1919.505n 1.8v 1929.495n 1.8v 1929.505n 1.8v 1939.495n 1.8v 1939.505n 1.8v 1949.495n 1.8v 1949.505n 1.8v 1959.495n 1.8v 1959.505n 1.8v 1969.495n 1.8v 1969.505n 1.8v 1979.495n 1.8v 1979.505n 1.8v 1989.495n 1.8v 1989.505n 1.8v 1999.495n 1.8v 1999.505n 1.8v 2009.495n 1.8v 2009.505n 1.8v 2019.495n 1.8v 2019.505n 1.8v 2029.495n 1.8v 2029.505n 0.0v 2039.495n 0.0v 2039.505n 0.0v 2049.495n 0.0v 2049.505n 0.0v )
* (time, data): [(0, 0), (10, 1), (20, 1), (30, 0), (40, 0), (50, 0), (60, 0), (70, 0), (80, 0), (90, 0), (100, 0), (110, 0), (120, 0), (130, 0), (140, 0), (150, 0), (160, 0), (170, 0), (180, 0), (190, 0), (200, 0), (210, 0), (220, 0), (230, 0), (240, 0), (250, 0), (260, 0), (270, 0), (280, 0), (290, 0), (300, 0), (310, 0), (320, 0), (330, 0), (340, 0), (350, 0), (360, 0), (370, 0), (380, 0), (390, 0), (400, 0), (410, 0), (420, 0), (430, 0), (440, 0), (450, 0), (460, 0), (470, 0), (480, 0), (490, 0), (500, 0), (510, 0), (520, 0), (530, 0), (540, 0), (550, 0), (560, 0), (570, 0), (580, 0), (590, 0), (600, 0), (610, 0), (620, 1), (630, 1), (640, 1), (650, 1), (660, 0), (670, 0), (680, 0), (690, 0), (700, 0), (710, 0), (720, 0), (730, 0), (740, 0), (750, 0), (760, 0), (770, 0), (780, 0), (790, 0), (800, 0), (810, 0), (820, 1), (830, 1), (840, 1), (850, 1), (860, 1), (870, 1), (880, 1), (890, 1), (900, 1), (910, 1), (920, 1), (930, 0), (940, 0), (950, 0), (960, 1), (970, 1), (980, 1), (990, 1), (1000, 1), (1010, 1), (1020, 1), (1030, 1), (1040, 1), (1050, 1), (1060, 1), (1070, 1), (1080, 0), (1090, 0), (1100, 0), (1110, 0), (1120, 0), (1130, 0), (1140, 0), (1150, 0), (1160, 0), (1170, 0), (1180, 0), (1190, 0), (1200, 0), (1210, 0), (1220, 0), (1230, 0), (1240, 0), (1250, 0), (1260, 1), (1270, 1), (1280, 0), (1290, 0), (1300, 0), (1310, 0), (1320, 0), (1330, 0), (1340, 0), (1350, 0), (1360, 0), (1370, 1), (1380, 1), (1390, 1), (1400, 0), (1410, 0), (1420, 0), (1430, 0), (1440, 0), (1450, 0), (1460, 0), (1470, 0), (1480, 0), (1490, 0), (1500, 0), (1510, 0), (1520, 0), (1530, 0), (1540, 0), (1550, 0), (1560, 0), (1570, 0), (1580, 0), (1590, 0), (1600, 0), (1610, 0), (1620, 1), (1630, 1), (1640, 1), (1650, 1), (1660, 1), (1670, 1), (1680, 1), (1690, 0), (1700, 0), (1710, 1), (1720, 1), (1730, 0), (1740, 1), (1750, 1), (1760, 1), (1770, 1), (1780, 1), (1790, 1), (1800, 1), (1810, 1), (1820, 1), (1830, 1), (1840, 1), (1850, 1), (1860, 1), (1870, 1), (1880, 0), (1890, 0), (1900, 0), (1910, 1), (1920, 1), (1930, 1), (1940, 1), (1950, 1), (1960, 1), (1970, 1), (1980, 1), (1990, 1), (2000, 1), (2010, 1), (2020, 1), (2030, 0), (2040, 0), (2050, 0)]
Vdin0_38  din0_38  0 PWL (0n 0.0v 9.495n 0.0v 9.505n 1.8v 19.495n 1.8v 19.505n 1.8v 29.495n 1.8v 29.505n 0.0v 39.495n 0.0v 39.505n 0.0v 49.495n 0.0v 49.505n 0.0v 59.495n 0.0v 59.505n 0.0v 69.495n 0.0v 69.505n 0.0v 79.495n 0.0v 79.505n 0.0v 89.495n 0.0v 89.505n 0.0v 99.495n 0.0v 99.505n 0.0v 109.495n 0.0v 109.505n 0.0v 119.495n 0.0v 119.505n 0.0v 129.495n 0.0v 129.505n 0.0v 139.495n 0.0v 139.505n 0.0v 149.495n 0.0v 149.505n 0.0v 159.495n 0.0v 159.505n 0.0v 169.495n 0.0v 169.505n 0.0v 179.495n 0.0v 179.505n 0.0v 189.495n 0.0v 189.505n 0.0v 199.495n 0.0v 199.505n 0.0v 209.495n 0.0v 209.505n 0.0v 219.495n 0.0v 219.505n 0.0v 229.495n 0.0v 229.505n 0.0v 239.495n 0.0v 239.505n 0.0v 249.495n 0.0v 249.505n 0.0v 259.495n 0.0v 259.505n 0.0v 269.495n 0.0v 269.505n 0.0v 279.495n 0.0v 279.505n 0.0v 289.495n 0.0v 289.505n 0.0v 299.495n 0.0v 299.505n 0.0v 309.495n 0.0v 309.505n 0.0v 319.495n 0.0v 319.505n 0.0v 329.495n 0.0v 329.505n 0.0v 339.495n 0.0v 339.505n 0.0v 349.495n 0.0v 349.505n 0.0v 359.495n 0.0v 359.505n 0.0v 369.495n 0.0v 369.505n 0.0v 379.495n 0.0v 379.505n 0.0v 389.495n 0.0v 389.505n 0.0v 399.495n 0.0v 399.505n 0.0v 409.495n 0.0v 409.505n 0.0v 419.495n 0.0v 419.505n 0.0v 429.495n 0.0v 429.505n 0.0v 439.495n 0.0v 439.505n 0.0v 449.495n 0.0v 449.505n 0.0v 459.495n 0.0v 459.505n 0.0v 469.495n 0.0v 469.505n 0.0v 479.495n 0.0v 479.505n 0.0v 489.495n 0.0v 489.505n 0.0v 499.495n 0.0v 499.505n 0.0v 509.495n 0.0v 509.505n 0.0v 519.495n 0.0v 519.505n 0.0v 529.495n 0.0v 529.505n 0.0v 539.495n 0.0v 539.505n 0.0v 549.495n 0.0v 549.505n 0.0v 559.495n 0.0v 559.505n 0.0v 569.495n 0.0v 569.505n 0.0v 579.495n 0.0v 579.505n 0.0v 589.495n 0.0v 589.505n 0.0v 599.495n 0.0v 599.505n 0.0v 609.495n 0.0v 609.505n 0.0v 619.495n 0.0v 619.505n 1.8v 629.495n 1.8v 629.505n 1.8v 639.495n 1.8v 639.505n 1.8v 649.495n 1.8v 649.505n 1.8v 659.495n 1.8v 659.505n 0.0v 669.495n 0.0v 669.505n 0.0v 679.495n 0.0v 679.505n 0.0v 689.495n 0.0v 689.505n 0.0v 699.495n 0.0v 699.505n 0.0v 709.495n 0.0v 709.505n 0.0v 719.495n 0.0v 719.505n 0.0v 729.495n 0.0v 729.505n 0.0v 739.495n 0.0v 739.505n 0.0v 749.495n 0.0v 749.505n 0.0v 759.495n 0.0v 759.505n 0.0v 769.495n 0.0v 769.505n 0.0v 779.495n 0.0v 779.505n 0.0v 789.495n 0.0v 789.505n 0.0v 799.495n 0.0v 799.505n 0.0v 809.495n 0.0v 809.505n 0.0v 819.495n 0.0v 819.505n 1.8v 829.495n 1.8v 829.505n 1.8v 839.495n 1.8v 839.505n 1.8v 849.495n 1.8v 849.505n 1.8v 859.495n 1.8v 859.505n 1.8v 869.495n 1.8v 869.505n 1.8v 879.495n 1.8v 879.505n 1.8v 889.495n 1.8v 889.505n 1.8v 899.495n 1.8v 899.505n 1.8v 909.495n 1.8v 909.505n 1.8v 919.495n 1.8v 919.505n 1.8v 929.495n 1.8v 929.505n 0.0v 939.495n 0.0v 939.505n 0.0v 949.495n 0.0v 949.505n 0.0v 959.495n 0.0v 959.505n 1.8v 969.495n 1.8v 969.505n 1.8v 979.495n 1.8v 979.505n 1.8v 989.495n 1.8v 989.505n 1.8v 999.495n 1.8v 999.505n 1.8v 1009.495n 1.8v 1009.505n 1.8v 1019.495n 1.8v 1019.505n 1.8v 1029.495n 1.8v 1029.505n 1.8v 1039.495n 1.8v 1039.505n 1.8v 1049.495n 1.8v 1049.505n 1.8v 1059.495n 1.8v 1059.505n 1.8v 1069.495n 1.8v 1069.505n 1.8v 1079.495n 1.8v 1079.505n 0.0v 1089.495n 0.0v 1089.505n 0.0v 1099.495n 0.0v 1099.505n 0.0v 1109.495n 0.0v 1109.505n 0.0v 1119.495n 0.0v 1119.505n 0.0v 1129.495n 0.0v 1129.505n 0.0v 1139.495n 0.0v 1139.505n 0.0v 1149.495n 0.0v 1149.505n 0.0v 1159.495n 0.0v 1159.505n 0.0v 1169.495n 0.0v 1169.505n 0.0v 1179.495n 0.0v 1179.505n 0.0v 1189.495n 0.0v 1189.505n 0.0v 1199.495n 0.0v 1199.505n 0.0v 1209.495n 0.0v 1209.505n 0.0v 1219.495n 0.0v 1219.505n 0.0v 1229.495n 0.0v 1229.505n 0.0v 1239.495n 0.0v 1239.505n 0.0v 1249.495n 0.0v 1249.505n 0.0v 1259.495n 0.0v 1259.505n 1.8v 1269.495n 1.8v 1269.505n 1.8v 1279.495n 1.8v 1279.505n 0.0v 1289.495n 0.0v 1289.505n 0.0v 1299.495n 0.0v 1299.505n 0.0v 1309.495n 0.0v 1309.505n 0.0v 1319.495n 0.0v 1319.505n 0.0v 1329.495n 0.0v 1329.505n 0.0v 1339.495n 0.0v 1339.505n 0.0v 1349.495n 0.0v 1349.505n 0.0v 1359.495n 0.0v 1359.505n 0.0v 1369.495n 0.0v 1369.505n 1.8v 1379.495n 1.8v 1379.505n 1.8v 1389.495n 1.8v 1389.505n 1.8v 1399.495n 1.8v 1399.505n 0.0v 1409.495n 0.0v 1409.505n 0.0v 1419.495n 0.0v 1419.505n 0.0v 1429.495n 0.0v 1429.505n 0.0v 1439.495n 0.0v 1439.505n 0.0v 1449.495n 0.0v 1449.505n 0.0v 1459.495n 0.0v 1459.505n 0.0v 1469.495n 0.0v 1469.505n 0.0v 1479.495n 0.0v 1479.505n 0.0v 1489.495n 0.0v 1489.505n 0.0v 1499.495n 0.0v 1499.505n 0.0v 1509.495n 0.0v 1509.505n 0.0v 1519.495n 0.0v 1519.505n 0.0v 1529.495n 0.0v 1529.505n 0.0v 1539.495n 0.0v 1539.505n 0.0v 1549.495n 0.0v 1549.505n 0.0v 1559.495n 0.0v 1559.505n 0.0v 1569.495n 0.0v 1569.505n 0.0v 1579.495n 0.0v 1579.505n 0.0v 1589.495n 0.0v 1589.505n 0.0v 1599.495n 0.0v 1599.505n 0.0v 1609.495n 0.0v 1609.505n 0.0v 1619.495n 0.0v 1619.505n 1.8v 1629.495n 1.8v 1629.505n 1.8v 1639.495n 1.8v 1639.505n 1.8v 1649.495n 1.8v 1649.505n 1.8v 1659.495n 1.8v 1659.505n 1.8v 1669.495n 1.8v 1669.505n 1.8v 1679.495n 1.8v 1679.505n 1.8v 1689.495n 1.8v 1689.505n 0.0v 1699.495n 0.0v 1699.505n 0.0v 1709.495n 0.0v 1709.505n 1.8v 1719.495n 1.8v 1719.505n 1.8v 1729.495n 1.8v 1729.505n 0.0v 1739.495n 0.0v 1739.505n 1.8v 1749.495n 1.8v 1749.505n 1.8v 1759.495n 1.8v 1759.505n 1.8v 1769.495n 1.8v 1769.505n 1.8v 1779.495n 1.8v 1779.505n 1.8v 1789.495n 1.8v 1789.505n 1.8v 1799.495n 1.8v 1799.505n 1.8v 1809.495n 1.8v 1809.505n 1.8v 1819.495n 1.8v 1819.505n 1.8v 1829.495n 1.8v 1829.505n 1.8v 1839.495n 1.8v 1839.505n 1.8v 1849.495n 1.8v 1849.505n 1.8v 1859.495n 1.8v 1859.505n 1.8v 1869.495n 1.8v 1869.505n 1.8v 1879.495n 1.8v 1879.505n 0.0v 1889.495n 0.0v 1889.505n 0.0v 1899.495n 0.0v 1899.505n 0.0v 1909.495n 0.0v 1909.505n 1.8v 1919.495n 1.8v 1919.505n 1.8v 1929.495n 1.8v 1929.505n 1.8v 1939.495n 1.8v 1939.505n 1.8v 1949.495n 1.8v 1949.505n 1.8v 1959.495n 1.8v 1959.505n 1.8v 1969.495n 1.8v 1969.505n 1.8v 1979.495n 1.8v 1979.505n 1.8v 1989.495n 1.8v 1989.505n 1.8v 1999.495n 1.8v 1999.505n 1.8v 2009.495n 1.8v 2009.505n 1.8v 2019.495n 1.8v 2019.505n 1.8v 2029.495n 1.8v 2029.505n 0.0v 2039.495n 0.0v 2039.505n 0.0v 2049.495n 0.0v 2049.505n 0.0v )
* (time, data): [(0, 0), (10, 0), (20, 1), (30, 0), (40, 0), (50, 0), (60, 0), (70, 0), (80, 0), (90, 0), (100, 0), (110, 0), (120, 0), (130, 0), (140, 0), (150, 0), (160, 0), (170, 0), (180, 0), (190, 0), (200, 0), (210, 0), (220, 0), (230, 0), (240, 0), (250, 0), (260, 0), (270, 0), (280, 0), (290, 0), (300, 0), (310, 0), (320, 0), (330, 0), (340, 0), (350, 0), (360, 0), (370, 0), (380, 0), (390, 1), (400, 1), (410, 1), (420, 0), (430, 0), (440, 0), (450, 0), (460, 0), (470, 1), (480, 1), (490, 0), (500, 0), (510, 0), (520, 0), (530, 0), (540, 0), (550, 0), (560, 0), (570, 0), (580, 0), (590, 0), (600, 0), (610, 0), (620, 1), (630, 1), (640, 1), (650, 1), (660, 1), (670, 1), (680, 1), (690, 1), (700, 1), (710, 1), (720, 1), (730, 1), (740, 1), (750, 1), (760, 1), (770, 0), (780, 0), (790, 0), (800, 0), (810, 0), (820, 0), (830, 0), (840, 1), (850, 1), (860, 1), (870, 1), (880, 1), (890, 1), (900, 1), (910, 1), (920, 1), (930, 0), (940, 0), (950, 0), (960, 0), (970, 0), (980, 0), (990, 0), (1000, 0), (1010, 0), (1020, 0), (1030, 0), (1040, 0), (1050, 0), (1060, 0), (1070, 0), (1080, 0), (1090, 0), (1100, 0), (1110, 0), (1120, 0), (1130, 1), (1140, 1), (1150, 1), (1160, 1), (1170, 1), (1180, 1), (1190, 1), (1200, 1), (1210, 1), (1220, 1), (1230, 1), (1240, 1), (1250, 1), (1260, 0), (1270, 0), (1280, 1), (1290, 1), (1300, 1), (1310, 1), (1320, 1), (1330, 1), (1340, 1), (1350, 1), (1360, 1), (1370, 0), (1380, 0), (1390, 0), (1400, 0), (1410, 0), (1420, 0), (1430, 0), (1440, 0), (1450, 0), (1460, 0), (1470, 0), (1480, 1), (1490, 1), (1500, 0), (1510, 0), (1520, 0), (1530, 0), (1540, 0), (1550, 0), (1560, 0), (1570, 1), (1580, 0), (1590, 0), (1600, 0), (1610, 0), (1620, 0), (1630, 0), (1640, 0), (1650, 0), (1660, 0), (1670, 0), (1680, 0), (1690, 0), (1700, 0), (1710, 0), (1720, 0), (1730, 1), (1740, 1), (1750, 1), (1760, 1), (1770, 1), (1780, 1), (1790, 0), (1800, 0), (1810, 0), (1820, 0), (1830, 0), (1840, 0), (1850, 1), (1860, 0), (1870, 0), (1880, 0), (1890, 0), (1900, 0), (1910, 0), (1920, 0), (1930, 0), (1940, 0), (1950, 0), (1960, 0), (1970, 0), (1980, 0), (1990, 0), (2000, 0), (2010, 0), (2020, 0), (2030, 0), (2040, 0), (2050, 0)]
Vdin0_39  din0_39  0 PWL (0n 0.0v 9.495n 0.0v 9.505n 0.0v 19.495n 0.0v 19.505n 1.8v 29.495n 1.8v 29.505n 0.0v 39.495n 0.0v 39.505n 0.0v 49.495n 0.0v 49.505n 0.0v 59.495n 0.0v 59.505n 0.0v 69.495n 0.0v 69.505n 0.0v 79.495n 0.0v 79.505n 0.0v 89.495n 0.0v 89.505n 0.0v 99.495n 0.0v 99.505n 0.0v 109.495n 0.0v 109.505n 0.0v 119.495n 0.0v 119.505n 0.0v 129.495n 0.0v 129.505n 0.0v 139.495n 0.0v 139.505n 0.0v 149.495n 0.0v 149.505n 0.0v 159.495n 0.0v 159.505n 0.0v 169.495n 0.0v 169.505n 0.0v 179.495n 0.0v 179.505n 0.0v 189.495n 0.0v 189.505n 0.0v 199.495n 0.0v 199.505n 0.0v 209.495n 0.0v 209.505n 0.0v 219.495n 0.0v 219.505n 0.0v 229.495n 0.0v 229.505n 0.0v 239.495n 0.0v 239.505n 0.0v 249.495n 0.0v 249.505n 0.0v 259.495n 0.0v 259.505n 0.0v 269.495n 0.0v 269.505n 0.0v 279.495n 0.0v 279.505n 0.0v 289.495n 0.0v 289.505n 0.0v 299.495n 0.0v 299.505n 0.0v 309.495n 0.0v 309.505n 0.0v 319.495n 0.0v 319.505n 0.0v 329.495n 0.0v 329.505n 0.0v 339.495n 0.0v 339.505n 0.0v 349.495n 0.0v 349.505n 0.0v 359.495n 0.0v 359.505n 0.0v 369.495n 0.0v 369.505n 0.0v 379.495n 0.0v 379.505n 0.0v 389.495n 0.0v 389.505n 1.8v 399.495n 1.8v 399.505n 1.8v 409.495n 1.8v 409.505n 1.8v 419.495n 1.8v 419.505n 0.0v 429.495n 0.0v 429.505n 0.0v 439.495n 0.0v 439.505n 0.0v 449.495n 0.0v 449.505n 0.0v 459.495n 0.0v 459.505n 0.0v 469.495n 0.0v 469.505n 1.8v 479.495n 1.8v 479.505n 1.8v 489.495n 1.8v 489.505n 0.0v 499.495n 0.0v 499.505n 0.0v 509.495n 0.0v 509.505n 0.0v 519.495n 0.0v 519.505n 0.0v 529.495n 0.0v 529.505n 0.0v 539.495n 0.0v 539.505n 0.0v 549.495n 0.0v 549.505n 0.0v 559.495n 0.0v 559.505n 0.0v 569.495n 0.0v 569.505n 0.0v 579.495n 0.0v 579.505n 0.0v 589.495n 0.0v 589.505n 0.0v 599.495n 0.0v 599.505n 0.0v 609.495n 0.0v 609.505n 0.0v 619.495n 0.0v 619.505n 1.8v 629.495n 1.8v 629.505n 1.8v 639.495n 1.8v 639.505n 1.8v 649.495n 1.8v 649.505n 1.8v 659.495n 1.8v 659.505n 1.8v 669.495n 1.8v 669.505n 1.8v 679.495n 1.8v 679.505n 1.8v 689.495n 1.8v 689.505n 1.8v 699.495n 1.8v 699.505n 1.8v 709.495n 1.8v 709.505n 1.8v 719.495n 1.8v 719.505n 1.8v 729.495n 1.8v 729.505n 1.8v 739.495n 1.8v 739.505n 1.8v 749.495n 1.8v 749.505n 1.8v 759.495n 1.8v 759.505n 1.8v 769.495n 1.8v 769.505n 0.0v 779.495n 0.0v 779.505n 0.0v 789.495n 0.0v 789.505n 0.0v 799.495n 0.0v 799.505n 0.0v 809.495n 0.0v 809.505n 0.0v 819.495n 0.0v 819.505n 0.0v 829.495n 0.0v 829.505n 0.0v 839.495n 0.0v 839.505n 1.8v 849.495n 1.8v 849.505n 1.8v 859.495n 1.8v 859.505n 1.8v 869.495n 1.8v 869.505n 1.8v 879.495n 1.8v 879.505n 1.8v 889.495n 1.8v 889.505n 1.8v 899.495n 1.8v 899.505n 1.8v 909.495n 1.8v 909.505n 1.8v 919.495n 1.8v 919.505n 1.8v 929.495n 1.8v 929.505n 0.0v 939.495n 0.0v 939.505n 0.0v 949.495n 0.0v 949.505n 0.0v 959.495n 0.0v 959.505n 0.0v 969.495n 0.0v 969.505n 0.0v 979.495n 0.0v 979.505n 0.0v 989.495n 0.0v 989.505n 0.0v 999.495n 0.0v 999.505n 0.0v 1009.495n 0.0v 1009.505n 0.0v 1019.495n 0.0v 1019.505n 0.0v 1029.495n 0.0v 1029.505n 0.0v 1039.495n 0.0v 1039.505n 0.0v 1049.495n 0.0v 1049.505n 0.0v 1059.495n 0.0v 1059.505n 0.0v 1069.495n 0.0v 1069.505n 0.0v 1079.495n 0.0v 1079.505n 0.0v 1089.495n 0.0v 1089.505n 0.0v 1099.495n 0.0v 1099.505n 0.0v 1109.495n 0.0v 1109.505n 0.0v 1119.495n 0.0v 1119.505n 0.0v 1129.495n 0.0v 1129.505n 1.8v 1139.495n 1.8v 1139.505n 1.8v 1149.495n 1.8v 1149.505n 1.8v 1159.495n 1.8v 1159.505n 1.8v 1169.495n 1.8v 1169.505n 1.8v 1179.495n 1.8v 1179.505n 1.8v 1189.495n 1.8v 1189.505n 1.8v 1199.495n 1.8v 1199.505n 1.8v 1209.495n 1.8v 1209.505n 1.8v 1219.495n 1.8v 1219.505n 1.8v 1229.495n 1.8v 1229.505n 1.8v 1239.495n 1.8v 1239.505n 1.8v 1249.495n 1.8v 1249.505n 1.8v 1259.495n 1.8v 1259.505n 0.0v 1269.495n 0.0v 1269.505n 0.0v 1279.495n 0.0v 1279.505n 1.8v 1289.495n 1.8v 1289.505n 1.8v 1299.495n 1.8v 1299.505n 1.8v 1309.495n 1.8v 1309.505n 1.8v 1319.495n 1.8v 1319.505n 1.8v 1329.495n 1.8v 1329.505n 1.8v 1339.495n 1.8v 1339.505n 1.8v 1349.495n 1.8v 1349.505n 1.8v 1359.495n 1.8v 1359.505n 1.8v 1369.495n 1.8v 1369.505n 0.0v 1379.495n 0.0v 1379.505n 0.0v 1389.495n 0.0v 1389.505n 0.0v 1399.495n 0.0v 1399.505n 0.0v 1409.495n 0.0v 1409.505n 0.0v 1419.495n 0.0v 1419.505n 0.0v 1429.495n 0.0v 1429.505n 0.0v 1439.495n 0.0v 1439.505n 0.0v 1449.495n 0.0v 1449.505n 0.0v 1459.495n 0.0v 1459.505n 0.0v 1469.495n 0.0v 1469.505n 0.0v 1479.495n 0.0v 1479.505n 1.8v 1489.495n 1.8v 1489.505n 1.8v 1499.495n 1.8v 1499.505n 0.0v 1509.495n 0.0v 1509.505n 0.0v 1519.495n 0.0v 1519.505n 0.0v 1529.495n 0.0v 1529.505n 0.0v 1539.495n 0.0v 1539.505n 0.0v 1549.495n 0.0v 1549.505n 0.0v 1559.495n 0.0v 1559.505n 0.0v 1569.495n 0.0v 1569.505n 1.8v 1579.495n 1.8v 1579.505n 0.0v 1589.495n 0.0v 1589.505n 0.0v 1599.495n 0.0v 1599.505n 0.0v 1609.495n 0.0v 1609.505n 0.0v 1619.495n 0.0v 1619.505n 0.0v 1629.495n 0.0v 1629.505n 0.0v 1639.495n 0.0v 1639.505n 0.0v 1649.495n 0.0v 1649.505n 0.0v 1659.495n 0.0v 1659.505n 0.0v 1669.495n 0.0v 1669.505n 0.0v 1679.495n 0.0v 1679.505n 0.0v 1689.495n 0.0v 1689.505n 0.0v 1699.495n 0.0v 1699.505n 0.0v 1709.495n 0.0v 1709.505n 0.0v 1719.495n 0.0v 1719.505n 0.0v 1729.495n 0.0v 1729.505n 1.8v 1739.495n 1.8v 1739.505n 1.8v 1749.495n 1.8v 1749.505n 1.8v 1759.495n 1.8v 1759.505n 1.8v 1769.495n 1.8v 1769.505n 1.8v 1779.495n 1.8v 1779.505n 1.8v 1789.495n 1.8v 1789.505n 0.0v 1799.495n 0.0v 1799.505n 0.0v 1809.495n 0.0v 1809.505n 0.0v 1819.495n 0.0v 1819.505n 0.0v 1829.495n 0.0v 1829.505n 0.0v 1839.495n 0.0v 1839.505n 0.0v 1849.495n 0.0v 1849.505n 1.8v 1859.495n 1.8v 1859.505n 0.0v 1869.495n 0.0v 1869.505n 0.0v 1879.495n 0.0v 1879.505n 0.0v 1889.495n 0.0v 1889.505n 0.0v 1899.495n 0.0v 1899.505n 0.0v 1909.495n 0.0v 1909.505n 0.0v 1919.495n 0.0v 1919.505n 0.0v 1929.495n 0.0v 1929.505n 0.0v 1939.495n 0.0v 1939.505n 0.0v 1949.495n 0.0v 1949.505n 0.0v 1959.495n 0.0v 1959.505n 0.0v 1969.495n 0.0v 1969.505n 0.0v 1979.495n 0.0v 1979.505n 0.0v 1989.495n 0.0v 1989.505n 0.0v 1999.495n 0.0v 1999.505n 0.0v 2009.495n 0.0v 2009.505n 0.0v 2019.495n 0.0v 2019.505n 0.0v 2029.495n 0.0v 2029.505n 0.0v 2039.495n 0.0v 2039.505n 0.0v 2049.495n 0.0v 2049.505n 0.0v )
* (time, data): [(0, 0), (10, 1), (20, 0), (30, 0), (40, 0), (50, 0), (60, 1), (70, 1), (80, 1), (90, 1), (100, 1), (110, 1), (120, 1), (130, 1), (140, 1), (150, 0), (160, 0), (170, 0), (180, 0), (190, 0), (200, 0), (210, 0), (220, 0), (230, 0), (240, 0), (250, 0), (260, 0), (270, 0), (280, 0), (290, 0), (300, 0), (310, 0), (320, 0), (330, 0), (340, 0), (350, 0), (360, 0), (370, 0), (380, 0), (390, 0), (400, 0), (410, 0), (420, 0), (430, 0), (440, 0), (450, 1), (460, 1), (470, 0), (480, 0), (490, 0), (500, 1), (510, 1), (520, 1), (530, 1), (540, 1), (550, 1), (560, 1), (570, 1), (580, 1), (590, 1), (600, 1), (610, 1), (620, 1), (630, 1), (640, 1), (650, 1), (660, 1), (670, 0), (680, 0), (690, 0), (700, 0), (710, 0), (720, 0), (730, 0), (740, 0), (750, 0), (760, 0), (770, 0), (780, 0), (790, 0), (800, 0), (810, 0), (820, 0), (830, 0), (840, 0), (850, 0), (860, 0), (870, 0), (880, 0), (890, 1), (900, 1), (910, 1), (920, 1), (930, 1), (940, 1), (950, 1), (960, 0), (970, 0), (980, 0), (990, 0), (1000, 0), (1010, 0), (1020, 0), (1030, 0), (1040, 0), (1050, 0), (1060, 0), (1070, 0), (1080, 1), (1090, 1), (1100, 1), (1110, 1), (1120, 1), (1130, 1), (1140, 1), (1150, 1), (1160, 1), (1170, 1), (1180, 1), (1190, 1), (1200, 1), (1210, 1), (1220, 1), (1230, 1), (1240, 1), (1250, 1), (1260, 0), (1270, 0), (1280, 0), (1290, 0), (1300, 0), (1310, 0), (1320, 0), (1330, 0), (1340, 0), (1350, 0), (1360, 0), (1370, 1), (1380, 1), (1390, 1), (1400, 0), (1410, 0), (1420, 0), (1430, 1), (1440, 1), (1450, 1), (1460, 1), (1470, 1), (1480, 1), (1490, 1), (1500, 1), (1510, 1), (1520, 1), (1530, 1), (1540, 1), (1550, 1), (1560, 1), (1570, 1), (1580, 1), (1590, 1), (1600, 1), (1610, 1), (1620, 1), (1630, 1), (1640, 1), (1650, 1), (1660, 1), (1670, 1), (1680, 1), (1690, 0), (1700, 0), (1710, 1), (1720, 1), (1730, 0), (1740, 0), (1750, 0), (1760, 0), (1770, 0), (1780, 0), (1790, 1), (1800, 1), (1810, 1), (1820, 1), (1830, 1), (1840, 1), (1850, 0), (1860, 0), (1870, 1), (1880, 1), (1890, 0), (1900, 0), (1910, 0), (1920, 0), (1930, 0), (1940, 0), (1950, 0), (1960, 0), (1970, 0), (1980, 0), (1990, 0), (2000, 0), (2010, 0), (2020, 0), (2030, 0), (2040, 0), (2050, 0)]
Vdin0_40  din0_40  0 PWL (0n 0.0v 9.495n 0.0v 9.505n 1.8v 19.495n 1.8v 19.505n 0.0v 29.495n 0.0v 29.505n 0.0v 39.495n 0.0v 39.505n 0.0v 49.495n 0.0v 49.505n 0.0v 59.495n 0.0v 59.505n 1.8v 69.495n 1.8v 69.505n 1.8v 79.495n 1.8v 79.505n 1.8v 89.495n 1.8v 89.505n 1.8v 99.495n 1.8v 99.505n 1.8v 109.495n 1.8v 109.505n 1.8v 119.495n 1.8v 119.505n 1.8v 129.495n 1.8v 129.505n 1.8v 139.495n 1.8v 139.505n 1.8v 149.495n 1.8v 149.505n 0.0v 159.495n 0.0v 159.505n 0.0v 169.495n 0.0v 169.505n 0.0v 179.495n 0.0v 179.505n 0.0v 189.495n 0.0v 189.505n 0.0v 199.495n 0.0v 199.505n 0.0v 209.495n 0.0v 209.505n 0.0v 219.495n 0.0v 219.505n 0.0v 229.495n 0.0v 229.505n 0.0v 239.495n 0.0v 239.505n 0.0v 249.495n 0.0v 249.505n 0.0v 259.495n 0.0v 259.505n 0.0v 269.495n 0.0v 269.505n 0.0v 279.495n 0.0v 279.505n 0.0v 289.495n 0.0v 289.505n 0.0v 299.495n 0.0v 299.505n 0.0v 309.495n 0.0v 309.505n 0.0v 319.495n 0.0v 319.505n 0.0v 329.495n 0.0v 329.505n 0.0v 339.495n 0.0v 339.505n 0.0v 349.495n 0.0v 349.505n 0.0v 359.495n 0.0v 359.505n 0.0v 369.495n 0.0v 369.505n 0.0v 379.495n 0.0v 379.505n 0.0v 389.495n 0.0v 389.505n 0.0v 399.495n 0.0v 399.505n 0.0v 409.495n 0.0v 409.505n 0.0v 419.495n 0.0v 419.505n 0.0v 429.495n 0.0v 429.505n 0.0v 439.495n 0.0v 439.505n 0.0v 449.495n 0.0v 449.505n 1.8v 459.495n 1.8v 459.505n 1.8v 469.495n 1.8v 469.505n 0.0v 479.495n 0.0v 479.505n 0.0v 489.495n 0.0v 489.505n 0.0v 499.495n 0.0v 499.505n 1.8v 509.495n 1.8v 509.505n 1.8v 519.495n 1.8v 519.505n 1.8v 529.495n 1.8v 529.505n 1.8v 539.495n 1.8v 539.505n 1.8v 549.495n 1.8v 549.505n 1.8v 559.495n 1.8v 559.505n 1.8v 569.495n 1.8v 569.505n 1.8v 579.495n 1.8v 579.505n 1.8v 589.495n 1.8v 589.505n 1.8v 599.495n 1.8v 599.505n 1.8v 609.495n 1.8v 609.505n 1.8v 619.495n 1.8v 619.505n 1.8v 629.495n 1.8v 629.505n 1.8v 639.495n 1.8v 639.505n 1.8v 649.495n 1.8v 649.505n 1.8v 659.495n 1.8v 659.505n 1.8v 669.495n 1.8v 669.505n 0.0v 679.495n 0.0v 679.505n 0.0v 689.495n 0.0v 689.505n 0.0v 699.495n 0.0v 699.505n 0.0v 709.495n 0.0v 709.505n 0.0v 719.495n 0.0v 719.505n 0.0v 729.495n 0.0v 729.505n 0.0v 739.495n 0.0v 739.505n 0.0v 749.495n 0.0v 749.505n 0.0v 759.495n 0.0v 759.505n 0.0v 769.495n 0.0v 769.505n 0.0v 779.495n 0.0v 779.505n 0.0v 789.495n 0.0v 789.505n 0.0v 799.495n 0.0v 799.505n 0.0v 809.495n 0.0v 809.505n 0.0v 819.495n 0.0v 819.505n 0.0v 829.495n 0.0v 829.505n 0.0v 839.495n 0.0v 839.505n 0.0v 849.495n 0.0v 849.505n 0.0v 859.495n 0.0v 859.505n 0.0v 869.495n 0.0v 869.505n 0.0v 879.495n 0.0v 879.505n 0.0v 889.495n 0.0v 889.505n 1.8v 899.495n 1.8v 899.505n 1.8v 909.495n 1.8v 909.505n 1.8v 919.495n 1.8v 919.505n 1.8v 929.495n 1.8v 929.505n 1.8v 939.495n 1.8v 939.505n 1.8v 949.495n 1.8v 949.505n 1.8v 959.495n 1.8v 959.505n 0.0v 969.495n 0.0v 969.505n 0.0v 979.495n 0.0v 979.505n 0.0v 989.495n 0.0v 989.505n 0.0v 999.495n 0.0v 999.505n 0.0v 1009.495n 0.0v 1009.505n 0.0v 1019.495n 0.0v 1019.505n 0.0v 1029.495n 0.0v 1029.505n 0.0v 1039.495n 0.0v 1039.505n 0.0v 1049.495n 0.0v 1049.505n 0.0v 1059.495n 0.0v 1059.505n 0.0v 1069.495n 0.0v 1069.505n 0.0v 1079.495n 0.0v 1079.505n 1.8v 1089.495n 1.8v 1089.505n 1.8v 1099.495n 1.8v 1099.505n 1.8v 1109.495n 1.8v 1109.505n 1.8v 1119.495n 1.8v 1119.505n 1.8v 1129.495n 1.8v 1129.505n 1.8v 1139.495n 1.8v 1139.505n 1.8v 1149.495n 1.8v 1149.505n 1.8v 1159.495n 1.8v 1159.505n 1.8v 1169.495n 1.8v 1169.505n 1.8v 1179.495n 1.8v 1179.505n 1.8v 1189.495n 1.8v 1189.505n 1.8v 1199.495n 1.8v 1199.505n 1.8v 1209.495n 1.8v 1209.505n 1.8v 1219.495n 1.8v 1219.505n 1.8v 1229.495n 1.8v 1229.505n 1.8v 1239.495n 1.8v 1239.505n 1.8v 1249.495n 1.8v 1249.505n 1.8v 1259.495n 1.8v 1259.505n 0.0v 1269.495n 0.0v 1269.505n 0.0v 1279.495n 0.0v 1279.505n 0.0v 1289.495n 0.0v 1289.505n 0.0v 1299.495n 0.0v 1299.505n 0.0v 1309.495n 0.0v 1309.505n 0.0v 1319.495n 0.0v 1319.505n 0.0v 1329.495n 0.0v 1329.505n 0.0v 1339.495n 0.0v 1339.505n 0.0v 1349.495n 0.0v 1349.505n 0.0v 1359.495n 0.0v 1359.505n 0.0v 1369.495n 0.0v 1369.505n 1.8v 1379.495n 1.8v 1379.505n 1.8v 1389.495n 1.8v 1389.505n 1.8v 1399.495n 1.8v 1399.505n 0.0v 1409.495n 0.0v 1409.505n 0.0v 1419.495n 0.0v 1419.505n 0.0v 1429.495n 0.0v 1429.505n 1.8v 1439.495n 1.8v 1439.505n 1.8v 1449.495n 1.8v 1449.505n 1.8v 1459.495n 1.8v 1459.505n 1.8v 1469.495n 1.8v 1469.505n 1.8v 1479.495n 1.8v 1479.505n 1.8v 1489.495n 1.8v 1489.505n 1.8v 1499.495n 1.8v 1499.505n 1.8v 1509.495n 1.8v 1509.505n 1.8v 1519.495n 1.8v 1519.505n 1.8v 1529.495n 1.8v 1529.505n 1.8v 1539.495n 1.8v 1539.505n 1.8v 1549.495n 1.8v 1549.505n 1.8v 1559.495n 1.8v 1559.505n 1.8v 1569.495n 1.8v 1569.505n 1.8v 1579.495n 1.8v 1579.505n 1.8v 1589.495n 1.8v 1589.505n 1.8v 1599.495n 1.8v 1599.505n 1.8v 1609.495n 1.8v 1609.505n 1.8v 1619.495n 1.8v 1619.505n 1.8v 1629.495n 1.8v 1629.505n 1.8v 1639.495n 1.8v 1639.505n 1.8v 1649.495n 1.8v 1649.505n 1.8v 1659.495n 1.8v 1659.505n 1.8v 1669.495n 1.8v 1669.505n 1.8v 1679.495n 1.8v 1679.505n 1.8v 1689.495n 1.8v 1689.505n 0.0v 1699.495n 0.0v 1699.505n 0.0v 1709.495n 0.0v 1709.505n 1.8v 1719.495n 1.8v 1719.505n 1.8v 1729.495n 1.8v 1729.505n 0.0v 1739.495n 0.0v 1739.505n 0.0v 1749.495n 0.0v 1749.505n 0.0v 1759.495n 0.0v 1759.505n 0.0v 1769.495n 0.0v 1769.505n 0.0v 1779.495n 0.0v 1779.505n 0.0v 1789.495n 0.0v 1789.505n 1.8v 1799.495n 1.8v 1799.505n 1.8v 1809.495n 1.8v 1809.505n 1.8v 1819.495n 1.8v 1819.505n 1.8v 1829.495n 1.8v 1829.505n 1.8v 1839.495n 1.8v 1839.505n 1.8v 1849.495n 1.8v 1849.505n 0.0v 1859.495n 0.0v 1859.505n 0.0v 1869.495n 0.0v 1869.505n 1.8v 1879.495n 1.8v 1879.505n 1.8v 1889.495n 1.8v 1889.505n 0.0v 1899.495n 0.0v 1899.505n 0.0v 1909.495n 0.0v 1909.505n 0.0v 1919.495n 0.0v 1919.505n 0.0v 1929.495n 0.0v 1929.505n 0.0v 1939.495n 0.0v 1939.505n 0.0v 1949.495n 0.0v 1949.505n 0.0v 1959.495n 0.0v 1959.505n 0.0v 1969.495n 0.0v 1969.505n 0.0v 1979.495n 0.0v 1979.505n 0.0v 1989.495n 0.0v 1989.505n 0.0v 1999.495n 0.0v 1999.505n 0.0v 2009.495n 0.0v 2009.505n 0.0v 2019.495n 0.0v 2019.505n 0.0v 2029.495n 0.0v 2029.505n 0.0v 2039.495n 0.0v 2039.505n 0.0v 2049.495n 0.0v 2049.505n 0.0v )
* (time, data): [(0, 0), (10, 1), (20, 0), (30, 0), (40, 0), (50, 0), (60, 0), (70, 0), (80, 0), (90, 0), (100, 0), (110, 0), (120, 0), (130, 0), (140, 0), (150, 0), (160, 0), (170, 0), (180, 0), (190, 0), (200, 0), (210, 0), (220, 0), (230, 0), (240, 0), (250, 0), (260, 0), (270, 0), (280, 0), (290, 0), (300, 0), (310, 0), (320, 0), (330, 0), (340, 0), (350, 0), (360, 0), (370, 0), (380, 0), (390, 0), (400, 0), (410, 0), (420, 1), (430, 1), (440, 1), (450, 1), (460, 1), (470, 1), (480, 1), (490, 1), (500, 1), (510, 1), (520, 1), (530, 1), (540, 1), (550, 1), (560, 1), (570, 1), (580, 1), (590, 1), (600, 1), (610, 1), (620, 1), (630, 1), (640, 1), (650, 1), (660, 1), (670, 0), (680, 0), (690, 0), (700, 0), (710, 1), (720, 1), (730, 1), (740, 1), (750, 1), (760, 1), (770, 1), (780, 1), (790, 1), (800, 1), (810, 1), (820, 0), (830, 0), (840, 1), (850, 1), (860, 1), (870, 1), (880, 1), (890, 1), (900, 1), (910, 1), (920, 1), (930, 1), (940, 1), (950, 1), (960, 1), (970, 1), (980, 1), (990, 1), (1000, 1), (1010, 1), (1020, 1), (1030, 1), (1040, 1), (1050, 1), (1060, 1), (1070, 1), (1080, 0), (1090, 0), (1100, 0), (1110, 0), (1120, 0), (1130, 0), (1140, 0), (1150, 0), (1160, 0), (1170, 0), (1180, 0), (1190, 0), (1200, 0), (1210, 0), (1220, 0), (1230, 0), (1240, 0), (1250, 0), (1260, 0), (1270, 0), (1280, 0), (1290, 0), (1300, 0), (1310, 0), (1320, 0), (1330, 0), (1340, 0), (1350, 0), (1360, 0), (1370, 1), (1380, 1), (1390, 1), (1400, 0), (1410, 0), (1420, 0), (1430, 0), (1440, 0), (1450, 0), (1460, 0), (1470, 0), (1480, 0), (1490, 0), (1500, 1), (1510, 1), (1520, 1), (1530, 1), (1540, 1), (1550, 1), (1560, 1), (1570, 1), (1580, 1), (1590, 0), (1600, 0), (1610, 0), (1620, 0), (1630, 0), (1640, 0), (1650, 0), (1660, 0), (1670, 0), (1680, 0), (1690, 0), (1700, 0), (1710, 0), (1720, 0), (1730, 1), (1740, 1), (1750, 1), (1760, 1), (1770, 1), (1780, 1), (1790, 1), (1800, 1), (1810, 1), (1820, 1), (1830, 1), (1840, 1), (1850, 0), (1860, 1), (1870, 0), (1880, 0), (1890, 1), (1900, 1), (1910, 1), (1920, 1), (1930, 1), (1940, 1), (1950, 1), (1960, 1), (1970, 1), (1980, 1), (1990, 1), (2000, 1), (2010, 1), (2020, 1), (2030, 0), (2040, 0), (2050, 0)]
Vdin0_41  din0_41  0 PWL (0n 0.0v 9.495n 0.0v 9.505n 1.8v 19.495n 1.8v 19.505n 0.0v 29.495n 0.0v 29.505n 0.0v 39.495n 0.0v 39.505n 0.0v 49.495n 0.0v 49.505n 0.0v 59.495n 0.0v 59.505n 0.0v 69.495n 0.0v 69.505n 0.0v 79.495n 0.0v 79.505n 0.0v 89.495n 0.0v 89.505n 0.0v 99.495n 0.0v 99.505n 0.0v 109.495n 0.0v 109.505n 0.0v 119.495n 0.0v 119.505n 0.0v 129.495n 0.0v 129.505n 0.0v 139.495n 0.0v 139.505n 0.0v 149.495n 0.0v 149.505n 0.0v 159.495n 0.0v 159.505n 0.0v 169.495n 0.0v 169.505n 0.0v 179.495n 0.0v 179.505n 0.0v 189.495n 0.0v 189.505n 0.0v 199.495n 0.0v 199.505n 0.0v 209.495n 0.0v 209.505n 0.0v 219.495n 0.0v 219.505n 0.0v 229.495n 0.0v 229.505n 0.0v 239.495n 0.0v 239.505n 0.0v 249.495n 0.0v 249.505n 0.0v 259.495n 0.0v 259.505n 0.0v 269.495n 0.0v 269.505n 0.0v 279.495n 0.0v 279.505n 0.0v 289.495n 0.0v 289.505n 0.0v 299.495n 0.0v 299.505n 0.0v 309.495n 0.0v 309.505n 0.0v 319.495n 0.0v 319.505n 0.0v 329.495n 0.0v 329.505n 0.0v 339.495n 0.0v 339.505n 0.0v 349.495n 0.0v 349.505n 0.0v 359.495n 0.0v 359.505n 0.0v 369.495n 0.0v 369.505n 0.0v 379.495n 0.0v 379.505n 0.0v 389.495n 0.0v 389.505n 0.0v 399.495n 0.0v 399.505n 0.0v 409.495n 0.0v 409.505n 0.0v 419.495n 0.0v 419.505n 1.8v 429.495n 1.8v 429.505n 1.8v 439.495n 1.8v 439.505n 1.8v 449.495n 1.8v 449.505n 1.8v 459.495n 1.8v 459.505n 1.8v 469.495n 1.8v 469.505n 1.8v 479.495n 1.8v 479.505n 1.8v 489.495n 1.8v 489.505n 1.8v 499.495n 1.8v 499.505n 1.8v 509.495n 1.8v 509.505n 1.8v 519.495n 1.8v 519.505n 1.8v 529.495n 1.8v 529.505n 1.8v 539.495n 1.8v 539.505n 1.8v 549.495n 1.8v 549.505n 1.8v 559.495n 1.8v 559.505n 1.8v 569.495n 1.8v 569.505n 1.8v 579.495n 1.8v 579.505n 1.8v 589.495n 1.8v 589.505n 1.8v 599.495n 1.8v 599.505n 1.8v 609.495n 1.8v 609.505n 1.8v 619.495n 1.8v 619.505n 1.8v 629.495n 1.8v 629.505n 1.8v 639.495n 1.8v 639.505n 1.8v 649.495n 1.8v 649.505n 1.8v 659.495n 1.8v 659.505n 1.8v 669.495n 1.8v 669.505n 0.0v 679.495n 0.0v 679.505n 0.0v 689.495n 0.0v 689.505n 0.0v 699.495n 0.0v 699.505n 0.0v 709.495n 0.0v 709.505n 1.8v 719.495n 1.8v 719.505n 1.8v 729.495n 1.8v 729.505n 1.8v 739.495n 1.8v 739.505n 1.8v 749.495n 1.8v 749.505n 1.8v 759.495n 1.8v 759.505n 1.8v 769.495n 1.8v 769.505n 1.8v 779.495n 1.8v 779.505n 1.8v 789.495n 1.8v 789.505n 1.8v 799.495n 1.8v 799.505n 1.8v 809.495n 1.8v 809.505n 1.8v 819.495n 1.8v 819.505n 0.0v 829.495n 0.0v 829.505n 0.0v 839.495n 0.0v 839.505n 1.8v 849.495n 1.8v 849.505n 1.8v 859.495n 1.8v 859.505n 1.8v 869.495n 1.8v 869.505n 1.8v 879.495n 1.8v 879.505n 1.8v 889.495n 1.8v 889.505n 1.8v 899.495n 1.8v 899.505n 1.8v 909.495n 1.8v 909.505n 1.8v 919.495n 1.8v 919.505n 1.8v 929.495n 1.8v 929.505n 1.8v 939.495n 1.8v 939.505n 1.8v 949.495n 1.8v 949.505n 1.8v 959.495n 1.8v 959.505n 1.8v 969.495n 1.8v 969.505n 1.8v 979.495n 1.8v 979.505n 1.8v 989.495n 1.8v 989.505n 1.8v 999.495n 1.8v 999.505n 1.8v 1009.495n 1.8v 1009.505n 1.8v 1019.495n 1.8v 1019.505n 1.8v 1029.495n 1.8v 1029.505n 1.8v 1039.495n 1.8v 1039.505n 1.8v 1049.495n 1.8v 1049.505n 1.8v 1059.495n 1.8v 1059.505n 1.8v 1069.495n 1.8v 1069.505n 1.8v 1079.495n 1.8v 1079.505n 0.0v 1089.495n 0.0v 1089.505n 0.0v 1099.495n 0.0v 1099.505n 0.0v 1109.495n 0.0v 1109.505n 0.0v 1119.495n 0.0v 1119.505n 0.0v 1129.495n 0.0v 1129.505n 0.0v 1139.495n 0.0v 1139.505n 0.0v 1149.495n 0.0v 1149.505n 0.0v 1159.495n 0.0v 1159.505n 0.0v 1169.495n 0.0v 1169.505n 0.0v 1179.495n 0.0v 1179.505n 0.0v 1189.495n 0.0v 1189.505n 0.0v 1199.495n 0.0v 1199.505n 0.0v 1209.495n 0.0v 1209.505n 0.0v 1219.495n 0.0v 1219.505n 0.0v 1229.495n 0.0v 1229.505n 0.0v 1239.495n 0.0v 1239.505n 0.0v 1249.495n 0.0v 1249.505n 0.0v 1259.495n 0.0v 1259.505n 0.0v 1269.495n 0.0v 1269.505n 0.0v 1279.495n 0.0v 1279.505n 0.0v 1289.495n 0.0v 1289.505n 0.0v 1299.495n 0.0v 1299.505n 0.0v 1309.495n 0.0v 1309.505n 0.0v 1319.495n 0.0v 1319.505n 0.0v 1329.495n 0.0v 1329.505n 0.0v 1339.495n 0.0v 1339.505n 0.0v 1349.495n 0.0v 1349.505n 0.0v 1359.495n 0.0v 1359.505n 0.0v 1369.495n 0.0v 1369.505n 1.8v 1379.495n 1.8v 1379.505n 1.8v 1389.495n 1.8v 1389.505n 1.8v 1399.495n 1.8v 1399.505n 0.0v 1409.495n 0.0v 1409.505n 0.0v 1419.495n 0.0v 1419.505n 0.0v 1429.495n 0.0v 1429.505n 0.0v 1439.495n 0.0v 1439.505n 0.0v 1449.495n 0.0v 1449.505n 0.0v 1459.495n 0.0v 1459.505n 0.0v 1469.495n 0.0v 1469.505n 0.0v 1479.495n 0.0v 1479.505n 0.0v 1489.495n 0.0v 1489.505n 0.0v 1499.495n 0.0v 1499.505n 1.8v 1509.495n 1.8v 1509.505n 1.8v 1519.495n 1.8v 1519.505n 1.8v 1529.495n 1.8v 1529.505n 1.8v 1539.495n 1.8v 1539.505n 1.8v 1549.495n 1.8v 1549.505n 1.8v 1559.495n 1.8v 1559.505n 1.8v 1569.495n 1.8v 1569.505n 1.8v 1579.495n 1.8v 1579.505n 1.8v 1589.495n 1.8v 1589.505n 0.0v 1599.495n 0.0v 1599.505n 0.0v 1609.495n 0.0v 1609.505n 0.0v 1619.495n 0.0v 1619.505n 0.0v 1629.495n 0.0v 1629.505n 0.0v 1639.495n 0.0v 1639.505n 0.0v 1649.495n 0.0v 1649.505n 0.0v 1659.495n 0.0v 1659.505n 0.0v 1669.495n 0.0v 1669.505n 0.0v 1679.495n 0.0v 1679.505n 0.0v 1689.495n 0.0v 1689.505n 0.0v 1699.495n 0.0v 1699.505n 0.0v 1709.495n 0.0v 1709.505n 0.0v 1719.495n 0.0v 1719.505n 0.0v 1729.495n 0.0v 1729.505n 1.8v 1739.495n 1.8v 1739.505n 1.8v 1749.495n 1.8v 1749.505n 1.8v 1759.495n 1.8v 1759.505n 1.8v 1769.495n 1.8v 1769.505n 1.8v 1779.495n 1.8v 1779.505n 1.8v 1789.495n 1.8v 1789.505n 1.8v 1799.495n 1.8v 1799.505n 1.8v 1809.495n 1.8v 1809.505n 1.8v 1819.495n 1.8v 1819.505n 1.8v 1829.495n 1.8v 1829.505n 1.8v 1839.495n 1.8v 1839.505n 1.8v 1849.495n 1.8v 1849.505n 0.0v 1859.495n 0.0v 1859.505n 1.8v 1869.495n 1.8v 1869.505n 0.0v 1879.495n 0.0v 1879.505n 0.0v 1889.495n 0.0v 1889.505n 1.8v 1899.495n 1.8v 1899.505n 1.8v 1909.495n 1.8v 1909.505n 1.8v 1919.495n 1.8v 1919.505n 1.8v 1929.495n 1.8v 1929.505n 1.8v 1939.495n 1.8v 1939.505n 1.8v 1949.495n 1.8v 1949.505n 1.8v 1959.495n 1.8v 1959.505n 1.8v 1969.495n 1.8v 1969.505n 1.8v 1979.495n 1.8v 1979.505n 1.8v 1989.495n 1.8v 1989.505n 1.8v 1999.495n 1.8v 1999.505n 1.8v 2009.495n 1.8v 2009.505n 1.8v 2019.495n 1.8v 2019.505n 1.8v 2029.495n 1.8v 2029.505n 0.0v 2039.495n 0.0v 2039.505n 0.0v 2049.495n 0.0v 2049.505n 0.0v )
* (time, data): [(0, 0), (10, 0), (20, 0), (30, 0), (40, 0), (50, 0), (60, 0), (70, 0), (80, 0), (90, 0), (100, 0), (110, 0), (120, 0), (130, 0), (140, 0), (150, 1), (160, 1), (170, 1), (180, 1), (190, 1), (200, 1), (210, 1), (220, 1), (230, 1), (240, 1), (250, 1), (260, 0), (270, 0), (280, 0), (290, 0), (300, 0), (310, 0), (320, 0), (330, 0), (340, 0), (350, 1), (360, 1), (370, 1), (380, 1), (390, 0), (400, 1), (410, 1), (420, 1), (430, 1), (440, 1), (450, 0), (460, 0), (470, 0), (480, 0), (490, 0), (500, 1), (510, 1), (520, 1), (530, 1), (540, 1), (550, 1), (560, 1), (570, 1), (580, 1), (590, 1), (600, 1), (610, 1), (620, 1), (630, 1), (640, 1), (650, 1), (660, 0), (670, 1), (680, 1), (690, 1), (700, 1), (710, 1), (720, 1), (730, 1), (740, 1), (750, 1), (760, 1), (770, 0), (780, 0), (790, 0), (800, 0), (810, 0), (820, 1), (830, 1), (840, 0), (850, 0), (860, 0), (870, 0), (880, 0), (890, 1), (900, 1), (910, 1), (920, 1), (930, 0), (940, 0), (950, 0), (960, 1), (970, 1), (980, 1), (990, 1), (1000, 1), (1010, 1), (1020, 1), (1030, 1), (1040, 1), (1050, 1), (1060, 1), (1070, 1), (1080, 0), (1090, 0), (1100, 0), (1110, 0), (1120, 0), (1130, 0), (1140, 0), (1150, 0), (1160, 0), (1170, 0), (1180, 0), (1190, 0), (1200, 0), (1210, 0), (1220, 0), (1230, 0), (1240, 0), (1250, 0), (1260, 0), (1270, 0), (1280, 0), (1290, 0), (1300, 0), (1310, 0), (1320, 0), (1330, 0), (1340, 0), (1350, 0), (1360, 0), (1370, 1), (1380, 1), (1390, 1), (1400, 1), (1410, 1), (1420, 1), (1430, 0), (1440, 0), (1450, 0), (1460, 0), (1470, 0), (1480, 1), (1490, 1), (1500, 0), (1510, 0), (1520, 0), (1530, 0), (1540, 0), (1550, 0), (1560, 0), (1570, 0), (1580, 0), (1590, 1), (1600, 1), (1610, 1), (1620, 0), (1630, 0), (1640, 0), (1650, 0), (1660, 0), (1670, 0), (1680, 0), (1690, 0), (1700, 0), (1710, 1), (1720, 1), (1730, 0), (1740, 1), (1750, 1), (1760, 1), (1770, 1), (1780, 1), (1790, 0), (1800, 0), (1810, 0), (1820, 0), (1830, 0), (1840, 0), (1850, 1), (1860, 0), (1870, 1), (1880, 1), (1890, 1), (1900, 1), (1910, 1), (1920, 1), (1930, 1), (1940, 1), (1950, 1), (1960, 1), (1970, 1), (1980, 1), (1990, 1), (2000, 1), (2010, 1), (2020, 1), (2030, 0), (2040, 0), (2050, 0)]
Vdin0_42  din0_42  0 PWL (0n 0.0v 9.495n 0.0v 9.505n 0.0v 19.495n 0.0v 19.505n 0.0v 29.495n 0.0v 29.505n 0.0v 39.495n 0.0v 39.505n 0.0v 49.495n 0.0v 49.505n 0.0v 59.495n 0.0v 59.505n 0.0v 69.495n 0.0v 69.505n 0.0v 79.495n 0.0v 79.505n 0.0v 89.495n 0.0v 89.505n 0.0v 99.495n 0.0v 99.505n 0.0v 109.495n 0.0v 109.505n 0.0v 119.495n 0.0v 119.505n 0.0v 129.495n 0.0v 129.505n 0.0v 139.495n 0.0v 139.505n 0.0v 149.495n 0.0v 149.505n 1.8v 159.495n 1.8v 159.505n 1.8v 169.495n 1.8v 169.505n 1.8v 179.495n 1.8v 179.505n 1.8v 189.495n 1.8v 189.505n 1.8v 199.495n 1.8v 199.505n 1.8v 209.495n 1.8v 209.505n 1.8v 219.495n 1.8v 219.505n 1.8v 229.495n 1.8v 229.505n 1.8v 239.495n 1.8v 239.505n 1.8v 249.495n 1.8v 249.505n 1.8v 259.495n 1.8v 259.505n 0.0v 269.495n 0.0v 269.505n 0.0v 279.495n 0.0v 279.505n 0.0v 289.495n 0.0v 289.505n 0.0v 299.495n 0.0v 299.505n 0.0v 309.495n 0.0v 309.505n 0.0v 319.495n 0.0v 319.505n 0.0v 329.495n 0.0v 329.505n 0.0v 339.495n 0.0v 339.505n 0.0v 349.495n 0.0v 349.505n 1.8v 359.495n 1.8v 359.505n 1.8v 369.495n 1.8v 369.505n 1.8v 379.495n 1.8v 379.505n 1.8v 389.495n 1.8v 389.505n 0.0v 399.495n 0.0v 399.505n 1.8v 409.495n 1.8v 409.505n 1.8v 419.495n 1.8v 419.505n 1.8v 429.495n 1.8v 429.505n 1.8v 439.495n 1.8v 439.505n 1.8v 449.495n 1.8v 449.505n 0.0v 459.495n 0.0v 459.505n 0.0v 469.495n 0.0v 469.505n 0.0v 479.495n 0.0v 479.505n 0.0v 489.495n 0.0v 489.505n 0.0v 499.495n 0.0v 499.505n 1.8v 509.495n 1.8v 509.505n 1.8v 519.495n 1.8v 519.505n 1.8v 529.495n 1.8v 529.505n 1.8v 539.495n 1.8v 539.505n 1.8v 549.495n 1.8v 549.505n 1.8v 559.495n 1.8v 559.505n 1.8v 569.495n 1.8v 569.505n 1.8v 579.495n 1.8v 579.505n 1.8v 589.495n 1.8v 589.505n 1.8v 599.495n 1.8v 599.505n 1.8v 609.495n 1.8v 609.505n 1.8v 619.495n 1.8v 619.505n 1.8v 629.495n 1.8v 629.505n 1.8v 639.495n 1.8v 639.505n 1.8v 649.495n 1.8v 649.505n 1.8v 659.495n 1.8v 659.505n 0.0v 669.495n 0.0v 669.505n 1.8v 679.495n 1.8v 679.505n 1.8v 689.495n 1.8v 689.505n 1.8v 699.495n 1.8v 699.505n 1.8v 709.495n 1.8v 709.505n 1.8v 719.495n 1.8v 719.505n 1.8v 729.495n 1.8v 729.505n 1.8v 739.495n 1.8v 739.505n 1.8v 749.495n 1.8v 749.505n 1.8v 759.495n 1.8v 759.505n 1.8v 769.495n 1.8v 769.505n 0.0v 779.495n 0.0v 779.505n 0.0v 789.495n 0.0v 789.505n 0.0v 799.495n 0.0v 799.505n 0.0v 809.495n 0.0v 809.505n 0.0v 819.495n 0.0v 819.505n 1.8v 829.495n 1.8v 829.505n 1.8v 839.495n 1.8v 839.505n 0.0v 849.495n 0.0v 849.505n 0.0v 859.495n 0.0v 859.505n 0.0v 869.495n 0.0v 869.505n 0.0v 879.495n 0.0v 879.505n 0.0v 889.495n 0.0v 889.505n 1.8v 899.495n 1.8v 899.505n 1.8v 909.495n 1.8v 909.505n 1.8v 919.495n 1.8v 919.505n 1.8v 929.495n 1.8v 929.505n 0.0v 939.495n 0.0v 939.505n 0.0v 949.495n 0.0v 949.505n 0.0v 959.495n 0.0v 959.505n 1.8v 969.495n 1.8v 969.505n 1.8v 979.495n 1.8v 979.505n 1.8v 989.495n 1.8v 989.505n 1.8v 999.495n 1.8v 999.505n 1.8v 1009.495n 1.8v 1009.505n 1.8v 1019.495n 1.8v 1019.505n 1.8v 1029.495n 1.8v 1029.505n 1.8v 1039.495n 1.8v 1039.505n 1.8v 1049.495n 1.8v 1049.505n 1.8v 1059.495n 1.8v 1059.505n 1.8v 1069.495n 1.8v 1069.505n 1.8v 1079.495n 1.8v 1079.505n 0.0v 1089.495n 0.0v 1089.505n 0.0v 1099.495n 0.0v 1099.505n 0.0v 1109.495n 0.0v 1109.505n 0.0v 1119.495n 0.0v 1119.505n 0.0v 1129.495n 0.0v 1129.505n 0.0v 1139.495n 0.0v 1139.505n 0.0v 1149.495n 0.0v 1149.505n 0.0v 1159.495n 0.0v 1159.505n 0.0v 1169.495n 0.0v 1169.505n 0.0v 1179.495n 0.0v 1179.505n 0.0v 1189.495n 0.0v 1189.505n 0.0v 1199.495n 0.0v 1199.505n 0.0v 1209.495n 0.0v 1209.505n 0.0v 1219.495n 0.0v 1219.505n 0.0v 1229.495n 0.0v 1229.505n 0.0v 1239.495n 0.0v 1239.505n 0.0v 1249.495n 0.0v 1249.505n 0.0v 1259.495n 0.0v 1259.505n 0.0v 1269.495n 0.0v 1269.505n 0.0v 1279.495n 0.0v 1279.505n 0.0v 1289.495n 0.0v 1289.505n 0.0v 1299.495n 0.0v 1299.505n 0.0v 1309.495n 0.0v 1309.505n 0.0v 1319.495n 0.0v 1319.505n 0.0v 1329.495n 0.0v 1329.505n 0.0v 1339.495n 0.0v 1339.505n 0.0v 1349.495n 0.0v 1349.505n 0.0v 1359.495n 0.0v 1359.505n 0.0v 1369.495n 0.0v 1369.505n 1.8v 1379.495n 1.8v 1379.505n 1.8v 1389.495n 1.8v 1389.505n 1.8v 1399.495n 1.8v 1399.505n 1.8v 1409.495n 1.8v 1409.505n 1.8v 1419.495n 1.8v 1419.505n 1.8v 1429.495n 1.8v 1429.505n 0.0v 1439.495n 0.0v 1439.505n 0.0v 1449.495n 0.0v 1449.505n 0.0v 1459.495n 0.0v 1459.505n 0.0v 1469.495n 0.0v 1469.505n 0.0v 1479.495n 0.0v 1479.505n 1.8v 1489.495n 1.8v 1489.505n 1.8v 1499.495n 1.8v 1499.505n 0.0v 1509.495n 0.0v 1509.505n 0.0v 1519.495n 0.0v 1519.505n 0.0v 1529.495n 0.0v 1529.505n 0.0v 1539.495n 0.0v 1539.505n 0.0v 1549.495n 0.0v 1549.505n 0.0v 1559.495n 0.0v 1559.505n 0.0v 1569.495n 0.0v 1569.505n 0.0v 1579.495n 0.0v 1579.505n 0.0v 1589.495n 0.0v 1589.505n 1.8v 1599.495n 1.8v 1599.505n 1.8v 1609.495n 1.8v 1609.505n 1.8v 1619.495n 1.8v 1619.505n 0.0v 1629.495n 0.0v 1629.505n 0.0v 1639.495n 0.0v 1639.505n 0.0v 1649.495n 0.0v 1649.505n 0.0v 1659.495n 0.0v 1659.505n 0.0v 1669.495n 0.0v 1669.505n 0.0v 1679.495n 0.0v 1679.505n 0.0v 1689.495n 0.0v 1689.505n 0.0v 1699.495n 0.0v 1699.505n 0.0v 1709.495n 0.0v 1709.505n 1.8v 1719.495n 1.8v 1719.505n 1.8v 1729.495n 1.8v 1729.505n 0.0v 1739.495n 0.0v 1739.505n 1.8v 1749.495n 1.8v 1749.505n 1.8v 1759.495n 1.8v 1759.505n 1.8v 1769.495n 1.8v 1769.505n 1.8v 1779.495n 1.8v 1779.505n 1.8v 1789.495n 1.8v 1789.505n 0.0v 1799.495n 0.0v 1799.505n 0.0v 1809.495n 0.0v 1809.505n 0.0v 1819.495n 0.0v 1819.505n 0.0v 1829.495n 0.0v 1829.505n 0.0v 1839.495n 0.0v 1839.505n 0.0v 1849.495n 0.0v 1849.505n 1.8v 1859.495n 1.8v 1859.505n 0.0v 1869.495n 0.0v 1869.505n 1.8v 1879.495n 1.8v 1879.505n 1.8v 1889.495n 1.8v 1889.505n 1.8v 1899.495n 1.8v 1899.505n 1.8v 1909.495n 1.8v 1909.505n 1.8v 1919.495n 1.8v 1919.505n 1.8v 1929.495n 1.8v 1929.505n 1.8v 1939.495n 1.8v 1939.505n 1.8v 1949.495n 1.8v 1949.505n 1.8v 1959.495n 1.8v 1959.505n 1.8v 1969.495n 1.8v 1969.505n 1.8v 1979.495n 1.8v 1979.505n 1.8v 1989.495n 1.8v 1989.505n 1.8v 1999.495n 1.8v 1999.505n 1.8v 2009.495n 1.8v 2009.505n 1.8v 2019.495n 1.8v 2019.505n 1.8v 2029.495n 1.8v 2029.505n 0.0v 2039.495n 0.0v 2039.505n 0.0v 2049.495n 0.0v 2049.505n 0.0v )
* (time, data): [(0, 0), (10, 1), (20, 0), (30, 1), (40, 1), (50, 1), (60, 1), (70, 1), (80, 1), (90, 1), (100, 1), (110, 1), (120, 1), (130, 1), (140, 1), (150, 0), (160, 0), (170, 0), (180, 0), (190, 0), (200, 0), (210, 0), (220, 0), (230, 0), (240, 0), (250, 0), (260, 0), (270, 0), (280, 0), (290, 0), (300, 0), (310, 0), (320, 0), (330, 0), (340, 0), (350, 1), (360, 1), (370, 1), (380, 1), (390, 1), (400, 1), (410, 1), (420, 1), (430, 1), (440, 1), (450, 1), (460, 1), (470, 0), (480, 0), (490, 0), (500, 1), (510, 1), (520, 1), (530, 1), (540, 1), (550, 1), (560, 1), (570, 1), (580, 1), (590, 1), (600, 1), (610, 1), (620, 1), (630, 1), (640, 1), (650, 1), (660, 0), (670, 0), (680, 0), (690, 0), (700, 0), (710, 0), (720, 0), (730, 0), (740, 0), (750, 0), (760, 0), (770, 0), (780, 0), (790, 0), (800, 0), (810, 0), (820, 1), (830, 1), (840, 1), (850, 1), (860, 1), (870, 1), (880, 1), (890, 1), (900, 1), (910, 1), (920, 1), (930, 1), (940, 1), (950, 1), (960, 0), (970, 0), (980, 0), (990, 0), (1000, 0), (1010, 0), (1020, 0), (1030, 0), (1040, 0), (1050, 0), (1060, 0), (1070, 0), (1080, 1), (1090, 1), (1100, 1), (1110, 1), (1120, 1), (1130, 0), (1140, 0), (1150, 0), (1160, 0), (1170, 0), (1180, 0), (1190, 0), (1200, 0), (1210, 0), (1220, 0), (1230, 0), (1240, 0), (1250, 0), (1260, 0), (1270, 0), (1280, 0), (1290, 0), (1300, 0), (1310, 0), (1320, 0), (1330, 0), (1340, 0), (1350, 0), (1360, 0), (1370, 1), (1380, 1), (1390, 1), (1400, 1), (1410, 1), (1420, 1), (1430, 0), (1440, 0), (1450, 0), (1460, 0), (1470, 0), (1480, 1), (1490, 1), (1500, 1), (1510, 1), (1520, 1), (1530, 1), (1540, 1), (1550, 1), (1560, 1), (1570, 1), (1580, 0), (1590, 0), (1600, 0), (1610, 0), (1620, 0), (1630, 0), (1640, 0), (1650, 0), (1660, 0), (1670, 0), (1680, 0), (1690, 1), (1700, 1), (1710, 1), (1720, 1), (1730, 1), (1740, 1), (1750, 1), (1760, 1), (1770, 1), (1780, 1), (1790, 1), (1800, 1), (1810, 1), (1820, 1), (1830, 1), (1840, 1), (1850, 0), (1860, 1), (1870, 0), (1880, 1), (1890, 0), (1900, 0), (1910, 0), (1920, 0), (1930, 0), (1940, 0), (1950, 0), (1960, 0), (1970, 0), (1980, 0), (1990, 0), (2000, 0), (2010, 0), (2020, 0), (2030, 1), (2040, 1), (2050, 1)]
Vdin0_43  din0_43  0 PWL (0n 0.0v 9.495n 0.0v 9.505n 1.8v 19.495n 1.8v 19.505n 0.0v 29.495n 0.0v 29.505n 1.8v 39.495n 1.8v 39.505n 1.8v 49.495n 1.8v 49.505n 1.8v 59.495n 1.8v 59.505n 1.8v 69.495n 1.8v 69.505n 1.8v 79.495n 1.8v 79.505n 1.8v 89.495n 1.8v 89.505n 1.8v 99.495n 1.8v 99.505n 1.8v 109.495n 1.8v 109.505n 1.8v 119.495n 1.8v 119.505n 1.8v 129.495n 1.8v 129.505n 1.8v 139.495n 1.8v 139.505n 1.8v 149.495n 1.8v 149.505n 0.0v 159.495n 0.0v 159.505n 0.0v 169.495n 0.0v 169.505n 0.0v 179.495n 0.0v 179.505n 0.0v 189.495n 0.0v 189.505n 0.0v 199.495n 0.0v 199.505n 0.0v 209.495n 0.0v 209.505n 0.0v 219.495n 0.0v 219.505n 0.0v 229.495n 0.0v 229.505n 0.0v 239.495n 0.0v 239.505n 0.0v 249.495n 0.0v 249.505n 0.0v 259.495n 0.0v 259.505n 0.0v 269.495n 0.0v 269.505n 0.0v 279.495n 0.0v 279.505n 0.0v 289.495n 0.0v 289.505n 0.0v 299.495n 0.0v 299.505n 0.0v 309.495n 0.0v 309.505n 0.0v 319.495n 0.0v 319.505n 0.0v 329.495n 0.0v 329.505n 0.0v 339.495n 0.0v 339.505n 0.0v 349.495n 0.0v 349.505n 1.8v 359.495n 1.8v 359.505n 1.8v 369.495n 1.8v 369.505n 1.8v 379.495n 1.8v 379.505n 1.8v 389.495n 1.8v 389.505n 1.8v 399.495n 1.8v 399.505n 1.8v 409.495n 1.8v 409.505n 1.8v 419.495n 1.8v 419.505n 1.8v 429.495n 1.8v 429.505n 1.8v 439.495n 1.8v 439.505n 1.8v 449.495n 1.8v 449.505n 1.8v 459.495n 1.8v 459.505n 1.8v 469.495n 1.8v 469.505n 0.0v 479.495n 0.0v 479.505n 0.0v 489.495n 0.0v 489.505n 0.0v 499.495n 0.0v 499.505n 1.8v 509.495n 1.8v 509.505n 1.8v 519.495n 1.8v 519.505n 1.8v 529.495n 1.8v 529.505n 1.8v 539.495n 1.8v 539.505n 1.8v 549.495n 1.8v 549.505n 1.8v 559.495n 1.8v 559.505n 1.8v 569.495n 1.8v 569.505n 1.8v 579.495n 1.8v 579.505n 1.8v 589.495n 1.8v 589.505n 1.8v 599.495n 1.8v 599.505n 1.8v 609.495n 1.8v 609.505n 1.8v 619.495n 1.8v 619.505n 1.8v 629.495n 1.8v 629.505n 1.8v 639.495n 1.8v 639.505n 1.8v 649.495n 1.8v 649.505n 1.8v 659.495n 1.8v 659.505n 0.0v 669.495n 0.0v 669.505n 0.0v 679.495n 0.0v 679.505n 0.0v 689.495n 0.0v 689.505n 0.0v 699.495n 0.0v 699.505n 0.0v 709.495n 0.0v 709.505n 0.0v 719.495n 0.0v 719.505n 0.0v 729.495n 0.0v 729.505n 0.0v 739.495n 0.0v 739.505n 0.0v 749.495n 0.0v 749.505n 0.0v 759.495n 0.0v 759.505n 0.0v 769.495n 0.0v 769.505n 0.0v 779.495n 0.0v 779.505n 0.0v 789.495n 0.0v 789.505n 0.0v 799.495n 0.0v 799.505n 0.0v 809.495n 0.0v 809.505n 0.0v 819.495n 0.0v 819.505n 1.8v 829.495n 1.8v 829.505n 1.8v 839.495n 1.8v 839.505n 1.8v 849.495n 1.8v 849.505n 1.8v 859.495n 1.8v 859.505n 1.8v 869.495n 1.8v 869.505n 1.8v 879.495n 1.8v 879.505n 1.8v 889.495n 1.8v 889.505n 1.8v 899.495n 1.8v 899.505n 1.8v 909.495n 1.8v 909.505n 1.8v 919.495n 1.8v 919.505n 1.8v 929.495n 1.8v 929.505n 1.8v 939.495n 1.8v 939.505n 1.8v 949.495n 1.8v 949.505n 1.8v 959.495n 1.8v 959.505n 0.0v 969.495n 0.0v 969.505n 0.0v 979.495n 0.0v 979.505n 0.0v 989.495n 0.0v 989.505n 0.0v 999.495n 0.0v 999.505n 0.0v 1009.495n 0.0v 1009.505n 0.0v 1019.495n 0.0v 1019.505n 0.0v 1029.495n 0.0v 1029.505n 0.0v 1039.495n 0.0v 1039.505n 0.0v 1049.495n 0.0v 1049.505n 0.0v 1059.495n 0.0v 1059.505n 0.0v 1069.495n 0.0v 1069.505n 0.0v 1079.495n 0.0v 1079.505n 1.8v 1089.495n 1.8v 1089.505n 1.8v 1099.495n 1.8v 1099.505n 1.8v 1109.495n 1.8v 1109.505n 1.8v 1119.495n 1.8v 1119.505n 1.8v 1129.495n 1.8v 1129.505n 0.0v 1139.495n 0.0v 1139.505n 0.0v 1149.495n 0.0v 1149.505n 0.0v 1159.495n 0.0v 1159.505n 0.0v 1169.495n 0.0v 1169.505n 0.0v 1179.495n 0.0v 1179.505n 0.0v 1189.495n 0.0v 1189.505n 0.0v 1199.495n 0.0v 1199.505n 0.0v 1209.495n 0.0v 1209.505n 0.0v 1219.495n 0.0v 1219.505n 0.0v 1229.495n 0.0v 1229.505n 0.0v 1239.495n 0.0v 1239.505n 0.0v 1249.495n 0.0v 1249.505n 0.0v 1259.495n 0.0v 1259.505n 0.0v 1269.495n 0.0v 1269.505n 0.0v 1279.495n 0.0v 1279.505n 0.0v 1289.495n 0.0v 1289.505n 0.0v 1299.495n 0.0v 1299.505n 0.0v 1309.495n 0.0v 1309.505n 0.0v 1319.495n 0.0v 1319.505n 0.0v 1329.495n 0.0v 1329.505n 0.0v 1339.495n 0.0v 1339.505n 0.0v 1349.495n 0.0v 1349.505n 0.0v 1359.495n 0.0v 1359.505n 0.0v 1369.495n 0.0v 1369.505n 1.8v 1379.495n 1.8v 1379.505n 1.8v 1389.495n 1.8v 1389.505n 1.8v 1399.495n 1.8v 1399.505n 1.8v 1409.495n 1.8v 1409.505n 1.8v 1419.495n 1.8v 1419.505n 1.8v 1429.495n 1.8v 1429.505n 0.0v 1439.495n 0.0v 1439.505n 0.0v 1449.495n 0.0v 1449.505n 0.0v 1459.495n 0.0v 1459.505n 0.0v 1469.495n 0.0v 1469.505n 0.0v 1479.495n 0.0v 1479.505n 1.8v 1489.495n 1.8v 1489.505n 1.8v 1499.495n 1.8v 1499.505n 1.8v 1509.495n 1.8v 1509.505n 1.8v 1519.495n 1.8v 1519.505n 1.8v 1529.495n 1.8v 1529.505n 1.8v 1539.495n 1.8v 1539.505n 1.8v 1549.495n 1.8v 1549.505n 1.8v 1559.495n 1.8v 1559.505n 1.8v 1569.495n 1.8v 1569.505n 1.8v 1579.495n 1.8v 1579.505n 0.0v 1589.495n 0.0v 1589.505n 0.0v 1599.495n 0.0v 1599.505n 0.0v 1609.495n 0.0v 1609.505n 0.0v 1619.495n 0.0v 1619.505n 0.0v 1629.495n 0.0v 1629.505n 0.0v 1639.495n 0.0v 1639.505n 0.0v 1649.495n 0.0v 1649.505n 0.0v 1659.495n 0.0v 1659.505n 0.0v 1669.495n 0.0v 1669.505n 0.0v 1679.495n 0.0v 1679.505n 0.0v 1689.495n 0.0v 1689.505n 1.8v 1699.495n 1.8v 1699.505n 1.8v 1709.495n 1.8v 1709.505n 1.8v 1719.495n 1.8v 1719.505n 1.8v 1729.495n 1.8v 1729.505n 1.8v 1739.495n 1.8v 1739.505n 1.8v 1749.495n 1.8v 1749.505n 1.8v 1759.495n 1.8v 1759.505n 1.8v 1769.495n 1.8v 1769.505n 1.8v 1779.495n 1.8v 1779.505n 1.8v 1789.495n 1.8v 1789.505n 1.8v 1799.495n 1.8v 1799.505n 1.8v 1809.495n 1.8v 1809.505n 1.8v 1819.495n 1.8v 1819.505n 1.8v 1829.495n 1.8v 1829.505n 1.8v 1839.495n 1.8v 1839.505n 1.8v 1849.495n 1.8v 1849.505n 0.0v 1859.495n 0.0v 1859.505n 1.8v 1869.495n 1.8v 1869.505n 0.0v 1879.495n 0.0v 1879.505n 1.8v 1889.495n 1.8v 1889.505n 0.0v 1899.495n 0.0v 1899.505n 0.0v 1909.495n 0.0v 1909.505n 0.0v 1919.495n 0.0v 1919.505n 0.0v 1929.495n 0.0v 1929.505n 0.0v 1939.495n 0.0v 1939.505n 0.0v 1949.495n 0.0v 1949.505n 0.0v 1959.495n 0.0v 1959.505n 0.0v 1969.495n 0.0v 1969.505n 0.0v 1979.495n 0.0v 1979.505n 0.0v 1989.495n 0.0v 1989.505n 0.0v 1999.495n 0.0v 1999.505n 0.0v 2009.495n 0.0v 2009.505n 0.0v 2019.495n 0.0v 2019.505n 0.0v 2029.495n 0.0v 2029.505n 1.8v 2039.495n 1.8v 2039.505n 1.8v 2049.495n 1.8v 2049.505n 1.8v )
* (time, data): [(0, 0), (10, 1), (20, 1), (30, 1), (40, 1), (50, 1), (60, 0), (70, 0), (80, 0), (90, 0), (100, 0), (110, 0), (120, 0), (130, 0), (140, 0), (150, 1), (160, 1), (170, 1), (180, 1), (190, 1), (200, 1), (210, 1), (220, 1), (230, 1), (240, 1), (250, 1), (260, 0), (270, 0), (280, 0), (290, 0), (300, 0), (310, 0), (320, 0), (330, 0), (340, 0), (350, 0), (360, 0), (370, 0), (380, 0), (390, 0), (400, 1), (410, 1), (420, 0), (430, 0), (440, 0), (450, 1), (460, 1), (470, 1), (480, 1), (490, 0), (500, 0), (510, 0), (520, 0), (530, 0), (540, 0), (550, 0), (560, 0), (570, 0), (580, 0), (590, 0), (600, 0), (610, 0), (620, 1), (630, 1), (640, 1), (650, 1), (660, 1), (670, 0), (680, 0), (690, 0), (700, 0), (710, 1), (720, 1), (730, 1), (740, 1), (750, 1), (760, 1), (770, 0), (780, 0), (790, 0), (800, 0), (810, 0), (820, 1), (830, 1), (840, 0), (850, 0), (860, 0), (870, 0), (880, 0), (890, 0), (900, 0), (910, 0), (920, 0), (930, 0), (940, 0), (950, 0), (960, 0), (970, 0), (980, 0), (990, 0), (1000, 0), (1010, 0), (1020, 0), (1030, 0), (1040, 0), (1050, 0), (1060, 0), (1070, 0), (1080, 0), (1090, 0), (1100, 0), (1110, 0), (1120, 0), (1130, 0), (1140, 0), (1150, 0), (1160, 0), (1170, 0), (1180, 0), (1190, 0), (1200, 0), (1210, 0), (1220, 0), (1230, 0), (1240, 0), (1250, 0), (1260, 1), (1270, 1), (1280, 0), (1290, 0), (1300, 0), (1310, 0), (1320, 0), (1330, 0), (1340, 0), (1350, 0), (1360, 0), (1370, 1), (1380, 1), (1390, 1), (1400, 1), (1410, 1), (1420, 1), (1430, 0), (1440, 0), (1450, 0), (1460, 0), (1470, 0), (1480, 1), (1490, 1), (1500, 1), (1510, 1), (1520, 1), (1530, 1), (1540, 1), (1550, 1), (1560, 1), (1570, 1), (1580, 0), (1590, 1), (1600, 1), (1610, 1), (1620, 0), (1630, 0), (1640, 0), (1650, 0), (1660, 0), (1670, 0), (1680, 0), (1690, 1), (1700, 1), (1710, 0), (1720, 0), (1730, 0), (1740, 0), (1750, 0), (1760, 0), (1770, 0), (1780, 0), (1790, 1), (1800, 1), (1810, 1), (1820, 1), (1830, 1), (1840, 1), (1850, 1), (1860, 0), (1870, 1), (1880, 0), (1890, 1), (1900, 1), (1910, 0), (1920, 0), (1930, 0), (1940, 0), (1950, 0), (1960, 0), (1970, 0), (1980, 0), (1990, 0), (2000, 0), (2010, 0), (2020, 0), (2030, 0), (2040, 0), (2050, 0)]
Vdin0_44  din0_44  0 PWL (0n 0.0v 9.495n 0.0v 9.505n 1.8v 19.495n 1.8v 19.505n 1.8v 29.495n 1.8v 29.505n 1.8v 39.495n 1.8v 39.505n 1.8v 49.495n 1.8v 49.505n 1.8v 59.495n 1.8v 59.505n 0.0v 69.495n 0.0v 69.505n 0.0v 79.495n 0.0v 79.505n 0.0v 89.495n 0.0v 89.505n 0.0v 99.495n 0.0v 99.505n 0.0v 109.495n 0.0v 109.505n 0.0v 119.495n 0.0v 119.505n 0.0v 129.495n 0.0v 129.505n 0.0v 139.495n 0.0v 139.505n 0.0v 149.495n 0.0v 149.505n 1.8v 159.495n 1.8v 159.505n 1.8v 169.495n 1.8v 169.505n 1.8v 179.495n 1.8v 179.505n 1.8v 189.495n 1.8v 189.505n 1.8v 199.495n 1.8v 199.505n 1.8v 209.495n 1.8v 209.505n 1.8v 219.495n 1.8v 219.505n 1.8v 229.495n 1.8v 229.505n 1.8v 239.495n 1.8v 239.505n 1.8v 249.495n 1.8v 249.505n 1.8v 259.495n 1.8v 259.505n 0.0v 269.495n 0.0v 269.505n 0.0v 279.495n 0.0v 279.505n 0.0v 289.495n 0.0v 289.505n 0.0v 299.495n 0.0v 299.505n 0.0v 309.495n 0.0v 309.505n 0.0v 319.495n 0.0v 319.505n 0.0v 329.495n 0.0v 329.505n 0.0v 339.495n 0.0v 339.505n 0.0v 349.495n 0.0v 349.505n 0.0v 359.495n 0.0v 359.505n 0.0v 369.495n 0.0v 369.505n 0.0v 379.495n 0.0v 379.505n 0.0v 389.495n 0.0v 389.505n 0.0v 399.495n 0.0v 399.505n 1.8v 409.495n 1.8v 409.505n 1.8v 419.495n 1.8v 419.505n 0.0v 429.495n 0.0v 429.505n 0.0v 439.495n 0.0v 439.505n 0.0v 449.495n 0.0v 449.505n 1.8v 459.495n 1.8v 459.505n 1.8v 469.495n 1.8v 469.505n 1.8v 479.495n 1.8v 479.505n 1.8v 489.495n 1.8v 489.505n 0.0v 499.495n 0.0v 499.505n 0.0v 509.495n 0.0v 509.505n 0.0v 519.495n 0.0v 519.505n 0.0v 529.495n 0.0v 529.505n 0.0v 539.495n 0.0v 539.505n 0.0v 549.495n 0.0v 549.505n 0.0v 559.495n 0.0v 559.505n 0.0v 569.495n 0.0v 569.505n 0.0v 579.495n 0.0v 579.505n 0.0v 589.495n 0.0v 589.505n 0.0v 599.495n 0.0v 599.505n 0.0v 609.495n 0.0v 609.505n 0.0v 619.495n 0.0v 619.505n 1.8v 629.495n 1.8v 629.505n 1.8v 639.495n 1.8v 639.505n 1.8v 649.495n 1.8v 649.505n 1.8v 659.495n 1.8v 659.505n 1.8v 669.495n 1.8v 669.505n 0.0v 679.495n 0.0v 679.505n 0.0v 689.495n 0.0v 689.505n 0.0v 699.495n 0.0v 699.505n 0.0v 709.495n 0.0v 709.505n 1.8v 719.495n 1.8v 719.505n 1.8v 729.495n 1.8v 729.505n 1.8v 739.495n 1.8v 739.505n 1.8v 749.495n 1.8v 749.505n 1.8v 759.495n 1.8v 759.505n 1.8v 769.495n 1.8v 769.505n 0.0v 779.495n 0.0v 779.505n 0.0v 789.495n 0.0v 789.505n 0.0v 799.495n 0.0v 799.505n 0.0v 809.495n 0.0v 809.505n 0.0v 819.495n 0.0v 819.505n 1.8v 829.495n 1.8v 829.505n 1.8v 839.495n 1.8v 839.505n 0.0v 849.495n 0.0v 849.505n 0.0v 859.495n 0.0v 859.505n 0.0v 869.495n 0.0v 869.505n 0.0v 879.495n 0.0v 879.505n 0.0v 889.495n 0.0v 889.505n 0.0v 899.495n 0.0v 899.505n 0.0v 909.495n 0.0v 909.505n 0.0v 919.495n 0.0v 919.505n 0.0v 929.495n 0.0v 929.505n 0.0v 939.495n 0.0v 939.505n 0.0v 949.495n 0.0v 949.505n 0.0v 959.495n 0.0v 959.505n 0.0v 969.495n 0.0v 969.505n 0.0v 979.495n 0.0v 979.505n 0.0v 989.495n 0.0v 989.505n 0.0v 999.495n 0.0v 999.505n 0.0v 1009.495n 0.0v 1009.505n 0.0v 1019.495n 0.0v 1019.505n 0.0v 1029.495n 0.0v 1029.505n 0.0v 1039.495n 0.0v 1039.505n 0.0v 1049.495n 0.0v 1049.505n 0.0v 1059.495n 0.0v 1059.505n 0.0v 1069.495n 0.0v 1069.505n 0.0v 1079.495n 0.0v 1079.505n 0.0v 1089.495n 0.0v 1089.505n 0.0v 1099.495n 0.0v 1099.505n 0.0v 1109.495n 0.0v 1109.505n 0.0v 1119.495n 0.0v 1119.505n 0.0v 1129.495n 0.0v 1129.505n 0.0v 1139.495n 0.0v 1139.505n 0.0v 1149.495n 0.0v 1149.505n 0.0v 1159.495n 0.0v 1159.505n 0.0v 1169.495n 0.0v 1169.505n 0.0v 1179.495n 0.0v 1179.505n 0.0v 1189.495n 0.0v 1189.505n 0.0v 1199.495n 0.0v 1199.505n 0.0v 1209.495n 0.0v 1209.505n 0.0v 1219.495n 0.0v 1219.505n 0.0v 1229.495n 0.0v 1229.505n 0.0v 1239.495n 0.0v 1239.505n 0.0v 1249.495n 0.0v 1249.505n 0.0v 1259.495n 0.0v 1259.505n 1.8v 1269.495n 1.8v 1269.505n 1.8v 1279.495n 1.8v 1279.505n 0.0v 1289.495n 0.0v 1289.505n 0.0v 1299.495n 0.0v 1299.505n 0.0v 1309.495n 0.0v 1309.505n 0.0v 1319.495n 0.0v 1319.505n 0.0v 1329.495n 0.0v 1329.505n 0.0v 1339.495n 0.0v 1339.505n 0.0v 1349.495n 0.0v 1349.505n 0.0v 1359.495n 0.0v 1359.505n 0.0v 1369.495n 0.0v 1369.505n 1.8v 1379.495n 1.8v 1379.505n 1.8v 1389.495n 1.8v 1389.505n 1.8v 1399.495n 1.8v 1399.505n 1.8v 1409.495n 1.8v 1409.505n 1.8v 1419.495n 1.8v 1419.505n 1.8v 1429.495n 1.8v 1429.505n 0.0v 1439.495n 0.0v 1439.505n 0.0v 1449.495n 0.0v 1449.505n 0.0v 1459.495n 0.0v 1459.505n 0.0v 1469.495n 0.0v 1469.505n 0.0v 1479.495n 0.0v 1479.505n 1.8v 1489.495n 1.8v 1489.505n 1.8v 1499.495n 1.8v 1499.505n 1.8v 1509.495n 1.8v 1509.505n 1.8v 1519.495n 1.8v 1519.505n 1.8v 1529.495n 1.8v 1529.505n 1.8v 1539.495n 1.8v 1539.505n 1.8v 1549.495n 1.8v 1549.505n 1.8v 1559.495n 1.8v 1559.505n 1.8v 1569.495n 1.8v 1569.505n 1.8v 1579.495n 1.8v 1579.505n 0.0v 1589.495n 0.0v 1589.505n 1.8v 1599.495n 1.8v 1599.505n 1.8v 1609.495n 1.8v 1609.505n 1.8v 1619.495n 1.8v 1619.505n 0.0v 1629.495n 0.0v 1629.505n 0.0v 1639.495n 0.0v 1639.505n 0.0v 1649.495n 0.0v 1649.505n 0.0v 1659.495n 0.0v 1659.505n 0.0v 1669.495n 0.0v 1669.505n 0.0v 1679.495n 0.0v 1679.505n 0.0v 1689.495n 0.0v 1689.505n 1.8v 1699.495n 1.8v 1699.505n 1.8v 1709.495n 1.8v 1709.505n 0.0v 1719.495n 0.0v 1719.505n 0.0v 1729.495n 0.0v 1729.505n 0.0v 1739.495n 0.0v 1739.505n 0.0v 1749.495n 0.0v 1749.505n 0.0v 1759.495n 0.0v 1759.505n 0.0v 1769.495n 0.0v 1769.505n 0.0v 1779.495n 0.0v 1779.505n 0.0v 1789.495n 0.0v 1789.505n 1.8v 1799.495n 1.8v 1799.505n 1.8v 1809.495n 1.8v 1809.505n 1.8v 1819.495n 1.8v 1819.505n 1.8v 1829.495n 1.8v 1829.505n 1.8v 1839.495n 1.8v 1839.505n 1.8v 1849.495n 1.8v 1849.505n 1.8v 1859.495n 1.8v 1859.505n 0.0v 1869.495n 0.0v 1869.505n 1.8v 1879.495n 1.8v 1879.505n 0.0v 1889.495n 0.0v 1889.505n 1.8v 1899.495n 1.8v 1899.505n 1.8v 1909.495n 1.8v 1909.505n 0.0v 1919.495n 0.0v 1919.505n 0.0v 1929.495n 0.0v 1929.505n 0.0v 1939.495n 0.0v 1939.505n 0.0v 1949.495n 0.0v 1949.505n 0.0v 1959.495n 0.0v 1959.505n 0.0v 1969.495n 0.0v 1969.505n 0.0v 1979.495n 0.0v 1979.505n 0.0v 1989.495n 0.0v 1989.505n 0.0v 1999.495n 0.0v 1999.505n 0.0v 2009.495n 0.0v 2009.505n 0.0v 2019.495n 0.0v 2019.505n 0.0v 2029.495n 0.0v 2029.505n 0.0v 2039.495n 0.0v 2039.505n 0.0v 2049.495n 0.0v 2049.505n 0.0v )
* (time, data): [(0, 0), (10, 1), (20, 0), (30, 1), (40, 1), (50, 1), (60, 1), (70, 1), (80, 1), (90, 1), (100, 1), (110, 1), (120, 1), (130, 1), (140, 1), (150, 1), (160, 1), (170, 1), (180, 1), (190, 1), (200, 1), (210, 1), (220, 1), (230, 1), (240, 1), (250, 1), (260, 0), (270, 0), (280, 0), (290, 0), (300, 0), (310, 1), (320, 1), (330, 1), (340, 1), (350, 0), (360, 0), (370, 0), (380, 0), (390, 0), (400, 1), (410, 1), (420, 0), (430, 0), (440, 0), (450, 0), (460, 0), (470, 1), (480, 1), (490, 1), (500, 0), (510, 0), (520, 0), (530, 0), (540, 0), (550, 0), (560, 0), (570, 0), (580, 0), (590, 0), (600, 0), (610, 0), (620, 1), (630, 1), (640, 1), (650, 1), (660, 1), (670, 1), (680, 1), (690, 1), (700, 1), (710, 1), (720, 1), (730, 1), (740, 1), (750, 1), (760, 1), (770, 0), (780, 0), (790, 0), (800, 0), (810, 0), (820, 1), (830, 1), (840, 0), (850, 0), (860, 0), (870, 0), (880, 0), (890, 1), (900, 1), (910, 1), (920, 1), (930, 1), (940, 1), (950, 1), (960, 1), (970, 1), (980, 1), (990, 1), (1000, 1), (1010, 1), (1020, 1), (1030, 1), (1040, 1), (1050, 1), (1060, 1), (1070, 1), (1080, 1), (1090, 1), (1100, 1), (1110, 1), (1120, 1), (1130, 0), (1140, 0), (1150, 0), (1160, 0), (1170, 0), (1180, 0), (1190, 0), (1200, 0), (1210, 0), (1220, 0), (1230, 0), (1240, 0), (1250, 0), (1260, 1), (1270, 1), (1280, 0), (1290, 0), (1300, 0), (1310, 0), (1320, 0), (1330, 0), (1340, 0), (1350, 0), (1360, 0), (1370, 1), (1380, 1), (1390, 1), (1400, 1), (1410, 1), (1420, 1), (1430, 1), (1440, 1), (1450, 1), (1460, 1), (1470, 1), (1480, 1), (1490, 1), (1500, 1), (1510, 1), (1520, 1), (1530, 1), (1540, 1), (1550, 1), (1560, 1), (1570, 0), (1580, 0), (1590, 0), (1600, 0), (1610, 0), (1620, 0), (1630, 0), (1640, 0), (1650, 0), (1660, 0), (1670, 0), (1680, 0), (1690, 0), (1700, 0), (1710, 0), (1720, 0), (1730, 1), (1740, 1), (1750, 1), (1760, 1), (1770, 1), (1780, 1), (1790, 0), (1800, 0), (1810, 0), (1820, 0), (1830, 0), (1840, 0), (1850, 0), (1860, 1), (1870, 0), (1880, 0), (1890, 0), (1900, 0), (1910, 0), (1920, 0), (1930, 0), (1940, 0), (1950, 0), (1960, 0), (1970, 0), (1980, 0), (1990, 0), (2000, 0), (2010, 0), (2020, 0), (2030, 0), (2040, 0), (2050, 0)]
Vdin0_45  din0_45  0 PWL (0n 0.0v 9.495n 0.0v 9.505n 1.8v 19.495n 1.8v 19.505n 0.0v 29.495n 0.0v 29.505n 1.8v 39.495n 1.8v 39.505n 1.8v 49.495n 1.8v 49.505n 1.8v 59.495n 1.8v 59.505n 1.8v 69.495n 1.8v 69.505n 1.8v 79.495n 1.8v 79.505n 1.8v 89.495n 1.8v 89.505n 1.8v 99.495n 1.8v 99.505n 1.8v 109.495n 1.8v 109.505n 1.8v 119.495n 1.8v 119.505n 1.8v 129.495n 1.8v 129.505n 1.8v 139.495n 1.8v 139.505n 1.8v 149.495n 1.8v 149.505n 1.8v 159.495n 1.8v 159.505n 1.8v 169.495n 1.8v 169.505n 1.8v 179.495n 1.8v 179.505n 1.8v 189.495n 1.8v 189.505n 1.8v 199.495n 1.8v 199.505n 1.8v 209.495n 1.8v 209.505n 1.8v 219.495n 1.8v 219.505n 1.8v 229.495n 1.8v 229.505n 1.8v 239.495n 1.8v 239.505n 1.8v 249.495n 1.8v 249.505n 1.8v 259.495n 1.8v 259.505n 0.0v 269.495n 0.0v 269.505n 0.0v 279.495n 0.0v 279.505n 0.0v 289.495n 0.0v 289.505n 0.0v 299.495n 0.0v 299.505n 0.0v 309.495n 0.0v 309.505n 1.8v 319.495n 1.8v 319.505n 1.8v 329.495n 1.8v 329.505n 1.8v 339.495n 1.8v 339.505n 1.8v 349.495n 1.8v 349.505n 0.0v 359.495n 0.0v 359.505n 0.0v 369.495n 0.0v 369.505n 0.0v 379.495n 0.0v 379.505n 0.0v 389.495n 0.0v 389.505n 0.0v 399.495n 0.0v 399.505n 1.8v 409.495n 1.8v 409.505n 1.8v 419.495n 1.8v 419.505n 0.0v 429.495n 0.0v 429.505n 0.0v 439.495n 0.0v 439.505n 0.0v 449.495n 0.0v 449.505n 0.0v 459.495n 0.0v 459.505n 0.0v 469.495n 0.0v 469.505n 1.8v 479.495n 1.8v 479.505n 1.8v 489.495n 1.8v 489.505n 1.8v 499.495n 1.8v 499.505n 0.0v 509.495n 0.0v 509.505n 0.0v 519.495n 0.0v 519.505n 0.0v 529.495n 0.0v 529.505n 0.0v 539.495n 0.0v 539.505n 0.0v 549.495n 0.0v 549.505n 0.0v 559.495n 0.0v 559.505n 0.0v 569.495n 0.0v 569.505n 0.0v 579.495n 0.0v 579.505n 0.0v 589.495n 0.0v 589.505n 0.0v 599.495n 0.0v 599.505n 0.0v 609.495n 0.0v 609.505n 0.0v 619.495n 0.0v 619.505n 1.8v 629.495n 1.8v 629.505n 1.8v 639.495n 1.8v 639.505n 1.8v 649.495n 1.8v 649.505n 1.8v 659.495n 1.8v 659.505n 1.8v 669.495n 1.8v 669.505n 1.8v 679.495n 1.8v 679.505n 1.8v 689.495n 1.8v 689.505n 1.8v 699.495n 1.8v 699.505n 1.8v 709.495n 1.8v 709.505n 1.8v 719.495n 1.8v 719.505n 1.8v 729.495n 1.8v 729.505n 1.8v 739.495n 1.8v 739.505n 1.8v 749.495n 1.8v 749.505n 1.8v 759.495n 1.8v 759.505n 1.8v 769.495n 1.8v 769.505n 0.0v 779.495n 0.0v 779.505n 0.0v 789.495n 0.0v 789.505n 0.0v 799.495n 0.0v 799.505n 0.0v 809.495n 0.0v 809.505n 0.0v 819.495n 0.0v 819.505n 1.8v 829.495n 1.8v 829.505n 1.8v 839.495n 1.8v 839.505n 0.0v 849.495n 0.0v 849.505n 0.0v 859.495n 0.0v 859.505n 0.0v 869.495n 0.0v 869.505n 0.0v 879.495n 0.0v 879.505n 0.0v 889.495n 0.0v 889.505n 1.8v 899.495n 1.8v 899.505n 1.8v 909.495n 1.8v 909.505n 1.8v 919.495n 1.8v 919.505n 1.8v 929.495n 1.8v 929.505n 1.8v 939.495n 1.8v 939.505n 1.8v 949.495n 1.8v 949.505n 1.8v 959.495n 1.8v 959.505n 1.8v 969.495n 1.8v 969.505n 1.8v 979.495n 1.8v 979.505n 1.8v 989.495n 1.8v 989.505n 1.8v 999.495n 1.8v 999.505n 1.8v 1009.495n 1.8v 1009.505n 1.8v 1019.495n 1.8v 1019.505n 1.8v 1029.495n 1.8v 1029.505n 1.8v 1039.495n 1.8v 1039.505n 1.8v 1049.495n 1.8v 1049.505n 1.8v 1059.495n 1.8v 1059.505n 1.8v 1069.495n 1.8v 1069.505n 1.8v 1079.495n 1.8v 1079.505n 1.8v 1089.495n 1.8v 1089.505n 1.8v 1099.495n 1.8v 1099.505n 1.8v 1109.495n 1.8v 1109.505n 1.8v 1119.495n 1.8v 1119.505n 1.8v 1129.495n 1.8v 1129.505n 0.0v 1139.495n 0.0v 1139.505n 0.0v 1149.495n 0.0v 1149.505n 0.0v 1159.495n 0.0v 1159.505n 0.0v 1169.495n 0.0v 1169.505n 0.0v 1179.495n 0.0v 1179.505n 0.0v 1189.495n 0.0v 1189.505n 0.0v 1199.495n 0.0v 1199.505n 0.0v 1209.495n 0.0v 1209.505n 0.0v 1219.495n 0.0v 1219.505n 0.0v 1229.495n 0.0v 1229.505n 0.0v 1239.495n 0.0v 1239.505n 0.0v 1249.495n 0.0v 1249.505n 0.0v 1259.495n 0.0v 1259.505n 1.8v 1269.495n 1.8v 1269.505n 1.8v 1279.495n 1.8v 1279.505n 0.0v 1289.495n 0.0v 1289.505n 0.0v 1299.495n 0.0v 1299.505n 0.0v 1309.495n 0.0v 1309.505n 0.0v 1319.495n 0.0v 1319.505n 0.0v 1329.495n 0.0v 1329.505n 0.0v 1339.495n 0.0v 1339.505n 0.0v 1349.495n 0.0v 1349.505n 0.0v 1359.495n 0.0v 1359.505n 0.0v 1369.495n 0.0v 1369.505n 1.8v 1379.495n 1.8v 1379.505n 1.8v 1389.495n 1.8v 1389.505n 1.8v 1399.495n 1.8v 1399.505n 1.8v 1409.495n 1.8v 1409.505n 1.8v 1419.495n 1.8v 1419.505n 1.8v 1429.495n 1.8v 1429.505n 1.8v 1439.495n 1.8v 1439.505n 1.8v 1449.495n 1.8v 1449.505n 1.8v 1459.495n 1.8v 1459.505n 1.8v 1469.495n 1.8v 1469.505n 1.8v 1479.495n 1.8v 1479.505n 1.8v 1489.495n 1.8v 1489.505n 1.8v 1499.495n 1.8v 1499.505n 1.8v 1509.495n 1.8v 1509.505n 1.8v 1519.495n 1.8v 1519.505n 1.8v 1529.495n 1.8v 1529.505n 1.8v 1539.495n 1.8v 1539.505n 1.8v 1549.495n 1.8v 1549.505n 1.8v 1559.495n 1.8v 1559.505n 1.8v 1569.495n 1.8v 1569.505n 0.0v 1579.495n 0.0v 1579.505n 0.0v 1589.495n 0.0v 1589.505n 0.0v 1599.495n 0.0v 1599.505n 0.0v 1609.495n 0.0v 1609.505n 0.0v 1619.495n 0.0v 1619.505n 0.0v 1629.495n 0.0v 1629.505n 0.0v 1639.495n 0.0v 1639.505n 0.0v 1649.495n 0.0v 1649.505n 0.0v 1659.495n 0.0v 1659.505n 0.0v 1669.495n 0.0v 1669.505n 0.0v 1679.495n 0.0v 1679.505n 0.0v 1689.495n 0.0v 1689.505n 0.0v 1699.495n 0.0v 1699.505n 0.0v 1709.495n 0.0v 1709.505n 0.0v 1719.495n 0.0v 1719.505n 0.0v 1729.495n 0.0v 1729.505n 1.8v 1739.495n 1.8v 1739.505n 1.8v 1749.495n 1.8v 1749.505n 1.8v 1759.495n 1.8v 1759.505n 1.8v 1769.495n 1.8v 1769.505n 1.8v 1779.495n 1.8v 1779.505n 1.8v 1789.495n 1.8v 1789.505n 0.0v 1799.495n 0.0v 1799.505n 0.0v 1809.495n 0.0v 1809.505n 0.0v 1819.495n 0.0v 1819.505n 0.0v 1829.495n 0.0v 1829.505n 0.0v 1839.495n 0.0v 1839.505n 0.0v 1849.495n 0.0v 1849.505n 0.0v 1859.495n 0.0v 1859.505n 1.8v 1869.495n 1.8v 1869.505n 0.0v 1879.495n 0.0v 1879.505n 0.0v 1889.495n 0.0v 1889.505n 0.0v 1899.495n 0.0v 1899.505n 0.0v 1909.495n 0.0v 1909.505n 0.0v 1919.495n 0.0v 1919.505n 0.0v 1929.495n 0.0v 1929.505n 0.0v 1939.495n 0.0v 1939.505n 0.0v 1949.495n 0.0v 1949.505n 0.0v 1959.495n 0.0v 1959.505n 0.0v 1969.495n 0.0v 1969.505n 0.0v 1979.495n 0.0v 1979.505n 0.0v 1989.495n 0.0v 1989.505n 0.0v 1999.495n 0.0v 1999.505n 0.0v 2009.495n 0.0v 2009.505n 0.0v 2019.495n 0.0v 2019.505n 0.0v 2029.495n 0.0v 2029.505n 0.0v 2039.495n 0.0v 2039.505n 0.0v 2049.495n 0.0v 2049.505n 0.0v )
* (time, data): [(0, 0), (10, 1), (20, 0), (30, 1), (40, 1), (50, 1), (60, 0), (70, 0), (80, 0), (90, 0), (100, 0), (110, 0), (120, 0), (130, 0), (140, 0), (150, 1), (160, 1), (170, 1), (180, 1), (190, 1), (200, 1), (210, 1), (220, 1), (230, 1), (240, 1), (250, 1), (260, 1), (270, 1), (280, 1), (290, 1), (300, 1), (310, 0), (320, 0), (330, 0), (340, 0), (350, 1), (360, 1), (370, 1), (380, 1), (390, 1), (400, 0), (410, 0), (420, 0), (430, 0), (440, 0), (450, 1), (460, 1), (470, 1), (480, 1), (490, 1), (500, 0), (510, 0), (520, 0), (530, 0), (540, 0), (550, 0), (560, 0), (570, 0), (580, 0), (590, 0), (600, 0), (610, 0), (620, 0), (630, 0), (640, 0), (650, 0), (660, 0), (670, 1), (680, 1), (690, 1), (700, 1), (710, 1), (720, 1), (730, 1), (740, 1), (750, 1), (760, 1), (770, 1), (780, 1), (790, 1), (800, 1), (810, 1), (820, 0), (830, 0), (840, 1), (850, 1), (860, 1), (870, 1), (880, 1), (890, 0), (900, 0), (910, 0), (920, 0), (930, 1), (940, 1), (950, 1), (960, 0), (970, 0), (980, 0), (990, 0), (1000, 0), (1010, 0), (1020, 0), (1030, 0), (1040, 0), (1050, 0), (1060, 0), (1070, 0), (1080, 0), (1090, 0), (1100, 0), (1110, 0), (1120, 0), (1130, 1), (1140, 1), (1150, 1), (1160, 1), (1170, 1), (1180, 1), (1190, 1), (1200, 1), (1210, 1), (1220, 1), (1230, 1), (1240, 1), (1250, 1), (1260, 1), (1270, 1), (1280, 1), (1290, 1), (1300, 1), (1310, 1), (1320, 1), (1330, 1), (1340, 1), (1350, 1), (1360, 1), (1370, 0), (1380, 0), (1390, 0), (1400, 0), (1410, 0), (1420, 0), (1430, 0), (1440, 0), (1450, 0), (1460, 0), (1470, 0), (1480, 0), (1490, 0), (1500, 0), (1510, 0), (1520, 0), (1530, 0), (1540, 0), (1550, 0), (1560, 0), (1570, 0), (1580, 1), (1590, 0), (1600, 0), (1610, 0), (1620, 0), (1630, 0), (1640, 0), (1650, 0), (1660, 0), (1670, 0), (1680, 0), (1690, 1), (1700, 1), (1710, 0), (1720, 0), (1730, 0), (1740, 1), (1750, 1), (1760, 1), (1770, 1), (1780, 1), (1790, 0), (1800, 0), (1810, 0), (1820, 0), (1830, 0), (1840, 0), (1850, 1), (1860, 1), (1870, 0), (1880, 1), (1890, 0), (1900, 0), (1910, 1), (1920, 1), (1930, 1), (1940, 1), (1950, 1), (1960, 1), (1970, 1), (1980, 1), (1990, 1), (2000, 1), (2010, 1), (2020, 1), (2030, 1), (2040, 1), (2050, 1)]
Vdin0_46  din0_46  0 PWL (0n 0.0v 9.495n 0.0v 9.505n 1.8v 19.495n 1.8v 19.505n 0.0v 29.495n 0.0v 29.505n 1.8v 39.495n 1.8v 39.505n 1.8v 49.495n 1.8v 49.505n 1.8v 59.495n 1.8v 59.505n 0.0v 69.495n 0.0v 69.505n 0.0v 79.495n 0.0v 79.505n 0.0v 89.495n 0.0v 89.505n 0.0v 99.495n 0.0v 99.505n 0.0v 109.495n 0.0v 109.505n 0.0v 119.495n 0.0v 119.505n 0.0v 129.495n 0.0v 129.505n 0.0v 139.495n 0.0v 139.505n 0.0v 149.495n 0.0v 149.505n 1.8v 159.495n 1.8v 159.505n 1.8v 169.495n 1.8v 169.505n 1.8v 179.495n 1.8v 179.505n 1.8v 189.495n 1.8v 189.505n 1.8v 199.495n 1.8v 199.505n 1.8v 209.495n 1.8v 209.505n 1.8v 219.495n 1.8v 219.505n 1.8v 229.495n 1.8v 229.505n 1.8v 239.495n 1.8v 239.505n 1.8v 249.495n 1.8v 249.505n 1.8v 259.495n 1.8v 259.505n 1.8v 269.495n 1.8v 269.505n 1.8v 279.495n 1.8v 279.505n 1.8v 289.495n 1.8v 289.505n 1.8v 299.495n 1.8v 299.505n 1.8v 309.495n 1.8v 309.505n 0.0v 319.495n 0.0v 319.505n 0.0v 329.495n 0.0v 329.505n 0.0v 339.495n 0.0v 339.505n 0.0v 349.495n 0.0v 349.505n 1.8v 359.495n 1.8v 359.505n 1.8v 369.495n 1.8v 369.505n 1.8v 379.495n 1.8v 379.505n 1.8v 389.495n 1.8v 389.505n 1.8v 399.495n 1.8v 399.505n 0.0v 409.495n 0.0v 409.505n 0.0v 419.495n 0.0v 419.505n 0.0v 429.495n 0.0v 429.505n 0.0v 439.495n 0.0v 439.505n 0.0v 449.495n 0.0v 449.505n 1.8v 459.495n 1.8v 459.505n 1.8v 469.495n 1.8v 469.505n 1.8v 479.495n 1.8v 479.505n 1.8v 489.495n 1.8v 489.505n 1.8v 499.495n 1.8v 499.505n 0.0v 509.495n 0.0v 509.505n 0.0v 519.495n 0.0v 519.505n 0.0v 529.495n 0.0v 529.505n 0.0v 539.495n 0.0v 539.505n 0.0v 549.495n 0.0v 549.505n 0.0v 559.495n 0.0v 559.505n 0.0v 569.495n 0.0v 569.505n 0.0v 579.495n 0.0v 579.505n 0.0v 589.495n 0.0v 589.505n 0.0v 599.495n 0.0v 599.505n 0.0v 609.495n 0.0v 609.505n 0.0v 619.495n 0.0v 619.505n 0.0v 629.495n 0.0v 629.505n 0.0v 639.495n 0.0v 639.505n 0.0v 649.495n 0.0v 649.505n 0.0v 659.495n 0.0v 659.505n 0.0v 669.495n 0.0v 669.505n 1.8v 679.495n 1.8v 679.505n 1.8v 689.495n 1.8v 689.505n 1.8v 699.495n 1.8v 699.505n 1.8v 709.495n 1.8v 709.505n 1.8v 719.495n 1.8v 719.505n 1.8v 729.495n 1.8v 729.505n 1.8v 739.495n 1.8v 739.505n 1.8v 749.495n 1.8v 749.505n 1.8v 759.495n 1.8v 759.505n 1.8v 769.495n 1.8v 769.505n 1.8v 779.495n 1.8v 779.505n 1.8v 789.495n 1.8v 789.505n 1.8v 799.495n 1.8v 799.505n 1.8v 809.495n 1.8v 809.505n 1.8v 819.495n 1.8v 819.505n 0.0v 829.495n 0.0v 829.505n 0.0v 839.495n 0.0v 839.505n 1.8v 849.495n 1.8v 849.505n 1.8v 859.495n 1.8v 859.505n 1.8v 869.495n 1.8v 869.505n 1.8v 879.495n 1.8v 879.505n 1.8v 889.495n 1.8v 889.505n 0.0v 899.495n 0.0v 899.505n 0.0v 909.495n 0.0v 909.505n 0.0v 919.495n 0.0v 919.505n 0.0v 929.495n 0.0v 929.505n 1.8v 939.495n 1.8v 939.505n 1.8v 949.495n 1.8v 949.505n 1.8v 959.495n 1.8v 959.505n 0.0v 969.495n 0.0v 969.505n 0.0v 979.495n 0.0v 979.505n 0.0v 989.495n 0.0v 989.505n 0.0v 999.495n 0.0v 999.505n 0.0v 1009.495n 0.0v 1009.505n 0.0v 1019.495n 0.0v 1019.505n 0.0v 1029.495n 0.0v 1029.505n 0.0v 1039.495n 0.0v 1039.505n 0.0v 1049.495n 0.0v 1049.505n 0.0v 1059.495n 0.0v 1059.505n 0.0v 1069.495n 0.0v 1069.505n 0.0v 1079.495n 0.0v 1079.505n 0.0v 1089.495n 0.0v 1089.505n 0.0v 1099.495n 0.0v 1099.505n 0.0v 1109.495n 0.0v 1109.505n 0.0v 1119.495n 0.0v 1119.505n 0.0v 1129.495n 0.0v 1129.505n 1.8v 1139.495n 1.8v 1139.505n 1.8v 1149.495n 1.8v 1149.505n 1.8v 1159.495n 1.8v 1159.505n 1.8v 1169.495n 1.8v 1169.505n 1.8v 1179.495n 1.8v 1179.505n 1.8v 1189.495n 1.8v 1189.505n 1.8v 1199.495n 1.8v 1199.505n 1.8v 1209.495n 1.8v 1209.505n 1.8v 1219.495n 1.8v 1219.505n 1.8v 1229.495n 1.8v 1229.505n 1.8v 1239.495n 1.8v 1239.505n 1.8v 1249.495n 1.8v 1249.505n 1.8v 1259.495n 1.8v 1259.505n 1.8v 1269.495n 1.8v 1269.505n 1.8v 1279.495n 1.8v 1279.505n 1.8v 1289.495n 1.8v 1289.505n 1.8v 1299.495n 1.8v 1299.505n 1.8v 1309.495n 1.8v 1309.505n 1.8v 1319.495n 1.8v 1319.505n 1.8v 1329.495n 1.8v 1329.505n 1.8v 1339.495n 1.8v 1339.505n 1.8v 1349.495n 1.8v 1349.505n 1.8v 1359.495n 1.8v 1359.505n 1.8v 1369.495n 1.8v 1369.505n 0.0v 1379.495n 0.0v 1379.505n 0.0v 1389.495n 0.0v 1389.505n 0.0v 1399.495n 0.0v 1399.505n 0.0v 1409.495n 0.0v 1409.505n 0.0v 1419.495n 0.0v 1419.505n 0.0v 1429.495n 0.0v 1429.505n 0.0v 1439.495n 0.0v 1439.505n 0.0v 1449.495n 0.0v 1449.505n 0.0v 1459.495n 0.0v 1459.505n 0.0v 1469.495n 0.0v 1469.505n 0.0v 1479.495n 0.0v 1479.505n 0.0v 1489.495n 0.0v 1489.505n 0.0v 1499.495n 0.0v 1499.505n 0.0v 1509.495n 0.0v 1509.505n 0.0v 1519.495n 0.0v 1519.505n 0.0v 1529.495n 0.0v 1529.505n 0.0v 1539.495n 0.0v 1539.505n 0.0v 1549.495n 0.0v 1549.505n 0.0v 1559.495n 0.0v 1559.505n 0.0v 1569.495n 0.0v 1569.505n 0.0v 1579.495n 0.0v 1579.505n 1.8v 1589.495n 1.8v 1589.505n 0.0v 1599.495n 0.0v 1599.505n 0.0v 1609.495n 0.0v 1609.505n 0.0v 1619.495n 0.0v 1619.505n 0.0v 1629.495n 0.0v 1629.505n 0.0v 1639.495n 0.0v 1639.505n 0.0v 1649.495n 0.0v 1649.505n 0.0v 1659.495n 0.0v 1659.505n 0.0v 1669.495n 0.0v 1669.505n 0.0v 1679.495n 0.0v 1679.505n 0.0v 1689.495n 0.0v 1689.505n 1.8v 1699.495n 1.8v 1699.505n 1.8v 1709.495n 1.8v 1709.505n 0.0v 1719.495n 0.0v 1719.505n 0.0v 1729.495n 0.0v 1729.505n 0.0v 1739.495n 0.0v 1739.505n 1.8v 1749.495n 1.8v 1749.505n 1.8v 1759.495n 1.8v 1759.505n 1.8v 1769.495n 1.8v 1769.505n 1.8v 1779.495n 1.8v 1779.505n 1.8v 1789.495n 1.8v 1789.505n 0.0v 1799.495n 0.0v 1799.505n 0.0v 1809.495n 0.0v 1809.505n 0.0v 1819.495n 0.0v 1819.505n 0.0v 1829.495n 0.0v 1829.505n 0.0v 1839.495n 0.0v 1839.505n 0.0v 1849.495n 0.0v 1849.505n 1.8v 1859.495n 1.8v 1859.505n 1.8v 1869.495n 1.8v 1869.505n 0.0v 1879.495n 0.0v 1879.505n 1.8v 1889.495n 1.8v 1889.505n 0.0v 1899.495n 0.0v 1899.505n 0.0v 1909.495n 0.0v 1909.505n 1.8v 1919.495n 1.8v 1919.505n 1.8v 1929.495n 1.8v 1929.505n 1.8v 1939.495n 1.8v 1939.505n 1.8v 1949.495n 1.8v 1949.505n 1.8v 1959.495n 1.8v 1959.505n 1.8v 1969.495n 1.8v 1969.505n 1.8v 1979.495n 1.8v 1979.505n 1.8v 1989.495n 1.8v 1989.505n 1.8v 1999.495n 1.8v 1999.505n 1.8v 2009.495n 1.8v 2009.505n 1.8v 2019.495n 1.8v 2019.505n 1.8v 2029.495n 1.8v 2029.505n 1.8v 2039.495n 1.8v 2039.505n 1.8v 2049.495n 1.8v 2049.505n 1.8v )
* (time, data): [(0, 0), (10, 0), (20, 1), (30, 0), (40, 0), (50, 0), (60, 1), (70, 1), (80, 1), (90, 1), (100, 1), (110, 1), (120, 1), (130, 1), (140, 1), (150, 0), (160, 0), (170, 0), (180, 0), (190, 0), (200, 0), (210, 0), (220, 0), (230, 0), (240, 0), (250, 0), (260, 0), (270, 0), (280, 0), (290, 0), (300, 0), (310, 1), (320, 1), (330, 1), (340, 1), (350, 1), (360, 1), (370, 1), (380, 1), (390, 0), (400, 0), (410, 0), (420, 1), (430, 1), (440, 1), (450, 1), (460, 1), (470, 0), (480, 0), (490, 0), (500, 0), (510, 0), (520, 0), (530, 0), (540, 0), (550, 0), (560, 0), (570, 0), (580, 0), (590, 0), (600, 0), (610, 0), (620, 1), (630, 1), (640, 1), (650, 1), (660, 0), (670, 1), (680, 1), (690, 1), (700, 1), (710, 1), (720, 1), (730, 1), (740, 1), (750, 1), (760, 1), (770, 0), (780, 0), (790, 0), (800, 0), (810, 0), (820, 0), (830, 0), (840, 1), (850, 1), (860, 1), (870, 1), (880, 1), (890, 0), (900, 0), (910, 0), (920, 0), (930, 0), (940, 0), (950, 0), (960, 1), (970, 1), (980, 1), (990, 1), (1000, 1), (1010, 1), (1020, 1), (1030, 1), (1040, 1), (1050, 1), (1060, 1), (1070, 1), (1080, 1), (1090, 1), (1100, 1), (1110, 1), (1120, 1), (1130, 1), (1140, 1), (1150, 1), (1160, 1), (1170, 1), (1180, 1), (1190, 1), (1200, 1), (1210, 1), (1220, 1), (1230, 1), (1240, 1), (1250, 1), (1260, 1), (1270, 1), (1280, 1), (1290, 1), (1300, 1), (1310, 1), (1320, 1), (1330, 1), (1340, 1), (1350, 1), (1360, 1), (1370, 1), (1380, 1), (1390, 1), (1400, 0), (1410, 0), (1420, 0), (1430, 1), (1440, 1), (1450, 1), (1460, 1), (1470, 1), (1480, 0), (1490, 0), (1500, 1), (1510, 1), (1520, 1), (1530, 1), (1540, 1), (1550, 1), (1560, 1), (1570, 0), (1580, 0), (1590, 1), (1600, 1), (1610, 1), (1620, 1), (1630, 1), (1640, 1), (1650, 1), (1660, 1), (1670, 1), (1680, 1), (1690, 0), (1700, 0), (1710, 0), (1720, 0), (1730, 1), (1740, 1), (1750, 1), (1760, 1), (1770, 1), (1780, 1), (1790, 0), (1800, 0), (1810, 0), (1820, 0), (1830, 0), (1840, 0), (1850, 0), (1860, 1), (1870, 1), (1880, 0), (1890, 0), (1900, 0), (1910, 0), (1920, 0), (1930, 0), (1940, 0), (1950, 0), (1960, 0), (1970, 0), (1980, 0), (1990, 0), (2000, 0), (2010, 0), (2020, 0), (2030, 1), (2040, 1), (2050, 1)]
Vdin0_47  din0_47  0 PWL (0n 0.0v 9.495n 0.0v 9.505n 0.0v 19.495n 0.0v 19.505n 1.8v 29.495n 1.8v 29.505n 0.0v 39.495n 0.0v 39.505n 0.0v 49.495n 0.0v 49.505n 0.0v 59.495n 0.0v 59.505n 1.8v 69.495n 1.8v 69.505n 1.8v 79.495n 1.8v 79.505n 1.8v 89.495n 1.8v 89.505n 1.8v 99.495n 1.8v 99.505n 1.8v 109.495n 1.8v 109.505n 1.8v 119.495n 1.8v 119.505n 1.8v 129.495n 1.8v 129.505n 1.8v 139.495n 1.8v 139.505n 1.8v 149.495n 1.8v 149.505n 0.0v 159.495n 0.0v 159.505n 0.0v 169.495n 0.0v 169.505n 0.0v 179.495n 0.0v 179.505n 0.0v 189.495n 0.0v 189.505n 0.0v 199.495n 0.0v 199.505n 0.0v 209.495n 0.0v 209.505n 0.0v 219.495n 0.0v 219.505n 0.0v 229.495n 0.0v 229.505n 0.0v 239.495n 0.0v 239.505n 0.0v 249.495n 0.0v 249.505n 0.0v 259.495n 0.0v 259.505n 0.0v 269.495n 0.0v 269.505n 0.0v 279.495n 0.0v 279.505n 0.0v 289.495n 0.0v 289.505n 0.0v 299.495n 0.0v 299.505n 0.0v 309.495n 0.0v 309.505n 1.8v 319.495n 1.8v 319.505n 1.8v 329.495n 1.8v 329.505n 1.8v 339.495n 1.8v 339.505n 1.8v 349.495n 1.8v 349.505n 1.8v 359.495n 1.8v 359.505n 1.8v 369.495n 1.8v 369.505n 1.8v 379.495n 1.8v 379.505n 1.8v 389.495n 1.8v 389.505n 0.0v 399.495n 0.0v 399.505n 0.0v 409.495n 0.0v 409.505n 0.0v 419.495n 0.0v 419.505n 1.8v 429.495n 1.8v 429.505n 1.8v 439.495n 1.8v 439.505n 1.8v 449.495n 1.8v 449.505n 1.8v 459.495n 1.8v 459.505n 1.8v 469.495n 1.8v 469.505n 0.0v 479.495n 0.0v 479.505n 0.0v 489.495n 0.0v 489.505n 0.0v 499.495n 0.0v 499.505n 0.0v 509.495n 0.0v 509.505n 0.0v 519.495n 0.0v 519.505n 0.0v 529.495n 0.0v 529.505n 0.0v 539.495n 0.0v 539.505n 0.0v 549.495n 0.0v 549.505n 0.0v 559.495n 0.0v 559.505n 0.0v 569.495n 0.0v 569.505n 0.0v 579.495n 0.0v 579.505n 0.0v 589.495n 0.0v 589.505n 0.0v 599.495n 0.0v 599.505n 0.0v 609.495n 0.0v 609.505n 0.0v 619.495n 0.0v 619.505n 1.8v 629.495n 1.8v 629.505n 1.8v 639.495n 1.8v 639.505n 1.8v 649.495n 1.8v 649.505n 1.8v 659.495n 1.8v 659.505n 0.0v 669.495n 0.0v 669.505n 1.8v 679.495n 1.8v 679.505n 1.8v 689.495n 1.8v 689.505n 1.8v 699.495n 1.8v 699.505n 1.8v 709.495n 1.8v 709.505n 1.8v 719.495n 1.8v 719.505n 1.8v 729.495n 1.8v 729.505n 1.8v 739.495n 1.8v 739.505n 1.8v 749.495n 1.8v 749.505n 1.8v 759.495n 1.8v 759.505n 1.8v 769.495n 1.8v 769.505n 0.0v 779.495n 0.0v 779.505n 0.0v 789.495n 0.0v 789.505n 0.0v 799.495n 0.0v 799.505n 0.0v 809.495n 0.0v 809.505n 0.0v 819.495n 0.0v 819.505n 0.0v 829.495n 0.0v 829.505n 0.0v 839.495n 0.0v 839.505n 1.8v 849.495n 1.8v 849.505n 1.8v 859.495n 1.8v 859.505n 1.8v 869.495n 1.8v 869.505n 1.8v 879.495n 1.8v 879.505n 1.8v 889.495n 1.8v 889.505n 0.0v 899.495n 0.0v 899.505n 0.0v 909.495n 0.0v 909.505n 0.0v 919.495n 0.0v 919.505n 0.0v 929.495n 0.0v 929.505n 0.0v 939.495n 0.0v 939.505n 0.0v 949.495n 0.0v 949.505n 0.0v 959.495n 0.0v 959.505n 1.8v 969.495n 1.8v 969.505n 1.8v 979.495n 1.8v 979.505n 1.8v 989.495n 1.8v 989.505n 1.8v 999.495n 1.8v 999.505n 1.8v 1009.495n 1.8v 1009.505n 1.8v 1019.495n 1.8v 1019.505n 1.8v 1029.495n 1.8v 1029.505n 1.8v 1039.495n 1.8v 1039.505n 1.8v 1049.495n 1.8v 1049.505n 1.8v 1059.495n 1.8v 1059.505n 1.8v 1069.495n 1.8v 1069.505n 1.8v 1079.495n 1.8v 1079.505n 1.8v 1089.495n 1.8v 1089.505n 1.8v 1099.495n 1.8v 1099.505n 1.8v 1109.495n 1.8v 1109.505n 1.8v 1119.495n 1.8v 1119.505n 1.8v 1129.495n 1.8v 1129.505n 1.8v 1139.495n 1.8v 1139.505n 1.8v 1149.495n 1.8v 1149.505n 1.8v 1159.495n 1.8v 1159.505n 1.8v 1169.495n 1.8v 1169.505n 1.8v 1179.495n 1.8v 1179.505n 1.8v 1189.495n 1.8v 1189.505n 1.8v 1199.495n 1.8v 1199.505n 1.8v 1209.495n 1.8v 1209.505n 1.8v 1219.495n 1.8v 1219.505n 1.8v 1229.495n 1.8v 1229.505n 1.8v 1239.495n 1.8v 1239.505n 1.8v 1249.495n 1.8v 1249.505n 1.8v 1259.495n 1.8v 1259.505n 1.8v 1269.495n 1.8v 1269.505n 1.8v 1279.495n 1.8v 1279.505n 1.8v 1289.495n 1.8v 1289.505n 1.8v 1299.495n 1.8v 1299.505n 1.8v 1309.495n 1.8v 1309.505n 1.8v 1319.495n 1.8v 1319.505n 1.8v 1329.495n 1.8v 1329.505n 1.8v 1339.495n 1.8v 1339.505n 1.8v 1349.495n 1.8v 1349.505n 1.8v 1359.495n 1.8v 1359.505n 1.8v 1369.495n 1.8v 1369.505n 1.8v 1379.495n 1.8v 1379.505n 1.8v 1389.495n 1.8v 1389.505n 1.8v 1399.495n 1.8v 1399.505n 0.0v 1409.495n 0.0v 1409.505n 0.0v 1419.495n 0.0v 1419.505n 0.0v 1429.495n 0.0v 1429.505n 1.8v 1439.495n 1.8v 1439.505n 1.8v 1449.495n 1.8v 1449.505n 1.8v 1459.495n 1.8v 1459.505n 1.8v 1469.495n 1.8v 1469.505n 1.8v 1479.495n 1.8v 1479.505n 0.0v 1489.495n 0.0v 1489.505n 0.0v 1499.495n 0.0v 1499.505n 1.8v 1509.495n 1.8v 1509.505n 1.8v 1519.495n 1.8v 1519.505n 1.8v 1529.495n 1.8v 1529.505n 1.8v 1539.495n 1.8v 1539.505n 1.8v 1549.495n 1.8v 1549.505n 1.8v 1559.495n 1.8v 1559.505n 1.8v 1569.495n 1.8v 1569.505n 0.0v 1579.495n 0.0v 1579.505n 0.0v 1589.495n 0.0v 1589.505n 1.8v 1599.495n 1.8v 1599.505n 1.8v 1609.495n 1.8v 1609.505n 1.8v 1619.495n 1.8v 1619.505n 1.8v 1629.495n 1.8v 1629.505n 1.8v 1639.495n 1.8v 1639.505n 1.8v 1649.495n 1.8v 1649.505n 1.8v 1659.495n 1.8v 1659.505n 1.8v 1669.495n 1.8v 1669.505n 1.8v 1679.495n 1.8v 1679.505n 1.8v 1689.495n 1.8v 1689.505n 0.0v 1699.495n 0.0v 1699.505n 0.0v 1709.495n 0.0v 1709.505n 0.0v 1719.495n 0.0v 1719.505n 0.0v 1729.495n 0.0v 1729.505n 1.8v 1739.495n 1.8v 1739.505n 1.8v 1749.495n 1.8v 1749.505n 1.8v 1759.495n 1.8v 1759.505n 1.8v 1769.495n 1.8v 1769.505n 1.8v 1779.495n 1.8v 1779.505n 1.8v 1789.495n 1.8v 1789.505n 0.0v 1799.495n 0.0v 1799.505n 0.0v 1809.495n 0.0v 1809.505n 0.0v 1819.495n 0.0v 1819.505n 0.0v 1829.495n 0.0v 1829.505n 0.0v 1839.495n 0.0v 1839.505n 0.0v 1849.495n 0.0v 1849.505n 0.0v 1859.495n 0.0v 1859.505n 1.8v 1869.495n 1.8v 1869.505n 1.8v 1879.495n 1.8v 1879.505n 0.0v 1889.495n 0.0v 1889.505n 0.0v 1899.495n 0.0v 1899.505n 0.0v 1909.495n 0.0v 1909.505n 0.0v 1919.495n 0.0v 1919.505n 0.0v 1929.495n 0.0v 1929.505n 0.0v 1939.495n 0.0v 1939.505n 0.0v 1949.495n 0.0v 1949.505n 0.0v 1959.495n 0.0v 1959.505n 0.0v 1969.495n 0.0v 1969.505n 0.0v 1979.495n 0.0v 1979.505n 0.0v 1989.495n 0.0v 1989.505n 0.0v 1999.495n 0.0v 1999.505n 0.0v 2009.495n 0.0v 2009.505n 0.0v 2019.495n 0.0v 2019.505n 0.0v 2029.495n 0.0v 2029.505n 1.8v 2039.495n 1.8v 2039.505n 1.8v 2049.495n 1.8v 2049.505n 1.8v )
* (time, data): [(0, 0), (10, 1), (20, 1), (30, 1), (40, 1), (50, 1), (60, 0), (70, 0), (80, 0), (90, 0), (100, 0), (110, 0), (120, 0), (130, 0), (140, 0), (150, 0), (160, 0), (170, 0), (180, 0), (190, 0), (200, 0), (210, 0), (220, 0), (230, 0), (240, 0), (250, 0), (260, 0), (270, 0), (280, 0), (290, 0), (300, 0), (310, 1), (320, 1), (330, 1), (340, 1), (350, 0), (360, 0), (370, 0), (380, 0), (390, 0), (400, 1), (410, 1), (420, 0), (430, 0), (440, 0), (450, 1), (460, 1), (470, 1), (480, 1), (490, 0), (500, 0), (510, 0), (520, 0), (530, 0), (540, 0), (550, 0), (560, 0), (570, 0), (580, 0), (590, 0), (600, 0), (610, 0), (620, 0), (630, 0), (640, 0), (650, 0), (660, 0), (670, 1), (680, 1), (690, 1), (700, 1), (710, 1), (720, 1), (730, 1), (740, 1), (750, 1), (760, 1), (770, 1), (780, 1), (790, 1), (800, 1), (810, 1), (820, 1), (830, 1), (840, 0), (850, 0), (860, 0), (870, 0), (880, 0), (890, 1), (900, 1), (910, 1), (920, 1), (930, 0), (940, 0), (950, 0), (960, 1), (970, 1), (980, 1), (990, 1), (1000, 1), (1010, 1), (1020, 1), (1030, 1), (1040, 1), (1050, 1), (1060, 1), (1070, 1), (1080, 1), (1090, 1), (1100, 1), (1110, 1), (1120, 1), (1130, 1), (1140, 1), (1150, 1), (1160, 1), (1170, 1), (1180, 1), (1190, 1), (1200, 1), (1210, 1), (1220, 1), (1230, 1), (1240, 1), (1250, 1), (1260, 1), (1270, 1), (1280, 1), (1290, 1), (1300, 1), (1310, 1), (1320, 1), (1330, 1), (1340, 1), (1350, 1), (1360, 1), (1370, 0), (1380, 0), (1390, 0), (1400, 1), (1410, 1), (1420, 1), (1430, 0), (1440, 0), (1450, 0), (1460, 0), (1470, 0), (1480, 1), (1490, 1), (1500, 1), (1510, 1), (1520, 1), (1530, 1), (1540, 1), (1550, 1), (1560, 1), (1570, 0), (1580, 0), (1590, 1), (1600, 1), (1610, 1), (1620, 0), (1630, 0), (1640, 0), (1650, 0), (1660, 0), (1670, 0), (1680, 0), (1690, 1), (1700, 1), (1710, 1), (1720, 1), (1730, 0), (1740, 1), (1750, 1), (1760, 1), (1770, 1), (1780, 1), (1790, 0), (1800, 0), (1810, 0), (1820, 0), (1830, 0), (1840, 0), (1850, 1), (1860, 1), (1870, 1), (1880, 0), (1890, 1), (1900, 1), (1910, 1), (1920, 1), (1930, 1), (1940, 1), (1950, 1), (1960, 1), (1970, 1), (1980, 1), (1990, 1), (2000, 1), (2010, 1), (2020, 1), (2030, 0), (2040, 0), (2050, 0)]
Vdin0_48  din0_48  0 PWL (0n 0.0v 9.495n 0.0v 9.505n 1.8v 19.495n 1.8v 19.505n 1.8v 29.495n 1.8v 29.505n 1.8v 39.495n 1.8v 39.505n 1.8v 49.495n 1.8v 49.505n 1.8v 59.495n 1.8v 59.505n 0.0v 69.495n 0.0v 69.505n 0.0v 79.495n 0.0v 79.505n 0.0v 89.495n 0.0v 89.505n 0.0v 99.495n 0.0v 99.505n 0.0v 109.495n 0.0v 109.505n 0.0v 119.495n 0.0v 119.505n 0.0v 129.495n 0.0v 129.505n 0.0v 139.495n 0.0v 139.505n 0.0v 149.495n 0.0v 149.505n 0.0v 159.495n 0.0v 159.505n 0.0v 169.495n 0.0v 169.505n 0.0v 179.495n 0.0v 179.505n 0.0v 189.495n 0.0v 189.505n 0.0v 199.495n 0.0v 199.505n 0.0v 209.495n 0.0v 209.505n 0.0v 219.495n 0.0v 219.505n 0.0v 229.495n 0.0v 229.505n 0.0v 239.495n 0.0v 239.505n 0.0v 249.495n 0.0v 249.505n 0.0v 259.495n 0.0v 259.505n 0.0v 269.495n 0.0v 269.505n 0.0v 279.495n 0.0v 279.505n 0.0v 289.495n 0.0v 289.505n 0.0v 299.495n 0.0v 299.505n 0.0v 309.495n 0.0v 309.505n 1.8v 319.495n 1.8v 319.505n 1.8v 329.495n 1.8v 329.505n 1.8v 339.495n 1.8v 339.505n 1.8v 349.495n 1.8v 349.505n 0.0v 359.495n 0.0v 359.505n 0.0v 369.495n 0.0v 369.505n 0.0v 379.495n 0.0v 379.505n 0.0v 389.495n 0.0v 389.505n 0.0v 399.495n 0.0v 399.505n 1.8v 409.495n 1.8v 409.505n 1.8v 419.495n 1.8v 419.505n 0.0v 429.495n 0.0v 429.505n 0.0v 439.495n 0.0v 439.505n 0.0v 449.495n 0.0v 449.505n 1.8v 459.495n 1.8v 459.505n 1.8v 469.495n 1.8v 469.505n 1.8v 479.495n 1.8v 479.505n 1.8v 489.495n 1.8v 489.505n 0.0v 499.495n 0.0v 499.505n 0.0v 509.495n 0.0v 509.505n 0.0v 519.495n 0.0v 519.505n 0.0v 529.495n 0.0v 529.505n 0.0v 539.495n 0.0v 539.505n 0.0v 549.495n 0.0v 549.505n 0.0v 559.495n 0.0v 559.505n 0.0v 569.495n 0.0v 569.505n 0.0v 579.495n 0.0v 579.505n 0.0v 589.495n 0.0v 589.505n 0.0v 599.495n 0.0v 599.505n 0.0v 609.495n 0.0v 609.505n 0.0v 619.495n 0.0v 619.505n 0.0v 629.495n 0.0v 629.505n 0.0v 639.495n 0.0v 639.505n 0.0v 649.495n 0.0v 649.505n 0.0v 659.495n 0.0v 659.505n 0.0v 669.495n 0.0v 669.505n 1.8v 679.495n 1.8v 679.505n 1.8v 689.495n 1.8v 689.505n 1.8v 699.495n 1.8v 699.505n 1.8v 709.495n 1.8v 709.505n 1.8v 719.495n 1.8v 719.505n 1.8v 729.495n 1.8v 729.505n 1.8v 739.495n 1.8v 739.505n 1.8v 749.495n 1.8v 749.505n 1.8v 759.495n 1.8v 759.505n 1.8v 769.495n 1.8v 769.505n 1.8v 779.495n 1.8v 779.505n 1.8v 789.495n 1.8v 789.505n 1.8v 799.495n 1.8v 799.505n 1.8v 809.495n 1.8v 809.505n 1.8v 819.495n 1.8v 819.505n 1.8v 829.495n 1.8v 829.505n 1.8v 839.495n 1.8v 839.505n 0.0v 849.495n 0.0v 849.505n 0.0v 859.495n 0.0v 859.505n 0.0v 869.495n 0.0v 869.505n 0.0v 879.495n 0.0v 879.505n 0.0v 889.495n 0.0v 889.505n 1.8v 899.495n 1.8v 899.505n 1.8v 909.495n 1.8v 909.505n 1.8v 919.495n 1.8v 919.505n 1.8v 929.495n 1.8v 929.505n 0.0v 939.495n 0.0v 939.505n 0.0v 949.495n 0.0v 949.505n 0.0v 959.495n 0.0v 959.505n 1.8v 969.495n 1.8v 969.505n 1.8v 979.495n 1.8v 979.505n 1.8v 989.495n 1.8v 989.505n 1.8v 999.495n 1.8v 999.505n 1.8v 1009.495n 1.8v 1009.505n 1.8v 1019.495n 1.8v 1019.505n 1.8v 1029.495n 1.8v 1029.505n 1.8v 1039.495n 1.8v 1039.505n 1.8v 1049.495n 1.8v 1049.505n 1.8v 1059.495n 1.8v 1059.505n 1.8v 1069.495n 1.8v 1069.505n 1.8v 1079.495n 1.8v 1079.505n 1.8v 1089.495n 1.8v 1089.505n 1.8v 1099.495n 1.8v 1099.505n 1.8v 1109.495n 1.8v 1109.505n 1.8v 1119.495n 1.8v 1119.505n 1.8v 1129.495n 1.8v 1129.505n 1.8v 1139.495n 1.8v 1139.505n 1.8v 1149.495n 1.8v 1149.505n 1.8v 1159.495n 1.8v 1159.505n 1.8v 1169.495n 1.8v 1169.505n 1.8v 1179.495n 1.8v 1179.505n 1.8v 1189.495n 1.8v 1189.505n 1.8v 1199.495n 1.8v 1199.505n 1.8v 1209.495n 1.8v 1209.505n 1.8v 1219.495n 1.8v 1219.505n 1.8v 1229.495n 1.8v 1229.505n 1.8v 1239.495n 1.8v 1239.505n 1.8v 1249.495n 1.8v 1249.505n 1.8v 1259.495n 1.8v 1259.505n 1.8v 1269.495n 1.8v 1269.505n 1.8v 1279.495n 1.8v 1279.505n 1.8v 1289.495n 1.8v 1289.505n 1.8v 1299.495n 1.8v 1299.505n 1.8v 1309.495n 1.8v 1309.505n 1.8v 1319.495n 1.8v 1319.505n 1.8v 1329.495n 1.8v 1329.505n 1.8v 1339.495n 1.8v 1339.505n 1.8v 1349.495n 1.8v 1349.505n 1.8v 1359.495n 1.8v 1359.505n 1.8v 1369.495n 1.8v 1369.505n 0.0v 1379.495n 0.0v 1379.505n 0.0v 1389.495n 0.0v 1389.505n 0.0v 1399.495n 0.0v 1399.505n 1.8v 1409.495n 1.8v 1409.505n 1.8v 1419.495n 1.8v 1419.505n 1.8v 1429.495n 1.8v 1429.505n 0.0v 1439.495n 0.0v 1439.505n 0.0v 1449.495n 0.0v 1449.505n 0.0v 1459.495n 0.0v 1459.505n 0.0v 1469.495n 0.0v 1469.505n 0.0v 1479.495n 0.0v 1479.505n 1.8v 1489.495n 1.8v 1489.505n 1.8v 1499.495n 1.8v 1499.505n 1.8v 1509.495n 1.8v 1509.505n 1.8v 1519.495n 1.8v 1519.505n 1.8v 1529.495n 1.8v 1529.505n 1.8v 1539.495n 1.8v 1539.505n 1.8v 1549.495n 1.8v 1549.505n 1.8v 1559.495n 1.8v 1559.505n 1.8v 1569.495n 1.8v 1569.505n 0.0v 1579.495n 0.0v 1579.505n 0.0v 1589.495n 0.0v 1589.505n 1.8v 1599.495n 1.8v 1599.505n 1.8v 1609.495n 1.8v 1609.505n 1.8v 1619.495n 1.8v 1619.505n 0.0v 1629.495n 0.0v 1629.505n 0.0v 1639.495n 0.0v 1639.505n 0.0v 1649.495n 0.0v 1649.505n 0.0v 1659.495n 0.0v 1659.505n 0.0v 1669.495n 0.0v 1669.505n 0.0v 1679.495n 0.0v 1679.505n 0.0v 1689.495n 0.0v 1689.505n 1.8v 1699.495n 1.8v 1699.505n 1.8v 1709.495n 1.8v 1709.505n 1.8v 1719.495n 1.8v 1719.505n 1.8v 1729.495n 1.8v 1729.505n 0.0v 1739.495n 0.0v 1739.505n 1.8v 1749.495n 1.8v 1749.505n 1.8v 1759.495n 1.8v 1759.505n 1.8v 1769.495n 1.8v 1769.505n 1.8v 1779.495n 1.8v 1779.505n 1.8v 1789.495n 1.8v 1789.505n 0.0v 1799.495n 0.0v 1799.505n 0.0v 1809.495n 0.0v 1809.505n 0.0v 1819.495n 0.0v 1819.505n 0.0v 1829.495n 0.0v 1829.505n 0.0v 1839.495n 0.0v 1839.505n 0.0v 1849.495n 0.0v 1849.505n 1.8v 1859.495n 1.8v 1859.505n 1.8v 1869.495n 1.8v 1869.505n 1.8v 1879.495n 1.8v 1879.505n 0.0v 1889.495n 0.0v 1889.505n 1.8v 1899.495n 1.8v 1899.505n 1.8v 1909.495n 1.8v 1909.505n 1.8v 1919.495n 1.8v 1919.505n 1.8v 1929.495n 1.8v 1929.505n 1.8v 1939.495n 1.8v 1939.505n 1.8v 1949.495n 1.8v 1949.505n 1.8v 1959.495n 1.8v 1959.505n 1.8v 1969.495n 1.8v 1969.505n 1.8v 1979.495n 1.8v 1979.505n 1.8v 1989.495n 1.8v 1989.505n 1.8v 1999.495n 1.8v 1999.505n 1.8v 2009.495n 1.8v 2009.505n 1.8v 2019.495n 1.8v 2019.505n 1.8v 2029.495n 1.8v 2029.505n 0.0v 2039.495n 0.0v 2039.505n 0.0v 2049.495n 0.0v 2049.505n 0.0v )
* (time, data): [(0, 0), (10, 0), (20, 0), (30, 1), (40, 1), (50, 1), (60, 1), (70, 1), (80, 1), (90, 1), (100, 1), (110, 1), (120, 1), (130, 1), (140, 1), (150, 0), (160, 0), (170, 0), (180, 0), (190, 0), (200, 0), (210, 0), (220, 0), (230, 0), (240, 0), (250, 0), (260, 0), (270, 0), (280, 0), (290, 0), (300, 0), (310, 1), (320, 1), (330, 1), (340, 1), (350, 0), (360, 0), (370, 0), (380, 0), (390, 1), (400, 0), (410, 0), (420, 0), (430, 0), (440, 0), (450, 0), (460, 0), (470, 0), (480, 0), (490, 1), (500, 0), (510, 0), (520, 0), (530, 0), (540, 0), (550, 0), (560, 0), (570, 0), (580, 0), (590, 0), (600, 0), (610, 0), (620, 1), (630, 1), (640, 1), (650, 1), (660, 1), (670, 1), (680, 1), (690, 1), (700, 1), (710, 1), (720, 1), (730, 1), (740, 1), (750, 1), (760, 1), (770, 0), (780, 0), (790, 0), (800, 0), (810, 0), (820, 1), (830, 1), (840, 0), (850, 0), (860, 0), (870, 0), (880, 0), (890, 0), (900, 0), (910, 0), (920, 0), (930, 1), (940, 1), (950, 1), (960, 1), (970, 1), (980, 1), (990, 1), (1000, 1), (1010, 1), (1020, 1), (1030, 1), (1040, 1), (1050, 1), (1060, 1), (1070, 1), (1080, 1), (1090, 1), (1100, 1), (1110, 1), (1120, 1), (1130, 1), (1140, 1), (1150, 1), (1160, 1), (1170, 1), (1180, 1), (1190, 1), (1200, 1), (1210, 1), (1220, 1), (1230, 1), (1240, 1), (1250, 1), (1260, 0), (1270, 0), (1280, 1), (1290, 1), (1300, 1), (1310, 1), (1320, 1), (1330, 1), (1340, 1), (1350, 1), (1360, 1), (1370, 1), (1380, 1), (1390, 1), (1400, 0), (1410, 0), (1420, 0), (1430, 1), (1440, 1), (1450, 1), (1460, 1), (1470, 1), (1480, 1), (1490, 1), (1500, 0), (1510, 0), (1520, 0), (1530, 0), (1540, 0), (1550, 0), (1560, 0), (1570, 1), (1580, 0), (1590, 0), (1600, 0), (1610, 0), (1620, 1), (1630, 1), (1640, 1), (1650, 1), (1660, 1), (1670, 1), (1680, 1), (1690, 1), (1700, 1), (1710, 1), (1720, 1), (1730, 1), (1740, 1), (1750, 1), (1760, 1), (1770, 1), (1780, 1), (1790, 1), (1800, 1), (1810, 1), (1820, 1), (1830, 1), (1840, 1), (1850, 1), (1860, 1), (1870, 0), (1880, 1), (1890, 1), (1900, 1), (1910, 1), (1920, 1), (1930, 1), (1940, 1), (1950, 1), (1960, 1), (1970, 1), (1980, 1), (1990, 1), (2000, 1), (2010, 1), (2020, 1), (2030, 0), (2040, 0), (2050, 0)]
Vdin0_49  din0_49  0 PWL (0n 0.0v 9.495n 0.0v 9.505n 0.0v 19.495n 0.0v 19.505n 0.0v 29.495n 0.0v 29.505n 1.8v 39.495n 1.8v 39.505n 1.8v 49.495n 1.8v 49.505n 1.8v 59.495n 1.8v 59.505n 1.8v 69.495n 1.8v 69.505n 1.8v 79.495n 1.8v 79.505n 1.8v 89.495n 1.8v 89.505n 1.8v 99.495n 1.8v 99.505n 1.8v 109.495n 1.8v 109.505n 1.8v 119.495n 1.8v 119.505n 1.8v 129.495n 1.8v 129.505n 1.8v 139.495n 1.8v 139.505n 1.8v 149.495n 1.8v 149.505n 0.0v 159.495n 0.0v 159.505n 0.0v 169.495n 0.0v 169.505n 0.0v 179.495n 0.0v 179.505n 0.0v 189.495n 0.0v 189.505n 0.0v 199.495n 0.0v 199.505n 0.0v 209.495n 0.0v 209.505n 0.0v 219.495n 0.0v 219.505n 0.0v 229.495n 0.0v 229.505n 0.0v 239.495n 0.0v 239.505n 0.0v 249.495n 0.0v 249.505n 0.0v 259.495n 0.0v 259.505n 0.0v 269.495n 0.0v 269.505n 0.0v 279.495n 0.0v 279.505n 0.0v 289.495n 0.0v 289.505n 0.0v 299.495n 0.0v 299.505n 0.0v 309.495n 0.0v 309.505n 1.8v 319.495n 1.8v 319.505n 1.8v 329.495n 1.8v 329.505n 1.8v 339.495n 1.8v 339.505n 1.8v 349.495n 1.8v 349.505n 0.0v 359.495n 0.0v 359.505n 0.0v 369.495n 0.0v 369.505n 0.0v 379.495n 0.0v 379.505n 0.0v 389.495n 0.0v 389.505n 1.8v 399.495n 1.8v 399.505n 0.0v 409.495n 0.0v 409.505n 0.0v 419.495n 0.0v 419.505n 0.0v 429.495n 0.0v 429.505n 0.0v 439.495n 0.0v 439.505n 0.0v 449.495n 0.0v 449.505n 0.0v 459.495n 0.0v 459.505n 0.0v 469.495n 0.0v 469.505n 0.0v 479.495n 0.0v 479.505n 0.0v 489.495n 0.0v 489.505n 1.8v 499.495n 1.8v 499.505n 0.0v 509.495n 0.0v 509.505n 0.0v 519.495n 0.0v 519.505n 0.0v 529.495n 0.0v 529.505n 0.0v 539.495n 0.0v 539.505n 0.0v 549.495n 0.0v 549.505n 0.0v 559.495n 0.0v 559.505n 0.0v 569.495n 0.0v 569.505n 0.0v 579.495n 0.0v 579.505n 0.0v 589.495n 0.0v 589.505n 0.0v 599.495n 0.0v 599.505n 0.0v 609.495n 0.0v 609.505n 0.0v 619.495n 0.0v 619.505n 1.8v 629.495n 1.8v 629.505n 1.8v 639.495n 1.8v 639.505n 1.8v 649.495n 1.8v 649.505n 1.8v 659.495n 1.8v 659.505n 1.8v 669.495n 1.8v 669.505n 1.8v 679.495n 1.8v 679.505n 1.8v 689.495n 1.8v 689.505n 1.8v 699.495n 1.8v 699.505n 1.8v 709.495n 1.8v 709.505n 1.8v 719.495n 1.8v 719.505n 1.8v 729.495n 1.8v 729.505n 1.8v 739.495n 1.8v 739.505n 1.8v 749.495n 1.8v 749.505n 1.8v 759.495n 1.8v 759.505n 1.8v 769.495n 1.8v 769.505n 0.0v 779.495n 0.0v 779.505n 0.0v 789.495n 0.0v 789.505n 0.0v 799.495n 0.0v 799.505n 0.0v 809.495n 0.0v 809.505n 0.0v 819.495n 0.0v 819.505n 1.8v 829.495n 1.8v 829.505n 1.8v 839.495n 1.8v 839.505n 0.0v 849.495n 0.0v 849.505n 0.0v 859.495n 0.0v 859.505n 0.0v 869.495n 0.0v 869.505n 0.0v 879.495n 0.0v 879.505n 0.0v 889.495n 0.0v 889.505n 0.0v 899.495n 0.0v 899.505n 0.0v 909.495n 0.0v 909.505n 0.0v 919.495n 0.0v 919.505n 0.0v 929.495n 0.0v 929.505n 1.8v 939.495n 1.8v 939.505n 1.8v 949.495n 1.8v 949.505n 1.8v 959.495n 1.8v 959.505n 1.8v 969.495n 1.8v 969.505n 1.8v 979.495n 1.8v 979.505n 1.8v 989.495n 1.8v 989.505n 1.8v 999.495n 1.8v 999.505n 1.8v 1009.495n 1.8v 1009.505n 1.8v 1019.495n 1.8v 1019.505n 1.8v 1029.495n 1.8v 1029.505n 1.8v 1039.495n 1.8v 1039.505n 1.8v 1049.495n 1.8v 1049.505n 1.8v 1059.495n 1.8v 1059.505n 1.8v 1069.495n 1.8v 1069.505n 1.8v 1079.495n 1.8v 1079.505n 1.8v 1089.495n 1.8v 1089.505n 1.8v 1099.495n 1.8v 1099.505n 1.8v 1109.495n 1.8v 1109.505n 1.8v 1119.495n 1.8v 1119.505n 1.8v 1129.495n 1.8v 1129.505n 1.8v 1139.495n 1.8v 1139.505n 1.8v 1149.495n 1.8v 1149.505n 1.8v 1159.495n 1.8v 1159.505n 1.8v 1169.495n 1.8v 1169.505n 1.8v 1179.495n 1.8v 1179.505n 1.8v 1189.495n 1.8v 1189.505n 1.8v 1199.495n 1.8v 1199.505n 1.8v 1209.495n 1.8v 1209.505n 1.8v 1219.495n 1.8v 1219.505n 1.8v 1229.495n 1.8v 1229.505n 1.8v 1239.495n 1.8v 1239.505n 1.8v 1249.495n 1.8v 1249.505n 1.8v 1259.495n 1.8v 1259.505n 0.0v 1269.495n 0.0v 1269.505n 0.0v 1279.495n 0.0v 1279.505n 1.8v 1289.495n 1.8v 1289.505n 1.8v 1299.495n 1.8v 1299.505n 1.8v 1309.495n 1.8v 1309.505n 1.8v 1319.495n 1.8v 1319.505n 1.8v 1329.495n 1.8v 1329.505n 1.8v 1339.495n 1.8v 1339.505n 1.8v 1349.495n 1.8v 1349.505n 1.8v 1359.495n 1.8v 1359.505n 1.8v 1369.495n 1.8v 1369.505n 1.8v 1379.495n 1.8v 1379.505n 1.8v 1389.495n 1.8v 1389.505n 1.8v 1399.495n 1.8v 1399.505n 0.0v 1409.495n 0.0v 1409.505n 0.0v 1419.495n 0.0v 1419.505n 0.0v 1429.495n 0.0v 1429.505n 1.8v 1439.495n 1.8v 1439.505n 1.8v 1449.495n 1.8v 1449.505n 1.8v 1459.495n 1.8v 1459.505n 1.8v 1469.495n 1.8v 1469.505n 1.8v 1479.495n 1.8v 1479.505n 1.8v 1489.495n 1.8v 1489.505n 1.8v 1499.495n 1.8v 1499.505n 0.0v 1509.495n 0.0v 1509.505n 0.0v 1519.495n 0.0v 1519.505n 0.0v 1529.495n 0.0v 1529.505n 0.0v 1539.495n 0.0v 1539.505n 0.0v 1549.495n 0.0v 1549.505n 0.0v 1559.495n 0.0v 1559.505n 0.0v 1569.495n 0.0v 1569.505n 1.8v 1579.495n 1.8v 1579.505n 0.0v 1589.495n 0.0v 1589.505n 0.0v 1599.495n 0.0v 1599.505n 0.0v 1609.495n 0.0v 1609.505n 0.0v 1619.495n 0.0v 1619.505n 1.8v 1629.495n 1.8v 1629.505n 1.8v 1639.495n 1.8v 1639.505n 1.8v 1649.495n 1.8v 1649.505n 1.8v 1659.495n 1.8v 1659.505n 1.8v 1669.495n 1.8v 1669.505n 1.8v 1679.495n 1.8v 1679.505n 1.8v 1689.495n 1.8v 1689.505n 1.8v 1699.495n 1.8v 1699.505n 1.8v 1709.495n 1.8v 1709.505n 1.8v 1719.495n 1.8v 1719.505n 1.8v 1729.495n 1.8v 1729.505n 1.8v 1739.495n 1.8v 1739.505n 1.8v 1749.495n 1.8v 1749.505n 1.8v 1759.495n 1.8v 1759.505n 1.8v 1769.495n 1.8v 1769.505n 1.8v 1779.495n 1.8v 1779.505n 1.8v 1789.495n 1.8v 1789.505n 1.8v 1799.495n 1.8v 1799.505n 1.8v 1809.495n 1.8v 1809.505n 1.8v 1819.495n 1.8v 1819.505n 1.8v 1829.495n 1.8v 1829.505n 1.8v 1839.495n 1.8v 1839.505n 1.8v 1849.495n 1.8v 1849.505n 1.8v 1859.495n 1.8v 1859.505n 1.8v 1869.495n 1.8v 1869.505n 0.0v 1879.495n 0.0v 1879.505n 1.8v 1889.495n 1.8v 1889.505n 1.8v 1899.495n 1.8v 1899.505n 1.8v 1909.495n 1.8v 1909.505n 1.8v 1919.495n 1.8v 1919.505n 1.8v 1929.495n 1.8v 1929.505n 1.8v 1939.495n 1.8v 1939.505n 1.8v 1949.495n 1.8v 1949.505n 1.8v 1959.495n 1.8v 1959.505n 1.8v 1969.495n 1.8v 1969.505n 1.8v 1979.495n 1.8v 1979.505n 1.8v 1989.495n 1.8v 1989.505n 1.8v 1999.495n 1.8v 1999.505n 1.8v 2009.495n 1.8v 2009.505n 1.8v 2019.495n 1.8v 2019.505n 1.8v 2029.495n 1.8v 2029.505n 0.0v 2039.495n 0.0v 2039.505n 0.0v 2049.495n 0.0v 2049.505n 0.0v )
* (time, data): [(0, 0), (10, 0), (20, 1), (30, 0), (40, 0), (50, 0), (60, 1), (70, 1), (80, 1), (90, 1), (100, 1), (110, 1), (120, 1), (130, 1), (140, 1), (150, 0), (160, 0), (170, 0), (180, 0), (190, 0), (200, 0), (210, 0), (220, 0), (230, 0), (240, 0), (250, 0), (260, 1), (270, 1), (280, 1), (290, 1), (300, 1), (310, 1), (320, 1), (330, 1), (340, 1), (350, 0), (360, 0), (370, 0), (380, 0), (390, 1), (400, 1), (410, 1), (420, 1), (430, 1), (440, 1), (450, 1), (460, 1), (470, 1), (480, 1), (490, 1), (500, 1), (510, 1), (520, 1), (530, 1), (540, 1), (550, 1), (560, 1), (570, 1), (580, 1), (590, 1), (600, 1), (610, 1), (620, 1), (630, 1), (640, 1), (650, 1), (660, 1), (670, 0), (680, 0), (690, 0), (700, 0), (710, 0), (720, 0), (730, 0), (740, 0), (750, 0), (760, 0), (770, 0), (780, 0), (790, 0), (800, 0), (810, 0), (820, 0), (830, 0), (840, 1), (850, 1), (860, 1), (870, 1), (880, 1), (890, 1), (900, 1), (910, 1), (920, 1), (930, 1), (940, 1), (950, 1), (960, 0), (970, 0), (980, 0), (990, 0), (1000, 0), (1010, 0), (1020, 0), (1030, 0), (1040, 0), (1050, 0), (1060, 0), (1070, 0), (1080, 0), (1090, 0), (1100, 0), (1110, 0), (1120, 0), (1130, 0), (1140, 0), (1150, 0), (1160, 0), (1170, 0), (1180, 0), (1190, 0), (1200, 0), (1210, 0), (1220, 0), (1230, 0), (1240, 0), (1250, 0), (1260, 0), (1270, 0), (1280, 0), (1290, 0), (1300, 0), (1310, 0), (1320, 0), (1330, 0), (1340, 0), (1350, 0), (1360, 0), (1370, 0), (1380, 0), (1390, 0), (1400, 0), (1410, 0), (1420, 0), (1430, 1), (1440, 1), (1450, 1), (1460, 1), (1470, 1), (1480, 1), (1490, 1), (1500, 1), (1510, 1), (1520, 1), (1530, 1), (1540, 1), (1550, 1), (1560, 1), (1570, 0), (1580, 1), (1590, 0), (1600, 0), (1610, 0), (1620, 1), (1630, 1), (1640, 1), (1650, 1), (1660, 1), (1670, 1), (1680, 1), (1690, 0), (1700, 0), (1710, 0), (1720, 0), (1730, 0), (1740, 0), (1750, 0), (1760, 0), (1770, 0), (1780, 0), (1790, 0), (1800, 0), (1810, 0), (1820, 0), (1830, 0), (1840, 0), (1850, 1), (1860, 1), (1870, 0), (1880, 1), (1890, 1), (1900, 1), (1910, 1), (1920, 1), (1930, 1), (1940, 1), (1950, 1), (1960, 1), (1970, 1), (1980, 1), (1990, 1), (2000, 1), (2010, 1), (2020, 1), (2030, 1), (2040, 1), (2050, 1)]
Vdin0_50  din0_50  0 PWL (0n 0.0v 9.495n 0.0v 9.505n 0.0v 19.495n 0.0v 19.505n 1.8v 29.495n 1.8v 29.505n 0.0v 39.495n 0.0v 39.505n 0.0v 49.495n 0.0v 49.505n 0.0v 59.495n 0.0v 59.505n 1.8v 69.495n 1.8v 69.505n 1.8v 79.495n 1.8v 79.505n 1.8v 89.495n 1.8v 89.505n 1.8v 99.495n 1.8v 99.505n 1.8v 109.495n 1.8v 109.505n 1.8v 119.495n 1.8v 119.505n 1.8v 129.495n 1.8v 129.505n 1.8v 139.495n 1.8v 139.505n 1.8v 149.495n 1.8v 149.505n 0.0v 159.495n 0.0v 159.505n 0.0v 169.495n 0.0v 169.505n 0.0v 179.495n 0.0v 179.505n 0.0v 189.495n 0.0v 189.505n 0.0v 199.495n 0.0v 199.505n 0.0v 209.495n 0.0v 209.505n 0.0v 219.495n 0.0v 219.505n 0.0v 229.495n 0.0v 229.505n 0.0v 239.495n 0.0v 239.505n 0.0v 249.495n 0.0v 249.505n 0.0v 259.495n 0.0v 259.505n 1.8v 269.495n 1.8v 269.505n 1.8v 279.495n 1.8v 279.505n 1.8v 289.495n 1.8v 289.505n 1.8v 299.495n 1.8v 299.505n 1.8v 309.495n 1.8v 309.505n 1.8v 319.495n 1.8v 319.505n 1.8v 329.495n 1.8v 329.505n 1.8v 339.495n 1.8v 339.505n 1.8v 349.495n 1.8v 349.505n 0.0v 359.495n 0.0v 359.505n 0.0v 369.495n 0.0v 369.505n 0.0v 379.495n 0.0v 379.505n 0.0v 389.495n 0.0v 389.505n 1.8v 399.495n 1.8v 399.505n 1.8v 409.495n 1.8v 409.505n 1.8v 419.495n 1.8v 419.505n 1.8v 429.495n 1.8v 429.505n 1.8v 439.495n 1.8v 439.505n 1.8v 449.495n 1.8v 449.505n 1.8v 459.495n 1.8v 459.505n 1.8v 469.495n 1.8v 469.505n 1.8v 479.495n 1.8v 479.505n 1.8v 489.495n 1.8v 489.505n 1.8v 499.495n 1.8v 499.505n 1.8v 509.495n 1.8v 509.505n 1.8v 519.495n 1.8v 519.505n 1.8v 529.495n 1.8v 529.505n 1.8v 539.495n 1.8v 539.505n 1.8v 549.495n 1.8v 549.505n 1.8v 559.495n 1.8v 559.505n 1.8v 569.495n 1.8v 569.505n 1.8v 579.495n 1.8v 579.505n 1.8v 589.495n 1.8v 589.505n 1.8v 599.495n 1.8v 599.505n 1.8v 609.495n 1.8v 609.505n 1.8v 619.495n 1.8v 619.505n 1.8v 629.495n 1.8v 629.505n 1.8v 639.495n 1.8v 639.505n 1.8v 649.495n 1.8v 649.505n 1.8v 659.495n 1.8v 659.505n 1.8v 669.495n 1.8v 669.505n 0.0v 679.495n 0.0v 679.505n 0.0v 689.495n 0.0v 689.505n 0.0v 699.495n 0.0v 699.505n 0.0v 709.495n 0.0v 709.505n 0.0v 719.495n 0.0v 719.505n 0.0v 729.495n 0.0v 729.505n 0.0v 739.495n 0.0v 739.505n 0.0v 749.495n 0.0v 749.505n 0.0v 759.495n 0.0v 759.505n 0.0v 769.495n 0.0v 769.505n 0.0v 779.495n 0.0v 779.505n 0.0v 789.495n 0.0v 789.505n 0.0v 799.495n 0.0v 799.505n 0.0v 809.495n 0.0v 809.505n 0.0v 819.495n 0.0v 819.505n 0.0v 829.495n 0.0v 829.505n 0.0v 839.495n 0.0v 839.505n 1.8v 849.495n 1.8v 849.505n 1.8v 859.495n 1.8v 859.505n 1.8v 869.495n 1.8v 869.505n 1.8v 879.495n 1.8v 879.505n 1.8v 889.495n 1.8v 889.505n 1.8v 899.495n 1.8v 899.505n 1.8v 909.495n 1.8v 909.505n 1.8v 919.495n 1.8v 919.505n 1.8v 929.495n 1.8v 929.505n 1.8v 939.495n 1.8v 939.505n 1.8v 949.495n 1.8v 949.505n 1.8v 959.495n 1.8v 959.505n 0.0v 969.495n 0.0v 969.505n 0.0v 979.495n 0.0v 979.505n 0.0v 989.495n 0.0v 989.505n 0.0v 999.495n 0.0v 999.505n 0.0v 1009.495n 0.0v 1009.505n 0.0v 1019.495n 0.0v 1019.505n 0.0v 1029.495n 0.0v 1029.505n 0.0v 1039.495n 0.0v 1039.505n 0.0v 1049.495n 0.0v 1049.505n 0.0v 1059.495n 0.0v 1059.505n 0.0v 1069.495n 0.0v 1069.505n 0.0v 1079.495n 0.0v 1079.505n 0.0v 1089.495n 0.0v 1089.505n 0.0v 1099.495n 0.0v 1099.505n 0.0v 1109.495n 0.0v 1109.505n 0.0v 1119.495n 0.0v 1119.505n 0.0v 1129.495n 0.0v 1129.505n 0.0v 1139.495n 0.0v 1139.505n 0.0v 1149.495n 0.0v 1149.505n 0.0v 1159.495n 0.0v 1159.505n 0.0v 1169.495n 0.0v 1169.505n 0.0v 1179.495n 0.0v 1179.505n 0.0v 1189.495n 0.0v 1189.505n 0.0v 1199.495n 0.0v 1199.505n 0.0v 1209.495n 0.0v 1209.505n 0.0v 1219.495n 0.0v 1219.505n 0.0v 1229.495n 0.0v 1229.505n 0.0v 1239.495n 0.0v 1239.505n 0.0v 1249.495n 0.0v 1249.505n 0.0v 1259.495n 0.0v 1259.505n 0.0v 1269.495n 0.0v 1269.505n 0.0v 1279.495n 0.0v 1279.505n 0.0v 1289.495n 0.0v 1289.505n 0.0v 1299.495n 0.0v 1299.505n 0.0v 1309.495n 0.0v 1309.505n 0.0v 1319.495n 0.0v 1319.505n 0.0v 1329.495n 0.0v 1329.505n 0.0v 1339.495n 0.0v 1339.505n 0.0v 1349.495n 0.0v 1349.505n 0.0v 1359.495n 0.0v 1359.505n 0.0v 1369.495n 0.0v 1369.505n 0.0v 1379.495n 0.0v 1379.505n 0.0v 1389.495n 0.0v 1389.505n 0.0v 1399.495n 0.0v 1399.505n 0.0v 1409.495n 0.0v 1409.505n 0.0v 1419.495n 0.0v 1419.505n 0.0v 1429.495n 0.0v 1429.505n 1.8v 1439.495n 1.8v 1439.505n 1.8v 1449.495n 1.8v 1449.505n 1.8v 1459.495n 1.8v 1459.505n 1.8v 1469.495n 1.8v 1469.505n 1.8v 1479.495n 1.8v 1479.505n 1.8v 1489.495n 1.8v 1489.505n 1.8v 1499.495n 1.8v 1499.505n 1.8v 1509.495n 1.8v 1509.505n 1.8v 1519.495n 1.8v 1519.505n 1.8v 1529.495n 1.8v 1529.505n 1.8v 1539.495n 1.8v 1539.505n 1.8v 1549.495n 1.8v 1549.505n 1.8v 1559.495n 1.8v 1559.505n 1.8v 1569.495n 1.8v 1569.505n 0.0v 1579.495n 0.0v 1579.505n 1.8v 1589.495n 1.8v 1589.505n 0.0v 1599.495n 0.0v 1599.505n 0.0v 1609.495n 0.0v 1609.505n 0.0v 1619.495n 0.0v 1619.505n 1.8v 1629.495n 1.8v 1629.505n 1.8v 1639.495n 1.8v 1639.505n 1.8v 1649.495n 1.8v 1649.505n 1.8v 1659.495n 1.8v 1659.505n 1.8v 1669.495n 1.8v 1669.505n 1.8v 1679.495n 1.8v 1679.505n 1.8v 1689.495n 1.8v 1689.505n 0.0v 1699.495n 0.0v 1699.505n 0.0v 1709.495n 0.0v 1709.505n 0.0v 1719.495n 0.0v 1719.505n 0.0v 1729.495n 0.0v 1729.505n 0.0v 1739.495n 0.0v 1739.505n 0.0v 1749.495n 0.0v 1749.505n 0.0v 1759.495n 0.0v 1759.505n 0.0v 1769.495n 0.0v 1769.505n 0.0v 1779.495n 0.0v 1779.505n 0.0v 1789.495n 0.0v 1789.505n 0.0v 1799.495n 0.0v 1799.505n 0.0v 1809.495n 0.0v 1809.505n 0.0v 1819.495n 0.0v 1819.505n 0.0v 1829.495n 0.0v 1829.505n 0.0v 1839.495n 0.0v 1839.505n 0.0v 1849.495n 0.0v 1849.505n 1.8v 1859.495n 1.8v 1859.505n 1.8v 1869.495n 1.8v 1869.505n 0.0v 1879.495n 0.0v 1879.505n 1.8v 1889.495n 1.8v 1889.505n 1.8v 1899.495n 1.8v 1899.505n 1.8v 1909.495n 1.8v 1909.505n 1.8v 1919.495n 1.8v 1919.505n 1.8v 1929.495n 1.8v 1929.505n 1.8v 1939.495n 1.8v 1939.505n 1.8v 1949.495n 1.8v 1949.505n 1.8v 1959.495n 1.8v 1959.505n 1.8v 1969.495n 1.8v 1969.505n 1.8v 1979.495n 1.8v 1979.505n 1.8v 1989.495n 1.8v 1989.505n 1.8v 1999.495n 1.8v 1999.505n 1.8v 2009.495n 1.8v 2009.505n 1.8v 2019.495n 1.8v 2019.505n 1.8v 2029.495n 1.8v 2029.505n 1.8v 2039.495n 1.8v 2039.505n 1.8v 2049.495n 1.8v 2049.505n 1.8v )
* (time, data): [(0, 0), (10, 0), (20, 0), (30, 0), (40, 0), (50, 0), (60, 1), (70, 1), (80, 1), (90, 1), (100, 1), (110, 1), (120, 1), (130, 1), (140, 1), (150, 0), (160, 0), (170, 0), (180, 0), (190, 0), (200, 0), (210, 0), (220, 0), (230, 0), (240, 0), (250, 0), (260, 1), (270, 1), (280, 1), (290, 1), (300, 1), (310, 1), (320, 1), (330, 1), (340, 1), (350, 1), (360, 1), (370, 1), (380, 1), (390, 1), (400, 0), (410, 0), (420, 0), (430, 0), (440, 0), (450, 1), (460, 1), (470, 1), (480, 1), (490, 0), (500, 1), (510, 1), (520, 1), (530, 1), (540, 1), (550, 1), (560, 1), (570, 1), (580, 1), (590, 1), (600, 1), (610, 1), (620, 0), (630, 0), (640, 0), (650, 0), (660, 1), (670, 0), (680, 0), (690, 0), (700, 0), (710, 0), (720, 0), (730, 0), (740, 0), (750, 0), (760, 0), (770, 0), (780, 0), (790, 0), (800, 0), (810, 0), (820, 0), (830, 0), (840, 0), (850, 0), (860, 0), (870, 0), (880, 0), (890, 1), (900, 1), (910, 1), (920, 1), (930, 0), (940, 0), (950, 0), (960, 0), (970, 0), (980, 0), (990, 0), (1000, 0), (1010, 0), (1020, 0), (1030, 0), (1040, 0), (1050, 0), (1060, 0), (1070, 0), (1080, 0), (1090, 0), (1100, 0), (1110, 0), (1120, 0), (1130, 1), (1140, 1), (1150, 1), (1160, 1), (1170, 1), (1180, 1), (1190, 1), (1200, 1), (1210, 1), (1220, 1), (1230, 1), (1240, 1), (1250, 1), (1260, 0), (1270, 0), (1280, 1), (1290, 1), (1300, 1), (1310, 1), (1320, 1), (1330, 1), (1340, 1), (1350, 1), (1360, 1), (1370, 0), (1380, 0), (1390, 0), (1400, 1), (1410, 1), (1420, 1), (1430, 0), (1440, 0), (1450, 0), (1460, 0), (1470, 0), (1480, 1), (1490, 1), (1500, 1), (1510, 1), (1520, 1), (1530, 1), (1540, 1), (1550, 1), (1560, 1), (1570, 0), (1580, 0), (1590, 1), (1600, 1), (1610, 1), (1620, 0), (1630, 0), (1640, 0), (1650, 0), (1660, 0), (1670, 0), (1680, 0), (1690, 0), (1700, 0), (1710, 1), (1720, 1), (1730, 1), (1740, 0), (1750, 0), (1760, 0), (1770, 0), (1780, 0), (1790, 0), (1800, 0), (1810, 0), (1820, 0), (1830, 0), (1840, 0), (1850, 0), (1860, 1), (1870, 0), (1880, 1), (1890, 0), (1900, 0), (1910, 1), (1920, 1), (1930, 1), (1940, 1), (1950, 1), (1960, 1), (1970, 1), (1980, 1), (1990, 1), (2000, 1), (2010, 1), (2020, 1), (2030, 1), (2040, 1), (2050, 1)]
Vdin0_51  din0_51  0 PWL (0n 0.0v 9.495n 0.0v 9.505n 0.0v 19.495n 0.0v 19.505n 0.0v 29.495n 0.0v 29.505n 0.0v 39.495n 0.0v 39.505n 0.0v 49.495n 0.0v 49.505n 0.0v 59.495n 0.0v 59.505n 1.8v 69.495n 1.8v 69.505n 1.8v 79.495n 1.8v 79.505n 1.8v 89.495n 1.8v 89.505n 1.8v 99.495n 1.8v 99.505n 1.8v 109.495n 1.8v 109.505n 1.8v 119.495n 1.8v 119.505n 1.8v 129.495n 1.8v 129.505n 1.8v 139.495n 1.8v 139.505n 1.8v 149.495n 1.8v 149.505n 0.0v 159.495n 0.0v 159.505n 0.0v 169.495n 0.0v 169.505n 0.0v 179.495n 0.0v 179.505n 0.0v 189.495n 0.0v 189.505n 0.0v 199.495n 0.0v 199.505n 0.0v 209.495n 0.0v 209.505n 0.0v 219.495n 0.0v 219.505n 0.0v 229.495n 0.0v 229.505n 0.0v 239.495n 0.0v 239.505n 0.0v 249.495n 0.0v 249.505n 0.0v 259.495n 0.0v 259.505n 1.8v 269.495n 1.8v 269.505n 1.8v 279.495n 1.8v 279.505n 1.8v 289.495n 1.8v 289.505n 1.8v 299.495n 1.8v 299.505n 1.8v 309.495n 1.8v 309.505n 1.8v 319.495n 1.8v 319.505n 1.8v 329.495n 1.8v 329.505n 1.8v 339.495n 1.8v 339.505n 1.8v 349.495n 1.8v 349.505n 1.8v 359.495n 1.8v 359.505n 1.8v 369.495n 1.8v 369.505n 1.8v 379.495n 1.8v 379.505n 1.8v 389.495n 1.8v 389.505n 1.8v 399.495n 1.8v 399.505n 0.0v 409.495n 0.0v 409.505n 0.0v 419.495n 0.0v 419.505n 0.0v 429.495n 0.0v 429.505n 0.0v 439.495n 0.0v 439.505n 0.0v 449.495n 0.0v 449.505n 1.8v 459.495n 1.8v 459.505n 1.8v 469.495n 1.8v 469.505n 1.8v 479.495n 1.8v 479.505n 1.8v 489.495n 1.8v 489.505n 0.0v 499.495n 0.0v 499.505n 1.8v 509.495n 1.8v 509.505n 1.8v 519.495n 1.8v 519.505n 1.8v 529.495n 1.8v 529.505n 1.8v 539.495n 1.8v 539.505n 1.8v 549.495n 1.8v 549.505n 1.8v 559.495n 1.8v 559.505n 1.8v 569.495n 1.8v 569.505n 1.8v 579.495n 1.8v 579.505n 1.8v 589.495n 1.8v 589.505n 1.8v 599.495n 1.8v 599.505n 1.8v 609.495n 1.8v 609.505n 1.8v 619.495n 1.8v 619.505n 0.0v 629.495n 0.0v 629.505n 0.0v 639.495n 0.0v 639.505n 0.0v 649.495n 0.0v 649.505n 0.0v 659.495n 0.0v 659.505n 1.8v 669.495n 1.8v 669.505n 0.0v 679.495n 0.0v 679.505n 0.0v 689.495n 0.0v 689.505n 0.0v 699.495n 0.0v 699.505n 0.0v 709.495n 0.0v 709.505n 0.0v 719.495n 0.0v 719.505n 0.0v 729.495n 0.0v 729.505n 0.0v 739.495n 0.0v 739.505n 0.0v 749.495n 0.0v 749.505n 0.0v 759.495n 0.0v 759.505n 0.0v 769.495n 0.0v 769.505n 0.0v 779.495n 0.0v 779.505n 0.0v 789.495n 0.0v 789.505n 0.0v 799.495n 0.0v 799.505n 0.0v 809.495n 0.0v 809.505n 0.0v 819.495n 0.0v 819.505n 0.0v 829.495n 0.0v 829.505n 0.0v 839.495n 0.0v 839.505n 0.0v 849.495n 0.0v 849.505n 0.0v 859.495n 0.0v 859.505n 0.0v 869.495n 0.0v 869.505n 0.0v 879.495n 0.0v 879.505n 0.0v 889.495n 0.0v 889.505n 1.8v 899.495n 1.8v 899.505n 1.8v 909.495n 1.8v 909.505n 1.8v 919.495n 1.8v 919.505n 1.8v 929.495n 1.8v 929.505n 0.0v 939.495n 0.0v 939.505n 0.0v 949.495n 0.0v 949.505n 0.0v 959.495n 0.0v 959.505n 0.0v 969.495n 0.0v 969.505n 0.0v 979.495n 0.0v 979.505n 0.0v 989.495n 0.0v 989.505n 0.0v 999.495n 0.0v 999.505n 0.0v 1009.495n 0.0v 1009.505n 0.0v 1019.495n 0.0v 1019.505n 0.0v 1029.495n 0.0v 1029.505n 0.0v 1039.495n 0.0v 1039.505n 0.0v 1049.495n 0.0v 1049.505n 0.0v 1059.495n 0.0v 1059.505n 0.0v 1069.495n 0.0v 1069.505n 0.0v 1079.495n 0.0v 1079.505n 0.0v 1089.495n 0.0v 1089.505n 0.0v 1099.495n 0.0v 1099.505n 0.0v 1109.495n 0.0v 1109.505n 0.0v 1119.495n 0.0v 1119.505n 0.0v 1129.495n 0.0v 1129.505n 1.8v 1139.495n 1.8v 1139.505n 1.8v 1149.495n 1.8v 1149.505n 1.8v 1159.495n 1.8v 1159.505n 1.8v 1169.495n 1.8v 1169.505n 1.8v 1179.495n 1.8v 1179.505n 1.8v 1189.495n 1.8v 1189.505n 1.8v 1199.495n 1.8v 1199.505n 1.8v 1209.495n 1.8v 1209.505n 1.8v 1219.495n 1.8v 1219.505n 1.8v 1229.495n 1.8v 1229.505n 1.8v 1239.495n 1.8v 1239.505n 1.8v 1249.495n 1.8v 1249.505n 1.8v 1259.495n 1.8v 1259.505n 0.0v 1269.495n 0.0v 1269.505n 0.0v 1279.495n 0.0v 1279.505n 1.8v 1289.495n 1.8v 1289.505n 1.8v 1299.495n 1.8v 1299.505n 1.8v 1309.495n 1.8v 1309.505n 1.8v 1319.495n 1.8v 1319.505n 1.8v 1329.495n 1.8v 1329.505n 1.8v 1339.495n 1.8v 1339.505n 1.8v 1349.495n 1.8v 1349.505n 1.8v 1359.495n 1.8v 1359.505n 1.8v 1369.495n 1.8v 1369.505n 0.0v 1379.495n 0.0v 1379.505n 0.0v 1389.495n 0.0v 1389.505n 0.0v 1399.495n 0.0v 1399.505n 1.8v 1409.495n 1.8v 1409.505n 1.8v 1419.495n 1.8v 1419.505n 1.8v 1429.495n 1.8v 1429.505n 0.0v 1439.495n 0.0v 1439.505n 0.0v 1449.495n 0.0v 1449.505n 0.0v 1459.495n 0.0v 1459.505n 0.0v 1469.495n 0.0v 1469.505n 0.0v 1479.495n 0.0v 1479.505n 1.8v 1489.495n 1.8v 1489.505n 1.8v 1499.495n 1.8v 1499.505n 1.8v 1509.495n 1.8v 1509.505n 1.8v 1519.495n 1.8v 1519.505n 1.8v 1529.495n 1.8v 1529.505n 1.8v 1539.495n 1.8v 1539.505n 1.8v 1549.495n 1.8v 1549.505n 1.8v 1559.495n 1.8v 1559.505n 1.8v 1569.495n 1.8v 1569.505n 0.0v 1579.495n 0.0v 1579.505n 0.0v 1589.495n 0.0v 1589.505n 1.8v 1599.495n 1.8v 1599.505n 1.8v 1609.495n 1.8v 1609.505n 1.8v 1619.495n 1.8v 1619.505n 0.0v 1629.495n 0.0v 1629.505n 0.0v 1639.495n 0.0v 1639.505n 0.0v 1649.495n 0.0v 1649.505n 0.0v 1659.495n 0.0v 1659.505n 0.0v 1669.495n 0.0v 1669.505n 0.0v 1679.495n 0.0v 1679.505n 0.0v 1689.495n 0.0v 1689.505n 0.0v 1699.495n 0.0v 1699.505n 0.0v 1709.495n 0.0v 1709.505n 1.8v 1719.495n 1.8v 1719.505n 1.8v 1729.495n 1.8v 1729.505n 1.8v 1739.495n 1.8v 1739.505n 0.0v 1749.495n 0.0v 1749.505n 0.0v 1759.495n 0.0v 1759.505n 0.0v 1769.495n 0.0v 1769.505n 0.0v 1779.495n 0.0v 1779.505n 0.0v 1789.495n 0.0v 1789.505n 0.0v 1799.495n 0.0v 1799.505n 0.0v 1809.495n 0.0v 1809.505n 0.0v 1819.495n 0.0v 1819.505n 0.0v 1829.495n 0.0v 1829.505n 0.0v 1839.495n 0.0v 1839.505n 0.0v 1849.495n 0.0v 1849.505n 0.0v 1859.495n 0.0v 1859.505n 1.8v 1869.495n 1.8v 1869.505n 0.0v 1879.495n 0.0v 1879.505n 1.8v 1889.495n 1.8v 1889.505n 0.0v 1899.495n 0.0v 1899.505n 0.0v 1909.495n 0.0v 1909.505n 1.8v 1919.495n 1.8v 1919.505n 1.8v 1929.495n 1.8v 1929.505n 1.8v 1939.495n 1.8v 1939.505n 1.8v 1949.495n 1.8v 1949.505n 1.8v 1959.495n 1.8v 1959.505n 1.8v 1969.495n 1.8v 1969.505n 1.8v 1979.495n 1.8v 1979.505n 1.8v 1989.495n 1.8v 1989.505n 1.8v 1999.495n 1.8v 1999.505n 1.8v 2009.495n 1.8v 2009.505n 1.8v 2019.495n 1.8v 2019.505n 1.8v 2029.495n 1.8v 2029.505n 1.8v 2039.495n 1.8v 2039.505n 1.8v 2049.495n 1.8v 2049.505n 1.8v )
* (time, data): [(0, 0), (10, 1), (20, 1), (30, 0), (40, 0), (50, 0), (60, 0), (70, 0), (80, 0), (90, 0), (100, 0), (110, 0), (120, 0), (130, 0), (140, 0), (150, 1), (160, 1), (170, 1), (180, 1), (190, 1), (200, 1), (210, 1), (220, 1), (230, 1), (240, 1), (250, 1), (260, 1), (270, 1), (280, 1), (290, 1), (300, 1), (310, 0), (320, 0), (330, 0), (340, 0), (350, 0), (360, 0), (370, 0), (380, 0), (390, 1), (400, 0), (410, 0), (420, 0), (430, 0), (440, 0), (450, 0), (460, 0), (470, 1), (480, 1), (490, 1), (500, 1), (510, 1), (520, 1), (530, 1), (540, 1), (550, 1), (560, 1), (570, 1), (580, 1), (590, 1), (600, 1), (610, 1), (620, 1), (630, 1), (640, 1), (650, 1), (660, 0), (670, 1), (680, 1), (690, 1), (700, 1), (710, 1), (720, 1), (730, 1), (740, 1), (750, 1), (760, 1), (770, 0), (780, 0), (790, 0), (800, 0), (810, 0), (820, 0), (830, 0), (840, 1), (850, 1), (860, 1), (870, 1), (880, 1), (890, 1), (900, 1), (910, 1), (920, 1), (930, 0), (940, 0), (950, 0), (960, 1), (970, 1), (980, 1), (990, 1), (1000, 1), (1010, 1), (1020, 1), (1030, 1), (1040, 1), (1050, 1), (1060, 1), (1070, 1), (1080, 0), (1090, 0), (1100, 0), (1110, 0), (1120, 0), (1130, 1), (1140, 1), (1150, 1), (1160, 1), (1170, 1), (1180, 1), (1190, 1), (1200, 1), (1210, 1), (1220, 1), (1230, 1), (1240, 1), (1250, 1), (1260, 1), (1270, 1), (1280, 0), (1290, 0), (1300, 0), (1310, 0), (1320, 0), (1330, 0), (1340, 0), (1350, 0), (1360, 0), (1370, 1), (1380, 1), (1390, 1), (1400, 1), (1410, 1), (1420, 1), (1430, 0), (1440, 0), (1450, 0), (1460, 0), (1470, 0), (1480, 0), (1490, 0), (1500, 1), (1510, 1), (1520, 1), (1530, 1), (1540, 1), (1550, 1), (1560, 1), (1570, 0), (1580, 0), (1590, 0), (1600, 0), (1610, 0), (1620, 0), (1630, 0), (1640, 0), (1650, 0), (1660, 0), (1670, 0), (1680, 0), (1690, 1), (1700, 1), (1710, 1), (1720, 1), (1730, 0), (1740, 0), (1750, 0), (1760, 0), (1770, 0), (1780, 0), (1790, 0), (1800, 0), (1810, 0), (1820, 0), (1830, 0), (1840, 0), (1850, 0), (1860, 0), (1870, 0), (1880, 0), (1890, 1), (1900, 1), (1910, 1), (1920, 1), (1930, 1), (1940, 1), (1950, 1), (1960, 1), (1970, 1), (1980, 1), (1990, 1), (2000, 1), (2010, 1), (2020, 1), (2030, 0), (2040, 0), (2050, 0)]
Vdin0_52  din0_52  0 PWL (0n 0.0v 9.495n 0.0v 9.505n 1.8v 19.495n 1.8v 19.505n 1.8v 29.495n 1.8v 29.505n 0.0v 39.495n 0.0v 39.505n 0.0v 49.495n 0.0v 49.505n 0.0v 59.495n 0.0v 59.505n 0.0v 69.495n 0.0v 69.505n 0.0v 79.495n 0.0v 79.505n 0.0v 89.495n 0.0v 89.505n 0.0v 99.495n 0.0v 99.505n 0.0v 109.495n 0.0v 109.505n 0.0v 119.495n 0.0v 119.505n 0.0v 129.495n 0.0v 129.505n 0.0v 139.495n 0.0v 139.505n 0.0v 149.495n 0.0v 149.505n 1.8v 159.495n 1.8v 159.505n 1.8v 169.495n 1.8v 169.505n 1.8v 179.495n 1.8v 179.505n 1.8v 189.495n 1.8v 189.505n 1.8v 199.495n 1.8v 199.505n 1.8v 209.495n 1.8v 209.505n 1.8v 219.495n 1.8v 219.505n 1.8v 229.495n 1.8v 229.505n 1.8v 239.495n 1.8v 239.505n 1.8v 249.495n 1.8v 249.505n 1.8v 259.495n 1.8v 259.505n 1.8v 269.495n 1.8v 269.505n 1.8v 279.495n 1.8v 279.505n 1.8v 289.495n 1.8v 289.505n 1.8v 299.495n 1.8v 299.505n 1.8v 309.495n 1.8v 309.505n 0.0v 319.495n 0.0v 319.505n 0.0v 329.495n 0.0v 329.505n 0.0v 339.495n 0.0v 339.505n 0.0v 349.495n 0.0v 349.505n 0.0v 359.495n 0.0v 359.505n 0.0v 369.495n 0.0v 369.505n 0.0v 379.495n 0.0v 379.505n 0.0v 389.495n 0.0v 389.505n 1.8v 399.495n 1.8v 399.505n 0.0v 409.495n 0.0v 409.505n 0.0v 419.495n 0.0v 419.505n 0.0v 429.495n 0.0v 429.505n 0.0v 439.495n 0.0v 439.505n 0.0v 449.495n 0.0v 449.505n 0.0v 459.495n 0.0v 459.505n 0.0v 469.495n 0.0v 469.505n 1.8v 479.495n 1.8v 479.505n 1.8v 489.495n 1.8v 489.505n 1.8v 499.495n 1.8v 499.505n 1.8v 509.495n 1.8v 509.505n 1.8v 519.495n 1.8v 519.505n 1.8v 529.495n 1.8v 529.505n 1.8v 539.495n 1.8v 539.505n 1.8v 549.495n 1.8v 549.505n 1.8v 559.495n 1.8v 559.505n 1.8v 569.495n 1.8v 569.505n 1.8v 579.495n 1.8v 579.505n 1.8v 589.495n 1.8v 589.505n 1.8v 599.495n 1.8v 599.505n 1.8v 609.495n 1.8v 609.505n 1.8v 619.495n 1.8v 619.505n 1.8v 629.495n 1.8v 629.505n 1.8v 639.495n 1.8v 639.505n 1.8v 649.495n 1.8v 649.505n 1.8v 659.495n 1.8v 659.505n 0.0v 669.495n 0.0v 669.505n 1.8v 679.495n 1.8v 679.505n 1.8v 689.495n 1.8v 689.505n 1.8v 699.495n 1.8v 699.505n 1.8v 709.495n 1.8v 709.505n 1.8v 719.495n 1.8v 719.505n 1.8v 729.495n 1.8v 729.505n 1.8v 739.495n 1.8v 739.505n 1.8v 749.495n 1.8v 749.505n 1.8v 759.495n 1.8v 759.505n 1.8v 769.495n 1.8v 769.505n 0.0v 779.495n 0.0v 779.505n 0.0v 789.495n 0.0v 789.505n 0.0v 799.495n 0.0v 799.505n 0.0v 809.495n 0.0v 809.505n 0.0v 819.495n 0.0v 819.505n 0.0v 829.495n 0.0v 829.505n 0.0v 839.495n 0.0v 839.505n 1.8v 849.495n 1.8v 849.505n 1.8v 859.495n 1.8v 859.505n 1.8v 869.495n 1.8v 869.505n 1.8v 879.495n 1.8v 879.505n 1.8v 889.495n 1.8v 889.505n 1.8v 899.495n 1.8v 899.505n 1.8v 909.495n 1.8v 909.505n 1.8v 919.495n 1.8v 919.505n 1.8v 929.495n 1.8v 929.505n 0.0v 939.495n 0.0v 939.505n 0.0v 949.495n 0.0v 949.505n 0.0v 959.495n 0.0v 959.505n 1.8v 969.495n 1.8v 969.505n 1.8v 979.495n 1.8v 979.505n 1.8v 989.495n 1.8v 989.505n 1.8v 999.495n 1.8v 999.505n 1.8v 1009.495n 1.8v 1009.505n 1.8v 1019.495n 1.8v 1019.505n 1.8v 1029.495n 1.8v 1029.505n 1.8v 1039.495n 1.8v 1039.505n 1.8v 1049.495n 1.8v 1049.505n 1.8v 1059.495n 1.8v 1059.505n 1.8v 1069.495n 1.8v 1069.505n 1.8v 1079.495n 1.8v 1079.505n 0.0v 1089.495n 0.0v 1089.505n 0.0v 1099.495n 0.0v 1099.505n 0.0v 1109.495n 0.0v 1109.505n 0.0v 1119.495n 0.0v 1119.505n 0.0v 1129.495n 0.0v 1129.505n 1.8v 1139.495n 1.8v 1139.505n 1.8v 1149.495n 1.8v 1149.505n 1.8v 1159.495n 1.8v 1159.505n 1.8v 1169.495n 1.8v 1169.505n 1.8v 1179.495n 1.8v 1179.505n 1.8v 1189.495n 1.8v 1189.505n 1.8v 1199.495n 1.8v 1199.505n 1.8v 1209.495n 1.8v 1209.505n 1.8v 1219.495n 1.8v 1219.505n 1.8v 1229.495n 1.8v 1229.505n 1.8v 1239.495n 1.8v 1239.505n 1.8v 1249.495n 1.8v 1249.505n 1.8v 1259.495n 1.8v 1259.505n 1.8v 1269.495n 1.8v 1269.505n 1.8v 1279.495n 1.8v 1279.505n 0.0v 1289.495n 0.0v 1289.505n 0.0v 1299.495n 0.0v 1299.505n 0.0v 1309.495n 0.0v 1309.505n 0.0v 1319.495n 0.0v 1319.505n 0.0v 1329.495n 0.0v 1329.505n 0.0v 1339.495n 0.0v 1339.505n 0.0v 1349.495n 0.0v 1349.505n 0.0v 1359.495n 0.0v 1359.505n 0.0v 1369.495n 0.0v 1369.505n 1.8v 1379.495n 1.8v 1379.505n 1.8v 1389.495n 1.8v 1389.505n 1.8v 1399.495n 1.8v 1399.505n 1.8v 1409.495n 1.8v 1409.505n 1.8v 1419.495n 1.8v 1419.505n 1.8v 1429.495n 1.8v 1429.505n 0.0v 1439.495n 0.0v 1439.505n 0.0v 1449.495n 0.0v 1449.505n 0.0v 1459.495n 0.0v 1459.505n 0.0v 1469.495n 0.0v 1469.505n 0.0v 1479.495n 0.0v 1479.505n 0.0v 1489.495n 0.0v 1489.505n 0.0v 1499.495n 0.0v 1499.505n 1.8v 1509.495n 1.8v 1509.505n 1.8v 1519.495n 1.8v 1519.505n 1.8v 1529.495n 1.8v 1529.505n 1.8v 1539.495n 1.8v 1539.505n 1.8v 1549.495n 1.8v 1549.505n 1.8v 1559.495n 1.8v 1559.505n 1.8v 1569.495n 1.8v 1569.505n 0.0v 1579.495n 0.0v 1579.505n 0.0v 1589.495n 0.0v 1589.505n 0.0v 1599.495n 0.0v 1599.505n 0.0v 1609.495n 0.0v 1609.505n 0.0v 1619.495n 0.0v 1619.505n 0.0v 1629.495n 0.0v 1629.505n 0.0v 1639.495n 0.0v 1639.505n 0.0v 1649.495n 0.0v 1649.505n 0.0v 1659.495n 0.0v 1659.505n 0.0v 1669.495n 0.0v 1669.505n 0.0v 1679.495n 0.0v 1679.505n 0.0v 1689.495n 0.0v 1689.505n 1.8v 1699.495n 1.8v 1699.505n 1.8v 1709.495n 1.8v 1709.505n 1.8v 1719.495n 1.8v 1719.505n 1.8v 1729.495n 1.8v 1729.505n 0.0v 1739.495n 0.0v 1739.505n 0.0v 1749.495n 0.0v 1749.505n 0.0v 1759.495n 0.0v 1759.505n 0.0v 1769.495n 0.0v 1769.505n 0.0v 1779.495n 0.0v 1779.505n 0.0v 1789.495n 0.0v 1789.505n 0.0v 1799.495n 0.0v 1799.505n 0.0v 1809.495n 0.0v 1809.505n 0.0v 1819.495n 0.0v 1819.505n 0.0v 1829.495n 0.0v 1829.505n 0.0v 1839.495n 0.0v 1839.505n 0.0v 1849.495n 0.0v 1849.505n 0.0v 1859.495n 0.0v 1859.505n 0.0v 1869.495n 0.0v 1869.505n 0.0v 1879.495n 0.0v 1879.505n 0.0v 1889.495n 0.0v 1889.505n 1.8v 1899.495n 1.8v 1899.505n 1.8v 1909.495n 1.8v 1909.505n 1.8v 1919.495n 1.8v 1919.505n 1.8v 1929.495n 1.8v 1929.505n 1.8v 1939.495n 1.8v 1939.505n 1.8v 1949.495n 1.8v 1949.505n 1.8v 1959.495n 1.8v 1959.505n 1.8v 1969.495n 1.8v 1969.505n 1.8v 1979.495n 1.8v 1979.505n 1.8v 1989.495n 1.8v 1989.505n 1.8v 1999.495n 1.8v 1999.505n 1.8v 2009.495n 1.8v 2009.505n 1.8v 2019.495n 1.8v 2019.505n 1.8v 2029.495n 1.8v 2029.505n 0.0v 2039.495n 0.0v 2039.505n 0.0v 2049.495n 0.0v 2049.505n 0.0v )
* (time, data): [(0, 0), (10, 0), (20, 1), (30, 0), (40, 0), (50, 0), (60, 1), (70, 1), (80, 1), (90, 1), (100, 1), (110, 1), (120, 1), (130, 1), (140, 1), (150, 0), (160, 0), (170, 0), (180, 0), (190, 0), (200, 0), (210, 0), (220, 0), (230, 0), (240, 0), (250, 0), (260, 0), (270, 0), (280, 0), (290, 0), (300, 0), (310, 1), (320, 1), (330, 1), (340, 1), (350, 1), (360, 1), (370, 1), (380, 1), (390, 1), (400, 1), (410, 1), (420, 1), (430, 1), (440, 1), (450, 0), (460, 0), (470, 0), (480, 0), (490, 0), (500, 1), (510, 1), (520, 1), (530, 1), (540, 1), (550, 1), (560, 1), (570, 1), (580, 1), (590, 1), (600, 1), (610, 1), (620, 0), (630, 0), (640, 0), (650, 0), (660, 0), (670, 0), (680, 0), (690, 0), (700, 0), (710, 1), (720, 1), (730, 1), (740, 1), (750, 1), (760, 1), (770, 1), (780, 1), (790, 1), (800, 1), (810, 1), (820, 0), (830, 0), (840, 1), (850, 1), (860, 1), (870, 1), (880, 1), (890, 0), (900, 0), (910, 0), (920, 0), (930, 1), (940, 1), (950, 1), (960, 0), (970, 0), (980, 0), (990, 0), (1000, 0), (1010, 0), (1020, 0), (1030, 0), (1040, 0), (1050, 0), (1060, 0), (1070, 0), (1080, 1), (1090, 1), (1100, 1), (1110, 1), (1120, 1), (1130, 1), (1140, 1), (1150, 1), (1160, 1), (1170, 1), (1180, 1), (1190, 1), (1200, 1), (1210, 1), (1220, 1), (1230, 1), (1240, 1), (1250, 1), (1260, 0), (1270, 0), (1280, 1), (1290, 1), (1300, 1), (1310, 1), (1320, 1), (1330, 1), (1340, 1), (1350, 1), (1360, 1), (1370, 1), (1380, 1), (1390, 1), (1400, 1), (1410, 1), (1420, 1), (1430, 1), (1440, 1), (1450, 1), (1460, 1), (1470, 1), (1480, 0), (1490, 0), (1500, 1), (1510, 1), (1520, 1), (1530, 1), (1540, 1), (1550, 1), (1560, 1), (1570, 0), (1580, 1), (1590, 0), (1600, 0), (1610, 0), (1620, 0), (1630, 0), (1640, 0), (1650, 0), (1660, 0), (1670, 0), (1680, 0), (1690, 0), (1700, 0), (1710, 1), (1720, 1), (1730, 0), (1740, 1), (1750, 1), (1760, 1), (1770, 1), (1780, 1), (1790, 0), (1800, 0), (1810, 0), (1820, 0), (1830, 0), (1840, 0), (1850, 0), (1860, 0), (1870, 0), (1880, 1), (1890, 1), (1900, 1), (1910, 1), (1920, 1), (1930, 1), (1940, 1), (1950, 1), (1960, 1), (1970, 1), (1980, 1), (1990, 1), (2000, 1), (2010, 1), (2020, 1), (2030, 0), (2040, 0), (2050, 0)]
Vdin0_53  din0_53  0 PWL (0n 0.0v 9.495n 0.0v 9.505n 0.0v 19.495n 0.0v 19.505n 1.8v 29.495n 1.8v 29.505n 0.0v 39.495n 0.0v 39.505n 0.0v 49.495n 0.0v 49.505n 0.0v 59.495n 0.0v 59.505n 1.8v 69.495n 1.8v 69.505n 1.8v 79.495n 1.8v 79.505n 1.8v 89.495n 1.8v 89.505n 1.8v 99.495n 1.8v 99.505n 1.8v 109.495n 1.8v 109.505n 1.8v 119.495n 1.8v 119.505n 1.8v 129.495n 1.8v 129.505n 1.8v 139.495n 1.8v 139.505n 1.8v 149.495n 1.8v 149.505n 0.0v 159.495n 0.0v 159.505n 0.0v 169.495n 0.0v 169.505n 0.0v 179.495n 0.0v 179.505n 0.0v 189.495n 0.0v 189.505n 0.0v 199.495n 0.0v 199.505n 0.0v 209.495n 0.0v 209.505n 0.0v 219.495n 0.0v 219.505n 0.0v 229.495n 0.0v 229.505n 0.0v 239.495n 0.0v 239.505n 0.0v 249.495n 0.0v 249.505n 0.0v 259.495n 0.0v 259.505n 0.0v 269.495n 0.0v 269.505n 0.0v 279.495n 0.0v 279.505n 0.0v 289.495n 0.0v 289.505n 0.0v 299.495n 0.0v 299.505n 0.0v 309.495n 0.0v 309.505n 1.8v 319.495n 1.8v 319.505n 1.8v 329.495n 1.8v 329.505n 1.8v 339.495n 1.8v 339.505n 1.8v 349.495n 1.8v 349.505n 1.8v 359.495n 1.8v 359.505n 1.8v 369.495n 1.8v 369.505n 1.8v 379.495n 1.8v 379.505n 1.8v 389.495n 1.8v 389.505n 1.8v 399.495n 1.8v 399.505n 1.8v 409.495n 1.8v 409.505n 1.8v 419.495n 1.8v 419.505n 1.8v 429.495n 1.8v 429.505n 1.8v 439.495n 1.8v 439.505n 1.8v 449.495n 1.8v 449.505n 0.0v 459.495n 0.0v 459.505n 0.0v 469.495n 0.0v 469.505n 0.0v 479.495n 0.0v 479.505n 0.0v 489.495n 0.0v 489.505n 0.0v 499.495n 0.0v 499.505n 1.8v 509.495n 1.8v 509.505n 1.8v 519.495n 1.8v 519.505n 1.8v 529.495n 1.8v 529.505n 1.8v 539.495n 1.8v 539.505n 1.8v 549.495n 1.8v 549.505n 1.8v 559.495n 1.8v 559.505n 1.8v 569.495n 1.8v 569.505n 1.8v 579.495n 1.8v 579.505n 1.8v 589.495n 1.8v 589.505n 1.8v 599.495n 1.8v 599.505n 1.8v 609.495n 1.8v 609.505n 1.8v 619.495n 1.8v 619.505n 0.0v 629.495n 0.0v 629.505n 0.0v 639.495n 0.0v 639.505n 0.0v 649.495n 0.0v 649.505n 0.0v 659.495n 0.0v 659.505n 0.0v 669.495n 0.0v 669.505n 0.0v 679.495n 0.0v 679.505n 0.0v 689.495n 0.0v 689.505n 0.0v 699.495n 0.0v 699.505n 0.0v 709.495n 0.0v 709.505n 1.8v 719.495n 1.8v 719.505n 1.8v 729.495n 1.8v 729.505n 1.8v 739.495n 1.8v 739.505n 1.8v 749.495n 1.8v 749.505n 1.8v 759.495n 1.8v 759.505n 1.8v 769.495n 1.8v 769.505n 1.8v 779.495n 1.8v 779.505n 1.8v 789.495n 1.8v 789.505n 1.8v 799.495n 1.8v 799.505n 1.8v 809.495n 1.8v 809.505n 1.8v 819.495n 1.8v 819.505n 0.0v 829.495n 0.0v 829.505n 0.0v 839.495n 0.0v 839.505n 1.8v 849.495n 1.8v 849.505n 1.8v 859.495n 1.8v 859.505n 1.8v 869.495n 1.8v 869.505n 1.8v 879.495n 1.8v 879.505n 1.8v 889.495n 1.8v 889.505n 0.0v 899.495n 0.0v 899.505n 0.0v 909.495n 0.0v 909.505n 0.0v 919.495n 0.0v 919.505n 0.0v 929.495n 0.0v 929.505n 1.8v 939.495n 1.8v 939.505n 1.8v 949.495n 1.8v 949.505n 1.8v 959.495n 1.8v 959.505n 0.0v 969.495n 0.0v 969.505n 0.0v 979.495n 0.0v 979.505n 0.0v 989.495n 0.0v 989.505n 0.0v 999.495n 0.0v 999.505n 0.0v 1009.495n 0.0v 1009.505n 0.0v 1019.495n 0.0v 1019.505n 0.0v 1029.495n 0.0v 1029.505n 0.0v 1039.495n 0.0v 1039.505n 0.0v 1049.495n 0.0v 1049.505n 0.0v 1059.495n 0.0v 1059.505n 0.0v 1069.495n 0.0v 1069.505n 0.0v 1079.495n 0.0v 1079.505n 1.8v 1089.495n 1.8v 1089.505n 1.8v 1099.495n 1.8v 1099.505n 1.8v 1109.495n 1.8v 1109.505n 1.8v 1119.495n 1.8v 1119.505n 1.8v 1129.495n 1.8v 1129.505n 1.8v 1139.495n 1.8v 1139.505n 1.8v 1149.495n 1.8v 1149.505n 1.8v 1159.495n 1.8v 1159.505n 1.8v 1169.495n 1.8v 1169.505n 1.8v 1179.495n 1.8v 1179.505n 1.8v 1189.495n 1.8v 1189.505n 1.8v 1199.495n 1.8v 1199.505n 1.8v 1209.495n 1.8v 1209.505n 1.8v 1219.495n 1.8v 1219.505n 1.8v 1229.495n 1.8v 1229.505n 1.8v 1239.495n 1.8v 1239.505n 1.8v 1249.495n 1.8v 1249.505n 1.8v 1259.495n 1.8v 1259.505n 0.0v 1269.495n 0.0v 1269.505n 0.0v 1279.495n 0.0v 1279.505n 1.8v 1289.495n 1.8v 1289.505n 1.8v 1299.495n 1.8v 1299.505n 1.8v 1309.495n 1.8v 1309.505n 1.8v 1319.495n 1.8v 1319.505n 1.8v 1329.495n 1.8v 1329.505n 1.8v 1339.495n 1.8v 1339.505n 1.8v 1349.495n 1.8v 1349.505n 1.8v 1359.495n 1.8v 1359.505n 1.8v 1369.495n 1.8v 1369.505n 1.8v 1379.495n 1.8v 1379.505n 1.8v 1389.495n 1.8v 1389.505n 1.8v 1399.495n 1.8v 1399.505n 1.8v 1409.495n 1.8v 1409.505n 1.8v 1419.495n 1.8v 1419.505n 1.8v 1429.495n 1.8v 1429.505n 1.8v 1439.495n 1.8v 1439.505n 1.8v 1449.495n 1.8v 1449.505n 1.8v 1459.495n 1.8v 1459.505n 1.8v 1469.495n 1.8v 1469.505n 1.8v 1479.495n 1.8v 1479.505n 0.0v 1489.495n 0.0v 1489.505n 0.0v 1499.495n 0.0v 1499.505n 1.8v 1509.495n 1.8v 1509.505n 1.8v 1519.495n 1.8v 1519.505n 1.8v 1529.495n 1.8v 1529.505n 1.8v 1539.495n 1.8v 1539.505n 1.8v 1549.495n 1.8v 1549.505n 1.8v 1559.495n 1.8v 1559.505n 1.8v 1569.495n 1.8v 1569.505n 0.0v 1579.495n 0.0v 1579.505n 1.8v 1589.495n 1.8v 1589.505n 0.0v 1599.495n 0.0v 1599.505n 0.0v 1609.495n 0.0v 1609.505n 0.0v 1619.495n 0.0v 1619.505n 0.0v 1629.495n 0.0v 1629.505n 0.0v 1639.495n 0.0v 1639.505n 0.0v 1649.495n 0.0v 1649.505n 0.0v 1659.495n 0.0v 1659.505n 0.0v 1669.495n 0.0v 1669.505n 0.0v 1679.495n 0.0v 1679.505n 0.0v 1689.495n 0.0v 1689.505n 0.0v 1699.495n 0.0v 1699.505n 0.0v 1709.495n 0.0v 1709.505n 1.8v 1719.495n 1.8v 1719.505n 1.8v 1729.495n 1.8v 1729.505n 0.0v 1739.495n 0.0v 1739.505n 1.8v 1749.495n 1.8v 1749.505n 1.8v 1759.495n 1.8v 1759.505n 1.8v 1769.495n 1.8v 1769.505n 1.8v 1779.495n 1.8v 1779.505n 1.8v 1789.495n 1.8v 1789.505n 0.0v 1799.495n 0.0v 1799.505n 0.0v 1809.495n 0.0v 1809.505n 0.0v 1819.495n 0.0v 1819.505n 0.0v 1829.495n 0.0v 1829.505n 0.0v 1839.495n 0.0v 1839.505n 0.0v 1849.495n 0.0v 1849.505n 0.0v 1859.495n 0.0v 1859.505n 0.0v 1869.495n 0.0v 1869.505n 0.0v 1879.495n 0.0v 1879.505n 1.8v 1889.495n 1.8v 1889.505n 1.8v 1899.495n 1.8v 1899.505n 1.8v 1909.495n 1.8v 1909.505n 1.8v 1919.495n 1.8v 1919.505n 1.8v 1929.495n 1.8v 1929.505n 1.8v 1939.495n 1.8v 1939.505n 1.8v 1949.495n 1.8v 1949.505n 1.8v 1959.495n 1.8v 1959.505n 1.8v 1969.495n 1.8v 1969.505n 1.8v 1979.495n 1.8v 1979.505n 1.8v 1989.495n 1.8v 1989.505n 1.8v 1999.495n 1.8v 1999.505n 1.8v 2009.495n 1.8v 2009.505n 1.8v 2019.495n 1.8v 2019.505n 1.8v 2029.495n 1.8v 2029.505n 0.0v 2039.495n 0.0v 2039.505n 0.0v 2049.495n 0.0v 2049.505n 0.0v )
* (time, data): [(0, 0), (10, 1), (20, 1), (30, 1), (40, 1), (50, 1), (60, 0), (70, 0), (80, 0), (90, 0), (100, 0), (110, 0), (120, 0), (130, 0), (140, 0), (150, 0), (160, 0), (170, 0), (180, 0), (190, 0), (200, 0), (210, 0), (220, 0), (230, 0), (240, 0), (250, 0), (260, 1), (270, 1), (280, 1), (290, 1), (300, 1), (310, 0), (320, 0), (330, 0), (340, 0), (350, 1), (360, 1), (370, 1), (380, 1), (390, 0), (400, 0), (410, 0), (420, 1), (430, 1), (440, 1), (450, 1), (460, 1), (470, 0), (480, 0), (490, 0), (500, 1), (510, 1), (520, 1), (530, 1), (540, 1), (550, 1), (560, 1), (570, 1), (580, 1), (590, 1), (600, 1), (610, 1), (620, 1), (630, 1), (640, 1), (650, 1), (660, 0), (670, 0), (680, 0), (690, 0), (700, 0), (710, 0), (720, 0), (730, 0), (740, 0), (750, 0), (760, 0), (770, 1), (780, 1), (790, 1), (800, 1), (810, 1), (820, 0), (830, 0), (840, 1), (850, 1), (860, 1), (870, 1), (880, 1), (890, 0), (900, 0), (910, 0), (920, 0), (930, 0), (940, 0), (950, 0), (960, 1), (970, 1), (980, 1), (990, 1), (1000, 1), (1010, 1), (1020, 1), (1030, 1), (1040, 1), (1050, 1), (1060, 1), (1070, 1), (1080, 1), (1090, 1), (1100, 1), (1110, 1), (1120, 1), (1130, 1), (1140, 1), (1150, 1), (1160, 1), (1170, 1), (1180, 1), (1190, 1), (1200, 1), (1210, 1), (1220, 1), (1230, 1), (1240, 1), (1250, 1), (1260, 0), (1270, 0), (1280, 1), (1290, 1), (1300, 1), (1310, 1), (1320, 1), (1330, 1), (1340, 1), (1350, 1), (1360, 1), (1370, 0), (1380, 0), (1390, 0), (1400, 1), (1410, 1), (1420, 1), (1430, 1), (1440, 1), (1450, 1), (1460, 1), (1470, 1), (1480, 0), (1490, 0), (1500, 1), (1510, 1), (1520, 1), (1530, 1), (1540, 1), (1550, 1), (1560, 1), (1570, 0), (1580, 0), (1590, 1), (1600, 1), (1610, 1), (1620, 0), (1630, 0), (1640, 0), (1650, 0), (1660, 0), (1670, 0), (1680, 0), (1690, 1), (1700, 1), (1710, 1), (1720, 1), (1730, 1), (1740, 1), (1750, 1), (1760, 1), (1770, 1), (1780, 1), (1790, 0), (1800, 0), (1810, 0), (1820, 0), (1830, 0), (1840, 0), (1850, 1), (1860, 1), (1870, 1), (1880, 0), (1890, 0), (1900, 0), (1910, 0), (1920, 0), (1930, 0), (1940, 0), (1950, 0), (1960, 0), (1970, 0), (1980, 0), (1990, 0), (2000, 0), (2010, 0), (2020, 0), (2030, 1), (2040, 1), (2050, 1)]
Vdin0_54  din0_54  0 PWL (0n 0.0v 9.495n 0.0v 9.505n 1.8v 19.495n 1.8v 19.505n 1.8v 29.495n 1.8v 29.505n 1.8v 39.495n 1.8v 39.505n 1.8v 49.495n 1.8v 49.505n 1.8v 59.495n 1.8v 59.505n 0.0v 69.495n 0.0v 69.505n 0.0v 79.495n 0.0v 79.505n 0.0v 89.495n 0.0v 89.505n 0.0v 99.495n 0.0v 99.505n 0.0v 109.495n 0.0v 109.505n 0.0v 119.495n 0.0v 119.505n 0.0v 129.495n 0.0v 129.505n 0.0v 139.495n 0.0v 139.505n 0.0v 149.495n 0.0v 149.505n 0.0v 159.495n 0.0v 159.505n 0.0v 169.495n 0.0v 169.505n 0.0v 179.495n 0.0v 179.505n 0.0v 189.495n 0.0v 189.505n 0.0v 199.495n 0.0v 199.505n 0.0v 209.495n 0.0v 209.505n 0.0v 219.495n 0.0v 219.505n 0.0v 229.495n 0.0v 229.505n 0.0v 239.495n 0.0v 239.505n 0.0v 249.495n 0.0v 249.505n 0.0v 259.495n 0.0v 259.505n 1.8v 269.495n 1.8v 269.505n 1.8v 279.495n 1.8v 279.505n 1.8v 289.495n 1.8v 289.505n 1.8v 299.495n 1.8v 299.505n 1.8v 309.495n 1.8v 309.505n 0.0v 319.495n 0.0v 319.505n 0.0v 329.495n 0.0v 329.505n 0.0v 339.495n 0.0v 339.505n 0.0v 349.495n 0.0v 349.505n 1.8v 359.495n 1.8v 359.505n 1.8v 369.495n 1.8v 369.505n 1.8v 379.495n 1.8v 379.505n 1.8v 389.495n 1.8v 389.505n 0.0v 399.495n 0.0v 399.505n 0.0v 409.495n 0.0v 409.505n 0.0v 419.495n 0.0v 419.505n 1.8v 429.495n 1.8v 429.505n 1.8v 439.495n 1.8v 439.505n 1.8v 449.495n 1.8v 449.505n 1.8v 459.495n 1.8v 459.505n 1.8v 469.495n 1.8v 469.505n 0.0v 479.495n 0.0v 479.505n 0.0v 489.495n 0.0v 489.505n 0.0v 499.495n 0.0v 499.505n 1.8v 509.495n 1.8v 509.505n 1.8v 519.495n 1.8v 519.505n 1.8v 529.495n 1.8v 529.505n 1.8v 539.495n 1.8v 539.505n 1.8v 549.495n 1.8v 549.505n 1.8v 559.495n 1.8v 559.505n 1.8v 569.495n 1.8v 569.505n 1.8v 579.495n 1.8v 579.505n 1.8v 589.495n 1.8v 589.505n 1.8v 599.495n 1.8v 599.505n 1.8v 609.495n 1.8v 609.505n 1.8v 619.495n 1.8v 619.505n 1.8v 629.495n 1.8v 629.505n 1.8v 639.495n 1.8v 639.505n 1.8v 649.495n 1.8v 649.505n 1.8v 659.495n 1.8v 659.505n 0.0v 669.495n 0.0v 669.505n 0.0v 679.495n 0.0v 679.505n 0.0v 689.495n 0.0v 689.505n 0.0v 699.495n 0.0v 699.505n 0.0v 709.495n 0.0v 709.505n 0.0v 719.495n 0.0v 719.505n 0.0v 729.495n 0.0v 729.505n 0.0v 739.495n 0.0v 739.505n 0.0v 749.495n 0.0v 749.505n 0.0v 759.495n 0.0v 759.505n 0.0v 769.495n 0.0v 769.505n 1.8v 779.495n 1.8v 779.505n 1.8v 789.495n 1.8v 789.505n 1.8v 799.495n 1.8v 799.505n 1.8v 809.495n 1.8v 809.505n 1.8v 819.495n 1.8v 819.505n 0.0v 829.495n 0.0v 829.505n 0.0v 839.495n 0.0v 839.505n 1.8v 849.495n 1.8v 849.505n 1.8v 859.495n 1.8v 859.505n 1.8v 869.495n 1.8v 869.505n 1.8v 879.495n 1.8v 879.505n 1.8v 889.495n 1.8v 889.505n 0.0v 899.495n 0.0v 899.505n 0.0v 909.495n 0.0v 909.505n 0.0v 919.495n 0.0v 919.505n 0.0v 929.495n 0.0v 929.505n 0.0v 939.495n 0.0v 939.505n 0.0v 949.495n 0.0v 949.505n 0.0v 959.495n 0.0v 959.505n 1.8v 969.495n 1.8v 969.505n 1.8v 979.495n 1.8v 979.505n 1.8v 989.495n 1.8v 989.505n 1.8v 999.495n 1.8v 999.505n 1.8v 1009.495n 1.8v 1009.505n 1.8v 1019.495n 1.8v 1019.505n 1.8v 1029.495n 1.8v 1029.505n 1.8v 1039.495n 1.8v 1039.505n 1.8v 1049.495n 1.8v 1049.505n 1.8v 1059.495n 1.8v 1059.505n 1.8v 1069.495n 1.8v 1069.505n 1.8v 1079.495n 1.8v 1079.505n 1.8v 1089.495n 1.8v 1089.505n 1.8v 1099.495n 1.8v 1099.505n 1.8v 1109.495n 1.8v 1109.505n 1.8v 1119.495n 1.8v 1119.505n 1.8v 1129.495n 1.8v 1129.505n 1.8v 1139.495n 1.8v 1139.505n 1.8v 1149.495n 1.8v 1149.505n 1.8v 1159.495n 1.8v 1159.505n 1.8v 1169.495n 1.8v 1169.505n 1.8v 1179.495n 1.8v 1179.505n 1.8v 1189.495n 1.8v 1189.505n 1.8v 1199.495n 1.8v 1199.505n 1.8v 1209.495n 1.8v 1209.505n 1.8v 1219.495n 1.8v 1219.505n 1.8v 1229.495n 1.8v 1229.505n 1.8v 1239.495n 1.8v 1239.505n 1.8v 1249.495n 1.8v 1249.505n 1.8v 1259.495n 1.8v 1259.505n 0.0v 1269.495n 0.0v 1269.505n 0.0v 1279.495n 0.0v 1279.505n 1.8v 1289.495n 1.8v 1289.505n 1.8v 1299.495n 1.8v 1299.505n 1.8v 1309.495n 1.8v 1309.505n 1.8v 1319.495n 1.8v 1319.505n 1.8v 1329.495n 1.8v 1329.505n 1.8v 1339.495n 1.8v 1339.505n 1.8v 1349.495n 1.8v 1349.505n 1.8v 1359.495n 1.8v 1359.505n 1.8v 1369.495n 1.8v 1369.505n 0.0v 1379.495n 0.0v 1379.505n 0.0v 1389.495n 0.0v 1389.505n 0.0v 1399.495n 0.0v 1399.505n 1.8v 1409.495n 1.8v 1409.505n 1.8v 1419.495n 1.8v 1419.505n 1.8v 1429.495n 1.8v 1429.505n 1.8v 1439.495n 1.8v 1439.505n 1.8v 1449.495n 1.8v 1449.505n 1.8v 1459.495n 1.8v 1459.505n 1.8v 1469.495n 1.8v 1469.505n 1.8v 1479.495n 1.8v 1479.505n 0.0v 1489.495n 0.0v 1489.505n 0.0v 1499.495n 0.0v 1499.505n 1.8v 1509.495n 1.8v 1509.505n 1.8v 1519.495n 1.8v 1519.505n 1.8v 1529.495n 1.8v 1529.505n 1.8v 1539.495n 1.8v 1539.505n 1.8v 1549.495n 1.8v 1549.505n 1.8v 1559.495n 1.8v 1559.505n 1.8v 1569.495n 1.8v 1569.505n 0.0v 1579.495n 0.0v 1579.505n 0.0v 1589.495n 0.0v 1589.505n 1.8v 1599.495n 1.8v 1599.505n 1.8v 1609.495n 1.8v 1609.505n 1.8v 1619.495n 1.8v 1619.505n 0.0v 1629.495n 0.0v 1629.505n 0.0v 1639.495n 0.0v 1639.505n 0.0v 1649.495n 0.0v 1649.505n 0.0v 1659.495n 0.0v 1659.505n 0.0v 1669.495n 0.0v 1669.505n 0.0v 1679.495n 0.0v 1679.505n 0.0v 1689.495n 0.0v 1689.505n 1.8v 1699.495n 1.8v 1699.505n 1.8v 1709.495n 1.8v 1709.505n 1.8v 1719.495n 1.8v 1719.505n 1.8v 1729.495n 1.8v 1729.505n 1.8v 1739.495n 1.8v 1739.505n 1.8v 1749.495n 1.8v 1749.505n 1.8v 1759.495n 1.8v 1759.505n 1.8v 1769.495n 1.8v 1769.505n 1.8v 1779.495n 1.8v 1779.505n 1.8v 1789.495n 1.8v 1789.505n 0.0v 1799.495n 0.0v 1799.505n 0.0v 1809.495n 0.0v 1809.505n 0.0v 1819.495n 0.0v 1819.505n 0.0v 1829.495n 0.0v 1829.505n 0.0v 1839.495n 0.0v 1839.505n 0.0v 1849.495n 0.0v 1849.505n 1.8v 1859.495n 1.8v 1859.505n 1.8v 1869.495n 1.8v 1869.505n 1.8v 1879.495n 1.8v 1879.505n 0.0v 1889.495n 0.0v 1889.505n 0.0v 1899.495n 0.0v 1899.505n 0.0v 1909.495n 0.0v 1909.505n 0.0v 1919.495n 0.0v 1919.505n 0.0v 1929.495n 0.0v 1929.505n 0.0v 1939.495n 0.0v 1939.505n 0.0v 1949.495n 0.0v 1949.505n 0.0v 1959.495n 0.0v 1959.505n 0.0v 1969.495n 0.0v 1969.505n 0.0v 1979.495n 0.0v 1979.505n 0.0v 1989.495n 0.0v 1989.505n 0.0v 1999.495n 0.0v 1999.505n 0.0v 2009.495n 0.0v 2009.505n 0.0v 2019.495n 0.0v 2019.505n 0.0v 2029.495n 0.0v 2029.505n 1.8v 2039.495n 1.8v 2039.505n 1.8v 2049.495n 1.8v 2049.505n 1.8v )
* (time, data): [(0, 0), (10, 0), (20, 1), (30, 1), (40, 1), (50, 1), (60, 1), (70, 1), (80, 1), (90, 1), (100, 1), (110, 1), (120, 1), (130, 1), (140, 1), (150, 0), (160, 0), (170, 0), (180, 0), (190, 0), (200, 0), (210, 0), (220, 0), (230, 0), (240, 0), (250, 0), (260, 1), (270, 1), (280, 1), (290, 1), (300, 1), (310, 1), (320, 1), (330, 1), (340, 1), (350, 1), (360, 1), (370, 1), (380, 1), (390, 1), (400, 0), (410, 0), (420, 1), (430, 1), (440, 1), (450, 1), (460, 1), (470, 0), (480, 0), (490, 0), (500, 1), (510, 1), (520, 1), (530, 1), (540, 1), (550, 1), (560, 1), (570, 1), (580, 1), (590, 1), (600, 1), (610, 1), (620, 0), (630, 0), (640, 0), (650, 0), (660, 0), (670, 0), (680, 0), (690, 0), (700, 0), (710, 0), (720, 0), (730, 0), (740, 0), (750, 0), (760, 0), (770, 0), (780, 0), (790, 0), (800, 0), (810, 0), (820, 0), (830, 0), (840, 0), (850, 0), (860, 0), (870, 0), (880, 0), (890, 1), (900, 1), (910, 1), (920, 1), (930, 1), (940, 1), (950, 1), (960, 1), (970, 1), (980, 1), (990, 1), (1000, 1), (1010, 1), (1020, 1), (1030, 1), (1040, 1), (1050, 1), (1060, 1), (1070, 1), (1080, 1), (1090, 1), (1100, 1), (1110, 1), (1120, 1), (1130, 1), (1140, 1), (1150, 1), (1160, 1), (1170, 1), (1180, 1), (1190, 1), (1200, 1), (1210, 1), (1220, 1), (1230, 1), (1240, 1), (1250, 1), (1260, 1), (1270, 1), (1280, 1), (1290, 1), (1300, 1), (1310, 1), (1320, 1), (1330, 1), (1340, 1), (1350, 1), (1360, 1), (1370, 0), (1380, 0), (1390, 0), (1400, 0), (1410, 0), (1420, 0), (1430, 1), (1440, 1), (1450, 1), (1460, 1), (1470, 1), (1480, 0), (1490, 0), (1500, 1), (1510, 1), (1520, 1), (1530, 1), (1540, 1), (1550, 1), (1560, 1), (1570, 0), (1580, 0), (1590, 1), (1600, 1), (1610, 1), (1620, 0), (1630, 0), (1640, 0), (1650, 0), (1660, 0), (1670, 0), (1680, 0), (1690, 1), (1700, 1), (1710, 0), (1720, 0), (1730, 1), (1740, 0), (1750, 0), (1760, 0), (1770, 0), (1780, 0), (1790, 1), (1800, 1), (1810, 1), (1820, 1), (1830, 1), (1840, 1), (1850, 1), (1860, 1), (1870, 1), (1880, 1), (1890, 1), (1900, 1), (1910, 1), (1920, 1), (1930, 1), (1940, 1), (1950, 1), (1960, 1), (1970, 1), (1980, 1), (1990, 1), (2000, 1), (2010, 1), (2020, 1), (2030, 1), (2040, 1), (2050, 1)]
Vdin0_55  din0_55  0 PWL (0n 0.0v 9.495n 0.0v 9.505n 0.0v 19.495n 0.0v 19.505n 1.8v 29.495n 1.8v 29.505n 1.8v 39.495n 1.8v 39.505n 1.8v 49.495n 1.8v 49.505n 1.8v 59.495n 1.8v 59.505n 1.8v 69.495n 1.8v 69.505n 1.8v 79.495n 1.8v 79.505n 1.8v 89.495n 1.8v 89.505n 1.8v 99.495n 1.8v 99.505n 1.8v 109.495n 1.8v 109.505n 1.8v 119.495n 1.8v 119.505n 1.8v 129.495n 1.8v 129.505n 1.8v 139.495n 1.8v 139.505n 1.8v 149.495n 1.8v 149.505n 0.0v 159.495n 0.0v 159.505n 0.0v 169.495n 0.0v 169.505n 0.0v 179.495n 0.0v 179.505n 0.0v 189.495n 0.0v 189.505n 0.0v 199.495n 0.0v 199.505n 0.0v 209.495n 0.0v 209.505n 0.0v 219.495n 0.0v 219.505n 0.0v 229.495n 0.0v 229.505n 0.0v 239.495n 0.0v 239.505n 0.0v 249.495n 0.0v 249.505n 0.0v 259.495n 0.0v 259.505n 1.8v 269.495n 1.8v 269.505n 1.8v 279.495n 1.8v 279.505n 1.8v 289.495n 1.8v 289.505n 1.8v 299.495n 1.8v 299.505n 1.8v 309.495n 1.8v 309.505n 1.8v 319.495n 1.8v 319.505n 1.8v 329.495n 1.8v 329.505n 1.8v 339.495n 1.8v 339.505n 1.8v 349.495n 1.8v 349.505n 1.8v 359.495n 1.8v 359.505n 1.8v 369.495n 1.8v 369.505n 1.8v 379.495n 1.8v 379.505n 1.8v 389.495n 1.8v 389.505n 1.8v 399.495n 1.8v 399.505n 0.0v 409.495n 0.0v 409.505n 0.0v 419.495n 0.0v 419.505n 1.8v 429.495n 1.8v 429.505n 1.8v 439.495n 1.8v 439.505n 1.8v 449.495n 1.8v 449.505n 1.8v 459.495n 1.8v 459.505n 1.8v 469.495n 1.8v 469.505n 0.0v 479.495n 0.0v 479.505n 0.0v 489.495n 0.0v 489.505n 0.0v 499.495n 0.0v 499.505n 1.8v 509.495n 1.8v 509.505n 1.8v 519.495n 1.8v 519.505n 1.8v 529.495n 1.8v 529.505n 1.8v 539.495n 1.8v 539.505n 1.8v 549.495n 1.8v 549.505n 1.8v 559.495n 1.8v 559.505n 1.8v 569.495n 1.8v 569.505n 1.8v 579.495n 1.8v 579.505n 1.8v 589.495n 1.8v 589.505n 1.8v 599.495n 1.8v 599.505n 1.8v 609.495n 1.8v 609.505n 1.8v 619.495n 1.8v 619.505n 0.0v 629.495n 0.0v 629.505n 0.0v 639.495n 0.0v 639.505n 0.0v 649.495n 0.0v 649.505n 0.0v 659.495n 0.0v 659.505n 0.0v 669.495n 0.0v 669.505n 0.0v 679.495n 0.0v 679.505n 0.0v 689.495n 0.0v 689.505n 0.0v 699.495n 0.0v 699.505n 0.0v 709.495n 0.0v 709.505n 0.0v 719.495n 0.0v 719.505n 0.0v 729.495n 0.0v 729.505n 0.0v 739.495n 0.0v 739.505n 0.0v 749.495n 0.0v 749.505n 0.0v 759.495n 0.0v 759.505n 0.0v 769.495n 0.0v 769.505n 0.0v 779.495n 0.0v 779.505n 0.0v 789.495n 0.0v 789.505n 0.0v 799.495n 0.0v 799.505n 0.0v 809.495n 0.0v 809.505n 0.0v 819.495n 0.0v 819.505n 0.0v 829.495n 0.0v 829.505n 0.0v 839.495n 0.0v 839.505n 0.0v 849.495n 0.0v 849.505n 0.0v 859.495n 0.0v 859.505n 0.0v 869.495n 0.0v 869.505n 0.0v 879.495n 0.0v 879.505n 0.0v 889.495n 0.0v 889.505n 1.8v 899.495n 1.8v 899.505n 1.8v 909.495n 1.8v 909.505n 1.8v 919.495n 1.8v 919.505n 1.8v 929.495n 1.8v 929.505n 1.8v 939.495n 1.8v 939.505n 1.8v 949.495n 1.8v 949.505n 1.8v 959.495n 1.8v 959.505n 1.8v 969.495n 1.8v 969.505n 1.8v 979.495n 1.8v 979.505n 1.8v 989.495n 1.8v 989.505n 1.8v 999.495n 1.8v 999.505n 1.8v 1009.495n 1.8v 1009.505n 1.8v 1019.495n 1.8v 1019.505n 1.8v 1029.495n 1.8v 1029.505n 1.8v 1039.495n 1.8v 1039.505n 1.8v 1049.495n 1.8v 1049.505n 1.8v 1059.495n 1.8v 1059.505n 1.8v 1069.495n 1.8v 1069.505n 1.8v 1079.495n 1.8v 1079.505n 1.8v 1089.495n 1.8v 1089.505n 1.8v 1099.495n 1.8v 1099.505n 1.8v 1109.495n 1.8v 1109.505n 1.8v 1119.495n 1.8v 1119.505n 1.8v 1129.495n 1.8v 1129.505n 1.8v 1139.495n 1.8v 1139.505n 1.8v 1149.495n 1.8v 1149.505n 1.8v 1159.495n 1.8v 1159.505n 1.8v 1169.495n 1.8v 1169.505n 1.8v 1179.495n 1.8v 1179.505n 1.8v 1189.495n 1.8v 1189.505n 1.8v 1199.495n 1.8v 1199.505n 1.8v 1209.495n 1.8v 1209.505n 1.8v 1219.495n 1.8v 1219.505n 1.8v 1229.495n 1.8v 1229.505n 1.8v 1239.495n 1.8v 1239.505n 1.8v 1249.495n 1.8v 1249.505n 1.8v 1259.495n 1.8v 1259.505n 1.8v 1269.495n 1.8v 1269.505n 1.8v 1279.495n 1.8v 1279.505n 1.8v 1289.495n 1.8v 1289.505n 1.8v 1299.495n 1.8v 1299.505n 1.8v 1309.495n 1.8v 1309.505n 1.8v 1319.495n 1.8v 1319.505n 1.8v 1329.495n 1.8v 1329.505n 1.8v 1339.495n 1.8v 1339.505n 1.8v 1349.495n 1.8v 1349.505n 1.8v 1359.495n 1.8v 1359.505n 1.8v 1369.495n 1.8v 1369.505n 0.0v 1379.495n 0.0v 1379.505n 0.0v 1389.495n 0.0v 1389.505n 0.0v 1399.495n 0.0v 1399.505n 0.0v 1409.495n 0.0v 1409.505n 0.0v 1419.495n 0.0v 1419.505n 0.0v 1429.495n 0.0v 1429.505n 1.8v 1439.495n 1.8v 1439.505n 1.8v 1449.495n 1.8v 1449.505n 1.8v 1459.495n 1.8v 1459.505n 1.8v 1469.495n 1.8v 1469.505n 1.8v 1479.495n 1.8v 1479.505n 0.0v 1489.495n 0.0v 1489.505n 0.0v 1499.495n 0.0v 1499.505n 1.8v 1509.495n 1.8v 1509.505n 1.8v 1519.495n 1.8v 1519.505n 1.8v 1529.495n 1.8v 1529.505n 1.8v 1539.495n 1.8v 1539.505n 1.8v 1549.495n 1.8v 1549.505n 1.8v 1559.495n 1.8v 1559.505n 1.8v 1569.495n 1.8v 1569.505n 0.0v 1579.495n 0.0v 1579.505n 0.0v 1589.495n 0.0v 1589.505n 1.8v 1599.495n 1.8v 1599.505n 1.8v 1609.495n 1.8v 1609.505n 1.8v 1619.495n 1.8v 1619.505n 0.0v 1629.495n 0.0v 1629.505n 0.0v 1639.495n 0.0v 1639.505n 0.0v 1649.495n 0.0v 1649.505n 0.0v 1659.495n 0.0v 1659.505n 0.0v 1669.495n 0.0v 1669.505n 0.0v 1679.495n 0.0v 1679.505n 0.0v 1689.495n 0.0v 1689.505n 1.8v 1699.495n 1.8v 1699.505n 1.8v 1709.495n 1.8v 1709.505n 0.0v 1719.495n 0.0v 1719.505n 0.0v 1729.495n 0.0v 1729.505n 1.8v 1739.495n 1.8v 1739.505n 0.0v 1749.495n 0.0v 1749.505n 0.0v 1759.495n 0.0v 1759.505n 0.0v 1769.495n 0.0v 1769.505n 0.0v 1779.495n 0.0v 1779.505n 0.0v 1789.495n 0.0v 1789.505n 1.8v 1799.495n 1.8v 1799.505n 1.8v 1809.495n 1.8v 1809.505n 1.8v 1819.495n 1.8v 1819.505n 1.8v 1829.495n 1.8v 1829.505n 1.8v 1839.495n 1.8v 1839.505n 1.8v 1849.495n 1.8v 1849.505n 1.8v 1859.495n 1.8v 1859.505n 1.8v 1869.495n 1.8v 1869.505n 1.8v 1879.495n 1.8v 1879.505n 1.8v 1889.495n 1.8v 1889.505n 1.8v 1899.495n 1.8v 1899.505n 1.8v 1909.495n 1.8v 1909.505n 1.8v 1919.495n 1.8v 1919.505n 1.8v 1929.495n 1.8v 1929.505n 1.8v 1939.495n 1.8v 1939.505n 1.8v 1949.495n 1.8v 1949.505n 1.8v 1959.495n 1.8v 1959.505n 1.8v 1969.495n 1.8v 1969.505n 1.8v 1979.495n 1.8v 1979.505n 1.8v 1989.495n 1.8v 1989.505n 1.8v 1999.495n 1.8v 1999.505n 1.8v 2009.495n 1.8v 2009.505n 1.8v 2019.495n 1.8v 2019.505n 1.8v 2029.495n 1.8v 2029.505n 1.8v 2039.495n 1.8v 2039.505n 1.8v 2049.495n 1.8v 2049.505n 1.8v )
* (time, data): [(0, 0), (10, 0), (20, 1), (30, 0), (40, 0), (50, 0), (60, 1), (70, 1), (80, 1), (90, 1), (100, 1), (110, 1), (120, 1), (130, 1), (140, 1), (150, 1), (160, 1), (170, 1), (180, 1), (190, 1), (200, 1), (210, 1), (220, 1), (230, 1), (240, 1), (250, 1), (260, 1), (270, 1), (280, 1), (290, 1), (300, 1), (310, 1), (320, 1), (330, 1), (340, 1), (350, 0), (360, 0), (370, 0), (380, 0), (390, 1), (400, 0), (410, 0), (420, 1), (430, 1), (440, 1), (450, 1), (460, 1), (470, 0), (480, 0), (490, 1), (500, 1), (510, 1), (520, 1), (530, 1), (540, 1), (550, 1), (560, 1), (570, 1), (580, 1), (590, 1), (600, 1), (610, 1), (620, 1), (630, 1), (640, 1), (650, 1), (660, 1), (670, 0), (680, 0), (690, 0), (700, 0), (710, 1), (720, 1), (730, 1), (740, 1), (750, 1), (760, 1), (770, 0), (780, 0), (790, 0), (800, 0), (810, 0), (820, 1), (830, 1), (840, 0), (850, 0), (860, 0), (870, 0), (880, 0), (890, 1), (900, 1), (910, 1), (920, 1), (930, 1), (940, 1), (950, 1), (960, 0), (970, 0), (980, 0), (990, 0), (1000, 0), (1010, 0), (1020, 0), (1030, 0), (1040, 0), (1050, 0), (1060, 0), (1070, 0), (1080, 1), (1090, 1), (1100, 1), (1110, 1), (1120, 1), (1130, 1), (1140, 1), (1150, 1), (1160, 1), (1170, 1), (1180, 1), (1190, 1), (1200, 1), (1210, 1), (1220, 1), (1230, 1), (1240, 1), (1250, 1), (1260, 0), (1270, 0), (1280, 1), (1290, 1), (1300, 1), (1310, 1), (1320, 1), (1330, 1), (1340, 1), (1350, 1), (1360, 1), (1370, 1), (1380, 1), (1390, 1), (1400, 1), (1410, 1), (1420, 1), (1430, 1), (1440, 1), (1450, 1), (1460, 1), (1470, 1), (1480, 1), (1490, 1), (1500, 0), (1510, 0), (1520, 0), (1530, 0), (1540, 0), (1550, 0), (1560, 0), (1570, 0), (1580, 0), (1590, 0), (1600, 0), (1610, 0), (1620, 0), (1630, 0), (1640, 0), (1650, 0), (1660, 0), (1670, 0), (1680, 0), (1690, 0), (1700, 0), (1710, 1), (1720, 1), (1730, 1), (1740, 0), (1750, 0), (1760, 0), (1770, 0), (1780, 0), (1790, 0), (1800, 0), (1810, 0), (1820, 0), (1830, 0), (1840, 0), (1850, 0), (1860, 1), (1870, 1), (1880, 1), (1890, 1), (1900, 1), (1910, 0), (1920, 0), (1930, 0), (1940, 0), (1950, 0), (1960, 0), (1970, 0), (1980, 0), (1990, 0), (2000, 0), (2010, 0), (2020, 0), (2030, 0), (2040, 0), (2050, 0)]
Vdin0_56  din0_56  0 PWL (0n 0.0v 9.495n 0.0v 9.505n 0.0v 19.495n 0.0v 19.505n 1.8v 29.495n 1.8v 29.505n 0.0v 39.495n 0.0v 39.505n 0.0v 49.495n 0.0v 49.505n 0.0v 59.495n 0.0v 59.505n 1.8v 69.495n 1.8v 69.505n 1.8v 79.495n 1.8v 79.505n 1.8v 89.495n 1.8v 89.505n 1.8v 99.495n 1.8v 99.505n 1.8v 109.495n 1.8v 109.505n 1.8v 119.495n 1.8v 119.505n 1.8v 129.495n 1.8v 129.505n 1.8v 139.495n 1.8v 139.505n 1.8v 149.495n 1.8v 149.505n 1.8v 159.495n 1.8v 159.505n 1.8v 169.495n 1.8v 169.505n 1.8v 179.495n 1.8v 179.505n 1.8v 189.495n 1.8v 189.505n 1.8v 199.495n 1.8v 199.505n 1.8v 209.495n 1.8v 209.505n 1.8v 219.495n 1.8v 219.505n 1.8v 229.495n 1.8v 229.505n 1.8v 239.495n 1.8v 239.505n 1.8v 249.495n 1.8v 249.505n 1.8v 259.495n 1.8v 259.505n 1.8v 269.495n 1.8v 269.505n 1.8v 279.495n 1.8v 279.505n 1.8v 289.495n 1.8v 289.505n 1.8v 299.495n 1.8v 299.505n 1.8v 309.495n 1.8v 309.505n 1.8v 319.495n 1.8v 319.505n 1.8v 329.495n 1.8v 329.505n 1.8v 339.495n 1.8v 339.505n 1.8v 349.495n 1.8v 349.505n 0.0v 359.495n 0.0v 359.505n 0.0v 369.495n 0.0v 369.505n 0.0v 379.495n 0.0v 379.505n 0.0v 389.495n 0.0v 389.505n 1.8v 399.495n 1.8v 399.505n 0.0v 409.495n 0.0v 409.505n 0.0v 419.495n 0.0v 419.505n 1.8v 429.495n 1.8v 429.505n 1.8v 439.495n 1.8v 439.505n 1.8v 449.495n 1.8v 449.505n 1.8v 459.495n 1.8v 459.505n 1.8v 469.495n 1.8v 469.505n 0.0v 479.495n 0.0v 479.505n 0.0v 489.495n 0.0v 489.505n 1.8v 499.495n 1.8v 499.505n 1.8v 509.495n 1.8v 509.505n 1.8v 519.495n 1.8v 519.505n 1.8v 529.495n 1.8v 529.505n 1.8v 539.495n 1.8v 539.505n 1.8v 549.495n 1.8v 549.505n 1.8v 559.495n 1.8v 559.505n 1.8v 569.495n 1.8v 569.505n 1.8v 579.495n 1.8v 579.505n 1.8v 589.495n 1.8v 589.505n 1.8v 599.495n 1.8v 599.505n 1.8v 609.495n 1.8v 609.505n 1.8v 619.495n 1.8v 619.505n 1.8v 629.495n 1.8v 629.505n 1.8v 639.495n 1.8v 639.505n 1.8v 649.495n 1.8v 649.505n 1.8v 659.495n 1.8v 659.505n 1.8v 669.495n 1.8v 669.505n 0.0v 679.495n 0.0v 679.505n 0.0v 689.495n 0.0v 689.505n 0.0v 699.495n 0.0v 699.505n 0.0v 709.495n 0.0v 709.505n 1.8v 719.495n 1.8v 719.505n 1.8v 729.495n 1.8v 729.505n 1.8v 739.495n 1.8v 739.505n 1.8v 749.495n 1.8v 749.505n 1.8v 759.495n 1.8v 759.505n 1.8v 769.495n 1.8v 769.505n 0.0v 779.495n 0.0v 779.505n 0.0v 789.495n 0.0v 789.505n 0.0v 799.495n 0.0v 799.505n 0.0v 809.495n 0.0v 809.505n 0.0v 819.495n 0.0v 819.505n 1.8v 829.495n 1.8v 829.505n 1.8v 839.495n 1.8v 839.505n 0.0v 849.495n 0.0v 849.505n 0.0v 859.495n 0.0v 859.505n 0.0v 869.495n 0.0v 869.505n 0.0v 879.495n 0.0v 879.505n 0.0v 889.495n 0.0v 889.505n 1.8v 899.495n 1.8v 899.505n 1.8v 909.495n 1.8v 909.505n 1.8v 919.495n 1.8v 919.505n 1.8v 929.495n 1.8v 929.505n 1.8v 939.495n 1.8v 939.505n 1.8v 949.495n 1.8v 949.505n 1.8v 959.495n 1.8v 959.505n 0.0v 969.495n 0.0v 969.505n 0.0v 979.495n 0.0v 979.505n 0.0v 989.495n 0.0v 989.505n 0.0v 999.495n 0.0v 999.505n 0.0v 1009.495n 0.0v 1009.505n 0.0v 1019.495n 0.0v 1019.505n 0.0v 1029.495n 0.0v 1029.505n 0.0v 1039.495n 0.0v 1039.505n 0.0v 1049.495n 0.0v 1049.505n 0.0v 1059.495n 0.0v 1059.505n 0.0v 1069.495n 0.0v 1069.505n 0.0v 1079.495n 0.0v 1079.505n 1.8v 1089.495n 1.8v 1089.505n 1.8v 1099.495n 1.8v 1099.505n 1.8v 1109.495n 1.8v 1109.505n 1.8v 1119.495n 1.8v 1119.505n 1.8v 1129.495n 1.8v 1129.505n 1.8v 1139.495n 1.8v 1139.505n 1.8v 1149.495n 1.8v 1149.505n 1.8v 1159.495n 1.8v 1159.505n 1.8v 1169.495n 1.8v 1169.505n 1.8v 1179.495n 1.8v 1179.505n 1.8v 1189.495n 1.8v 1189.505n 1.8v 1199.495n 1.8v 1199.505n 1.8v 1209.495n 1.8v 1209.505n 1.8v 1219.495n 1.8v 1219.505n 1.8v 1229.495n 1.8v 1229.505n 1.8v 1239.495n 1.8v 1239.505n 1.8v 1249.495n 1.8v 1249.505n 1.8v 1259.495n 1.8v 1259.505n 0.0v 1269.495n 0.0v 1269.505n 0.0v 1279.495n 0.0v 1279.505n 1.8v 1289.495n 1.8v 1289.505n 1.8v 1299.495n 1.8v 1299.505n 1.8v 1309.495n 1.8v 1309.505n 1.8v 1319.495n 1.8v 1319.505n 1.8v 1329.495n 1.8v 1329.505n 1.8v 1339.495n 1.8v 1339.505n 1.8v 1349.495n 1.8v 1349.505n 1.8v 1359.495n 1.8v 1359.505n 1.8v 1369.495n 1.8v 1369.505n 1.8v 1379.495n 1.8v 1379.505n 1.8v 1389.495n 1.8v 1389.505n 1.8v 1399.495n 1.8v 1399.505n 1.8v 1409.495n 1.8v 1409.505n 1.8v 1419.495n 1.8v 1419.505n 1.8v 1429.495n 1.8v 1429.505n 1.8v 1439.495n 1.8v 1439.505n 1.8v 1449.495n 1.8v 1449.505n 1.8v 1459.495n 1.8v 1459.505n 1.8v 1469.495n 1.8v 1469.505n 1.8v 1479.495n 1.8v 1479.505n 1.8v 1489.495n 1.8v 1489.505n 1.8v 1499.495n 1.8v 1499.505n 0.0v 1509.495n 0.0v 1509.505n 0.0v 1519.495n 0.0v 1519.505n 0.0v 1529.495n 0.0v 1529.505n 0.0v 1539.495n 0.0v 1539.505n 0.0v 1549.495n 0.0v 1549.505n 0.0v 1559.495n 0.0v 1559.505n 0.0v 1569.495n 0.0v 1569.505n 0.0v 1579.495n 0.0v 1579.505n 0.0v 1589.495n 0.0v 1589.505n 0.0v 1599.495n 0.0v 1599.505n 0.0v 1609.495n 0.0v 1609.505n 0.0v 1619.495n 0.0v 1619.505n 0.0v 1629.495n 0.0v 1629.505n 0.0v 1639.495n 0.0v 1639.505n 0.0v 1649.495n 0.0v 1649.505n 0.0v 1659.495n 0.0v 1659.505n 0.0v 1669.495n 0.0v 1669.505n 0.0v 1679.495n 0.0v 1679.505n 0.0v 1689.495n 0.0v 1689.505n 0.0v 1699.495n 0.0v 1699.505n 0.0v 1709.495n 0.0v 1709.505n 1.8v 1719.495n 1.8v 1719.505n 1.8v 1729.495n 1.8v 1729.505n 1.8v 1739.495n 1.8v 1739.505n 0.0v 1749.495n 0.0v 1749.505n 0.0v 1759.495n 0.0v 1759.505n 0.0v 1769.495n 0.0v 1769.505n 0.0v 1779.495n 0.0v 1779.505n 0.0v 1789.495n 0.0v 1789.505n 0.0v 1799.495n 0.0v 1799.505n 0.0v 1809.495n 0.0v 1809.505n 0.0v 1819.495n 0.0v 1819.505n 0.0v 1829.495n 0.0v 1829.505n 0.0v 1839.495n 0.0v 1839.505n 0.0v 1849.495n 0.0v 1849.505n 0.0v 1859.495n 0.0v 1859.505n 1.8v 1869.495n 1.8v 1869.505n 1.8v 1879.495n 1.8v 1879.505n 1.8v 1889.495n 1.8v 1889.505n 1.8v 1899.495n 1.8v 1899.505n 1.8v 1909.495n 1.8v 1909.505n 0.0v 1919.495n 0.0v 1919.505n 0.0v 1929.495n 0.0v 1929.505n 0.0v 1939.495n 0.0v 1939.505n 0.0v 1949.495n 0.0v 1949.505n 0.0v 1959.495n 0.0v 1959.505n 0.0v 1969.495n 0.0v 1969.505n 0.0v 1979.495n 0.0v 1979.505n 0.0v 1989.495n 0.0v 1989.505n 0.0v 1999.495n 0.0v 1999.505n 0.0v 2009.495n 0.0v 2009.505n 0.0v 2019.495n 0.0v 2019.505n 0.0v 2029.495n 0.0v 2029.505n 0.0v 2039.495n 0.0v 2039.505n 0.0v 2049.495n 0.0v 2049.505n 0.0v )
* (time, data): [(0, 0), (10, 0), (20, 1), (30, 0), (40, 0), (50, 0), (60, 0), (70, 0), (80, 0), (90, 0), (100, 0), (110, 0), (120, 0), (130, 0), (140, 0), (150, 0), (160, 0), (170, 0), (180, 0), (190, 0), (200, 0), (210, 0), (220, 0), (230, 0), (240, 0), (250, 0), (260, 1), (270, 1), (280, 1), (290, 1), (300, 1), (310, 0), (320, 0), (330, 0), (340, 0), (350, 1), (360, 1), (370, 1), (380, 1), (390, 0), (400, 0), (410, 0), (420, 1), (430, 1), (440, 1), (450, 0), (460, 0), (470, 1), (480, 1), (490, 1), (500, 0), (510, 0), (520, 0), (530, 0), (540, 0), (550, 0), (560, 0), (570, 0), (580, 0), (590, 0), (600, 0), (610, 0), (620, 0), (630, 0), (640, 0), (650, 0), (660, 0), (670, 1), (680, 1), (690, 1), (700, 1), (710, 0), (720, 0), (730, 0), (740, 0), (750, 0), (760, 0), (770, 1), (780, 1), (790, 1), (800, 1), (810, 1), (820, 0), (830, 0), (840, 0), (850, 0), (860, 0), (870, 0), (880, 0), (890, 0), (900, 0), (910, 0), (920, 0), (930, 0), (940, 0), (950, 0), (960, 0), (970, 0), (980, 0), (990, 0), (1000, 0), (1010, 0), (1020, 0), (1030, 0), (1040, 0), (1050, 0), (1060, 0), (1070, 0), (1080, 1), (1090, 1), (1100, 1), (1110, 1), (1120, 1), (1130, 1), (1140, 1), (1150, 1), (1160, 1), (1170, 1), (1180, 1), (1190, 1), (1200, 1), (1210, 1), (1220, 1), (1230, 1), (1240, 1), (1250, 1), (1260, 1), (1270, 1), (1280, 1), (1290, 1), (1300, 1), (1310, 1), (1320, 1), (1330, 1), (1340, 1), (1350, 1), (1360, 1), (1370, 0), (1380, 0), (1390, 0), (1400, 1), (1410, 1), (1420, 1), (1430, 1), (1440, 1), (1450, 1), (1460, 1), (1470, 1), (1480, 1), (1490, 1), (1500, 0), (1510, 0), (1520, 0), (1530, 0), (1540, 0), (1550, 0), (1560, 0), (1570, 0), (1580, 0), (1590, 0), (1600, 0), (1610, 0), (1620, 0), (1630, 0), (1640, 0), (1650, 0), (1660, 0), (1670, 0), (1680, 0), (1690, 1), (1700, 1), (1710, 1), (1720, 1), (1730, 1), (1740, 1), (1750, 1), (1760, 1), (1770, 1), (1780, 1), (1790, 0), (1800, 0), (1810, 0), (1820, 0), (1830, 0), (1840, 0), (1850, 0), (1860, 1), (1870, 0), (1880, 0), (1890, 0), (1900, 0), (1910, 1), (1920, 1), (1930, 1), (1940, 1), (1950, 1), (1960, 1), (1970, 1), (1980, 1), (1990, 1), (2000, 1), (2010, 1), (2020, 1), (2030, 0), (2040, 0), (2050, 0)]
Vdin0_57  din0_57  0 PWL (0n 0.0v 9.495n 0.0v 9.505n 0.0v 19.495n 0.0v 19.505n 1.8v 29.495n 1.8v 29.505n 0.0v 39.495n 0.0v 39.505n 0.0v 49.495n 0.0v 49.505n 0.0v 59.495n 0.0v 59.505n 0.0v 69.495n 0.0v 69.505n 0.0v 79.495n 0.0v 79.505n 0.0v 89.495n 0.0v 89.505n 0.0v 99.495n 0.0v 99.505n 0.0v 109.495n 0.0v 109.505n 0.0v 119.495n 0.0v 119.505n 0.0v 129.495n 0.0v 129.505n 0.0v 139.495n 0.0v 139.505n 0.0v 149.495n 0.0v 149.505n 0.0v 159.495n 0.0v 159.505n 0.0v 169.495n 0.0v 169.505n 0.0v 179.495n 0.0v 179.505n 0.0v 189.495n 0.0v 189.505n 0.0v 199.495n 0.0v 199.505n 0.0v 209.495n 0.0v 209.505n 0.0v 219.495n 0.0v 219.505n 0.0v 229.495n 0.0v 229.505n 0.0v 239.495n 0.0v 239.505n 0.0v 249.495n 0.0v 249.505n 0.0v 259.495n 0.0v 259.505n 1.8v 269.495n 1.8v 269.505n 1.8v 279.495n 1.8v 279.505n 1.8v 289.495n 1.8v 289.505n 1.8v 299.495n 1.8v 299.505n 1.8v 309.495n 1.8v 309.505n 0.0v 319.495n 0.0v 319.505n 0.0v 329.495n 0.0v 329.505n 0.0v 339.495n 0.0v 339.505n 0.0v 349.495n 0.0v 349.505n 1.8v 359.495n 1.8v 359.505n 1.8v 369.495n 1.8v 369.505n 1.8v 379.495n 1.8v 379.505n 1.8v 389.495n 1.8v 389.505n 0.0v 399.495n 0.0v 399.505n 0.0v 409.495n 0.0v 409.505n 0.0v 419.495n 0.0v 419.505n 1.8v 429.495n 1.8v 429.505n 1.8v 439.495n 1.8v 439.505n 1.8v 449.495n 1.8v 449.505n 0.0v 459.495n 0.0v 459.505n 0.0v 469.495n 0.0v 469.505n 1.8v 479.495n 1.8v 479.505n 1.8v 489.495n 1.8v 489.505n 1.8v 499.495n 1.8v 499.505n 0.0v 509.495n 0.0v 509.505n 0.0v 519.495n 0.0v 519.505n 0.0v 529.495n 0.0v 529.505n 0.0v 539.495n 0.0v 539.505n 0.0v 549.495n 0.0v 549.505n 0.0v 559.495n 0.0v 559.505n 0.0v 569.495n 0.0v 569.505n 0.0v 579.495n 0.0v 579.505n 0.0v 589.495n 0.0v 589.505n 0.0v 599.495n 0.0v 599.505n 0.0v 609.495n 0.0v 609.505n 0.0v 619.495n 0.0v 619.505n 0.0v 629.495n 0.0v 629.505n 0.0v 639.495n 0.0v 639.505n 0.0v 649.495n 0.0v 649.505n 0.0v 659.495n 0.0v 659.505n 0.0v 669.495n 0.0v 669.505n 1.8v 679.495n 1.8v 679.505n 1.8v 689.495n 1.8v 689.505n 1.8v 699.495n 1.8v 699.505n 1.8v 709.495n 1.8v 709.505n 0.0v 719.495n 0.0v 719.505n 0.0v 729.495n 0.0v 729.505n 0.0v 739.495n 0.0v 739.505n 0.0v 749.495n 0.0v 749.505n 0.0v 759.495n 0.0v 759.505n 0.0v 769.495n 0.0v 769.505n 1.8v 779.495n 1.8v 779.505n 1.8v 789.495n 1.8v 789.505n 1.8v 799.495n 1.8v 799.505n 1.8v 809.495n 1.8v 809.505n 1.8v 819.495n 1.8v 819.505n 0.0v 829.495n 0.0v 829.505n 0.0v 839.495n 0.0v 839.505n 0.0v 849.495n 0.0v 849.505n 0.0v 859.495n 0.0v 859.505n 0.0v 869.495n 0.0v 869.505n 0.0v 879.495n 0.0v 879.505n 0.0v 889.495n 0.0v 889.505n 0.0v 899.495n 0.0v 899.505n 0.0v 909.495n 0.0v 909.505n 0.0v 919.495n 0.0v 919.505n 0.0v 929.495n 0.0v 929.505n 0.0v 939.495n 0.0v 939.505n 0.0v 949.495n 0.0v 949.505n 0.0v 959.495n 0.0v 959.505n 0.0v 969.495n 0.0v 969.505n 0.0v 979.495n 0.0v 979.505n 0.0v 989.495n 0.0v 989.505n 0.0v 999.495n 0.0v 999.505n 0.0v 1009.495n 0.0v 1009.505n 0.0v 1019.495n 0.0v 1019.505n 0.0v 1029.495n 0.0v 1029.505n 0.0v 1039.495n 0.0v 1039.505n 0.0v 1049.495n 0.0v 1049.505n 0.0v 1059.495n 0.0v 1059.505n 0.0v 1069.495n 0.0v 1069.505n 0.0v 1079.495n 0.0v 1079.505n 1.8v 1089.495n 1.8v 1089.505n 1.8v 1099.495n 1.8v 1099.505n 1.8v 1109.495n 1.8v 1109.505n 1.8v 1119.495n 1.8v 1119.505n 1.8v 1129.495n 1.8v 1129.505n 1.8v 1139.495n 1.8v 1139.505n 1.8v 1149.495n 1.8v 1149.505n 1.8v 1159.495n 1.8v 1159.505n 1.8v 1169.495n 1.8v 1169.505n 1.8v 1179.495n 1.8v 1179.505n 1.8v 1189.495n 1.8v 1189.505n 1.8v 1199.495n 1.8v 1199.505n 1.8v 1209.495n 1.8v 1209.505n 1.8v 1219.495n 1.8v 1219.505n 1.8v 1229.495n 1.8v 1229.505n 1.8v 1239.495n 1.8v 1239.505n 1.8v 1249.495n 1.8v 1249.505n 1.8v 1259.495n 1.8v 1259.505n 1.8v 1269.495n 1.8v 1269.505n 1.8v 1279.495n 1.8v 1279.505n 1.8v 1289.495n 1.8v 1289.505n 1.8v 1299.495n 1.8v 1299.505n 1.8v 1309.495n 1.8v 1309.505n 1.8v 1319.495n 1.8v 1319.505n 1.8v 1329.495n 1.8v 1329.505n 1.8v 1339.495n 1.8v 1339.505n 1.8v 1349.495n 1.8v 1349.505n 1.8v 1359.495n 1.8v 1359.505n 1.8v 1369.495n 1.8v 1369.505n 0.0v 1379.495n 0.0v 1379.505n 0.0v 1389.495n 0.0v 1389.505n 0.0v 1399.495n 0.0v 1399.505n 1.8v 1409.495n 1.8v 1409.505n 1.8v 1419.495n 1.8v 1419.505n 1.8v 1429.495n 1.8v 1429.505n 1.8v 1439.495n 1.8v 1439.505n 1.8v 1449.495n 1.8v 1449.505n 1.8v 1459.495n 1.8v 1459.505n 1.8v 1469.495n 1.8v 1469.505n 1.8v 1479.495n 1.8v 1479.505n 1.8v 1489.495n 1.8v 1489.505n 1.8v 1499.495n 1.8v 1499.505n 0.0v 1509.495n 0.0v 1509.505n 0.0v 1519.495n 0.0v 1519.505n 0.0v 1529.495n 0.0v 1529.505n 0.0v 1539.495n 0.0v 1539.505n 0.0v 1549.495n 0.0v 1549.505n 0.0v 1559.495n 0.0v 1559.505n 0.0v 1569.495n 0.0v 1569.505n 0.0v 1579.495n 0.0v 1579.505n 0.0v 1589.495n 0.0v 1589.505n 0.0v 1599.495n 0.0v 1599.505n 0.0v 1609.495n 0.0v 1609.505n 0.0v 1619.495n 0.0v 1619.505n 0.0v 1629.495n 0.0v 1629.505n 0.0v 1639.495n 0.0v 1639.505n 0.0v 1649.495n 0.0v 1649.505n 0.0v 1659.495n 0.0v 1659.505n 0.0v 1669.495n 0.0v 1669.505n 0.0v 1679.495n 0.0v 1679.505n 0.0v 1689.495n 0.0v 1689.505n 1.8v 1699.495n 1.8v 1699.505n 1.8v 1709.495n 1.8v 1709.505n 1.8v 1719.495n 1.8v 1719.505n 1.8v 1729.495n 1.8v 1729.505n 1.8v 1739.495n 1.8v 1739.505n 1.8v 1749.495n 1.8v 1749.505n 1.8v 1759.495n 1.8v 1759.505n 1.8v 1769.495n 1.8v 1769.505n 1.8v 1779.495n 1.8v 1779.505n 1.8v 1789.495n 1.8v 1789.505n 0.0v 1799.495n 0.0v 1799.505n 0.0v 1809.495n 0.0v 1809.505n 0.0v 1819.495n 0.0v 1819.505n 0.0v 1829.495n 0.0v 1829.505n 0.0v 1839.495n 0.0v 1839.505n 0.0v 1849.495n 0.0v 1849.505n 0.0v 1859.495n 0.0v 1859.505n 1.8v 1869.495n 1.8v 1869.505n 0.0v 1879.495n 0.0v 1879.505n 0.0v 1889.495n 0.0v 1889.505n 0.0v 1899.495n 0.0v 1899.505n 0.0v 1909.495n 0.0v 1909.505n 1.8v 1919.495n 1.8v 1919.505n 1.8v 1929.495n 1.8v 1929.505n 1.8v 1939.495n 1.8v 1939.505n 1.8v 1949.495n 1.8v 1949.505n 1.8v 1959.495n 1.8v 1959.505n 1.8v 1969.495n 1.8v 1969.505n 1.8v 1979.495n 1.8v 1979.505n 1.8v 1989.495n 1.8v 1989.505n 1.8v 1999.495n 1.8v 1999.505n 1.8v 2009.495n 1.8v 2009.505n 1.8v 2019.495n 1.8v 2019.505n 1.8v 2029.495n 1.8v 2029.505n 0.0v 2039.495n 0.0v 2039.505n 0.0v 2049.495n 0.0v 2049.505n 0.0v )
* (time, data): [(0, 0), (10, 0), (20, 0), (30, 1), (40, 1), (50, 1), (60, 1), (70, 1), (80, 1), (90, 1), (100, 1), (110, 1), (120, 1), (130, 1), (140, 1), (150, 0), (160, 0), (170, 0), (180, 0), (190, 0), (200, 0), (210, 0), (220, 0), (230, 0), (240, 0), (250, 0), (260, 0), (270, 0), (280, 0), (290, 0), (300, 0), (310, 1), (320, 1), (330, 1), (340, 1), (350, 1), (360, 1), (370, 1), (380, 1), (390, 1), (400, 1), (410, 1), (420, 0), (430, 0), (440, 0), (450, 0), (460, 0), (470, 1), (480, 1), (490, 0), (500, 0), (510, 0), (520, 0), (530, 0), (540, 0), (550, 0), (560, 0), (570, 0), (580, 0), (590, 0), (600, 0), (610, 0), (620, 0), (630, 0), (640, 0), (650, 0), (660, 1), (670, 1), (680, 1), (690, 1), (700, 1), (710, 0), (720, 0), (730, 0), (740, 0), (750, 0), (760, 0), (770, 1), (780, 1), (790, 1), (800, 1), (810, 1), (820, 0), (830, 0), (840, 1), (850, 1), (860, 1), (870, 1), (880, 1), (890, 1), (900, 1), (910, 1), (920, 1), (930, 1), (940, 1), (950, 1), (960, 0), (970, 0), (980, 0), (990, 0), (1000, 0), (1010, 0), (1020, 0), (1030, 0), (1040, 0), (1050, 0), (1060, 0), (1070, 0), (1080, 0), (1090, 0), (1100, 0), (1110, 0), (1120, 0), (1130, 0), (1140, 0), (1150, 0), (1160, 0), (1170, 0), (1180, 0), (1190, 0), (1200, 0), (1210, 0), (1220, 0), (1230, 0), (1240, 0), (1250, 0), (1260, 1), (1270, 1), (1280, 1), (1290, 1), (1300, 1), (1310, 1), (1320, 1), (1330, 1), (1340, 1), (1350, 1), (1360, 1), (1370, 0), (1380, 0), (1390, 0), (1400, 0), (1410, 0), (1420, 0), (1430, 0), (1440, 0), (1450, 0), (1460, 0), (1470, 0), (1480, 0), (1490, 0), (1500, 0), (1510, 0), (1520, 0), (1530, 0), (1540, 0), (1550, 0), (1560, 0), (1570, 0), (1580, 0), (1590, 0), (1600, 0), (1610, 0), (1620, 1), (1630, 1), (1640, 1), (1650, 1), (1660, 1), (1670, 1), (1680, 1), (1690, 1), (1700, 1), (1710, 1), (1720, 1), (1730, 1), (1740, 0), (1750, 0), (1760, 0), (1770, 0), (1780, 0), (1790, 0), (1800, 0), (1810, 0), (1820, 0), (1830, 0), (1840, 0), (1850, 0), (1860, 1), (1870, 1), (1880, 1), (1890, 1), (1900, 1), (1910, 0), (1920, 0), (1930, 0), (1940, 0), (1950, 0), (1960, 0), (1970, 0), (1980, 0), (1990, 0), (2000, 0), (2010, 0), (2020, 0), (2030, 1), (2040, 1), (2050, 1)]
Vdin0_58  din0_58  0 PWL (0n 0.0v 9.495n 0.0v 9.505n 0.0v 19.495n 0.0v 19.505n 0.0v 29.495n 0.0v 29.505n 1.8v 39.495n 1.8v 39.505n 1.8v 49.495n 1.8v 49.505n 1.8v 59.495n 1.8v 59.505n 1.8v 69.495n 1.8v 69.505n 1.8v 79.495n 1.8v 79.505n 1.8v 89.495n 1.8v 89.505n 1.8v 99.495n 1.8v 99.505n 1.8v 109.495n 1.8v 109.505n 1.8v 119.495n 1.8v 119.505n 1.8v 129.495n 1.8v 129.505n 1.8v 139.495n 1.8v 139.505n 1.8v 149.495n 1.8v 149.505n 0.0v 159.495n 0.0v 159.505n 0.0v 169.495n 0.0v 169.505n 0.0v 179.495n 0.0v 179.505n 0.0v 189.495n 0.0v 189.505n 0.0v 199.495n 0.0v 199.505n 0.0v 209.495n 0.0v 209.505n 0.0v 219.495n 0.0v 219.505n 0.0v 229.495n 0.0v 229.505n 0.0v 239.495n 0.0v 239.505n 0.0v 249.495n 0.0v 249.505n 0.0v 259.495n 0.0v 259.505n 0.0v 269.495n 0.0v 269.505n 0.0v 279.495n 0.0v 279.505n 0.0v 289.495n 0.0v 289.505n 0.0v 299.495n 0.0v 299.505n 0.0v 309.495n 0.0v 309.505n 1.8v 319.495n 1.8v 319.505n 1.8v 329.495n 1.8v 329.505n 1.8v 339.495n 1.8v 339.505n 1.8v 349.495n 1.8v 349.505n 1.8v 359.495n 1.8v 359.505n 1.8v 369.495n 1.8v 369.505n 1.8v 379.495n 1.8v 379.505n 1.8v 389.495n 1.8v 389.505n 1.8v 399.495n 1.8v 399.505n 1.8v 409.495n 1.8v 409.505n 1.8v 419.495n 1.8v 419.505n 0.0v 429.495n 0.0v 429.505n 0.0v 439.495n 0.0v 439.505n 0.0v 449.495n 0.0v 449.505n 0.0v 459.495n 0.0v 459.505n 0.0v 469.495n 0.0v 469.505n 1.8v 479.495n 1.8v 479.505n 1.8v 489.495n 1.8v 489.505n 0.0v 499.495n 0.0v 499.505n 0.0v 509.495n 0.0v 509.505n 0.0v 519.495n 0.0v 519.505n 0.0v 529.495n 0.0v 529.505n 0.0v 539.495n 0.0v 539.505n 0.0v 549.495n 0.0v 549.505n 0.0v 559.495n 0.0v 559.505n 0.0v 569.495n 0.0v 569.505n 0.0v 579.495n 0.0v 579.505n 0.0v 589.495n 0.0v 589.505n 0.0v 599.495n 0.0v 599.505n 0.0v 609.495n 0.0v 609.505n 0.0v 619.495n 0.0v 619.505n 0.0v 629.495n 0.0v 629.505n 0.0v 639.495n 0.0v 639.505n 0.0v 649.495n 0.0v 649.505n 0.0v 659.495n 0.0v 659.505n 1.8v 669.495n 1.8v 669.505n 1.8v 679.495n 1.8v 679.505n 1.8v 689.495n 1.8v 689.505n 1.8v 699.495n 1.8v 699.505n 1.8v 709.495n 1.8v 709.505n 0.0v 719.495n 0.0v 719.505n 0.0v 729.495n 0.0v 729.505n 0.0v 739.495n 0.0v 739.505n 0.0v 749.495n 0.0v 749.505n 0.0v 759.495n 0.0v 759.505n 0.0v 769.495n 0.0v 769.505n 1.8v 779.495n 1.8v 779.505n 1.8v 789.495n 1.8v 789.505n 1.8v 799.495n 1.8v 799.505n 1.8v 809.495n 1.8v 809.505n 1.8v 819.495n 1.8v 819.505n 0.0v 829.495n 0.0v 829.505n 0.0v 839.495n 0.0v 839.505n 1.8v 849.495n 1.8v 849.505n 1.8v 859.495n 1.8v 859.505n 1.8v 869.495n 1.8v 869.505n 1.8v 879.495n 1.8v 879.505n 1.8v 889.495n 1.8v 889.505n 1.8v 899.495n 1.8v 899.505n 1.8v 909.495n 1.8v 909.505n 1.8v 919.495n 1.8v 919.505n 1.8v 929.495n 1.8v 929.505n 1.8v 939.495n 1.8v 939.505n 1.8v 949.495n 1.8v 949.505n 1.8v 959.495n 1.8v 959.505n 0.0v 969.495n 0.0v 969.505n 0.0v 979.495n 0.0v 979.505n 0.0v 989.495n 0.0v 989.505n 0.0v 999.495n 0.0v 999.505n 0.0v 1009.495n 0.0v 1009.505n 0.0v 1019.495n 0.0v 1019.505n 0.0v 1029.495n 0.0v 1029.505n 0.0v 1039.495n 0.0v 1039.505n 0.0v 1049.495n 0.0v 1049.505n 0.0v 1059.495n 0.0v 1059.505n 0.0v 1069.495n 0.0v 1069.505n 0.0v 1079.495n 0.0v 1079.505n 0.0v 1089.495n 0.0v 1089.505n 0.0v 1099.495n 0.0v 1099.505n 0.0v 1109.495n 0.0v 1109.505n 0.0v 1119.495n 0.0v 1119.505n 0.0v 1129.495n 0.0v 1129.505n 0.0v 1139.495n 0.0v 1139.505n 0.0v 1149.495n 0.0v 1149.505n 0.0v 1159.495n 0.0v 1159.505n 0.0v 1169.495n 0.0v 1169.505n 0.0v 1179.495n 0.0v 1179.505n 0.0v 1189.495n 0.0v 1189.505n 0.0v 1199.495n 0.0v 1199.505n 0.0v 1209.495n 0.0v 1209.505n 0.0v 1219.495n 0.0v 1219.505n 0.0v 1229.495n 0.0v 1229.505n 0.0v 1239.495n 0.0v 1239.505n 0.0v 1249.495n 0.0v 1249.505n 0.0v 1259.495n 0.0v 1259.505n 1.8v 1269.495n 1.8v 1269.505n 1.8v 1279.495n 1.8v 1279.505n 1.8v 1289.495n 1.8v 1289.505n 1.8v 1299.495n 1.8v 1299.505n 1.8v 1309.495n 1.8v 1309.505n 1.8v 1319.495n 1.8v 1319.505n 1.8v 1329.495n 1.8v 1329.505n 1.8v 1339.495n 1.8v 1339.505n 1.8v 1349.495n 1.8v 1349.505n 1.8v 1359.495n 1.8v 1359.505n 1.8v 1369.495n 1.8v 1369.505n 0.0v 1379.495n 0.0v 1379.505n 0.0v 1389.495n 0.0v 1389.505n 0.0v 1399.495n 0.0v 1399.505n 0.0v 1409.495n 0.0v 1409.505n 0.0v 1419.495n 0.0v 1419.505n 0.0v 1429.495n 0.0v 1429.505n 0.0v 1439.495n 0.0v 1439.505n 0.0v 1449.495n 0.0v 1449.505n 0.0v 1459.495n 0.0v 1459.505n 0.0v 1469.495n 0.0v 1469.505n 0.0v 1479.495n 0.0v 1479.505n 0.0v 1489.495n 0.0v 1489.505n 0.0v 1499.495n 0.0v 1499.505n 0.0v 1509.495n 0.0v 1509.505n 0.0v 1519.495n 0.0v 1519.505n 0.0v 1529.495n 0.0v 1529.505n 0.0v 1539.495n 0.0v 1539.505n 0.0v 1549.495n 0.0v 1549.505n 0.0v 1559.495n 0.0v 1559.505n 0.0v 1569.495n 0.0v 1569.505n 0.0v 1579.495n 0.0v 1579.505n 0.0v 1589.495n 0.0v 1589.505n 0.0v 1599.495n 0.0v 1599.505n 0.0v 1609.495n 0.0v 1609.505n 0.0v 1619.495n 0.0v 1619.505n 1.8v 1629.495n 1.8v 1629.505n 1.8v 1639.495n 1.8v 1639.505n 1.8v 1649.495n 1.8v 1649.505n 1.8v 1659.495n 1.8v 1659.505n 1.8v 1669.495n 1.8v 1669.505n 1.8v 1679.495n 1.8v 1679.505n 1.8v 1689.495n 1.8v 1689.505n 1.8v 1699.495n 1.8v 1699.505n 1.8v 1709.495n 1.8v 1709.505n 1.8v 1719.495n 1.8v 1719.505n 1.8v 1729.495n 1.8v 1729.505n 1.8v 1739.495n 1.8v 1739.505n 0.0v 1749.495n 0.0v 1749.505n 0.0v 1759.495n 0.0v 1759.505n 0.0v 1769.495n 0.0v 1769.505n 0.0v 1779.495n 0.0v 1779.505n 0.0v 1789.495n 0.0v 1789.505n 0.0v 1799.495n 0.0v 1799.505n 0.0v 1809.495n 0.0v 1809.505n 0.0v 1819.495n 0.0v 1819.505n 0.0v 1829.495n 0.0v 1829.505n 0.0v 1839.495n 0.0v 1839.505n 0.0v 1849.495n 0.0v 1849.505n 0.0v 1859.495n 0.0v 1859.505n 1.8v 1869.495n 1.8v 1869.505n 1.8v 1879.495n 1.8v 1879.505n 1.8v 1889.495n 1.8v 1889.505n 1.8v 1899.495n 1.8v 1899.505n 1.8v 1909.495n 1.8v 1909.505n 0.0v 1919.495n 0.0v 1919.505n 0.0v 1929.495n 0.0v 1929.505n 0.0v 1939.495n 0.0v 1939.505n 0.0v 1949.495n 0.0v 1949.505n 0.0v 1959.495n 0.0v 1959.505n 0.0v 1969.495n 0.0v 1969.505n 0.0v 1979.495n 0.0v 1979.505n 0.0v 1989.495n 0.0v 1989.505n 0.0v 1999.495n 0.0v 1999.505n 0.0v 2009.495n 0.0v 2009.505n 0.0v 2019.495n 0.0v 2019.505n 0.0v 2029.495n 0.0v 2029.505n 1.8v 2039.495n 1.8v 2039.505n 1.8v 2049.495n 1.8v 2049.505n 1.8v )
* (time, data): [(0, 0), (10, 0), (20, 1), (30, 0), (40, 0), (50, 0), (60, 1), (70, 1), (80, 1), (90, 1), (100, 1), (110, 1), (120, 1), (130, 1), (140, 1), (150, 1), (160, 1), (170, 1), (180, 1), (190, 1), (200, 1), (210, 1), (220, 1), (230, 1), (240, 1), (250, 1), (260, 0), (270, 0), (280, 0), (290, 0), (300, 0), (310, 1), (320, 1), (330, 1), (340, 1), (350, 0), (360, 0), (370, 0), (380, 0), (390, 1), (400, 1), (410, 1), (420, 1), (430, 1), (440, 1), (450, 1), (460, 1), (470, 1), (480, 1), (490, 0), (500, 1), (510, 1), (520, 1), (530, 1), (540, 1), (550, 1), (560, 1), (570, 1), (580, 1), (590, 1), (600, 1), (610, 1), (620, 1), (630, 1), (640, 1), (650, 1), (660, 0), (670, 0), (680, 0), (690, 0), (700, 0), (710, 1), (720, 1), (730, 1), (740, 1), (750, 1), (760, 1), (770, 0), (780, 0), (790, 0), (800, 0), (810, 0), (820, 0), (830, 0), (840, 0), (850, 0), (860, 0), (870, 0), (880, 0), (890, 0), (900, 0), (910, 0), (920, 0), (930, 1), (940, 1), (950, 1), (960, 0), (970, 0), (980, 0), (990, 0), (1000, 0), (1010, 0), (1020, 0), (1030, 0), (1040, 0), (1050, 0), (1060, 0), (1070, 0), (1080, 0), (1090, 0), (1100, 0), (1110, 0), (1120, 0), (1130, 1), (1140, 1), (1150, 1), (1160, 1), (1170, 1), (1180, 1), (1190, 1), (1200, 1), (1210, 1), (1220, 1), (1230, 1), (1240, 1), (1250, 1), (1260, 0), (1270, 0), (1280, 0), (1290, 0), (1300, 0), (1310, 0), (1320, 0), (1330, 0), (1340, 0), (1350, 0), (1360, 0), (1370, 0), (1380, 0), (1390, 0), (1400, 1), (1410, 1), (1420, 1), (1430, 1), (1440, 1), (1450, 1), (1460, 1), (1470, 1), (1480, 0), (1490, 0), (1500, 0), (1510, 0), (1520, 0), (1530, 0), (1540, 0), (1550, 0), (1560, 0), (1570, 0), (1580, 0), (1590, 0), (1600, 0), (1610, 0), (1620, 1), (1630, 1), (1640, 1), (1650, 1), (1660, 1), (1670, 1), (1680, 1), (1690, 0), (1700, 0), (1710, 1), (1720, 1), (1730, 0), (1740, 1), (1750, 1), (1760, 1), (1770, 1), (1780, 1), (1790, 1), (1800, 1), (1810, 1), (1820, 1), (1830, 1), (1840, 1), (1850, 1), (1860, 1), (1870, 0), (1880, 1), (1890, 1), (1900, 1), (1910, 1), (1920, 1), (1930, 1), (1940, 1), (1950, 1), (1960, 1), (1970, 1), (1980, 1), (1990, 1), (2000, 1), (2010, 1), (2020, 1), (2030, 0), (2040, 0), (2050, 0)]
Vdin0_59  din0_59  0 PWL (0n 0.0v 9.495n 0.0v 9.505n 0.0v 19.495n 0.0v 19.505n 1.8v 29.495n 1.8v 29.505n 0.0v 39.495n 0.0v 39.505n 0.0v 49.495n 0.0v 49.505n 0.0v 59.495n 0.0v 59.505n 1.8v 69.495n 1.8v 69.505n 1.8v 79.495n 1.8v 79.505n 1.8v 89.495n 1.8v 89.505n 1.8v 99.495n 1.8v 99.505n 1.8v 109.495n 1.8v 109.505n 1.8v 119.495n 1.8v 119.505n 1.8v 129.495n 1.8v 129.505n 1.8v 139.495n 1.8v 139.505n 1.8v 149.495n 1.8v 149.505n 1.8v 159.495n 1.8v 159.505n 1.8v 169.495n 1.8v 169.505n 1.8v 179.495n 1.8v 179.505n 1.8v 189.495n 1.8v 189.505n 1.8v 199.495n 1.8v 199.505n 1.8v 209.495n 1.8v 209.505n 1.8v 219.495n 1.8v 219.505n 1.8v 229.495n 1.8v 229.505n 1.8v 239.495n 1.8v 239.505n 1.8v 249.495n 1.8v 249.505n 1.8v 259.495n 1.8v 259.505n 0.0v 269.495n 0.0v 269.505n 0.0v 279.495n 0.0v 279.505n 0.0v 289.495n 0.0v 289.505n 0.0v 299.495n 0.0v 299.505n 0.0v 309.495n 0.0v 309.505n 1.8v 319.495n 1.8v 319.505n 1.8v 329.495n 1.8v 329.505n 1.8v 339.495n 1.8v 339.505n 1.8v 349.495n 1.8v 349.505n 0.0v 359.495n 0.0v 359.505n 0.0v 369.495n 0.0v 369.505n 0.0v 379.495n 0.0v 379.505n 0.0v 389.495n 0.0v 389.505n 1.8v 399.495n 1.8v 399.505n 1.8v 409.495n 1.8v 409.505n 1.8v 419.495n 1.8v 419.505n 1.8v 429.495n 1.8v 429.505n 1.8v 439.495n 1.8v 439.505n 1.8v 449.495n 1.8v 449.505n 1.8v 459.495n 1.8v 459.505n 1.8v 469.495n 1.8v 469.505n 1.8v 479.495n 1.8v 479.505n 1.8v 489.495n 1.8v 489.505n 0.0v 499.495n 0.0v 499.505n 1.8v 509.495n 1.8v 509.505n 1.8v 519.495n 1.8v 519.505n 1.8v 529.495n 1.8v 529.505n 1.8v 539.495n 1.8v 539.505n 1.8v 549.495n 1.8v 549.505n 1.8v 559.495n 1.8v 559.505n 1.8v 569.495n 1.8v 569.505n 1.8v 579.495n 1.8v 579.505n 1.8v 589.495n 1.8v 589.505n 1.8v 599.495n 1.8v 599.505n 1.8v 609.495n 1.8v 609.505n 1.8v 619.495n 1.8v 619.505n 1.8v 629.495n 1.8v 629.505n 1.8v 639.495n 1.8v 639.505n 1.8v 649.495n 1.8v 649.505n 1.8v 659.495n 1.8v 659.505n 0.0v 669.495n 0.0v 669.505n 0.0v 679.495n 0.0v 679.505n 0.0v 689.495n 0.0v 689.505n 0.0v 699.495n 0.0v 699.505n 0.0v 709.495n 0.0v 709.505n 1.8v 719.495n 1.8v 719.505n 1.8v 729.495n 1.8v 729.505n 1.8v 739.495n 1.8v 739.505n 1.8v 749.495n 1.8v 749.505n 1.8v 759.495n 1.8v 759.505n 1.8v 769.495n 1.8v 769.505n 0.0v 779.495n 0.0v 779.505n 0.0v 789.495n 0.0v 789.505n 0.0v 799.495n 0.0v 799.505n 0.0v 809.495n 0.0v 809.505n 0.0v 819.495n 0.0v 819.505n 0.0v 829.495n 0.0v 829.505n 0.0v 839.495n 0.0v 839.505n 0.0v 849.495n 0.0v 849.505n 0.0v 859.495n 0.0v 859.505n 0.0v 869.495n 0.0v 869.505n 0.0v 879.495n 0.0v 879.505n 0.0v 889.495n 0.0v 889.505n 0.0v 899.495n 0.0v 899.505n 0.0v 909.495n 0.0v 909.505n 0.0v 919.495n 0.0v 919.505n 0.0v 929.495n 0.0v 929.505n 1.8v 939.495n 1.8v 939.505n 1.8v 949.495n 1.8v 949.505n 1.8v 959.495n 1.8v 959.505n 0.0v 969.495n 0.0v 969.505n 0.0v 979.495n 0.0v 979.505n 0.0v 989.495n 0.0v 989.505n 0.0v 999.495n 0.0v 999.505n 0.0v 1009.495n 0.0v 1009.505n 0.0v 1019.495n 0.0v 1019.505n 0.0v 1029.495n 0.0v 1029.505n 0.0v 1039.495n 0.0v 1039.505n 0.0v 1049.495n 0.0v 1049.505n 0.0v 1059.495n 0.0v 1059.505n 0.0v 1069.495n 0.0v 1069.505n 0.0v 1079.495n 0.0v 1079.505n 0.0v 1089.495n 0.0v 1089.505n 0.0v 1099.495n 0.0v 1099.505n 0.0v 1109.495n 0.0v 1109.505n 0.0v 1119.495n 0.0v 1119.505n 0.0v 1129.495n 0.0v 1129.505n 1.8v 1139.495n 1.8v 1139.505n 1.8v 1149.495n 1.8v 1149.505n 1.8v 1159.495n 1.8v 1159.505n 1.8v 1169.495n 1.8v 1169.505n 1.8v 1179.495n 1.8v 1179.505n 1.8v 1189.495n 1.8v 1189.505n 1.8v 1199.495n 1.8v 1199.505n 1.8v 1209.495n 1.8v 1209.505n 1.8v 1219.495n 1.8v 1219.505n 1.8v 1229.495n 1.8v 1229.505n 1.8v 1239.495n 1.8v 1239.505n 1.8v 1249.495n 1.8v 1249.505n 1.8v 1259.495n 1.8v 1259.505n 0.0v 1269.495n 0.0v 1269.505n 0.0v 1279.495n 0.0v 1279.505n 0.0v 1289.495n 0.0v 1289.505n 0.0v 1299.495n 0.0v 1299.505n 0.0v 1309.495n 0.0v 1309.505n 0.0v 1319.495n 0.0v 1319.505n 0.0v 1329.495n 0.0v 1329.505n 0.0v 1339.495n 0.0v 1339.505n 0.0v 1349.495n 0.0v 1349.505n 0.0v 1359.495n 0.0v 1359.505n 0.0v 1369.495n 0.0v 1369.505n 0.0v 1379.495n 0.0v 1379.505n 0.0v 1389.495n 0.0v 1389.505n 0.0v 1399.495n 0.0v 1399.505n 1.8v 1409.495n 1.8v 1409.505n 1.8v 1419.495n 1.8v 1419.505n 1.8v 1429.495n 1.8v 1429.505n 1.8v 1439.495n 1.8v 1439.505n 1.8v 1449.495n 1.8v 1449.505n 1.8v 1459.495n 1.8v 1459.505n 1.8v 1469.495n 1.8v 1469.505n 1.8v 1479.495n 1.8v 1479.505n 0.0v 1489.495n 0.0v 1489.505n 0.0v 1499.495n 0.0v 1499.505n 0.0v 1509.495n 0.0v 1509.505n 0.0v 1519.495n 0.0v 1519.505n 0.0v 1529.495n 0.0v 1529.505n 0.0v 1539.495n 0.0v 1539.505n 0.0v 1549.495n 0.0v 1549.505n 0.0v 1559.495n 0.0v 1559.505n 0.0v 1569.495n 0.0v 1569.505n 0.0v 1579.495n 0.0v 1579.505n 0.0v 1589.495n 0.0v 1589.505n 0.0v 1599.495n 0.0v 1599.505n 0.0v 1609.495n 0.0v 1609.505n 0.0v 1619.495n 0.0v 1619.505n 1.8v 1629.495n 1.8v 1629.505n 1.8v 1639.495n 1.8v 1639.505n 1.8v 1649.495n 1.8v 1649.505n 1.8v 1659.495n 1.8v 1659.505n 1.8v 1669.495n 1.8v 1669.505n 1.8v 1679.495n 1.8v 1679.505n 1.8v 1689.495n 1.8v 1689.505n 0.0v 1699.495n 0.0v 1699.505n 0.0v 1709.495n 0.0v 1709.505n 1.8v 1719.495n 1.8v 1719.505n 1.8v 1729.495n 1.8v 1729.505n 0.0v 1739.495n 0.0v 1739.505n 1.8v 1749.495n 1.8v 1749.505n 1.8v 1759.495n 1.8v 1759.505n 1.8v 1769.495n 1.8v 1769.505n 1.8v 1779.495n 1.8v 1779.505n 1.8v 1789.495n 1.8v 1789.505n 1.8v 1799.495n 1.8v 1799.505n 1.8v 1809.495n 1.8v 1809.505n 1.8v 1819.495n 1.8v 1819.505n 1.8v 1829.495n 1.8v 1829.505n 1.8v 1839.495n 1.8v 1839.505n 1.8v 1849.495n 1.8v 1849.505n 1.8v 1859.495n 1.8v 1859.505n 1.8v 1869.495n 1.8v 1869.505n 0.0v 1879.495n 0.0v 1879.505n 1.8v 1889.495n 1.8v 1889.505n 1.8v 1899.495n 1.8v 1899.505n 1.8v 1909.495n 1.8v 1909.505n 1.8v 1919.495n 1.8v 1919.505n 1.8v 1929.495n 1.8v 1929.505n 1.8v 1939.495n 1.8v 1939.505n 1.8v 1949.495n 1.8v 1949.505n 1.8v 1959.495n 1.8v 1959.505n 1.8v 1969.495n 1.8v 1969.505n 1.8v 1979.495n 1.8v 1979.505n 1.8v 1989.495n 1.8v 1989.505n 1.8v 1999.495n 1.8v 1999.505n 1.8v 2009.495n 1.8v 2009.505n 1.8v 2019.495n 1.8v 2019.505n 1.8v 2029.495n 1.8v 2029.505n 0.0v 2039.495n 0.0v 2039.505n 0.0v 2049.495n 0.0v 2049.505n 0.0v )
* (time, data): [(0, 0), (10, 1), (20, 0), (30, 0), (40, 0), (50, 0), (60, 1), (70, 1), (80, 1), (90, 1), (100, 1), (110, 1), (120, 1), (130, 1), (140, 1), (150, 0), (160, 0), (170, 0), (180, 0), (190, 0), (200, 0), (210, 0), (220, 0), (230, 0), (240, 0), (250, 0), (260, 1), (270, 1), (280, 1), (290, 1), (300, 1), (310, 1), (320, 1), (330, 1), (340, 1), (350, 0), (360, 0), (370, 0), (380, 0), (390, 1), (400, 0), (410, 0), (420, 0), (430, 0), (440, 0), (450, 1), (460, 1), (470, 0), (480, 0), (490, 1), (500, 0), (510, 0), (520, 0), (530, 0), (540, 0), (550, 0), (560, 0), (570, 0), (580, 0), (590, 0), (600, 0), (610, 0), (620, 0), (630, 0), (640, 0), (650, 0), (660, 0), (670, 0), (680, 0), (690, 0), (700, 0), (710, 0), (720, 0), (730, 0), (740, 0), (750, 0), (760, 0), (770, 0), (780, 0), (790, 0), (800, 0), (810, 0), (820, 0), (830, 0), (840, 0), (850, 0), (860, 0), (870, 0), (880, 0), (890, 0), (900, 0), (910, 0), (920, 0), (930, 0), (940, 0), (950, 0), (960, 0), (970, 0), (980, 0), (990, 0), (1000, 0), (1010, 0), (1020, 0), (1030, 0), (1040, 0), (1050, 0), (1060, 0), (1070, 0), (1080, 1), (1090, 1), (1100, 1), (1110, 1), (1120, 1), (1130, 1), (1140, 1), (1150, 1), (1160, 1), (1170, 1), (1180, 1), (1190, 1), (1200, 1), (1210, 1), (1220, 1), (1230, 1), (1240, 1), (1250, 1), (1260, 0), (1270, 0), (1280, 1), (1290, 1), (1300, 1), (1310, 1), (1320, 1), (1330, 1), (1340, 1), (1350, 1), (1360, 1), (1370, 0), (1380, 0), (1390, 0), (1400, 1), (1410, 1), (1420, 1), (1430, 0), (1440, 0), (1450, 0), (1460, 0), (1470, 0), (1480, 0), (1490, 0), (1500, 0), (1510, 0), (1520, 0), (1530, 0), (1540, 0), (1550, 0), (1560, 0), (1570, 1), (1580, 1), (1590, 0), (1600, 0), (1610, 0), (1620, 1), (1630, 1), (1640, 1), (1650, 1), (1660, 1), (1670, 1), (1680, 1), (1690, 0), (1700, 0), (1710, 1), (1720, 1), (1730, 0), (1740, 0), (1750, 0), (1760, 0), (1770, 0), (1780, 0), (1790, 1), (1800, 1), (1810, 1), (1820, 1), (1830, 1), (1840, 1), (1850, 1), (1860, 0), (1870, 1), (1880, 1), (1890, 1), (1900, 1), (1910, 1), (1920, 1), (1930, 1), (1940, 1), (1950, 1), (1960, 1), (1970, 1), (1980, 1), (1990, 1), (2000, 1), (2010, 1), (2020, 1), (2030, 1), (2040, 1), (2050, 1)]
Vdin0_60  din0_60  0 PWL (0n 0.0v 9.495n 0.0v 9.505n 1.8v 19.495n 1.8v 19.505n 0.0v 29.495n 0.0v 29.505n 0.0v 39.495n 0.0v 39.505n 0.0v 49.495n 0.0v 49.505n 0.0v 59.495n 0.0v 59.505n 1.8v 69.495n 1.8v 69.505n 1.8v 79.495n 1.8v 79.505n 1.8v 89.495n 1.8v 89.505n 1.8v 99.495n 1.8v 99.505n 1.8v 109.495n 1.8v 109.505n 1.8v 119.495n 1.8v 119.505n 1.8v 129.495n 1.8v 129.505n 1.8v 139.495n 1.8v 139.505n 1.8v 149.495n 1.8v 149.505n 0.0v 159.495n 0.0v 159.505n 0.0v 169.495n 0.0v 169.505n 0.0v 179.495n 0.0v 179.505n 0.0v 189.495n 0.0v 189.505n 0.0v 199.495n 0.0v 199.505n 0.0v 209.495n 0.0v 209.505n 0.0v 219.495n 0.0v 219.505n 0.0v 229.495n 0.0v 229.505n 0.0v 239.495n 0.0v 239.505n 0.0v 249.495n 0.0v 249.505n 0.0v 259.495n 0.0v 259.505n 1.8v 269.495n 1.8v 269.505n 1.8v 279.495n 1.8v 279.505n 1.8v 289.495n 1.8v 289.505n 1.8v 299.495n 1.8v 299.505n 1.8v 309.495n 1.8v 309.505n 1.8v 319.495n 1.8v 319.505n 1.8v 329.495n 1.8v 329.505n 1.8v 339.495n 1.8v 339.505n 1.8v 349.495n 1.8v 349.505n 0.0v 359.495n 0.0v 359.505n 0.0v 369.495n 0.0v 369.505n 0.0v 379.495n 0.0v 379.505n 0.0v 389.495n 0.0v 389.505n 1.8v 399.495n 1.8v 399.505n 0.0v 409.495n 0.0v 409.505n 0.0v 419.495n 0.0v 419.505n 0.0v 429.495n 0.0v 429.505n 0.0v 439.495n 0.0v 439.505n 0.0v 449.495n 0.0v 449.505n 1.8v 459.495n 1.8v 459.505n 1.8v 469.495n 1.8v 469.505n 0.0v 479.495n 0.0v 479.505n 0.0v 489.495n 0.0v 489.505n 1.8v 499.495n 1.8v 499.505n 0.0v 509.495n 0.0v 509.505n 0.0v 519.495n 0.0v 519.505n 0.0v 529.495n 0.0v 529.505n 0.0v 539.495n 0.0v 539.505n 0.0v 549.495n 0.0v 549.505n 0.0v 559.495n 0.0v 559.505n 0.0v 569.495n 0.0v 569.505n 0.0v 579.495n 0.0v 579.505n 0.0v 589.495n 0.0v 589.505n 0.0v 599.495n 0.0v 599.505n 0.0v 609.495n 0.0v 609.505n 0.0v 619.495n 0.0v 619.505n 0.0v 629.495n 0.0v 629.505n 0.0v 639.495n 0.0v 639.505n 0.0v 649.495n 0.0v 649.505n 0.0v 659.495n 0.0v 659.505n 0.0v 669.495n 0.0v 669.505n 0.0v 679.495n 0.0v 679.505n 0.0v 689.495n 0.0v 689.505n 0.0v 699.495n 0.0v 699.505n 0.0v 709.495n 0.0v 709.505n 0.0v 719.495n 0.0v 719.505n 0.0v 729.495n 0.0v 729.505n 0.0v 739.495n 0.0v 739.505n 0.0v 749.495n 0.0v 749.505n 0.0v 759.495n 0.0v 759.505n 0.0v 769.495n 0.0v 769.505n 0.0v 779.495n 0.0v 779.505n 0.0v 789.495n 0.0v 789.505n 0.0v 799.495n 0.0v 799.505n 0.0v 809.495n 0.0v 809.505n 0.0v 819.495n 0.0v 819.505n 0.0v 829.495n 0.0v 829.505n 0.0v 839.495n 0.0v 839.505n 0.0v 849.495n 0.0v 849.505n 0.0v 859.495n 0.0v 859.505n 0.0v 869.495n 0.0v 869.505n 0.0v 879.495n 0.0v 879.505n 0.0v 889.495n 0.0v 889.505n 0.0v 899.495n 0.0v 899.505n 0.0v 909.495n 0.0v 909.505n 0.0v 919.495n 0.0v 919.505n 0.0v 929.495n 0.0v 929.505n 0.0v 939.495n 0.0v 939.505n 0.0v 949.495n 0.0v 949.505n 0.0v 959.495n 0.0v 959.505n 0.0v 969.495n 0.0v 969.505n 0.0v 979.495n 0.0v 979.505n 0.0v 989.495n 0.0v 989.505n 0.0v 999.495n 0.0v 999.505n 0.0v 1009.495n 0.0v 1009.505n 0.0v 1019.495n 0.0v 1019.505n 0.0v 1029.495n 0.0v 1029.505n 0.0v 1039.495n 0.0v 1039.505n 0.0v 1049.495n 0.0v 1049.505n 0.0v 1059.495n 0.0v 1059.505n 0.0v 1069.495n 0.0v 1069.505n 0.0v 1079.495n 0.0v 1079.505n 1.8v 1089.495n 1.8v 1089.505n 1.8v 1099.495n 1.8v 1099.505n 1.8v 1109.495n 1.8v 1109.505n 1.8v 1119.495n 1.8v 1119.505n 1.8v 1129.495n 1.8v 1129.505n 1.8v 1139.495n 1.8v 1139.505n 1.8v 1149.495n 1.8v 1149.505n 1.8v 1159.495n 1.8v 1159.505n 1.8v 1169.495n 1.8v 1169.505n 1.8v 1179.495n 1.8v 1179.505n 1.8v 1189.495n 1.8v 1189.505n 1.8v 1199.495n 1.8v 1199.505n 1.8v 1209.495n 1.8v 1209.505n 1.8v 1219.495n 1.8v 1219.505n 1.8v 1229.495n 1.8v 1229.505n 1.8v 1239.495n 1.8v 1239.505n 1.8v 1249.495n 1.8v 1249.505n 1.8v 1259.495n 1.8v 1259.505n 0.0v 1269.495n 0.0v 1269.505n 0.0v 1279.495n 0.0v 1279.505n 1.8v 1289.495n 1.8v 1289.505n 1.8v 1299.495n 1.8v 1299.505n 1.8v 1309.495n 1.8v 1309.505n 1.8v 1319.495n 1.8v 1319.505n 1.8v 1329.495n 1.8v 1329.505n 1.8v 1339.495n 1.8v 1339.505n 1.8v 1349.495n 1.8v 1349.505n 1.8v 1359.495n 1.8v 1359.505n 1.8v 1369.495n 1.8v 1369.505n 0.0v 1379.495n 0.0v 1379.505n 0.0v 1389.495n 0.0v 1389.505n 0.0v 1399.495n 0.0v 1399.505n 1.8v 1409.495n 1.8v 1409.505n 1.8v 1419.495n 1.8v 1419.505n 1.8v 1429.495n 1.8v 1429.505n 0.0v 1439.495n 0.0v 1439.505n 0.0v 1449.495n 0.0v 1449.505n 0.0v 1459.495n 0.0v 1459.505n 0.0v 1469.495n 0.0v 1469.505n 0.0v 1479.495n 0.0v 1479.505n 0.0v 1489.495n 0.0v 1489.505n 0.0v 1499.495n 0.0v 1499.505n 0.0v 1509.495n 0.0v 1509.505n 0.0v 1519.495n 0.0v 1519.505n 0.0v 1529.495n 0.0v 1529.505n 0.0v 1539.495n 0.0v 1539.505n 0.0v 1549.495n 0.0v 1549.505n 0.0v 1559.495n 0.0v 1559.505n 0.0v 1569.495n 0.0v 1569.505n 1.8v 1579.495n 1.8v 1579.505n 1.8v 1589.495n 1.8v 1589.505n 0.0v 1599.495n 0.0v 1599.505n 0.0v 1609.495n 0.0v 1609.505n 0.0v 1619.495n 0.0v 1619.505n 1.8v 1629.495n 1.8v 1629.505n 1.8v 1639.495n 1.8v 1639.505n 1.8v 1649.495n 1.8v 1649.505n 1.8v 1659.495n 1.8v 1659.505n 1.8v 1669.495n 1.8v 1669.505n 1.8v 1679.495n 1.8v 1679.505n 1.8v 1689.495n 1.8v 1689.505n 0.0v 1699.495n 0.0v 1699.505n 0.0v 1709.495n 0.0v 1709.505n 1.8v 1719.495n 1.8v 1719.505n 1.8v 1729.495n 1.8v 1729.505n 0.0v 1739.495n 0.0v 1739.505n 0.0v 1749.495n 0.0v 1749.505n 0.0v 1759.495n 0.0v 1759.505n 0.0v 1769.495n 0.0v 1769.505n 0.0v 1779.495n 0.0v 1779.505n 0.0v 1789.495n 0.0v 1789.505n 1.8v 1799.495n 1.8v 1799.505n 1.8v 1809.495n 1.8v 1809.505n 1.8v 1819.495n 1.8v 1819.505n 1.8v 1829.495n 1.8v 1829.505n 1.8v 1839.495n 1.8v 1839.505n 1.8v 1849.495n 1.8v 1849.505n 1.8v 1859.495n 1.8v 1859.505n 0.0v 1869.495n 0.0v 1869.505n 1.8v 1879.495n 1.8v 1879.505n 1.8v 1889.495n 1.8v 1889.505n 1.8v 1899.495n 1.8v 1899.505n 1.8v 1909.495n 1.8v 1909.505n 1.8v 1919.495n 1.8v 1919.505n 1.8v 1929.495n 1.8v 1929.505n 1.8v 1939.495n 1.8v 1939.505n 1.8v 1949.495n 1.8v 1949.505n 1.8v 1959.495n 1.8v 1959.505n 1.8v 1969.495n 1.8v 1969.505n 1.8v 1979.495n 1.8v 1979.505n 1.8v 1989.495n 1.8v 1989.505n 1.8v 1999.495n 1.8v 1999.505n 1.8v 2009.495n 1.8v 2009.505n 1.8v 2019.495n 1.8v 2019.505n 1.8v 2029.495n 1.8v 2029.505n 1.8v 2039.495n 1.8v 2039.505n 1.8v 2049.495n 1.8v 2049.505n 1.8v )
* (time, data): [(0, 0), (10, 1), (20, 0), (30, 0), (40, 0), (50, 0), (60, 1), (70, 1), (80, 1), (90, 1), (100, 1), (110, 1), (120, 1), (130, 1), (140, 1), (150, 0), (160, 0), (170, 0), (180, 0), (190, 0), (200, 0), (210, 0), (220, 0), (230, 0), (240, 0), (250, 0), (260, 0), (270, 0), (280, 0), (290, 0), (300, 0), (310, 1), (320, 1), (330, 1), (340, 1), (350, 0), (360, 0), (370, 0), (380, 0), (390, 0), (400, 0), (410, 0), (420, 0), (430, 0), (440, 0), (450, 0), (460, 0), (470, 0), (480, 0), (490, 0), (500, 0), (510, 0), (520, 0), (530, 0), (540, 0), (550, 0), (560, 0), (570, 0), (580, 0), (590, 0), (600, 0), (610, 0), (620, 1), (630, 1), (640, 1), (650, 1), (660, 1), (670, 0), (680, 0), (690, 0), (700, 0), (710, 0), (720, 0), (730, 0), (740, 0), (750, 0), (760, 0), (770, 0), (780, 0), (790, 0), (800, 0), (810, 0), (820, 1), (830, 1), (840, 0), (850, 0), (860, 0), (870, 0), (880, 0), (890, 0), (900, 0), (910, 0), (920, 0), (930, 1), (940, 1), (950, 1), (960, 0), (970, 0), (980, 0), (990, 0), (1000, 0), (1010, 0), (1020, 0), (1030, 0), (1040, 0), (1050, 0), (1060, 0), (1070, 0), (1080, 0), (1090, 0), (1100, 0), (1110, 0), (1120, 0), (1130, 1), (1140, 1), (1150, 1), (1160, 1), (1170, 1), (1180, 1), (1190, 1), (1200, 1), (1210, 1), (1220, 1), (1230, 1), (1240, 1), (1250, 1), (1260, 1), (1270, 1), (1280, 0), (1290, 0), (1300, 0), (1310, 0), (1320, 0), (1330, 0), (1340, 0), (1350, 0), (1360, 0), (1370, 0), (1380, 0), (1390, 0), (1400, 1), (1410, 1), (1420, 1), (1430, 1), (1440, 1), (1450, 1), (1460, 1), (1470, 1), (1480, 1), (1490, 1), (1500, 0), (1510, 0), (1520, 0), (1530, 0), (1540, 0), (1550, 0), (1560, 0), (1570, 1), (1580, 0), (1590, 0), (1600, 0), (1610, 0), (1620, 1), (1630, 1), (1640, 1), (1650, 1), (1660, 1), (1670, 1), (1680, 1), (1690, 1), (1700, 1), (1710, 0), (1720, 0), (1730, 0), (1740, 1), (1750, 1), (1760, 1), (1770, 1), (1780, 1), (1790, 0), (1800, 0), (1810, 0), (1820, 0), (1830, 0), (1840, 0), (1850, 1), (1860, 0), (1870, 1), (1880, 1), (1890, 1), (1900, 1), (1910, 0), (1920, 0), (1930, 0), (1940, 0), (1950, 0), (1960, 0), (1970, 0), (1980, 0), (1990, 0), (2000, 0), (2010, 0), (2020, 0), (2030, 1), (2040, 1), (2050, 1)]
Vdin0_61  din0_61  0 PWL (0n 0.0v 9.495n 0.0v 9.505n 1.8v 19.495n 1.8v 19.505n 0.0v 29.495n 0.0v 29.505n 0.0v 39.495n 0.0v 39.505n 0.0v 49.495n 0.0v 49.505n 0.0v 59.495n 0.0v 59.505n 1.8v 69.495n 1.8v 69.505n 1.8v 79.495n 1.8v 79.505n 1.8v 89.495n 1.8v 89.505n 1.8v 99.495n 1.8v 99.505n 1.8v 109.495n 1.8v 109.505n 1.8v 119.495n 1.8v 119.505n 1.8v 129.495n 1.8v 129.505n 1.8v 139.495n 1.8v 139.505n 1.8v 149.495n 1.8v 149.505n 0.0v 159.495n 0.0v 159.505n 0.0v 169.495n 0.0v 169.505n 0.0v 179.495n 0.0v 179.505n 0.0v 189.495n 0.0v 189.505n 0.0v 199.495n 0.0v 199.505n 0.0v 209.495n 0.0v 209.505n 0.0v 219.495n 0.0v 219.505n 0.0v 229.495n 0.0v 229.505n 0.0v 239.495n 0.0v 239.505n 0.0v 249.495n 0.0v 249.505n 0.0v 259.495n 0.0v 259.505n 0.0v 269.495n 0.0v 269.505n 0.0v 279.495n 0.0v 279.505n 0.0v 289.495n 0.0v 289.505n 0.0v 299.495n 0.0v 299.505n 0.0v 309.495n 0.0v 309.505n 1.8v 319.495n 1.8v 319.505n 1.8v 329.495n 1.8v 329.505n 1.8v 339.495n 1.8v 339.505n 1.8v 349.495n 1.8v 349.505n 0.0v 359.495n 0.0v 359.505n 0.0v 369.495n 0.0v 369.505n 0.0v 379.495n 0.0v 379.505n 0.0v 389.495n 0.0v 389.505n 0.0v 399.495n 0.0v 399.505n 0.0v 409.495n 0.0v 409.505n 0.0v 419.495n 0.0v 419.505n 0.0v 429.495n 0.0v 429.505n 0.0v 439.495n 0.0v 439.505n 0.0v 449.495n 0.0v 449.505n 0.0v 459.495n 0.0v 459.505n 0.0v 469.495n 0.0v 469.505n 0.0v 479.495n 0.0v 479.505n 0.0v 489.495n 0.0v 489.505n 0.0v 499.495n 0.0v 499.505n 0.0v 509.495n 0.0v 509.505n 0.0v 519.495n 0.0v 519.505n 0.0v 529.495n 0.0v 529.505n 0.0v 539.495n 0.0v 539.505n 0.0v 549.495n 0.0v 549.505n 0.0v 559.495n 0.0v 559.505n 0.0v 569.495n 0.0v 569.505n 0.0v 579.495n 0.0v 579.505n 0.0v 589.495n 0.0v 589.505n 0.0v 599.495n 0.0v 599.505n 0.0v 609.495n 0.0v 609.505n 0.0v 619.495n 0.0v 619.505n 1.8v 629.495n 1.8v 629.505n 1.8v 639.495n 1.8v 639.505n 1.8v 649.495n 1.8v 649.505n 1.8v 659.495n 1.8v 659.505n 1.8v 669.495n 1.8v 669.505n 0.0v 679.495n 0.0v 679.505n 0.0v 689.495n 0.0v 689.505n 0.0v 699.495n 0.0v 699.505n 0.0v 709.495n 0.0v 709.505n 0.0v 719.495n 0.0v 719.505n 0.0v 729.495n 0.0v 729.505n 0.0v 739.495n 0.0v 739.505n 0.0v 749.495n 0.0v 749.505n 0.0v 759.495n 0.0v 759.505n 0.0v 769.495n 0.0v 769.505n 0.0v 779.495n 0.0v 779.505n 0.0v 789.495n 0.0v 789.505n 0.0v 799.495n 0.0v 799.505n 0.0v 809.495n 0.0v 809.505n 0.0v 819.495n 0.0v 819.505n 1.8v 829.495n 1.8v 829.505n 1.8v 839.495n 1.8v 839.505n 0.0v 849.495n 0.0v 849.505n 0.0v 859.495n 0.0v 859.505n 0.0v 869.495n 0.0v 869.505n 0.0v 879.495n 0.0v 879.505n 0.0v 889.495n 0.0v 889.505n 0.0v 899.495n 0.0v 899.505n 0.0v 909.495n 0.0v 909.505n 0.0v 919.495n 0.0v 919.505n 0.0v 929.495n 0.0v 929.505n 1.8v 939.495n 1.8v 939.505n 1.8v 949.495n 1.8v 949.505n 1.8v 959.495n 1.8v 959.505n 0.0v 969.495n 0.0v 969.505n 0.0v 979.495n 0.0v 979.505n 0.0v 989.495n 0.0v 989.505n 0.0v 999.495n 0.0v 999.505n 0.0v 1009.495n 0.0v 1009.505n 0.0v 1019.495n 0.0v 1019.505n 0.0v 1029.495n 0.0v 1029.505n 0.0v 1039.495n 0.0v 1039.505n 0.0v 1049.495n 0.0v 1049.505n 0.0v 1059.495n 0.0v 1059.505n 0.0v 1069.495n 0.0v 1069.505n 0.0v 1079.495n 0.0v 1079.505n 0.0v 1089.495n 0.0v 1089.505n 0.0v 1099.495n 0.0v 1099.505n 0.0v 1109.495n 0.0v 1109.505n 0.0v 1119.495n 0.0v 1119.505n 0.0v 1129.495n 0.0v 1129.505n 1.8v 1139.495n 1.8v 1139.505n 1.8v 1149.495n 1.8v 1149.505n 1.8v 1159.495n 1.8v 1159.505n 1.8v 1169.495n 1.8v 1169.505n 1.8v 1179.495n 1.8v 1179.505n 1.8v 1189.495n 1.8v 1189.505n 1.8v 1199.495n 1.8v 1199.505n 1.8v 1209.495n 1.8v 1209.505n 1.8v 1219.495n 1.8v 1219.505n 1.8v 1229.495n 1.8v 1229.505n 1.8v 1239.495n 1.8v 1239.505n 1.8v 1249.495n 1.8v 1249.505n 1.8v 1259.495n 1.8v 1259.505n 1.8v 1269.495n 1.8v 1269.505n 1.8v 1279.495n 1.8v 1279.505n 0.0v 1289.495n 0.0v 1289.505n 0.0v 1299.495n 0.0v 1299.505n 0.0v 1309.495n 0.0v 1309.505n 0.0v 1319.495n 0.0v 1319.505n 0.0v 1329.495n 0.0v 1329.505n 0.0v 1339.495n 0.0v 1339.505n 0.0v 1349.495n 0.0v 1349.505n 0.0v 1359.495n 0.0v 1359.505n 0.0v 1369.495n 0.0v 1369.505n 0.0v 1379.495n 0.0v 1379.505n 0.0v 1389.495n 0.0v 1389.505n 0.0v 1399.495n 0.0v 1399.505n 1.8v 1409.495n 1.8v 1409.505n 1.8v 1419.495n 1.8v 1419.505n 1.8v 1429.495n 1.8v 1429.505n 1.8v 1439.495n 1.8v 1439.505n 1.8v 1449.495n 1.8v 1449.505n 1.8v 1459.495n 1.8v 1459.505n 1.8v 1469.495n 1.8v 1469.505n 1.8v 1479.495n 1.8v 1479.505n 1.8v 1489.495n 1.8v 1489.505n 1.8v 1499.495n 1.8v 1499.505n 0.0v 1509.495n 0.0v 1509.505n 0.0v 1519.495n 0.0v 1519.505n 0.0v 1529.495n 0.0v 1529.505n 0.0v 1539.495n 0.0v 1539.505n 0.0v 1549.495n 0.0v 1549.505n 0.0v 1559.495n 0.0v 1559.505n 0.0v 1569.495n 0.0v 1569.505n 1.8v 1579.495n 1.8v 1579.505n 0.0v 1589.495n 0.0v 1589.505n 0.0v 1599.495n 0.0v 1599.505n 0.0v 1609.495n 0.0v 1609.505n 0.0v 1619.495n 0.0v 1619.505n 1.8v 1629.495n 1.8v 1629.505n 1.8v 1639.495n 1.8v 1639.505n 1.8v 1649.495n 1.8v 1649.505n 1.8v 1659.495n 1.8v 1659.505n 1.8v 1669.495n 1.8v 1669.505n 1.8v 1679.495n 1.8v 1679.505n 1.8v 1689.495n 1.8v 1689.505n 1.8v 1699.495n 1.8v 1699.505n 1.8v 1709.495n 1.8v 1709.505n 0.0v 1719.495n 0.0v 1719.505n 0.0v 1729.495n 0.0v 1729.505n 0.0v 1739.495n 0.0v 1739.505n 1.8v 1749.495n 1.8v 1749.505n 1.8v 1759.495n 1.8v 1759.505n 1.8v 1769.495n 1.8v 1769.505n 1.8v 1779.495n 1.8v 1779.505n 1.8v 1789.495n 1.8v 1789.505n 0.0v 1799.495n 0.0v 1799.505n 0.0v 1809.495n 0.0v 1809.505n 0.0v 1819.495n 0.0v 1819.505n 0.0v 1829.495n 0.0v 1829.505n 0.0v 1839.495n 0.0v 1839.505n 0.0v 1849.495n 0.0v 1849.505n 1.8v 1859.495n 1.8v 1859.505n 0.0v 1869.495n 0.0v 1869.505n 1.8v 1879.495n 1.8v 1879.505n 1.8v 1889.495n 1.8v 1889.505n 1.8v 1899.495n 1.8v 1899.505n 1.8v 1909.495n 1.8v 1909.505n 0.0v 1919.495n 0.0v 1919.505n 0.0v 1929.495n 0.0v 1929.505n 0.0v 1939.495n 0.0v 1939.505n 0.0v 1949.495n 0.0v 1949.505n 0.0v 1959.495n 0.0v 1959.505n 0.0v 1969.495n 0.0v 1969.505n 0.0v 1979.495n 0.0v 1979.505n 0.0v 1989.495n 0.0v 1989.505n 0.0v 1999.495n 0.0v 1999.505n 0.0v 2009.495n 0.0v 2009.505n 0.0v 2019.495n 0.0v 2019.505n 0.0v 2029.495n 0.0v 2029.505n 1.8v 2039.495n 1.8v 2039.505n 1.8v 2049.495n 1.8v 2049.505n 1.8v )
* (time, data): [(0, 0), (10, 0), (20, 0), (30, 1), (40, 1), (50, 1), (60, 0), (70, 0), (80, 0), (90, 0), (100, 0), (110, 0), (120, 0), (130, 0), (140, 0), (150, 0), (160, 0), (170, 0), (180, 0), (190, 0), (200, 0), (210, 0), (220, 0), (230, 0), (240, 0), (250, 0), (260, 1), (270, 1), (280, 1), (290, 1), (300, 1), (310, 0), (320, 0), (330, 0), (340, 0), (350, 1), (360, 1), (370, 1), (380, 1), (390, 0), (400, 0), (410, 0), (420, 0), (430, 0), (440, 0), (450, 0), (460, 0), (470, 0), (480, 0), (490, 0), (500, 1), (510, 1), (520, 1), (530, 1), (540, 1), (550, 1), (560, 1), (570, 1), (580, 1), (590, 1), (600, 1), (610, 1), (620, 1), (630, 1), (640, 1), (650, 1), (660, 1), (670, 0), (680, 0), (690, 0), (700, 0), (710, 0), (720, 0), (730, 0), (740, 0), (750, 0), (760, 0), (770, 1), (780, 1), (790, 1), (800, 1), (810, 1), (820, 1), (830, 1), (840, 0), (850, 0), (860, 0), (870, 0), (880, 0), (890, 1), (900, 1), (910, 1), (920, 1), (930, 1), (940, 1), (950, 1), (960, 1), (970, 1), (980, 1), (990, 1), (1000, 1), (1010, 1), (1020, 1), (1030, 1), (1040, 1), (1050, 1), (1060, 1), (1070, 1), (1080, 1), (1090, 1), (1100, 1), (1110, 1), (1120, 1), (1130, 0), (1140, 0), (1150, 0), (1160, 0), (1170, 0), (1180, 0), (1190, 0), (1200, 0), (1210, 0), (1220, 0), (1230, 0), (1240, 0), (1250, 0), (1260, 1), (1270, 1), (1280, 0), (1290, 0), (1300, 0), (1310, 0), (1320, 0), (1330, 0), (1340, 0), (1350, 0), (1360, 0), (1370, 0), (1380, 0), (1390, 0), (1400, 0), (1410, 0), (1420, 0), (1430, 0), (1440, 0), (1450, 0), (1460, 0), (1470, 0), (1480, 0), (1490, 0), (1500, 1), (1510, 1), (1520, 1), (1530, 1), (1540, 1), (1550, 1), (1560, 1), (1570, 1), (1580, 0), (1590, 1), (1600, 1), (1610, 1), (1620, 1), (1630, 1), (1640, 1), (1650, 1), (1660, 1), (1670, 1), (1680, 1), (1690, 0), (1700, 0), (1710, 1), (1720, 1), (1730, 0), (1740, 1), (1750, 1), (1760, 1), (1770, 1), (1780, 1), (1790, 0), (1800, 0), (1810, 0), (1820, 0), (1830, 0), (1840, 0), (1850, 0), (1860, 1), (1870, 1), (1880, 0), (1890, 1), (1900, 1), (1910, 0), (1920, 0), (1930, 0), (1940, 0), (1950, 0), (1960, 0), (1970, 0), (1980, 0), (1990, 0), (2000, 0), (2010, 0), (2020, 0), (2030, 1), (2040, 1), (2050, 1)]
Vdin0_62  din0_62  0 PWL (0n 0.0v 9.495n 0.0v 9.505n 0.0v 19.495n 0.0v 19.505n 0.0v 29.495n 0.0v 29.505n 1.8v 39.495n 1.8v 39.505n 1.8v 49.495n 1.8v 49.505n 1.8v 59.495n 1.8v 59.505n 0.0v 69.495n 0.0v 69.505n 0.0v 79.495n 0.0v 79.505n 0.0v 89.495n 0.0v 89.505n 0.0v 99.495n 0.0v 99.505n 0.0v 109.495n 0.0v 109.505n 0.0v 119.495n 0.0v 119.505n 0.0v 129.495n 0.0v 129.505n 0.0v 139.495n 0.0v 139.505n 0.0v 149.495n 0.0v 149.505n 0.0v 159.495n 0.0v 159.505n 0.0v 169.495n 0.0v 169.505n 0.0v 179.495n 0.0v 179.505n 0.0v 189.495n 0.0v 189.505n 0.0v 199.495n 0.0v 199.505n 0.0v 209.495n 0.0v 209.505n 0.0v 219.495n 0.0v 219.505n 0.0v 229.495n 0.0v 229.505n 0.0v 239.495n 0.0v 239.505n 0.0v 249.495n 0.0v 249.505n 0.0v 259.495n 0.0v 259.505n 1.8v 269.495n 1.8v 269.505n 1.8v 279.495n 1.8v 279.505n 1.8v 289.495n 1.8v 289.505n 1.8v 299.495n 1.8v 299.505n 1.8v 309.495n 1.8v 309.505n 0.0v 319.495n 0.0v 319.505n 0.0v 329.495n 0.0v 329.505n 0.0v 339.495n 0.0v 339.505n 0.0v 349.495n 0.0v 349.505n 1.8v 359.495n 1.8v 359.505n 1.8v 369.495n 1.8v 369.505n 1.8v 379.495n 1.8v 379.505n 1.8v 389.495n 1.8v 389.505n 0.0v 399.495n 0.0v 399.505n 0.0v 409.495n 0.0v 409.505n 0.0v 419.495n 0.0v 419.505n 0.0v 429.495n 0.0v 429.505n 0.0v 439.495n 0.0v 439.505n 0.0v 449.495n 0.0v 449.505n 0.0v 459.495n 0.0v 459.505n 0.0v 469.495n 0.0v 469.505n 0.0v 479.495n 0.0v 479.505n 0.0v 489.495n 0.0v 489.505n 0.0v 499.495n 0.0v 499.505n 1.8v 509.495n 1.8v 509.505n 1.8v 519.495n 1.8v 519.505n 1.8v 529.495n 1.8v 529.505n 1.8v 539.495n 1.8v 539.505n 1.8v 549.495n 1.8v 549.505n 1.8v 559.495n 1.8v 559.505n 1.8v 569.495n 1.8v 569.505n 1.8v 579.495n 1.8v 579.505n 1.8v 589.495n 1.8v 589.505n 1.8v 599.495n 1.8v 599.505n 1.8v 609.495n 1.8v 609.505n 1.8v 619.495n 1.8v 619.505n 1.8v 629.495n 1.8v 629.505n 1.8v 639.495n 1.8v 639.505n 1.8v 649.495n 1.8v 649.505n 1.8v 659.495n 1.8v 659.505n 1.8v 669.495n 1.8v 669.505n 0.0v 679.495n 0.0v 679.505n 0.0v 689.495n 0.0v 689.505n 0.0v 699.495n 0.0v 699.505n 0.0v 709.495n 0.0v 709.505n 0.0v 719.495n 0.0v 719.505n 0.0v 729.495n 0.0v 729.505n 0.0v 739.495n 0.0v 739.505n 0.0v 749.495n 0.0v 749.505n 0.0v 759.495n 0.0v 759.505n 0.0v 769.495n 0.0v 769.505n 1.8v 779.495n 1.8v 779.505n 1.8v 789.495n 1.8v 789.505n 1.8v 799.495n 1.8v 799.505n 1.8v 809.495n 1.8v 809.505n 1.8v 819.495n 1.8v 819.505n 1.8v 829.495n 1.8v 829.505n 1.8v 839.495n 1.8v 839.505n 0.0v 849.495n 0.0v 849.505n 0.0v 859.495n 0.0v 859.505n 0.0v 869.495n 0.0v 869.505n 0.0v 879.495n 0.0v 879.505n 0.0v 889.495n 0.0v 889.505n 1.8v 899.495n 1.8v 899.505n 1.8v 909.495n 1.8v 909.505n 1.8v 919.495n 1.8v 919.505n 1.8v 929.495n 1.8v 929.505n 1.8v 939.495n 1.8v 939.505n 1.8v 949.495n 1.8v 949.505n 1.8v 959.495n 1.8v 959.505n 1.8v 969.495n 1.8v 969.505n 1.8v 979.495n 1.8v 979.505n 1.8v 989.495n 1.8v 989.505n 1.8v 999.495n 1.8v 999.505n 1.8v 1009.495n 1.8v 1009.505n 1.8v 1019.495n 1.8v 1019.505n 1.8v 1029.495n 1.8v 1029.505n 1.8v 1039.495n 1.8v 1039.505n 1.8v 1049.495n 1.8v 1049.505n 1.8v 1059.495n 1.8v 1059.505n 1.8v 1069.495n 1.8v 1069.505n 1.8v 1079.495n 1.8v 1079.505n 1.8v 1089.495n 1.8v 1089.505n 1.8v 1099.495n 1.8v 1099.505n 1.8v 1109.495n 1.8v 1109.505n 1.8v 1119.495n 1.8v 1119.505n 1.8v 1129.495n 1.8v 1129.505n 0.0v 1139.495n 0.0v 1139.505n 0.0v 1149.495n 0.0v 1149.505n 0.0v 1159.495n 0.0v 1159.505n 0.0v 1169.495n 0.0v 1169.505n 0.0v 1179.495n 0.0v 1179.505n 0.0v 1189.495n 0.0v 1189.505n 0.0v 1199.495n 0.0v 1199.505n 0.0v 1209.495n 0.0v 1209.505n 0.0v 1219.495n 0.0v 1219.505n 0.0v 1229.495n 0.0v 1229.505n 0.0v 1239.495n 0.0v 1239.505n 0.0v 1249.495n 0.0v 1249.505n 0.0v 1259.495n 0.0v 1259.505n 1.8v 1269.495n 1.8v 1269.505n 1.8v 1279.495n 1.8v 1279.505n 0.0v 1289.495n 0.0v 1289.505n 0.0v 1299.495n 0.0v 1299.505n 0.0v 1309.495n 0.0v 1309.505n 0.0v 1319.495n 0.0v 1319.505n 0.0v 1329.495n 0.0v 1329.505n 0.0v 1339.495n 0.0v 1339.505n 0.0v 1349.495n 0.0v 1349.505n 0.0v 1359.495n 0.0v 1359.505n 0.0v 1369.495n 0.0v 1369.505n 0.0v 1379.495n 0.0v 1379.505n 0.0v 1389.495n 0.0v 1389.505n 0.0v 1399.495n 0.0v 1399.505n 0.0v 1409.495n 0.0v 1409.505n 0.0v 1419.495n 0.0v 1419.505n 0.0v 1429.495n 0.0v 1429.505n 0.0v 1439.495n 0.0v 1439.505n 0.0v 1449.495n 0.0v 1449.505n 0.0v 1459.495n 0.0v 1459.505n 0.0v 1469.495n 0.0v 1469.505n 0.0v 1479.495n 0.0v 1479.505n 0.0v 1489.495n 0.0v 1489.505n 0.0v 1499.495n 0.0v 1499.505n 1.8v 1509.495n 1.8v 1509.505n 1.8v 1519.495n 1.8v 1519.505n 1.8v 1529.495n 1.8v 1529.505n 1.8v 1539.495n 1.8v 1539.505n 1.8v 1549.495n 1.8v 1549.505n 1.8v 1559.495n 1.8v 1559.505n 1.8v 1569.495n 1.8v 1569.505n 1.8v 1579.495n 1.8v 1579.505n 0.0v 1589.495n 0.0v 1589.505n 1.8v 1599.495n 1.8v 1599.505n 1.8v 1609.495n 1.8v 1609.505n 1.8v 1619.495n 1.8v 1619.505n 1.8v 1629.495n 1.8v 1629.505n 1.8v 1639.495n 1.8v 1639.505n 1.8v 1649.495n 1.8v 1649.505n 1.8v 1659.495n 1.8v 1659.505n 1.8v 1669.495n 1.8v 1669.505n 1.8v 1679.495n 1.8v 1679.505n 1.8v 1689.495n 1.8v 1689.505n 0.0v 1699.495n 0.0v 1699.505n 0.0v 1709.495n 0.0v 1709.505n 1.8v 1719.495n 1.8v 1719.505n 1.8v 1729.495n 1.8v 1729.505n 0.0v 1739.495n 0.0v 1739.505n 1.8v 1749.495n 1.8v 1749.505n 1.8v 1759.495n 1.8v 1759.505n 1.8v 1769.495n 1.8v 1769.505n 1.8v 1779.495n 1.8v 1779.505n 1.8v 1789.495n 1.8v 1789.505n 0.0v 1799.495n 0.0v 1799.505n 0.0v 1809.495n 0.0v 1809.505n 0.0v 1819.495n 0.0v 1819.505n 0.0v 1829.495n 0.0v 1829.505n 0.0v 1839.495n 0.0v 1839.505n 0.0v 1849.495n 0.0v 1849.505n 0.0v 1859.495n 0.0v 1859.505n 1.8v 1869.495n 1.8v 1869.505n 1.8v 1879.495n 1.8v 1879.505n 0.0v 1889.495n 0.0v 1889.505n 1.8v 1899.495n 1.8v 1899.505n 1.8v 1909.495n 1.8v 1909.505n 0.0v 1919.495n 0.0v 1919.505n 0.0v 1929.495n 0.0v 1929.505n 0.0v 1939.495n 0.0v 1939.505n 0.0v 1949.495n 0.0v 1949.505n 0.0v 1959.495n 0.0v 1959.505n 0.0v 1969.495n 0.0v 1969.505n 0.0v 1979.495n 0.0v 1979.505n 0.0v 1989.495n 0.0v 1989.505n 0.0v 1999.495n 0.0v 1999.505n 0.0v 2009.495n 0.0v 2009.505n 0.0v 2019.495n 0.0v 2019.505n 0.0v 2029.495n 0.0v 2029.505n 1.8v 2039.495n 1.8v 2039.505n 1.8v 2049.495n 1.8v 2049.505n 1.8v )
* (time, data): [(0, 0), (10, 0), (20, 0), (30, 1), (40, 1), (50, 1), (60, 0), (70, 0), (80, 0), (90, 0), (100, 0), (110, 0), (120, 0), (130, 0), (140, 0), (150, 1), (160, 1), (170, 1), (180, 1), (190, 1), (200, 1), (210, 1), (220, 1), (230, 1), (240, 1), (250, 1), (260, 1), (270, 1), (280, 1), (290, 1), (300, 1), (310, 0), (320, 0), (330, 0), (340, 0), (350, 0), (360, 0), (370, 0), (380, 0), (390, 0), (400, 1), (410, 1), (420, 0), (430, 0), (440, 0), (450, 0), (460, 0), (470, 1), (480, 1), (490, 1), (500, 0), (510, 0), (520, 0), (530, 0), (540, 0), (550, 0), (560, 0), (570, 0), (580, 0), (590, 0), (600, 0), (610, 0), (620, 1), (630, 1), (640, 1), (650, 1), (660, 1), (670, 1), (680, 1), (690, 1), (700, 1), (710, 1), (720, 1), (730, 1), (740, 1), (750, 1), (760, 1), (770, 1), (780, 1), (790, 1), (800, 1), (810, 1), (820, 1), (830, 1), (840, 1), (850, 1), (860, 1), (870, 1), (880, 1), (890, 1), (900, 1), (910, 1), (920, 1), (930, 0), (940, 0), (950, 0), (960, 1), (970, 1), (980, 1), (990, 1), (1000, 1), (1010, 1), (1020, 1), (1030, 1), (1040, 1), (1050, 1), (1060, 1), (1070, 1), (1080, 0), (1090, 0), (1100, 0), (1110, 0), (1120, 0), (1130, 0), (1140, 0), (1150, 0), (1160, 0), (1170, 0), (1180, 0), (1190, 0), (1200, 0), (1210, 0), (1220, 0), (1230, 0), (1240, 0), (1250, 0), (1260, 0), (1270, 0), (1280, 0), (1290, 0), (1300, 0), (1310, 0), (1320, 0), (1330, 0), (1340, 0), (1350, 0), (1360, 0), (1370, 1), (1380, 1), (1390, 1), (1400, 1), (1410, 1), (1420, 1), (1430, 0), (1440, 0), (1450, 0), (1460, 0), (1470, 0), (1480, 0), (1490, 0), (1500, 0), (1510, 0), (1520, 0), (1530, 0), (1540, 0), (1550, 0), (1560, 0), (1570, 1), (1580, 1), (1590, 0), (1600, 0), (1610, 0), (1620, 1), (1630, 1), (1640, 1), (1650, 1), (1660, 1), (1670, 1), (1680, 1), (1690, 0), (1700, 0), (1710, 0), (1720, 0), (1730, 0), (1740, 1), (1750, 1), (1760, 1), (1770, 1), (1780, 1), (1790, 0), (1800, 0), (1810, 0), (1820, 0), (1830, 0), (1840, 0), (1850, 1), (1860, 0), (1870, 0), (1880, 1), (1890, 1), (1900, 1), (1910, 1), (1920, 1), (1930, 1), (1940, 1), (1950, 1), (1960, 1), (1970, 1), (1980, 1), (1990, 1), (2000, 1), (2010, 1), (2020, 1), (2030, 1), (2040, 1), (2050, 1)]
Vdin0_63  din0_63  0 PWL (0n 0.0v 9.495n 0.0v 9.505n 0.0v 19.495n 0.0v 19.505n 0.0v 29.495n 0.0v 29.505n 1.8v 39.495n 1.8v 39.505n 1.8v 49.495n 1.8v 49.505n 1.8v 59.495n 1.8v 59.505n 0.0v 69.495n 0.0v 69.505n 0.0v 79.495n 0.0v 79.505n 0.0v 89.495n 0.0v 89.505n 0.0v 99.495n 0.0v 99.505n 0.0v 109.495n 0.0v 109.505n 0.0v 119.495n 0.0v 119.505n 0.0v 129.495n 0.0v 129.505n 0.0v 139.495n 0.0v 139.505n 0.0v 149.495n 0.0v 149.505n 1.8v 159.495n 1.8v 159.505n 1.8v 169.495n 1.8v 169.505n 1.8v 179.495n 1.8v 179.505n 1.8v 189.495n 1.8v 189.505n 1.8v 199.495n 1.8v 199.505n 1.8v 209.495n 1.8v 209.505n 1.8v 219.495n 1.8v 219.505n 1.8v 229.495n 1.8v 229.505n 1.8v 239.495n 1.8v 239.505n 1.8v 249.495n 1.8v 249.505n 1.8v 259.495n 1.8v 259.505n 1.8v 269.495n 1.8v 269.505n 1.8v 279.495n 1.8v 279.505n 1.8v 289.495n 1.8v 289.505n 1.8v 299.495n 1.8v 299.505n 1.8v 309.495n 1.8v 309.505n 0.0v 319.495n 0.0v 319.505n 0.0v 329.495n 0.0v 329.505n 0.0v 339.495n 0.0v 339.505n 0.0v 349.495n 0.0v 349.505n 0.0v 359.495n 0.0v 359.505n 0.0v 369.495n 0.0v 369.505n 0.0v 379.495n 0.0v 379.505n 0.0v 389.495n 0.0v 389.505n 0.0v 399.495n 0.0v 399.505n 1.8v 409.495n 1.8v 409.505n 1.8v 419.495n 1.8v 419.505n 0.0v 429.495n 0.0v 429.505n 0.0v 439.495n 0.0v 439.505n 0.0v 449.495n 0.0v 449.505n 0.0v 459.495n 0.0v 459.505n 0.0v 469.495n 0.0v 469.505n 1.8v 479.495n 1.8v 479.505n 1.8v 489.495n 1.8v 489.505n 1.8v 499.495n 1.8v 499.505n 0.0v 509.495n 0.0v 509.505n 0.0v 519.495n 0.0v 519.505n 0.0v 529.495n 0.0v 529.505n 0.0v 539.495n 0.0v 539.505n 0.0v 549.495n 0.0v 549.505n 0.0v 559.495n 0.0v 559.505n 0.0v 569.495n 0.0v 569.505n 0.0v 579.495n 0.0v 579.505n 0.0v 589.495n 0.0v 589.505n 0.0v 599.495n 0.0v 599.505n 0.0v 609.495n 0.0v 609.505n 0.0v 619.495n 0.0v 619.505n 1.8v 629.495n 1.8v 629.505n 1.8v 639.495n 1.8v 639.505n 1.8v 649.495n 1.8v 649.505n 1.8v 659.495n 1.8v 659.505n 1.8v 669.495n 1.8v 669.505n 1.8v 679.495n 1.8v 679.505n 1.8v 689.495n 1.8v 689.505n 1.8v 699.495n 1.8v 699.505n 1.8v 709.495n 1.8v 709.505n 1.8v 719.495n 1.8v 719.505n 1.8v 729.495n 1.8v 729.505n 1.8v 739.495n 1.8v 739.505n 1.8v 749.495n 1.8v 749.505n 1.8v 759.495n 1.8v 759.505n 1.8v 769.495n 1.8v 769.505n 1.8v 779.495n 1.8v 779.505n 1.8v 789.495n 1.8v 789.505n 1.8v 799.495n 1.8v 799.505n 1.8v 809.495n 1.8v 809.505n 1.8v 819.495n 1.8v 819.505n 1.8v 829.495n 1.8v 829.505n 1.8v 839.495n 1.8v 839.505n 1.8v 849.495n 1.8v 849.505n 1.8v 859.495n 1.8v 859.505n 1.8v 869.495n 1.8v 869.505n 1.8v 879.495n 1.8v 879.505n 1.8v 889.495n 1.8v 889.505n 1.8v 899.495n 1.8v 899.505n 1.8v 909.495n 1.8v 909.505n 1.8v 919.495n 1.8v 919.505n 1.8v 929.495n 1.8v 929.505n 0.0v 939.495n 0.0v 939.505n 0.0v 949.495n 0.0v 949.505n 0.0v 959.495n 0.0v 959.505n 1.8v 969.495n 1.8v 969.505n 1.8v 979.495n 1.8v 979.505n 1.8v 989.495n 1.8v 989.505n 1.8v 999.495n 1.8v 999.505n 1.8v 1009.495n 1.8v 1009.505n 1.8v 1019.495n 1.8v 1019.505n 1.8v 1029.495n 1.8v 1029.505n 1.8v 1039.495n 1.8v 1039.505n 1.8v 1049.495n 1.8v 1049.505n 1.8v 1059.495n 1.8v 1059.505n 1.8v 1069.495n 1.8v 1069.505n 1.8v 1079.495n 1.8v 1079.505n 0.0v 1089.495n 0.0v 1089.505n 0.0v 1099.495n 0.0v 1099.505n 0.0v 1109.495n 0.0v 1109.505n 0.0v 1119.495n 0.0v 1119.505n 0.0v 1129.495n 0.0v 1129.505n 0.0v 1139.495n 0.0v 1139.505n 0.0v 1149.495n 0.0v 1149.505n 0.0v 1159.495n 0.0v 1159.505n 0.0v 1169.495n 0.0v 1169.505n 0.0v 1179.495n 0.0v 1179.505n 0.0v 1189.495n 0.0v 1189.505n 0.0v 1199.495n 0.0v 1199.505n 0.0v 1209.495n 0.0v 1209.505n 0.0v 1219.495n 0.0v 1219.505n 0.0v 1229.495n 0.0v 1229.505n 0.0v 1239.495n 0.0v 1239.505n 0.0v 1249.495n 0.0v 1249.505n 0.0v 1259.495n 0.0v 1259.505n 0.0v 1269.495n 0.0v 1269.505n 0.0v 1279.495n 0.0v 1279.505n 0.0v 1289.495n 0.0v 1289.505n 0.0v 1299.495n 0.0v 1299.505n 0.0v 1309.495n 0.0v 1309.505n 0.0v 1319.495n 0.0v 1319.505n 0.0v 1329.495n 0.0v 1329.505n 0.0v 1339.495n 0.0v 1339.505n 0.0v 1349.495n 0.0v 1349.505n 0.0v 1359.495n 0.0v 1359.505n 0.0v 1369.495n 0.0v 1369.505n 1.8v 1379.495n 1.8v 1379.505n 1.8v 1389.495n 1.8v 1389.505n 1.8v 1399.495n 1.8v 1399.505n 1.8v 1409.495n 1.8v 1409.505n 1.8v 1419.495n 1.8v 1419.505n 1.8v 1429.495n 1.8v 1429.505n 0.0v 1439.495n 0.0v 1439.505n 0.0v 1449.495n 0.0v 1449.505n 0.0v 1459.495n 0.0v 1459.505n 0.0v 1469.495n 0.0v 1469.505n 0.0v 1479.495n 0.0v 1479.505n 0.0v 1489.495n 0.0v 1489.505n 0.0v 1499.495n 0.0v 1499.505n 0.0v 1509.495n 0.0v 1509.505n 0.0v 1519.495n 0.0v 1519.505n 0.0v 1529.495n 0.0v 1529.505n 0.0v 1539.495n 0.0v 1539.505n 0.0v 1549.495n 0.0v 1549.505n 0.0v 1559.495n 0.0v 1559.505n 0.0v 1569.495n 0.0v 1569.505n 1.8v 1579.495n 1.8v 1579.505n 1.8v 1589.495n 1.8v 1589.505n 0.0v 1599.495n 0.0v 1599.505n 0.0v 1609.495n 0.0v 1609.505n 0.0v 1619.495n 0.0v 1619.505n 1.8v 1629.495n 1.8v 1629.505n 1.8v 1639.495n 1.8v 1639.505n 1.8v 1649.495n 1.8v 1649.505n 1.8v 1659.495n 1.8v 1659.505n 1.8v 1669.495n 1.8v 1669.505n 1.8v 1679.495n 1.8v 1679.505n 1.8v 1689.495n 1.8v 1689.505n 0.0v 1699.495n 0.0v 1699.505n 0.0v 1709.495n 0.0v 1709.505n 0.0v 1719.495n 0.0v 1719.505n 0.0v 1729.495n 0.0v 1729.505n 0.0v 1739.495n 0.0v 1739.505n 1.8v 1749.495n 1.8v 1749.505n 1.8v 1759.495n 1.8v 1759.505n 1.8v 1769.495n 1.8v 1769.505n 1.8v 1779.495n 1.8v 1779.505n 1.8v 1789.495n 1.8v 1789.505n 0.0v 1799.495n 0.0v 1799.505n 0.0v 1809.495n 0.0v 1809.505n 0.0v 1819.495n 0.0v 1819.505n 0.0v 1829.495n 0.0v 1829.505n 0.0v 1839.495n 0.0v 1839.505n 0.0v 1849.495n 0.0v 1849.505n 1.8v 1859.495n 1.8v 1859.505n 0.0v 1869.495n 0.0v 1869.505n 0.0v 1879.495n 0.0v 1879.505n 1.8v 1889.495n 1.8v 1889.505n 1.8v 1899.495n 1.8v 1899.505n 1.8v 1909.495n 1.8v 1909.505n 1.8v 1919.495n 1.8v 1919.505n 1.8v 1929.495n 1.8v 1929.505n 1.8v 1939.495n 1.8v 1939.505n 1.8v 1949.495n 1.8v 1949.505n 1.8v 1959.495n 1.8v 1959.505n 1.8v 1969.495n 1.8v 1969.505n 1.8v 1979.495n 1.8v 1979.505n 1.8v 1989.495n 1.8v 1989.505n 1.8v 1999.495n 1.8v 1999.505n 1.8v 2009.495n 1.8v 2009.505n 1.8v 2019.495n 1.8v 2019.505n 1.8v 2029.495n 1.8v 2029.505n 1.8v 2039.495n 1.8v 2039.505n 1.8v 2049.495n 1.8v 2049.505n 1.8v )
* (time, data): [(0, 0), (10, 0), (20, 0), (30, 0), (40, 0), (50, 0), (60, 1), (70, 0), (80, 0), (90, 0), (100, 0), (110, 1), (120, 0), (130, 0), (140, 0), (150, 0), (160, 0), (170, 0), (180, 0), (190, 0), (200, 0), (210, 0), (220, 0), (230, 0), (240, 0), (250, 0), (260, 1), (270, 0), (280, 1), (290, 0), (300, 0), (310, 0), (320, 1), (330, 1), (340, 0), (350, 1), (360, 1), (370, 1), (380, 1), (390, 1), (400, 1), (410, 0), (420, 1), (430, 1), (440, 1), (450, 1), (460, 1), (470, 1), (480, 0), (490, 0), (500, 1), (510, 1), (520, 0), (530, 1), (540, 1), (550, 1), (560, 1), (570, 1), (580, 1), (590, 0), (600, 1), (610, 0), (620, 0), (630, 0), (640, 0), (650, 1), (660, 1), (670, 0), (680, 0), (690, 0), (700, 1), (710, 0), (720, 1), (730, 1), (740, 1), (750, 1), (760, 1), (770, 1), (780, 1), (790, 0), (800, 0), (810, 0), (820, 0), (830, 0), (840, 0), (850, 1), (860, 1), (870, 1), (880, 0), (890, 1), (900, 0), (910, 0), (920, 1), (930, 0), (940, 0), (950, 0), (960, 0), (970, 0), (980, 0), (990, 0), (1000, 0), (1010, 0), (1020, 0), (1030, 0), (1040, 0), (1050, 0), (1060, 0), (1070, 1), (1080, 1), (1090, 1), (1100, 0), (1110, 1), (1120, 1), (1130, 0), (1140, 0), (1150, 1), (1160, 1), (1170, 1), (1180, 1), (1190, 0), (1200, 0), (1210, 1), (1220, 0), (1230, 0), (1240, 0), (1250, 0), (1260, 0), (1270, 0), (1280, 1), (1290, 1), (1300, 1), (1310, 1), (1320, 1), (1330, 0), (1340, 0), (1350, 1), (1360, 0), (1370, 0), (1380, 1), (1390, 1), (1400, 0), (1410, 1), (1420, 1), (1430, 1), (1440, 0), (1450, 0), (1460, 1), (1470, 0), (1480, 1), (1490, 1), (1500, 1), (1510, 1), (1520, 1), (1530, 0), (1540, 0), (1550, 1), (1560, 1), (1570, 0), (1580, 1), (1590, 1), (1600, 0), (1610, 0), (1620, 0), (1630, 0), (1640, 0), (1650, 1), (1660, 1), (1670, 1), (1680, 0), (1690, 0), (1700, 1), (1710, 0), (1720, 1), (1730, 0), (1740, 1), (1750, 1), (1760, 0), (1770, 0), (1780, 0), (1790, 0), (1800, 1), (1810, 1), (1820, 1), (1830, 1), (1840, 1), (1850, 1), (1860, 1), (1870, 0), (1880, 0), (1890, 0), (1900, 0), (1910, 1), (1920, 1), (1930, 1), (1940, 1), (1950, 1), (1960, 0), (1970, 1), (1980, 1), (1990, 1), (2000, 1), (2010, 1), (2020, 0), (2030, 0), (2040, 0), (2050, 0)]
Va0_0  a0_0  0 PWL (0n 0.0v 9.495n 0.0v 9.505n 0.0v 19.495n 0.0v 19.505n 0.0v 29.495n 0.0v 29.505n 0.0v 39.495n 0.0v 39.505n 0.0v 49.495n 0.0v 49.505n 0.0v 59.495n 0.0v 59.505n 1.8v 69.495n 1.8v 69.505n 0.0v 79.495n 0.0v 79.505n 0.0v 89.495n 0.0v 89.505n 0.0v 99.495n 0.0v 99.505n 0.0v 109.495n 0.0v 109.505n 1.8v 119.495n 1.8v 119.505n 0.0v 129.495n 0.0v 129.505n 0.0v 139.495n 0.0v 139.505n 0.0v 149.495n 0.0v 149.505n 0.0v 159.495n 0.0v 159.505n 0.0v 169.495n 0.0v 169.505n 0.0v 179.495n 0.0v 179.505n 0.0v 189.495n 0.0v 189.505n 0.0v 199.495n 0.0v 199.505n 0.0v 209.495n 0.0v 209.505n 0.0v 219.495n 0.0v 219.505n 0.0v 229.495n 0.0v 229.505n 0.0v 239.495n 0.0v 239.505n 0.0v 249.495n 0.0v 249.505n 0.0v 259.495n 0.0v 259.505n 1.8v 269.495n 1.8v 269.505n 0.0v 279.495n 0.0v 279.505n 1.8v 289.495n 1.8v 289.505n 0.0v 299.495n 0.0v 299.505n 0.0v 309.495n 0.0v 309.505n 0.0v 319.495n 0.0v 319.505n 1.8v 329.495n 1.8v 329.505n 1.8v 339.495n 1.8v 339.505n 0.0v 349.495n 0.0v 349.505n 1.8v 359.495n 1.8v 359.505n 1.8v 369.495n 1.8v 369.505n 1.8v 379.495n 1.8v 379.505n 1.8v 389.495n 1.8v 389.505n 1.8v 399.495n 1.8v 399.505n 1.8v 409.495n 1.8v 409.505n 0.0v 419.495n 0.0v 419.505n 1.8v 429.495n 1.8v 429.505n 1.8v 439.495n 1.8v 439.505n 1.8v 449.495n 1.8v 449.505n 1.8v 459.495n 1.8v 459.505n 1.8v 469.495n 1.8v 469.505n 1.8v 479.495n 1.8v 479.505n 0.0v 489.495n 0.0v 489.505n 0.0v 499.495n 0.0v 499.505n 1.8v 509.495n 1.8v 509.505n 1.8v 519.495n 1.8v 519.505n 0.0v 529.495n 0.0v 529.505n 1.8v 539.495n 1.8v 539.505n 1.8v 549.495n 1.8v 549.505n 1.8v 559.495n 1.8v 559.505n 1.8v 569.495n 1.8v 569.505n 1.8v 579.495n 1.8v 579.505n 1.8v 589.495n 1.8v 589.505n 0.0v 599.495n 0.0v 599.505n 1.8v 609.495n 1.8v 609.505n 0.0v 619.495n 0.0v 619.505n 0.0v 629.495n 0.0v 629.505n 0.0v 639.495n 0.0v 639.505n 0.0v 649.495n 0.0v 649.505n 1.8v 659.495n 1.8v 659.505n 1.8v 669.495n 1.8v 669.505n 0.0v 679.495n 0.0v 679.505n 0.0v 689.495n 0.0v 689.505n 0.0v 699.495n 0.0v 699.505n 1.8v 709.495n 1.8v 709.505n 0.0v 719.495n 0.0v 719.505n 1.8v 729.495n 1.8v 729.505n 1.8v 739.495n 1.8v 739.505n 1.8v 749.495n 1.8v 749.505n 1.8v 759.495n 1.8v 759.505n 1.8v 769.495n 1.8v 769.505n 1.8v 779.495n 1.8v 779.505n 1.8v 789.495n 1.8v 789.505n 0.0v 799.495n 0.0v 799.505n 0.0v 809.495n 0.0v 809.505n 0.0v 819.495n 0.0v 819.505n 0.0v 829.495n 0.0v 829.505n 0.0v 839.495n 0.0v 839.505n 0.0v 849.495n 0.0v 849.505n 1.8v 859.495n 1.8v 859.505n 1.8v 869.495n 1.8v 869.505n 1.8v 879.495n 1.8v 879.505n 0.0v 889.495n 0.0v 889.505n 1.8v 899.495n 1.8v 899.505n 0.0v 909.495n 0.0v 909.505n 0.0v 919.495n 0.0v 919.505n 1.8v 929.495n 1.8v 929.505n 0.0v 939.495n 0.0v 939.505n 0.0v 949.495n 0.0v 949.505n 0.0v 959.495n 0.0v 959.505n 0.0v 969.495n 0.0v 969.505n 0.0v 979.495n 0.0v 979.505n 0.0v 989.495n 0.0v 989.505n 0.0v 999.495n 0.0v 999.505n 0.0v 1009.495n 0.0v 1009.505n 0.0v 1019.495n 0.0v 1019.505n 0.0v 1029.495n 0.0v 1029.505n 0.0v 1039.495n 0.0v 1039.505n 0.0v 1049.495n 0.0v 1049.505n 0.0v 1059.495n 0.0v 1059.505n 0.0v 1069.495n 0.0v 1069.505n 1.8v 1079.495n 1.8v 1079.505n 1.8v 1089.495n 1.8v 1089.505n 1.8v 1099.495n 1.8v 1099.505n 0.0v 1109.495n 0.0v 1109.505n 1.8v 1119.495n 1.8v 1119.505n 1.8v 1129.495n 1.8v 1129.505n 0.0v 1139.495n 0.0v 1139.505n 0.0v 1149.495n 0.0v 1149.505n 1.8v 1159.495n 1.8v 1159.505n 1.8v 1169.495n 1.8v 1169.505n 1.8v 1179.495n 1.8v 1179.505n 1.8v 1189.495n 1.8v 1189.505n 0.0v 1199.495n 0.0v 1199.505n 0.0v 1209.495n 0.0v 1209.505n 1.8v 1219.495n 1.8v 1219.505n 0.0v 1229.495n 0.0v 1229.505n 0.0v 1239.495n 0.0v 1239.505n 0.0v 1249.495n 0.0v 1249.505n 0.0v 1259.495n 0.0v 1259.505n 0.0v 1269.495n 0.0v 1269.505n 0.0v 1279.495n 0.0v 1279.505n 1.8v 1289.495n 1.8v 1289.505n 1.8v 1299.495n 1.8v 1299.505n 1.8v 1309.495n 1.8v 1309.505n 1.8v 1319.495n 1.8v 1319.505n 1.8v 1329.495n 1.8v 1329.505n 0.0v 1339.495n 0.0v 1339.505n 0.0v 1349.495n 0.0v 1349.505n 1.8v 1359.495n 1.8v 1359.505n 0.0v 1369.495n 0.0v 1369.505n 0.0v 1379.495n 0.0v 1379.505n 1.8v 1389.495n 1.8v 1389.505n 1.8v 1399.495n 1.8v 1399.505n 0.0v 1409.495n 0.0v 1409.505n 1.8v 1419.495n 1.8v 1419.505n 1.8v 1429.495n 1.8v 1429.505n 1.8v 1439.495n 1.8v 1439.505n 0.0v 1449.495n 0.0v 1449.505n 0.0v 1459.495n 0.0v 1459.505n 1.8v 1469.495n 1.8v 1469.505n 0.0v 1479.495n 0.0v 1479.505n 1.8v 1489.495n 1.8v 1489.505n 1.8v 1499.495n 1.8v 1499.505n 1.8v 1509.495n 1.8v 1509.505n 1.8v 1519.495n 1.8v 1519.505n 1.8v 1529.495n 1.8v 1529.505n 0.0v 1539.495n 0.0v 1539.505n 0.0v 1549.495n 0.0v 1549.505n 1.8v 1559.495n 1.8v 1559.505n 1.8v 1569.495n 1.8v 1569.505n 0.0v 1579.495n 0.0v 1579.505n 1.8v 1589.495n 1.8v 1589.505n 1.8v 1599.495n 1.8v 1599.505n 0.0v 1609.495n 0.0v 1609.505n 0.0v 1619.495n 0.0v 1619.505n 0.0v 1629.495n 0.0v 1629.505n 0.0v 1639.495n 0.0v 1639.505n 0.0v 1649.495n 0.0v 1649.505n 1.8v 1659.495n 1.8v 1659.505n 1.8v 1669.495n 1.8v 1669.505n 1.8v 1679.495n 1.8v 1679.505n 0.0v 1689.495n 0.0v 1689.505n 0.0v 1699.495n 0.0v 1699.505n 1.8v 1709.495n 1.8v 1709.505n 0.0v 1719.495n 0.0v 1719.505n 1.8v 1729.495n 1.8v 1729.505n 0.0v 1739.495n 0.0v 1739.505n 1.8v 1749.495n 1.8v 1749.505n 1.8v 1759.495n 1.8v 1759.505n 0.0v 1769.495n 0.0v 1769.505n 0.0v 1779.495n 0.0v 1779.505n 0.0v 1789.495n 0.0v 1789.505n 0.0v 1799.495n 0.0v 1799.505n 1.8v 1809.495n 1.8v 1809.505n 1.8v 1819.495n 1.8v 1819.505n 1.8v 1829.495n 1.8v 1829.505n 1.8v 1839.495n 1.8v 1839.505n 1.8v 1849.495n 1.8v 1849.505n 1.8v 1859.495n 1.8v 1859.505n 1.8v 1869.495n 1.8v 1869.505n 0.0v 1879.495n 0.0v 1879.505n 0.0v 1889.495n 0.0v 1889.505n 0.0v 1899.495n 0.0v 1899.505n 0.0v 1909.495n 0.0v 1909.505n 1.8v 1919.495n 1.8v 1919.505n 1.8v 1929.495n 1.8v 1929.505n 1.8v 1939.495n 1.8v 1939.505n 1.8v 1949.495n 1.8v 1949.505n 1.8v 1959.495n 1.8v 1959.505n 0.0v 1969.495n 0.0v 1969.505n 1.8v 1979.495n 1.8v 1979.505n 1.8v 1989.495n 1.8v 1989.505n 1.8v 1999.495n 1.8v 1999.505n 1.8v 2009.495n 1.8v 2009.505n 1.8v 2019.495n 1.8v 2019.505n 0.0v 2029.495n 0.0v 2029.505n 0.0v 2039.495n 0.0v 2039.505n 0.0v 2049.495n 0.0v 2049.505n 0.0v )
* (time, data): [(0, 0), (10, 0), (20, 1), (30, 0), (40, 1), (50, 0), (60, 0), (70, 0), (80, 0), (90, 0), (100, 0), (110, 0), (120, 1), (130, 0), (140, 1), (150, 1), (160, 1), (170, 1), (180, 1), (190, 1), (200, 1), (210, 0), (220, 1), (230, 0), (240, 0), (250, 1), (260, 0), (270, 1), (280, 0), (290, 0), (300, 1), (310, 0), (320, 0), (330, 0), (340, 0), (350, 0), (360, 0), (370, 0), (380, 0), (390, 0), (400, 0), (410, 1), (420, 0), (430, 0), (440, 0), (450, 0), (460, 0), (470, 0), (480, 1), (490, 0), (500, 0), (510, 0), (520, 1), (530, 0), (540, 0), (550, 0), (560, 0), (570, 0), (580, 0), (590, 0), (600, 0), (610, 0), (620, 0), (630, 0), (640, 1), (650, 0), (660, 0), (670, 1), (680, 0), (690, 0), (700, 0), (710, 0), (720, 0), (730, 0), (740, 0), (750, 0), (760, 0), (770, 0), (780, 0), (790, 1), (800, 1), (810, 0), (820, 1), (830, 0), (840, 1), (850, 0), (860, 0), (870, 0), (880, 1), (890, 0), (900, 0), (910, 0), (920, 0), (930, 0), (940, 0), (950, 1), (960, 1), (970, 1), (980, 0), (990, 1), (1000, 1), (1010, 1), (1020, 1), (1030, 1), (1040, 1), (1050, 1), (1060, 1), (1070, 0), (1080, 0), (1090, 0), (1100, 0), (1110, 0), (1120, 0), (1130, 1), (1140, 1), (1150, 0), (1160, 0), (1170, 0), (1180, 0), (1190, 1), (1200, 0), (1210, 0), (1220, 0), (1230, 0), (1240, 0), (1250, 0), (1260, 0), (1270, 0), (1280, 0), (1290, 0), (1300, 0), (1310, 0), (1320, 0), (1330, 1), (1340, 1), (1350, 0), (1360, 1), (1370, 0), (1380, 0), (1390, 0), (1400, 0), (1410, 0), (1420, 0), (1430, 0), (1440, 0), (1450, 1), (1460, 0), (1470, 1), (1480, 0), (1490, 0), (1500, 0), (1510, 0), (1520, 0), (1530, 0), (1540, 0), (1550, 0), (1560, 0), (1570, 1), (1580, 0), (1590, 0), (1600, 0), (1610, 0), (1620, 0), (1630, 0), (1640, 0), (1650, 0), (1660, 0), (1670, 0), (1680, 1), (1690, 1), (1700, 0), (1710, 1), (1720, 0), (1730, 1), (1740, 0), (1750, 0), (1760, 1), (1770, 1), (1780, 1), (1790, 0), (1800, 0), (1810, 0), (1820, 0), (1830, 0), (1840, 0), (1850, 0), (1860, 0), (1870, 0), (1880, 0), (1890, 0), (1900, 0), (1910, 0), (1920, 0), (1930, 0), (1940, 0), (1950, 0), (1960, 0), (1970, 0), (1980, 0), (1990, 0), (2000, 0), (2010, 0), (2020, 1), (2030, 1), (2040, 1), (2050, 1)]
Va0_1  a0_1  0 PWL (0n 0.0v 9.495n 0.0v 9.505n 0.0v 19.495n 0.0v 19.505n 1.8v 29.495n 1.8v 29.505n 0.0v 39.495n 0.0v 39.505n 1.8v 49.495n 1.8v 49.505n 0.0v 59.495n 0.0v 59.505n 0.0v 69.495n 0.0v 69.505n 0.0v 79.495n 0.0v 79.505n 0.0v 89.495n 0.0v 89.505n 0.0v 99.495n 0.0v 99.505n 0.0v 109.495n 0.0v 109.505n 0.0v 119.495n 0.0v 119.505n 1.8v 129.495n 1.8v 129.505n 0.0v 139.495n 0.0v 139.505n 1.8v 149.495n 1.8v 149.505n 1.8v 159.495n 1.8v 159.505n 1.8v 169.495n 1.8v 169.505n 1.8v 179.495n 1.8v 179.505n 1.8v 189.495n 1.8v 189.505n 1.8v 199.495n 1.8v 199.505n 1.8v 209.495n 1.8v 209.505n 0.0v 219.495n 0.0v 219.505n 1.8v 229.495n 1.8v 229.505n 0.0v 239.495n 0.0v 239.505n 0.0v 249.495n 0.0v 249.505n 1.8v 259.495n 1.8v 259.505n 0.0v 269.495n 0.0v 269.505n 1.8v 279.495n 1.8v 279.505n 0.0v 289.495n 0.0v 289.505n 0.0v 299.495n 0.0v 299.505n 1.8v 309.495n 1.8v 309.505n 0.0v 319.495n 0.0v 319.505n 0.0v 329.495n 0.0v 329.505n 0.0v 339.495n 0.0v 339.505n 0.0v 349.495n 0.0v 349.505n 0.0v 359.495n 0.0v 359.505n 0.0v 369.495n 0.0v 369.505n 0.0v 379.495n 0.0v 379.505n 0.0v 389.495n 0.0v 389.505n 0.0v 399.495n 0.0v 399.505n 0.0v 409.495n 0.0v 409.505n 1.8v 419.495n 1.8v 419.505n 0.0v 429.495n 0.0v 429.505n 0.0v 439.495n 0.0v 439.505n 0.0v 449.495n 0.0v 449.505n 0.0v 459.495n 0.0v 459.505n 0.0v 469.495n 0.0v 469.505n 0.0v 479.495n 0.0v 479.505n 1.8v 489.495n 1.8v 489.505n 0.0v 499.495n 0.0v 499.505n 0.0v 509.495n 0.0v 509.505n 0.0v 519.495n 0.0v 519.505n 1.8v 529.495n 1.8v 529.505n 0.0v 539.495n 0.0v 539.505n 0.0v 549.495n 0.0v 549.505n 0.0v 559.495n 0.0v 559.505n 0.0v 569.495n 0.0v 569.505n 0.0v 579.495n 0.0v 579.505n 0.0v 589.495n 0.0v 589.505n 0.0v 599.495n 0.0v 599.505n 0.0v 609.495n 0.0v 609.505n 0.0v 619.495n 0.0v 619.505n 0.0v 629.495n 0.0v 629.505n 0.0v 639.495n 0.0v 639.505n 1.8v 649.495n 1.8v 649.505n 0.0v 659.495n 0.0v 659.505n 0.0v 669.495n 0.0v 669.505n 1.8v 679.495n 1.8v 679.505n 0.0v 689.495n 0.0v 689.505n 0.0v 699.495n 0.0v 699.505n 0.0v 709.495n 0.0v 709.505n 0.0v 719.495n 0.0v 719.505n 0.0v 729.495n 0.0v 729.505n 0.0v 739.495n 0.0v 739.505n 0.0v 749.495n 0.0v 749.505n 0.0v 759.495n 0.0v 759.505n 0.0v 769.495n 0.0v 769.505n 0.0v 779.495n 0.0v 779.505n 0.0v 789.495n 0.0v 789.505n 1.8v 799.495n 1.8v 799.505n 1.8v 809.495n 1.8v 809.505n 0.0v 819.495n 0.0v 819.505n 1.8v 829.495n 1.8v 829.505n 0.0v 839.495n 0.0v 839.505n 1.8v 849.495n 1.8v 849.505n 0.0v 859.495n 0.0v 859.505n 0.0v 869.495n 0.0v 869.505n 0.0v 879.495n 0.0v 879.505n 1.8v 889.495n 1.8v 889.505n 0.0v 899.495n 0.0v 899.505n 0.0v 909.495n 0.0v 909.505n 0.0v 919.495n 0.0v 919.505n 0.0v 929.495n 0.0v 929.505n 0.0v 939.495n 0.0v 939.505n 0.0v 949.495n 0.0v 949.505n 1.8v 959.495n 1.8v 959.505n 1.8v 969.495n 1.8v 969.505n 1.8v 979.495n 1.8v 979.505n 0.0v 989.495n 0.0v 989.505n 1.8v 999.495n 1.8v 999.505n 1.8v 1009.495n 1.8v 1009.505n 1.8v 1019.495n 1.8v 1019.505n 1.8v 1029.495n 1.8v 1029.505n 1.8v 1039.495n 1.8v 1039.505n 1.8v 1049.495n 1.8v 1049.505n 1.8v 1059.495n 1.8v 1059.505n 1.8v 1069.495n 1.8v 1069.505n 0.0v 1079.495n 0.0v 1079.505n 0.0v 1089.495n 0.0v 1089.505n 0.0v 1099.495n 0.0v 1099.505n 0.0v 1109.495n 0.0v 1109.505n 0.0v 1119.495n 0.0v 1119.505n 0.0v 1129.495n 0.0v 1129.505n 1.8v 1139.495n 1.8v 1139.505n 1.8v 1149.495n 1.8v 1149.505n 0.0v 1159.495n 0.0v 1159.505n 0.0v 1169.495n 0.0v 1169.505n 0.0v 1179.495n 0.0v 1179.505n 0.0v 1189.495n 0.0v 1189.505n 1.8v 1199.495n 1.8v 1199.505n 0.0v 1209.495n 0.0v 1209.505n 0.0v 1219.495n 0.0v 1219.505n 0.0v 1229.495n 0.0v 1229.505n 0.0v 1239.495n 0.0v 1239.505n 0.0v 1249.495n 0.0v 1249.505n 0.0v 1259.495n 0.0v 1259.505n 0.0v 1269.495n 0.0v 1269.505n 0.0v 1279.495n 0.0v 1279.505n 0.0v 1289.495n 0.0v 1289.505n 0.0v 1299.495n 0.0v 1299.505n 0.0v 1309.495n 0.0v 1309.505n 0.0v 1319.495n 0.0v 1319.505n 0.0v 1329.495n 0.0v 1329.505n 1.8v 1339.495n 1.8v 1339.505n 1.8v 1349.495n 1.8v 1349.505n 0.0v 1359.495n 0.0v 1359.505n 1.8v 1369.495n 1.8v 1369.505n 0.0v 1379.495n 0.0v 1379.505n 0.0v 1389.495n 0.0v 1389.505n 0.0v 1399.495n 0.0v 1399.505n 0.0v 1409.495n 0.0v 1409.505n 0.0v 1419.495n 0.0v 1419.505n 0.0v 1429.495n 0.0v 1429.505n 0.0v 1439.495n 0.0v 1439.505n 0.0v 1449.495n 0.0v 1449.505n 1.8v 1459.495n 1.8v 1459.505n 0.0v 1469.495n 0.0v 1469.505n 1.8v 1479.495n 1.8v 1479.505n 0.0v 1489.495n 0.0v 1489.505n 0.0v 1499.495n 0.0v 1499.505n 0.0v 1509.495n 0.0v 1509.505n 0.0v 1519.495n 0.0v 1519.505n 0.0v 1529.495n 0.0v 1529.505n 0.0v 1539.495n 0.0v 1539.505n 0.0v 1549.495n 0.0v 1549.505n 0.0v 1559.495n 0.0v 1559.505n 0.0v 1569.495n 0.0v 1569.505n 1.8v 1579.495n 1.8v 1579.505n 0.0v 1589.495n 0.0v 1589.505n 0.0v 1599.495n 0.0v 1599.505n 0.0v 1609.495n 0.0v 1609.505n 0.0v 1619.495n 0.0v 1619.505n 0.0v 1629.495n 0.0v 1629.505n 0.0v 1639.495n 0.0v 1639.505n 0.0v 1649.495n 0.0v 1649.505n 0.0v 1659.495n 0.0v 1659.505n 0.0v 1669.495n 0.0v 1669.505n 0.0v 1679.495n 0.0v 1679.505n 1.8v 1689.495n 1.8v 1689.505n 1.8v 1699.495n 1.8v 1699.505n 0.0v 1709.495n 0.0v 1709.505n 1.8v 1719.495n 1.8v 1719.505n 0.0v 1729.495n 0.0v 1729.505n 1.8v 1739.495n 1.8v 1739.505n 0.0v 1749.495n 0.0v 1749.505n 0.0v 1759.495n 0.0v 1759.505n 1.8v 1769.495n 1.8v 1769.505n 1.8v 1779.495n 1.8v 1779.505n 1.8v 1789.495n 1.8v 1789.505n 0.0v 1799.495n 0.0v 1799.505n 0.0v 1809.495n 0.0v 1809.505n 0.0v 1819.495n 0.0v 1819.505n 0.0v 1829.495n 0.0v 1829.505n 0.0v 1839.495n 0.0v 1839.505n 0.0v 1849.495n 0.0v 1849.505n 0.0v 1859.495n 0.0v 1859.505n 0.0v 1869.495n 0.0v 1869.505n 0.0v 1879.495n 0.0v 1879.505n 0.0v 1889.495n 0.0v 1889.505n 0.0v 1899.495n 0.0v 1899.505n 0.0v 1909.495n 0.0v 1909.505n 0.0v 1919.495n 0.0v 1919.505n 0.0v 1929.495n 0.0v 1929.505n 0.0v 1939.495n 0.0v 1939.505n 0.0v 1949.495n 0.0v 1949.505n 0.0v 1959.495n 0.0v 1959.505n 0.0v 1969.495n 0.0v 1969.505n 0.0v 1979.495n 0.0v 1979.505n 0.0v 1989.495n 0.0v 1989.505n 0.0v 1999.495n 0.0v 1999.505n 0.0v 2009.495n 0.0v 2009.505n 0.0v 2019.495n 0.0v 2019.505n 1.8v 2029.495n 1.8v 2029.505n 1.8v 2039.495n 1.8v 2039.505n 1.8v 2049.495n 1.8v 2049.505n 1.8v )
* (time, data): [(0, 0), (10, 0), (20, 1), (30, 0), (40, 1), (50, 0), (60, 0), (70, 0), (80, 0), (90, 0), (100, 0), (110, 0), (120, 1), (130, 0), (140, 1), (150, 1), (160, 1), (170, 1), (180, 1), (190, 1), (200, 1), (210, 0), (220, 1), (230, 0), (240, 0), (250, 1), (260, 0), (270, 1), (280, 0), (290, 0), (300, 1), (310, 0), (320, 0), (330, 0), (340, 0), (350, 1), (360, 1), (370, 1), (380, 0), (390, 0), (400, 0), (410, 1), (420, 1), (430, 0), (440, 0), (450, 0), (460, 1), (470, 1), (480, 1), (490, 0), (500, 1), (510, 1), (520, 1), (530, 0), (540, 0), (550, 0), (560, 0), (570, 0), (580, 0), (590, 0), (600, 1), (610, 0), (620, 0), (630, 0), (640, 1), (650, 0), (660, 1), (670, 1), (680, 0), (690, 0), (700, 0), (710, 0), (720, 0), (730, 0), (740, 0), (750, 0), (760, 0), (770, 0), (780, 0), (790, 1), (800, 1), (810, 0), (820, 1), (830, 0), (840, 1), (850, 1), (860, 0), (870, 0), (880, 1), (890, 0), (900, 0), (910, 0), (920, 1), (930, 0), (940, 0), (950, 1), (960, 1), (970, 1), (980, 0), (990, 1), (1000, 1), (1010, 1), (1020, 1), (1030, 1), (1040, 1), (1050, 1), (1060, 1), (1070, 1), (1080, 0), (1090, 0), (1100, 0), (1110, 0), (1120, 0), (1130, 1), (1140, 1), (1150, 1), (1160, 1), (1170, 0), (1180, 1), (1190, 1), (1200, 0), (1210, 1), (1220, 0), (1230, 0), (1240, 0), (1250, 0), (1260, 0), (1270, 0), (1280, 0), (1290, 0), (1300, 0), (1310, 0), (1320, 0), (1330, 1), (1340, 1), (1350, 0), (1360, 1), (1370, 0), (1380, 0), (1390, 0), (1400, 0), (1410, 1), (1420, 1), (1430, 0), (1440, 0), (1450, 1), (1460, 1), (1470, 1), (1480, 0), (1490, 0), (1500, 1), (1510, 0), (1520, 0), (1530, 0), (1540, 0), (1550, 0), (1560, 1), (1570, 1), (1580, 1), (1590, 0), (1600, 0), (1610, 0), (1620, 0), (1630, 0), (1640, 0), (1650, 0), (1660, 0), (1670, 0), (1680, 1), (1690, 1), (1700, 1), (1710, 1), (1720, 0), (1730, 1), (1740, 0), (1750, 0), (1760, 1), (1770, 1), (1780, 1), (1790, 0), (1800, 0), (1810, 0), (1820, 1), (1830, 0), (1840, 0), (1850, 1), (1860, 1), (1870, 0), (1880, 0), (1890, 0), (1900, 0), (1910, 1), (1920, 0), (1930, 0), (1940, 0), (1950, 1), (1960, 0), (1970, 1), (1980, 1), (1990, 1), (2000, 1), (2010, 0), (2020, 1), (2030, 1), (2040, 1), (2050, 1)]
Va0_2  a0_2  0 PWL (0n 0.0v 9.495n 0.0v 9.505n 0.0v 19.495n 0.0v 19.505n 1.8v 29.495n 1.8v 29.505n 0.0v 39.495n 0.0v 39.505n 1.8v 49.495n 1.8v 49.505n 0.0v 59.495n 0.0v 59.505n 0.0v 69.495n 0.0v 69.505n 0.0v 79.495n 0.0v 79.505n 0.0v 89.495n 0.0v 89.505n 0.0v 99.495n 0.0v 99.505n 0.0v 109.495n 0.0v 109.505n 0.0v 119.495n 0.0v 119.505n 1.8v 129.495n 1.8v 129.505n 0.0v 139.495n 0.0v 139.505n 1.8v 149.495n 1.8v 149.505n 1.8v 159.495n 1.8v 159.505n 1.8v 169.495n 1.8v 169.505n 1.8v 179.495n 1.8v 179.505n 1.8v 189.495n 1.8v 189.505n 1.8v 199.495n 1.8v 199.505n 1.8v 209.495n 1.8v 209.505n 0.0v 219.495n 0.0v 219.505n 1.8v 229.495n 1.8v 229.505n 0.0v 239.495n 0.0v 239.505n 0.0v 249.495n 0.0v 249.505n 1.8v 259.495n 1.8v 259.505n 0.0v 269.495n 0.0v 269.505n 1.8v 279.495n 1.8v 279.505n 0.0v 289.495n 0.0v 289.505n 0.0v 299.495n 0.0v 299.505n 1.8v 309.495n 1.8v 309.505n 0.0v 319.495n 0.0v 319.505n 0.0v 329.495n 0.0v 329.505n 0.0v 339.495n 0.0v 339.505n 0.0v 349.495n 0.0v 349.505n 1.8v 359.495n 1.8v 359.505n 1.8v 369.495n 1.8v 369.505n 1.8v 379.495n 1.8v 379.505n 0.0v 389.495n 0.0v 389.505n 0.0v 399.495n 0.0v 399.505n 0.0v 409.495n 0.0v 409.505n 1.8v 419.495n 1.8v 419.505n 1.8v 429.495n 1.8v 429.505n 0.0v 439.495n 0.0v 439.505n 0.0v 449.495n 0.0v 449.505n 0.0v 459.495n 0.0v 459.505n 1.8v 469.495n 1.8v 469.505n 1.8v 479.495n 1.8v 479.505n 1.8v 489.495n 1.8v 489.505n 0.0v 499.495n 0.0v 499.505n 1.8v 509.495n 1.8v 509.505n 1.8v 519.495n 1.8v 519.505n 1.8v 529.495n 1.8v 529.505n 0.0v 539.495n 0.0v 539.505n 0.0v 549.495n 0.0v 549.505n 0.0v 559.495n 0.0v 559.505n 0.0v 569.495n 0.0v 569.505n 0.0v 579.495n 0.0v 579.505n 0.0v 589.495n 0.0v 589.505n 0.0v 599.495n 0.0v 599.505n 1.8v 609.495n 1.8v 609.505n 0.0v 619.495n 0.0v 619.505n 0.0v 629.495n 0.0v 629.505n 0.0v 639.495n 0.0v 639.505n 1.8v 649.495n 1.8v 649.505n 0.0v 659.495n 0.0v 659.505n 1.8v 669.495n 1.8v 669.505n 1.8v 679.495n 1.8v 679.505n 0.0v 689.495n 0.0v 689.505n 0.0v 699.495n 0.0v 699.505n 0.0v 709.495n 0.0v 709.505n 0.0v 719.495n 0.0v 719.505n 0.0v 729.495n 0.0v 729.505n 0.0v 739.495n 0.0v 739.505n 0.0v 749.495n 0.0v 749.505n 0.0v 759.495n 0.0v 759.505n 0.0v 769.495n 0.0v 769.505n 0.0v 779.495n 0.0v 779.505n 0.0v 789.495n 0.0v 789.505n 1.8v 799.495n 1.8v 799.505n 1.8v 809.495n 1.8v 809.505n 0.0v 819.495n 0.0v 819.505n 1.8v 829.495n 1.8v 829.505n 0.0v 839.495n 0.0v 839.505n 1.8v 849.495n 1.8v 849.505n 1.8v 859.495n 1.8v 859.505n 0.0v 869.495n 0.0v 869.505n 0.0v 879.495n 0.0v 879.505n 1.8v 889.495n 1.8v 889.505n 0.0v 899.495n 0.0v 899.505n 0.0v 909.495n 0.0v 909.505n 0.0v 919.495n 0.0v 919.505n 1.8v 929.495n 1.8v 929.505n 0.0v 939.495n 0.0v 939.505n 0.0v 949.495n 0.0v 949.505n 1.8v 959.495n 1.8v 959.505n 1.8v 969.495n 1.8v 969.505n 1.8v 979.495n 1.8v 979.505n 0.0v 989.495n 0.0v 989.505n 1.8v 999.495n 1.8v 999.505n 1.8v 1009.495n 1.8v 1009.505n 1.8v 1019.495n 1.8v 1019.505n 1.8v 1029.495n 1.8v 1029.505n 1.8v 1039.495n 1.8v 1039.505n 1.8v 1049.495n 1.8v 1049.505n 1.8v 1059.495n 1.8v 1059.505n 1.8v 1069.495n 1.8v 1069.505n 1.8v 1079.495n 1.8v 1079.505n 0.0v 1089.495n 0.0v 1089.505n 0.0v 1099.495n 0.0v 1099.505n 0.0v 1109.495n 0.0v 1109.505n 0.0v 1119.495n 0.0v 1119.505n 0.0v 1129.495n 0.0v 1129.505n 1.8v 1139.495n 1.8v 1139.505n 1.8v 1149.495n 1.8v 1149.505n 1.8v 1159.495n 1.8v 1159.505n 1.8v 1169.495n 1.8v 1169.505n 0.0v 1179.495n 0.0v 1179.505n 1.8v 1189.495n 1.8v 1189.505n 1.8v 1199.495n 1.8v 1199.505n 0.0v 1209.495n 0.0v 1209.505n 1.8v 1219.495n 1.8v 1219.505n 0.0v 1229.495n 0.0v 1229.505n 0.0v 1239.495n 0.0v 1239.505n 0.0v 1249.495n 0.0v 1249.505n 0.0v 1259.495n 0.0v 1259.505n 0.0v 1269.495n 0.0v 1269.505n 0.0v 1279.495n 0.0v 1279.505n 0.0v 1289.495n 0.0v 1289.505n 0.0v 1299.495n 0.0v 1299.505n 0.0v 1309.495n 0.0v 1309.505n 0.0v 1319.495n 0.0v 1319.505n 0.0v 1329.495n 0.0v 1329.505n 1.8v 1339.495n 1.8v 1339.505n 1.8v 1349.495n 1.8v 1349.505n 0.0v 1359.495n 0.0v 1359.505n 1.8v 1369.495n 1.8v 1369.505n 0.0v 1379.495n 0.0v 1379.505n 0.0v 1389.495n 0.0v 1389.505n 0.0v 1399.495n 0.0v 1399.505n 0.0v 1409.495n 0.0v 1409.505n 1.8v 1419.495n 1.8v 1419.505n 1.8v 1429.495n 1.8v 1429.505n 0.0v 1439.495n 0.0v 1439.505n 0.0v 1449.495n 0.0v 1449.505n 1.8v 1459.495n 1.8v 1459.505n 1.8v 1469.495n 1.8v 1469.505n 1.8v 1479.495n 1.8v 1479.505n 0.0v 1489.495n 0.0v 1489.505n 0.0v 1499.495n 0.0v 1499.505n 1.8v 1509.495n 1.8v 1509.505n 0.0v 1519.495n 0.0v 1519.505n 0.0v 1529.495n 0.0v 1529.505n 0.0v 1539.495n 0.0v 1539.505n 0.0v 1549.495n 0.0v 1549.505n 0.0v 1559.495n 0.0v 1559.505n 1.8v 1569.495n 1.8v 1569.505n 1.8v 1579.495n 1.8v 1579.505n 1.8v 1589.495n 1.8v 1589.505n 0.0v 1599.495n 0.0v 1599.505n 0.0v 1609.495n 0.0v 1609.505n 0.0v 1619.495n 0.0v 1619.505n 0.0v 1629.495n 0.0v 1629.505n 0.0v 1639.495n 0.0v 1639.505n 0.0v 1649.495n 0.0v 1649.505n 0.0v 1659.495n 0.0v 1659.505n 0.0v 1669.495n 0.0v 1669.505n 0.0v 1679.495n 0.0v 1679.505n 1.8v 1689.495n 1.8v 1689.505n 1.8v 1699.495n 1.8v 1699.505n 1.8v 1709.495n 1.8v 1709.505n 1.8v 1719.495n 1.8v 1719.505n 0.0v 1729.495n 0.0v 1729.505n 1.8v 1739.495n 1.8v 1739.505n 0.0v 1749.495n 0.0v 1749.505n 0.0v 1759.495n 0.0v 1759.505n 1.8v 1769.495n 1.8v 1769.505n 1.8v 1779.495n 1.8v 1779.505n 1.8v 1789.495n 1.8v 1789.505n 0.0v 1799.495n 0.0v 1799.505n 0.0v 1809.495n 0.0v 1809.505n 0.0v 1819.495n 0.0v 1819.505n 1.8v 1829.495n 1.8v 1829.505n 0.0v 1839.495n 0.0v 1839.505n 0.0v 1849.495n 0.0v 1849.505n 1.8v 1859.495n 1.8v 1859.505n 1.8v 1869.495n 1.8v 1869.505n 0.0v 1879.495n 0.0v 1879.505n 0.0v 1889.495n 0.0v 1889.505n 0.0v 1899.495n 0.0v 1899.505n 0.0v 1909.495n 0.0v 1909.505n 1.8v 1919.495n 1.8v 1919.505n 0.0v 1929.495n 0.0v 1929.505n 0.0v 1939.495n 0.0v 1939.505n 0.0v 1949.495n 0.0v 1949.505n 1.8v 1959.495n 1.8v 1959.505n 0.0v 1969.495n 0.0v 1969.505n 1.8v 1979.495n 1.8v 1979.505n 1.8v 1989.495n 1.8v 1989.505n 1.8v 1999.495n 1.8v 1999.505n 1.8v 2009.495n 1.8v 2009.505n 0.0v 2019.495n 0.0v 2019.505n 1.8v 2029.495n 1.8v 2029.505n 1.8v 2039.495n 1.8v 2039.505n 1.8v 2049.495n 1.8v 2049.505n 1.8v )
* (time, data): [(0, 0), (10, 0), (20, 1), (30, 0), (40, 1), (50, 0), (60, 0), (70, 0), (80, 0), (90, 0), (100, 0), (110, 0), (120, 1), (130, 0), (140, 1), (150, 1), (160, 1), (170, 1), (180, 1), (190, 1), (200, 1), (210, 0), (220, 1), (230, 0), (240, 0), (250, 1), (260, 0), (270, 1), (280, 0), (290, 0), (300, 1), (310, 0), (320, 0), (330, 0), (340, 0), (350, 1), (360, 1), (370, 1), (380, 0), (390, 0), (400, 0), (410, 1), (420, 1), (430, 0), (440, 0), (450, 0), (460, 1), (470, 1), (480, 1), (490, 0), (500, 1), (510, 1), (520, 1), (530, 0), (540, 0), (550, 0), (560, 0), (570, 0), (580, 0), (590, 0), (600, 1), (610, 0), (620, 0), (630, 0), (640, 1), (650, 0), (660, 1), (670, 1), (680, 0), (690, 0), (700, 0), (710, 0), (720, 0), (730, 0), (740, 0), (750, 0), (760, 0), (770, 0), (780, 0), (790, 1), (800, 1), (810, 0), (820, 1), (830, 0), (840, 1), (850, 1), (860, 0), (870, 0), (880, 1), (890, 0), (900, 0), (910, 0), (920, 1), (930, 0), (940, 0), (950, 1), (960, 1), (970, 1), (980, 0), (990, 1), (1000, 1), (1010, 1), (1020, 1), (1030, 1), (1040, 1), (1050, 1), (1060, 1), (1070, 1), (1080, 0), (1090, 0), (1100, 0), (1110, 0), (1120, 0), (1130, 1), (1140, 1), (1150, 1), (1160, 1), (1170, 0), (1180, 1), (1190, 1), (1200, 0), (1210, 1), (1220, 0), (1230, 0), (1240, 0), (1250, 0), (1260, 0), (1270, 0), (1280, 0), (1290, 0), (1300, 0), (1310, 0), (1320, 0), (1330, 1), (1340, 1), (1350, 0), (1360, 1), (1370, 0), (1380, 0), (1390, 0), (1400, 0), (1410, 1), (1420, 1), (1430, 0), (1440, 0), (1450, 1), (1460, 1), (1470, 1), (1480, 0), (1490, 0), (1500, 1), (1510, 0), (1520, 0), (1530, 0), (1540, 0), (1550, 0), (1560, 1), (1570, 1), (1580, 1), (1590, 0), (1600, 0), (1610, 0), (1620, 0), (1630, 0), (1640, 0), (1650, 0), (1660, 0), (1670, 0), (1680, 1), (1690, 1), (1700, 1), (1710, 1), (1720, 0), (1730, 1), (1740, 0), (1750, 0), (1760, 1), (1770, 1), (1780, 1), (1790, 0), (1800, 0), (1810, 0), (1820, 1), (1830, 0), (1840, 0), (1850, 1), (1860, 1), (1870, 0), (1880, 0), (1890, 0), (1900, 0), (1910, 1), (1920, 0), (1930, 0), (1940, 0), (1950, 1), (1960, 0), (1970, 1), (1980, 1), (1990, 1), (2000, 1), (2010, 0), (2020, 1), (2030, 1), (2040, 1), (2050, 1)]
Va0_3  a0_3  0 PWL (0n 0.0v 9.495n 0.0v 9.505n 0.0v 19.495n 0.0v 19.505n 1.8v 29.495n 1.8v 29.505n 0.0v 39.495n 0.0v 39.505n 1.8v 49.495n 1.8v 49.505n 0.0v 59.495n 0.0v 59.505n 0.0v 69.495n 0.0v 69.505n 0.0v 79.495n 0.0v 79.505n 0.0v 89.495n 0.0v 89.505n 0.0v 99.495n 0.0v 99.505n 0.0v 109.495n 0.0v 109.505n 0.0v 119.495n 0.0v 119.505n 1.8v 129.495n 1.8v 129.505n 0.0v 139.495n 0.0v 139.505n 1.8v 149.495n 1.8v 149.505n 1.8v 159.495n 1.8v 159.505n 1.8v 169.495n 1.8v 169.505n 1.8v 179.495n 1.8v 179.505n 1.8v 189.495n 1.8v 189.505n 1.8v 199.495n 1.8v 199.505n 1.8v 209.495n 1.8v 209.505n 0.0v 219.495n 0.0v 219.505n 1.8v 229.495n 1.8v 229.505n 0.0v 239.495n 0.0v 239.505n 0.0v 249.495n 0.0v 249.505n 1.8v 259.495n 1.8v 259.505n 0.0v 269.495n 0.0v 269.505n 1.8v 279.495n 1.8v 279.505n 0.0v 289.495n 0.0v 289.505n 0.0v 299.495n 0.0v 299.505n 1.8v 309.495n 1.8v 309.505n 0.0v 319.495n 0.0v 319.505n 0.0v 329.495n 0.0v 329.505n 0.0v 339.495n 0.0v 339.505n 0.0v 349.495n 0.0v 349.505n 1.8v 359.495n 1.8v 359.505n 1.8v 369.495n 1.8v 369.505n 1.8v 379.495n 1.8v 379.505n 0.0v 389.495n 0.0v 389.505n 0.0v 399.495n 0.0v 399.505n 0.0v 409.495n 0.0v 409.505n 1.8v 419.495n 1.8v 419.505n 1.8v 429.495n 1.8v 429.505n 0.0v 439.495n 0.0v 439.505n 0.0v 449.495n 0.0v 449.505n 0.0v 459.495n 0.0v 459.505n 1.8v 469.495n 1.8v 469.505n 1.8v 479.495n 1.8v 479.505n 1.8v 489.495n 1.8v 489.505n 0.0v 499.495n 0.0v 499.505n 1.8v 509.495n 1.8v 509.505n 1.8v 519.495n 1.8v 519.505n 1.8v 529.495n 1.8v 529.505n 0.0v 539.495n 0.0v 539.505n 0.0v 549.495n 0.0v 549.505n 0.0v 559.495n 0.0v 559.505n 0.0v 569.495n 0.0v 569.505n 0.0v 579.495n 0.0v 579.505n 0.0v 589.495n 0.0v 589.505n 0.0v 599.495n 0.0v 599.505n 1.8v 609.495n 1.8v 609.505n 0.0v 619.495n 0.0v 619.505n 0.0v 629.495n 0.0v 629.505n 0.0v 639.495n 0.0v 639.505n 1.8v 649.495n 1.8v 649.505n 0.0v 659.495n 0.0v 659.505n 1.8v 669.495n 1.8v 669.505n 1.8v 679.495n 1.8v 679.505n 0.0v 689.495n 0.0v 689.505n 0.0v 699.495n 0.0v 699.505n 0.0v 709.495n 0.0v 709.505n 0.0v 719.495n 0.0v 719.505n 0.0v 729.495n 0.0v 729.505n 0.0v 739.495n 0.0v 739.505n 0.0v 749.495n 0.0v 749.505n 0.0v 759.495n 0.0v 759.505n 0.0v 769.495n 0.0v 769.505n 0.0v 779.495n 0.0v 779.505n 0.0v 789.495n 0.0v 789.505n 1.8v 799.495n 1.8v 799.505n 1.8v 809.495n 1.8v 809.505n 0.0v 819.495n 0.0v 819.505n 1.8v 829.495n 1.8v 829.505n 0.0v 839.495n 0.0v 839.505n 1.8v 849.495n 1.8v 849.505n 1.8v 859.495n 1.8v 859.505n 0.0v 869.495n 0.0v 869.505n 0.0v 879.495n 0.0v 879.505n 1.8v 889.495n 1.8v 889.505n 0.0v 899.495n 0.0v 899.505n 0.0v 909.495n 0.0v 909.505n 0.0v 919.495n 0.0v 919.505n 1.8v 929.495n 1.8v 929.505n 0.0v 939.495n 0.0v 939.505n 0.0v 949.495n 0.0v 949.505n 1.8v 959.495n 1.8v 959.505n 1.8v 969.495n 1.8v 969.505n 1.8v 979.495n 1.8v 979.505n 0.0v 989.495n 0.0v 989.505n 1.8v 999.495n 1.8v 999.505n 1.8v 1009.495n 1.8v 1009.505n 1.8v 1019.495n 1.8v 1019.505n 1.8v 1029.495n 1.8v 1029.505n 1.8v 1039.495n 1.8v 1039.505n 1.8v 1049.495n 1.8v 1049.505n 1.8v 1059.495n 1.8v 1059.505n 1.8v 1069.495n 1.8v 1069.505n 1.8v 1079.495n 1.8v 1079.505n 0.0v 1089.495n 0.0v 1089.505n 0.0v 1099.495n 0.0v 1099.505n 0.0v 1109.495n 0.0v 1109.505n 0.0v 1119.495n 0.0v 1119.505n 0.0v 1129.495n 0.0v 1129.505n 1.8v 1139.495n 1.8v 1139.505n 1.8v 1149.495n 1.8v 1149.505n 1.8v 1159.495n 1.8v 1159.505n 1.8v 1169.495n 1.8v 1169.505n 0.0v 1179.495n 0.0v 1179.505n 1.8v 1189.495n 1.8v 1189.505n 1.8v 1199.495n 1.8v 1199.505n 0.0v 1209.495n 0.0v 1209.505n 1.8v 1219.495n 1.8v 1219.505n 0.0v 1229.495n 0.0v 1229.505n 0.0v 1239.495n 0.0v 1239.505n 0.0v 1249.495n 0.0v 1249.505n 0.0v 1259.495n 0.0v 1259.505n 0.0v 1269.495n 0.0v 1269.505n 0.0v 1279.495n 0.0v 1279.505n 0.0v 1289.495n 0.0v 1289.505n 0.0v 1299.495n 0.0v 1299.505n 0.0v 1309.495n 0.0v 1309.505n 0.0v 1319.495n 0.0v 1319.505n 0.0v 1329.495n 0.0v 1329.505n 1.8v 1339.495n 1.8v 1339.505n 1.8v 1349.495n 1.8v 1349.505n 0.0v 1359.495n 0.0v 1359.505n 1.8v 1369.495n 1.8v 1369.505n 0.0v 1379.495n 0.0v 1379.505n 0.0v 1389.495n 0.0v 1389.505n 0.0v 1399.495n 0.0v 1399.505n 0.0v 1409.495n 0.0v 1409.505n 1.8v 1419.495n 1.8v 1419.505n 1.8v 1429.495n 1.8v 1429.505n 0.0v 1439.495n 0.0v 1439.505n 0.0v 1449.495n 0.0v 1449.505n 1.8v 1459.495n 1.8v 1459.505n 1.8v 1469.495n 1.8v 1469.505n 1.8v 1479.495n 1.8v 1479.505n 0.0v 1489.495n 0.0v 1489.505n 0.0v 1499.495n 0.0v 1499.505n 1.8v 1509.495n 1.8v 1509.505n 0.0v 1519.495n 0.0v 1519.505n 0.0v 1529.495n 0.0v 1529.505n 0.0v 1539.495n 0.0v 1539.505n 0.0v 1549.495n 0.0v 1549.505n 0.0v 1559.495n 0.0v 1559.505n 1.8v 1569.495n 1.8v 1569.505n 1.8v 1579.495n 1.8v 1579.505n 1.8v 1589.495n 1.8v 1589.505n 0.0v 1599.495n 0.0v 1599.505n 0.0v 1609.495n 0.0v 1609.505n 0.0v 1619.495n 0.0v 1619.505n 0.0v 1629.495n 0.0v 1629.505n 0.0v 1639.495n 0.0v 1639.505n 0.0v 1649.495n 0.0v 1649.505n 0.0v 1659.495n 0.0v 1659.505n 0.0v 1669.495n 0.0v 1669.505n 0.0v 1679.495n 0.0v 1679.505n 1.8v 1689.495n 1.8v 1689.505n 1.8v 1699.495n 1.8v 1699.505n 1.8v 1709.495n 1.8v 1709.505n 1.8v 1719.495n 1.8v 1719.505n 0.0v 1729.495n 0.0v 1729.505n 1.8v 1739.495n 1.8v 1739.505n 0.0v 1749.495n 0.0v 1749.505n 0.0v 1759.495n 0.0v 1759.505n 1.8v 1769.495n 1.8v 1769.505n 1.8v 1779.495n 1.8v 1779.505n 1.8v 1789.495n 1.8v 1789.505n 0.0v 1799.495n 0.0v 1799.505n 0.0v 1809.495n 0.0v 1809.505n 0.0v 1819.495n 0.0v 1819.505n 1.8v 1829.495n 1.8v 1829.505n 0.0v 1839.495n 0.0v 1839.505n 0.0v 1849.495n 0.0v 1849.505n 1.8v 1859.495n 1.8v 1859.505n 1.8v 1869.495n 1.8v 1869.505n 0.0v 1879.495n 0.0v 1879.505n 0.0v 1889.495n 0.0v 1889.505n 0.0v 1899.495n 0.0v 1899.505n 0.0v 1909.495n 0.0v 1909.505n 1.8v 1919.495n 1.8v 1919.505n 0.0v 1929.495n 0.0v 1929.505n 0.0v 1939.495n 0.0v 1939.505n 0.0v 1949.495n 0.0v 1949.505n 1.8v 1959.495n 1.8v 1959.505n 0.0v 1969.495n 0.0v 1969.505n 1.8v 1979.495n 1.8v 1979.505n 1.8v 1989.495n 1.8v 1989.505n 1.8v 1999.495n 1.8v 1999.505n 1.8v 2009.495n 1.8v 2009.505n 0.0v 2019.495n 0.0v 2019.505n 1.8v 2029.495n 1.8v 2029.505n 1.8v 2039.495n 1.8v 2039.505n 1.8v 2049.495n 1.8v 2049.505n 1.8v )
* (time, data): [(0, 0), (10, 0), (20, 1), (30, 0), (40, 1), (50, 0), (60, 0), (70, 0), (80, 0), (90, 0), (100, 0), (110, 0), (120, 1), (130, 0), (140, 1), (150, 1), (160, 1), (170, 1), (180, 1), (190, 1), (200, 1), (210, 0), (220, 1), (230, 0), (240, 0), (250, 1), (260, 0), (270, 1), (280, 0), (290, 0), (300, 1), (310, 0), (320, 0), (330, 0), (340, 0), (350, 1), (360, 1), (370, 1), (380, 0), (390, 0), (400, 0), (410, 1), (420, 1), (430, 0), (440, 0), (450, 0), (460, 1), (470, 1), (480, 1), (490, 0), (500, 1), (510, 1), (520, 1), (530, 0), (540, 0), (550, 0), (560, 0), (570, 0), (580, 0), (590, 0), (600, 1), (610, 0), (620, 0), (630, 0), (640, 1), (650, 0), (660, 1), (670, 1), (680, 0), (690, 0), (700, 0), (710, 0), (720, 0), (730, 0), (740, 0), (750, 0), (760, 0), (770, 0), (780, 0), (790, 1), (800, 1), (810, 0), (820, 1), (830, 0), (840, 1), (850, 1), (860, 0), (870, 0), (880, 1), (890, 0), (900, 0), (910, 0), (920, 1), (930, 0), (940, 0), (950, 1), (960, 1), (970, 1), (980, 0), (990, 1), (1000, 1), (1010, 1), (1020, 1), (1030, 1), (1040, 1), (1050, 1), (1060, 1), (1070, 1), (1080, 0), (1090, 0), (1100, 0), (1110, 0), (1120, 0), (1130, 1), (1140, 1), (1150, 1), (1160, 1), (1170, 0), (1180, 1), (1190, 1), (1200, 0), (1210, 1), (1220, 0), (1230, 0), (1240, 0), (1250, 0), (1260, 0), (1270, 0), (1280, 0), (1290, 0), (1300, 0), (1310, 0), (1320, 0), (1330, 1), (1340, 1), (1350, 0), (1360, 1), (1370, 0), (1380, 0), (1390, 0), (1400, 0), (1410, 1), (1420, 1), (1430, 0), (1440, 0), (1450, 1), (1460, 1), (1470, 1), (1480, 0), (1490, 0), (1500, 1), (1510, 0), (1520, 0), (1530, 0), (1540, 0), (1550, 0), (1560, 1), (1570, 1), (1580, 1), (1590, 0), (1600, 0), (1610, 0), (1620, 0), (1630, 0), (1640, 0), (1650, 0), (1660, 0), (1670, 0), (1680, 1), (1690, 1), (1700, 1), (1710, 1), (1720, 0), (1730, 1), (1740, 0), (1750, 0), (1760, 1), (1770, 1), (1780, 1), (1790, 0), (1800, 0), (1810, 0), (1820, 1), (1830, 0), (1840, 0), (1850, 1), (1860, 1), (1870, 0), (1880, 0), (1890, 0), (1900, 0), (1910, 1), (1920, 0), (1930, 0), (1940, 0), (1950, 1), (1960, 0), (1970, 1), (1980, 1), (1990, 1), (2000, 1), (2010, 0), (2020, 1), (2030, 1), (2040, 1), (2050, 1)]
Va0_4  a0_4  0 PWL (0n 0.0v 9.495n 0.0v 9.505n 0.0v 19.495n 0.0v 19.505n 1.8v 29.495n 1.8v 29.505n 0.0v 39.495n 0.0v 39.505n 1.8v 49.495n 1.8v 49.505n 0.0v 59.495n 0.0v 59.505n 0.0v 69.495n 0.0v 69.505n 0.0v 79.495n 0.0v 79.505n 0.0v 89.495n 0.0v 89.505n 0.0v 99.495n 0.0v 99.505n 0.0v 109.495n 0.0v 109.505n 0.0v 119.495n 0.0v 119.505n 1.8v 129.495n 1.8v 129.505n 0.0v 139.495n 0.0v 139.505n 1.8v 149.495n 1.8v 149.505n 1.8v 159.495n 1.8v 159.505n 1.8v 169.495n 1.8v 169.505n 1.8v 179.495n 1.8v 179.505n 1.8v 189.495n 1.8v 189.505n 1.8v 199.495n 1.8v 199.505n 1.8v 209.495n 1.8v 209.505n 0.0v 219.495n 0.0v 219.505n 1.8v 229.495n 1.8v 229.505n 0.0v 239.495n 0.0v 239.505n 0.0v 249.495n 0.0v 249.505n 1.8v 259.495n 1.8v 259.505n 0.0v 269.495n 0.0v 269.505n 1.8v 279.495n 1.8v 279.505n 0.0v 289.495n 0.0v 289.505n 0.0v 299.495n 0.0v 299.505n 1.8v 309.495n 1.8v 309.505n 0.0v 319.495n 0.0v 319.505n 0.0v 329.495n 0.0v 329.505n 0.0v 339.495n 0.0v 339.505n 0.0v 349.495n 0.0v 349.505n 1.8v 359.495n 1.8v 359.505n 1.8v 369.495n 1.8v 369.505n 1.8v 379.495n 1.8v 379.505n 0.0v 389.495n 0.0v 389.505n 0.0v 399.495n 0.0v 399.505n 0.0v 409.495n 0.0v 409.505n 1.8v 419.495n 1.8v 419.505n 1.8v 429.495n 1.8v 429.505n 0.0v 439.495n 0.0v 439.505n 0.0v 449.495n 0.0v 449.505n 0.0v 459.495n 0.0v 459.505n 1.8v 469.495n 1.8v 469.505n 1.8v 479.495n 1.8v 479.505n 1.8v 489.495n 1.8v 489.505n 0.0v 499.495n 0.0v 499.505n 1.8v 509.495n 1.8v 509.505n 1.8v 519.495n 1.8v 519.505n 1.8v 529.495n 1.8v 529.505n 0.0v 539.495n 0.0v 539.505n 0.0v 549.495n 0.0v 549.505n 0.0v 559.495n 0.0v 559.505n 0.0v 569.495n 0.0v 569.505n 0.0v 579.495n 0.0v 579.505n 0.0v 589.495n 0.0v 589.505n 0.0v 599.495n 0.0v 599.505n 1.8v 609.495n 1.8v 609.505n 0.0v 619.495n 0.0v 619.505n 0.0v 629.495n 0.0v 629.505n 0.0v 639.495n 0.0v 639.505n 1.8v 649.495n 1.8v 649.505n 0.0v 659.495n 0.0v 659.505n 1.8v 669.495n 1.8v 669.505n 1.8v 679.495n 1.8v 679.505n 0.0v 689.495n 0.0v 689.505n 0.0v 699.495n 0.0v 699.505n 0.0v 709.495n 0.0v 709.505n 0.0v 719.495n 0.0v 719.505n 0.0v 729.495n 0.0v 729.505n 0.0v 739.495n 0.0v 739.505n 0.0v 749.495n 0.0v 749.505n 0.0v 759.495n 0.0v 759.505n 0.0v 769.495n 0.0v 769.505n 0.0v 779.495n 0.0v 779.505n 0.0v 789.495n 0.0v 789.505n 1.8v 799.495n 1.8v 799.505n 1.8v 809.495n 1.8v 809.505n 0.0v 819.495n 0.0v 819.505n 1.8v 829.495n 1.8v 829.505n 0.0v 839.495n 0.0v 839.505n 1.8v 849.495n 1.8v 849.505n 1.8v 859.495n 1.8v 859.505n 0.0v 869.495n 0.0v 869.505n 0.0v 879.495n 0.0v 879.505n 1.8v 889.495n 1.8v 889.505n 0.0v 899.495n 0.0v 899.505n 0.0v 909.495n 0.0v 909.505n 0.0v 919.495n 0.0v 919.505n 1.8v 929.495n 1.8v 929.505n 0.0v 939.495n 0.0v 939.505n 0.0v 949.495n 0.0v 949.505n 1.8v 959.495n 1.8v 959.505n 1.8v 969.495n 1.8v 969.505n 1.8v 979.495n 1.8v 979.505n 0.0v 989.495n 0.0v 989.505n 1.8v 999.495n 1.8v 999.505n 1.8v 1009.495n 1.8v 1009.505n 1.8v 1019.495n 1.8v 1019.505n 1.8v 1029.495n 1.8v 1029.505n 1.8v 1039.495n 1.8v 1039.505n 1.8v 1049.495n 1.8v 1049.505n 1.8v 1059.495n 1.8v 1059.505n 1.8v 1069.495n 1.8v 1069.505n 1.8v 1079.495n 1.8v 1079.505n 0.0v 1089.495n 0.0v 1089.505n 0.0v 1099.495n 0.0v 1099.505n 0.0v 1109.495n 0.0v 1109.505n 0.0v 1119.495n 0.0v 1119.505n 0.0v 1129.495n 0.0v 1129.505n 1.8v 1139.495n 1.8v 1139.505n 1.8v 1149.495n 1.8v 1149.505n 1.8v 1159.495n 1.8v 1159.505n 1.8v 1169.495n 1.8v 1169.505n 0.0v 1179.495n 0.0v 1179.505n 1.8v 1189.495n 1.8v 1189.505n 1.8v 1199.495n 1.8v 1199.505n 0.0v 1209.495n 0.0v 1209.505n 1.8v 1219.495n 1.8v 1219.505n 0.0v 1229.495n 0.0v 1229.505n 0.0v 1239.495n 0.0v 1239.505n 0.0v 1249.495n 0.0v 1249.505n 0.0v 1259.495n 0.0v 1259.505n 0.0v 1269.495n 0.0v 1269.505n 0.0v 1279.495n 0.0v 1279.505n 0.0v 1289.495n 0.0v 1289.505n 0.0v 1299.495n 0.0v 1299.505n 0.0v 1309.495n 0.0v 1309.505n 0.0v 1319.495n 0.0v 1319.505n 0.0v 1329.495n 0.0v 1329.505n 1.8v 1339.495n 1.8v 1339.505n 1.8v 1349.495n 1.8v 1349.505n 0.0v 1359.495n 0.0v 1359.505n 1.8v 1369.495n 1.8v 1369.505n 0.0v 1379.495n 0.0v 1379.505n 0.0v 1389.495n 0.0v 1389.505n 0.0v 1399.495n 0.0v 1399.505n 0.0v 1409.495n 0.0v 1409.505n 1.8v 1419.495n 1.8v 1419.505n 1.8v 1429.495n 1.8v 1429.505n 0.0v 1439.495n 0.0v 1439.505n 0.0v 1449.495n 0.0v 1449.505n 1.8v 1459.495n 1.8v 1459.505n 1.8v 1469.495n 1.8v 1469.505n 1.8v 1479.495n 1.8v 1479.505n 0.0v 1489.495n 0.0v 1489.505n 0.0v 1499.495n 0.0v 1499.505n 1.8v 1509.495n 1.8v 1509.505n 0.0v 1519.495n 0.0v 1519.505n 0.0v 1529.495n 0.0v 1529.505n 0.0v 1539.495n 0.0v 1539.505n 0.0v 1549.495n 0.0v 1549.505n 0.0v 1559.495n 0.0v 1559.505n 1.8v 1569.495n 1.8v 1569.505n 1.8v 1579.495n 1.8v 1579.505n 1.8v 1589.495n 1.8v 1589.505n 0.0v 1599.495n 0.0v 1599.505n 0.0v 1609.495n 0.0v 1609.505n 0.0v 1619.495n 0.0v 1619.505n 0.0v 1629.495n 0.0v 1629.505n 0.0v 1639.495n 0.0v 1639.505n 0.0v 1649.495n 0.0v 1649.505n 0.0v 1659.495n 0.0v 1659.505n 0.0v 1669.495n 0.0v 1669.505n 0.0v 1679.495n 0.0v 1679.505n 1.8v 1689.495n 1.8v 1689.505n 1.8v 1699.495n 1.8v 1699.505n 1.8v 1709.495n 1.8v 1709.505n 1.8v 1719.495n 1.8v 1719.505n 0.0v 1729.495n 0.0v 1729.505n 1.8v 1739.495n 1.8v 1739.505n 0.0v 1749.495n 0.0v 1749.505n 0.0v 1759.495n 0.0v 1759.505n 1.8v 1769.495n 1.8v 1769.505n 1.8v 1779.495n 1.8v 1779.505n 1.8v 1789.495n 1.8v 1789.505n 0.0v 1799.495n 0.0v 1799.505n 0.0v 1809.495n 0.0v 1809.505n 0.0v 1819.495n 0.0v 1819.505n 1.8v 1829.495n 1.8v 1829.505n 0.0v 1839.495n 0.0v 1839.505n 0.0v 1849.495n 0.0v 1849.505n 1.8v 1859.495n 1.8v 1859.505n 1.8v 1869.495n 1.8v 1869.505n 0.0v 1879.495n 0.0v 1879.505n 0.0v 1889.495n 0.0v 1889.505n 0.0v 1899.495n 0.0v 1899.505n 0.0v 1909.495n 0.0v 1909.505n 1.8v 1919.495n 1.8v 1919.505n 0.0v 1929.495n 0.0v 1929.505n 0.0v 1939.495n 0.0v 1939.505n 0.0v 1949.495n 0.0v 1949.505n 1.8v 1959.495n 1.8v 1959.505n 0.0v 1969.495n 0.0v 1969.505n 1.8v 1979.495n 1.8v 1979.505n 1.8v 1989.495n 1.8v 1989.505n 1.8v 1999.495n 1.8v 1999.505n 1.8v 2009.495n 1.8v 2009.505n 0.0v 2019.495n 0.0v 2019.505n 1.8v 2029.495n 1.8v 2029.505n 1.8v 2039.495n 1.8v 2039.505n 1.8v 2049.495n 1.8v 2049.505n 1.8v )
* (time, data): [(0, 0), (10, 0), (20, 1), (30, 0), (40, 1), (50, 0), (60, 0), (70, 0), (80, 0), (90, 0), (100, 0), (110, 0), (120, 1), (130, 0), (140, 1), (150, 1), (160, 1), (170, 1), (180, 1), (190, 1), (200, 1), (210, 0), (220, 1), (230, 0), (240, 0), (250, 1), (260, 0), (270, 1), (280, 0), (290, 0), (300, 1), (310, 0), (320, 0), (330, 0), (340, 0), (350, 1), (360, 1), (370, 1), (380, 0), (390, 0), (400, 0), (410, 1), (420, 1), (430, 0), (440, 0), (450, 0), (460, 1), (470, 1), (480, 1), (490, 0), (500, 1), (510, 1), (520, 1), (530, 0), (540, 0), (550, 0), (560, 0), (570, 0), (580, 0), (590, 0), (600, 1), (610, 0), (620, 0), (630, 0), (640, 1), (650, 0), (660, 1), (670, 1), (680, 0), (690, 0), (700, 0), (710, 0), (720, 0), (730, 0), (740, 0), (750, 0), (760, 0), (770, 0), (780, 0), (790, 1), (800, 1), (810, 0), (820, 1), (830, 0), (840, 1), (850, 1), (860, 0), (870, 0), (880, 1), (890, 0), (900, 0), (910, 0), (920, 1), (930, 0), (940, 0), (950, 1), (960, 1), (970, 1), (980, 0), (990, 1), (1000, 1), (1010, 1), (1020, 1), (1030, 1), (1040, 1), (1050, 1), (1060, 1), (1070, 1), (1080, 0), (1090, 0), (1100, 0), (1110, 0), (1120, 0), (1130, 1), (1140, 1), (1150, 1), (1160, 1), (1170, 0), (1180, 1), (1190, 1), (1200, 0), (1210, 1), (1220, 0), (1230, 0), (1240, 0), (1250, 0), (1260, 0), (1270, 0), (1280, 0), (1290, 0), (1300, 0), (1310, 0), (1320, 0), (1330, 1), (1340, 1), (1350, 0), (1360, 1), (1370, 0), (1380, 0), (1390, 0), (1400, 0), (1410, 1), (1420, 1), (1430, 0), (1440, 0), (1450, 1), (1460, 1), (1470, 1), (1480, 0), (1490, 0), (1500, 1), (1510, 0), (1520, 0), (1530, 0), (1540, 0), (1550, 0), (1560, 1), (1570, 1), (1580, 1), (1590, 0), (1600, 0), (1610, 0), (1620, 0), (1630, 0), (1640, 0), (1650, 0), (1660, 0), (1670, 0), (1680, 1), (1690, 1), (1700, 1), (1710, 1), (1720, 0), (1730, 1), (1740, 0), (1750, 0), (1760, 1), (1770, 1), (1780, 1), (1790, 0), (1800, 0), (1810, 0), (1820, 1), (1830, 0), (1840, 0), (1850, 1), (1860, 1), (1870, 0), (1880, 0), (1890, 0), (1900, 0), (1910, 1), (1920, 0), (1930, 0), (1940, 0), (1950, 1), (1960, 0), (1970, 1), (1980, 1), (1990, 1), (2000, 1), (2010, 0), (2020, 1), (2030, 1), (2040, 1), (2050, 1)]
Va0_5  a0_5  0 PWL (0n 0.0v 9.495n 0.0v 9.505n 0.0v 19.495n 0.0v 19.505n 1.8v 29.495n 1.8v 29.505n 0.0v 39.495n 0.0v 39.505n 1.8v 49.495n 1.8v 49.505n 0.0v 59.495n 0.0v 59.505n 0.0v 69.495n 0.0v 69.505n 0.0v 79.495n 0.0v 79.505n 0.0v 89.495n 0.0v 89.505n 0.0v 99.495n 0.0v 99.505n 0.0v 109.495n 0.0v 109.505n 0.0v 119.495n 0.0v 119.505n 1.8v 129.495n 1.8v 129.505n 0.0v 139.495n 0.0v 139.505n 1.8v 149.495n 1.8v 149.505n 1.8v 159.495n 1.8v 159.505n 1.8v 169.495n 1.8v 169.505n 1.8v 179.495n 1.8v 179.505n 1.8v 189.495n 1.8v 189.505n 1.8v 199.495n 1.8v 199.505n 1.8v 209.495n 1.8v 209.505n 0.0v 219.495n 0.0v 219.505n 1.8v 229.495n 1.8v 229.505n 0.0v 239.495n 0.0v 239.505n 0.0v 249.495n 0.0v 249.505n 1.8v 259.495n 1.8v 259.505n 0.0v 269.495n 0.0v 269.505n 1.8v 279.495n 1.8v 279.505n 0.0v 289.495n 0.0v 289.505n 0.0v 299.495n 0.0v 299.505n 1.8v 309.495n 1.8v 309.505n 0.0v 319.495n 0.0v 319.505n 0.0v 329.495n 0.0v 329.505n 0.0v 339.495n 0.0v 339.505n 0.0v 349.495n 0.0v 349.505n 1.8v 359.495n 1.8v 359.505n 1.8v 369.495n 1.8v 369.505n 1.8v 379.495n 1.8v 379.505n 0.0v 389.495n 0.0v 389.505n 0.0v 399.495n 0.0v 399.505n 0.0v 409.495n 0.0v 409.505n 1.8v 419.495n 1.8v 419.505n 1.8v 429.495n 1.8v 429.505n 0.0v 439.495n 0.0v 439.505n 0.0v 449.495n 0.0v 449.505n 0.0v 459.495n 0.0v 459.505n 1.8v 469.495n 1.8v 469.505n 1.8v 479.495n 1.8v 479.505n 1.8v 489.495n 1.8v 489.505n 0.0v 499.495n 0.0v 499.505n 1.8v 509.495n 1.8v 509.505n 1.8v 519.495n 1.8v 519.505n 1.8v 529.495n 1.8v 529.505n 0.0v 539.495n 0.0v 539.505n 0.0v 549.495n 0.0v 549.505n 0.0v 559.495n 0.0v 559.505n 0.0v 569.495n 0.0v 569.505n 0.0v 579.495n 0.0v 579.505n 0.0v 589.495n 0.0v 589.505n 0.0v 599.495n 0.0v 599.505n 1.8v 609.495n 1.8v 609.505n 0.0v 619.495n 0.0v 619.505n 0.0v 629.495n 0.0v 629.505n 0.0v 639.495n 0.0v 639.505n 1.8v 649.495n 1.8v 649.505n 0.0v 659.495n 0.0v 659.505n 1.8v 669.495n 1.8v 669.505n 1.8v 679.495n 1.8v 679.505n 0.0v 689.495n 0.0v 689.505n 0.0v 699.495n 0.0v 699.505n 0.0v 709.495n 0.0v 709.505n 0.0v 719.495n 0.0v 719.505n 0.0v 729.495n 0.0v 729.505n 0.0v 739.495n 0.0v 739.505n 0.0v 749.495n 0.0v 749.505n 0.0v 759.495n 0.0v 759.505n 0.0v 769.495n 0.0v 769.505n 0.0v 779.495n 0.0v 779.505n 0.0v 789.495n 0.0v 789.505n 1.8v 799.495n 1.8v 799.505n 1.8v 809.495n 1.8v 809.505n 0.0v 819.495n 0.0v 819.505n 1.8v 829.495n 1.8v 829.505n 0.0v 839.495n 0.0v 839.505n 1.8v 849.495n 1.8v 849.505n 1.8v 859.495n 1.8v 859.505n 0.0v 869.495n 0.0v 869.505n 0.0v 879.495n 0.0v 879.505n 1.8v 889.495n 1.8v 889.505n 0.0v 899.495n 0.0v 899.505n 0.0v 909.495n 0.0v 909.505n 0.0v 919.495n 0.0v 919.505n 1.8v 929.495n 1.8v 929.505n 0.0v 939.495n 0.0v 939.505n 0.0v 949.495n 0.0v 949.505n 1.8v 959.495n 1.8v 959.505n 1.8v 969.495n 1.8v 969.505n 1.8v 979.495n 1.8v 979.505n 0.0v 989.495n 0.0v 989.505n 1.8v 999.495n 1.8v 999.505n 1.8v 1009.495n 1.8v 1009.505n 1.8v 1019.495n 1.8v 1019.505n 1.8v 1029.495n 1.8v 1029.505n 1.8v 1039.495n 1.8v 1039.505n 1.8v 1049.495n 1.8v 1049.505n 1.8v 1059.495n 1.8v 1059.505n 1.8v 1069.495n 1.8v 1069.505n 1.8v 1079.495n 1.8v 1079.505n 0.0v 1089.495n 0.0v 1089.505n 0.0v 1099.495n 0.0v 1099.505n 0.0v 1109.495n 0.0v 1109.505n 0.0v 1119.495n 0.0v 1119.505n 0.0v 1129.495n 0.0v 1129.505n 1.8v 1139.495n 1.8v 1139.505n 1.8v 1149.495n 1.8v 1149.505n 1.8v 1159.495n 1.8v 1159.505n 1.8v 1169.495n 1.8v 1169.505n 0.0v 1179.495n 0.0v 1179.505n 1.8v 1189.495n 1.8v 1189.505n 1.8v 1199.495n 1.8v 1199.505n 0.0v 1209.495n 0.0v 1209.505n 1.8v 1219.495n 1.8v 1219.505n 0.0v 1229.495n 0.0v 1229.505n 0.0v 1239.495n 0.0v 1239.505n 0.0v 1249.495n 0.0v 1249.505n 0.0v 1259.495n 0.0v 1259.505n 0.0v 1269.495n 0.0v 1269.505n 0.0v 1279.495n 0.0v 1279.505n 0.0v 1289.495n 0.0v 1289.505n 0.0v 1299.495n 0.0v 1299.505n 0.0v 1309.495n 0.0v 1309.505n 0.0v 1319.495n 0.0v 1319.505n 0.0v 1329.495n 0.0v 1329.505n 1.8v 1339.495n 1.8v 1339.505n 1.8v 1349.495n 1.8v 1349.505n 0.0v 1359.495n 0.0v 1359.505n 1.8v 1369.495n 1.8v 1369.505n 0.0v 1379.495n 0.0v 1379.505n 0.0v 1389.495n 0.0v 1389.505n 0.0v 1399.495n 0.0v 1399.505n 0.0v 1409.495n 0.0v 1409.505n 1.8v 1419.495n 1.8v 1419.505n 1.8v 1429.495n 1.8v 1429.505n 0.0v 1439.495n 0.0v 1439.505n 0.0v 1449.495n 0.0v 1449.505n 1.8v 1459.495n 1.8v 1459.505n 1.8v 1469.495n 1.8v 1469.505n 1.8v 1479.495n 1.8v 1479.505n 0.0v 1489.495n 0.0v 1489.505n 0.0v 1499.495n 0.0v 1499.505n 1.8v 1509.495n 1.8v 1509.505n 0.0v 1519.495n 0.0v 1519.505n 0.0v 1529.495n 0.0v 1529.505n 0.0v 1539.495n 0.0v 1539.505n 0.0v 1549.495n 0.0v 1549.505n 0.0v 1559.495n 0.0v 1559.505n 1.8v 1569.495n 1.8v 1569.505n 1.8v 1579.495n 1.8v 1579.505n 1.8v 1589.495n 1.8v 1589.505n 0.0v 1599.495n 0.0v 1599.505n 0.0v 1609.495n 0.0v 1609.505n 0.0v 1619.495n 0.0v 1619.505n 0.0v 1629.495n 0.0v 1629.505n 0.0v 1639.495n 0.0v 1639.505n 0.0v 1649.495n 0.0v 1649.505n 0.0v 1659.495n 0.0v 1659.505n 0.0v 1669.495n 0.0v 1669.505n 0.0v 1679.495n 0.0v 1679.505n 1.8v 1689.495n 1.8v 1689.505n 1.8v 1699.495n 1.8v 1699.505n 1.8v 1709.495n 1.8v 1709.505n 1.8v 1719.495n 1.8v 1719.505n 0.0v 1729.495n 0.0v 1729.505n 1.8v 1739.495n 1.8v 1739.505n 0.0v 1749.495n 0.0v 1749.505n 0.0v 1759.495n 0.0v 1759.505n 1.8v 1769.495n 1.8v 1769.505n 1.8v 1779.495n 1.8v 1779.505n 1.8v 1789.495n 1.8v 1789.505n 0.0v 1799.495n 0.0v 1799.505n 0.0v 1809.495n 0.0v 1809.505n 0.0v 1819.495n 0.0v 1819.505n 1.8v 1829.495n 1.8v 1829.505n 0.0v 1839.495n 0.0v 1839.505n 0.0v 1849.495n 0.0v 1849.505n 1.8v 1859.495n 1.8v 1859.505n 1.8v 1869.495n 1.8v 1869.505n 0.0v 1879.495n 0.0v 1879.505n 0.0v 1889.495n 0.0v 1889.505n 0.0v 1899.495n 0.0v 1899.505n 0.0v 1909.495n 0.0v 1909.505n 1.8v 1919.495n 1.8v 1919.505n 0.0v 1929.495n 0.0v 1929.505n 0.0v 1939.495n 0.0v 1939.505n 0.0v 1949.495n 0.0v 1949.505n 1.8v 1959.495n 1.8v 1959.505n 0.0v 1969.495n 0.0v 1969.505n 1.8v 1979.495n 1.8v 1979.505n 1.8v 1989.495n 1.8v 1989.505n 1.8v 1999.495n 1.8v 1999.505n 1.8v 2009.495n 1.8v 2009.505n 0.0v 2019.495n 0.0v 2019.505n 1.8v 2029.495n 1.8v 2029.505n 1.8v 2039.495n 1.8v 2039.505n 1.8v 2049.495n 1.8v 2049.505n 1.8v )
* (time, data): [(0, 0), (10, 0), (20, 0), (30, 0), (40, 0), (50, 0), (60, 0), (70, 0), (80, 0), (90, 0), (100, 1), (110, 1), (120, 1), (130, 1), (140, 1), (150, 1), (160, 1), (170, 1), (180, 0), (190, 0), (200, 0), (210, 0), (220, 0), (230, 1), (240, 0), (250, 1), (260, 1), (270, 0), (280, 0), (290, 1), (300, 0), (310, 0), (320, 0), (330, 0), (340, 0), (350, 0), (360, 0), (370, 0), (380, 0), (390, 1), (400, 0), (410, 0), (420, 0), (430, 1), (440, 1), (450, 1), (460, 0), (470, 0), (480, 0), (490, 0), (500, 1), (510, 1), (520, 0), (530, 0), (540, 1), (550, 1), (560, 0), (570, 0), (580, 0), (590, 0), (600, 1), (610, 1), (620, 1), (630, 1), (640, 1), (650, 1), (660, 0), (670, 0), (680, 0), (690, 1), (700, 1), (710, 1), (720, 1), (730, 0), (740, 1), (750, 0), (760, 0), (770, 1), (780, 1), (790, 1), (800, 1), (810, 1), (820, 0), (830, 0), (840, 1), (850, 1), (860, 1), (870, 1), (880, 1), (890, 0), (900, 0), (910, 0), (920, 0), (930, 0), (940, 0), (950, 0), (960, 0), (970, 0), (980, 0), (990, 0), (1000, 0), (1010, 0), (1020, 0), (1030, 1), (1040, 1), (1050, 1), (1060, 1), (1070, 0), (1080, 0), (1090, 0), (1100, 0), (1110, 0), (1120, 0), (1130, 0), (1140, 0), (1150, 0), (1160, 0), (1170, 0), (1180, 0), (1190, 0), (1200, 1), (1210, 0), (1220, 0), (1230, 0), (1240, 1), (1250, 1), (1260, 1), (1270, 1), (1280, 1), (1290, 1), (1300, 0), (1310, 1), (1320, 1), (1330, 0), (1340, 0), (1350, 1), (1360, 1), (1370, 1), (1380, 0), (1390, 0), (1400, 0), (1410, 1), (1420, 0), (1430, 0), (1440, 0), (1450, 0), (1460, 0), (1470, 1), (1480, 0), (1490, 0), (1500, 0), (1510, 0), (1520, 0), (1530, 0), (1540, 1), (1550, 1), (1560, 1), (1570, 1), (1580, 1), (1590, 0), (1600, 0), (1610, 0), (1620, 0), (1630, 1), (1640, 1), (1650, 1), (1660, 1), (1670, 1), (1680, 1), (1690, 1), (1700, 1), (1710, 1), (1720, 1), (1730, 1), (1740, 0), (1750, 0), (1760, 0), (1770, 1), (1780, 1), (1790, 1), (1800, 0), (1810, 1), (1820, 1), (1830, 1), (1840, 0), (1850, 0), (1860, 0), (1870, 0), (1880, 1), (1890, 1), (1900, 0), (1910, 0), (1920, 0), (1930, 0), (1940, 0), (1950, 0), (1960, 0), (1970, 1), (1980, 0), (1990, 1), (2000, 1), (2010, 1), (2020, 1), (2030, 1), (2040, 1), (2050, 1)]
Va1_0  a1_0  0 PWL (0n 0.0v 9.495n 0.0v 9.505n 0.0v 19.495n 0.0v 19.505n 0.0v 29.495n 0.0v 29.505n 0.0v 39.495n 0.0v 39.505n 0.0v 49.495n 0.0v 49.505n 0.0v 59.495n 0.0v 59.505n 0.0v 69.495n 0.0v 69.505n 0.0v 79.495n 0.0v 79.505n 0.0v 89.495n 0.0v 89.505n 0.0v 99.495n 0.0v 99.505n 1.8v 109.495n 1.8v 109.505n 1.8v 119.495n 1.8v 119.505n 1.8v 129.495n 1.8v 129.505n 1.8v 139.495n 1.8v 139.505n 1.8v 149.495n 1.8v 149.505n 1.8v 159.495n 1.8v 159.505n 1.8v 169.495n 1.8v 169.505n 1.8v 179.495n 1.8v 179.505n 0.0v 189.495n 0.0v 189.505n 0.0v 199.495n 0.0v 199.505n 0.0v 209.495n 0.0v 209.505n 0.0v 219.495n 0.0v 219.505n 0.0v 229.495n 0.0v 229.505n 1.8v 239.495n 1.8v 239.505n 0.0v 249.495n 0.0v 249.505n 1.8v 259.495n 1.8v 259.505n 1.8v 269.495n 1.8v 269.505n 0.0v 279.495n 0.0v 279.505n 0.0v 289.495n 0.0v 289.505n 1.8v 299.495n 1.8v 299.505n 0.0v 309.495n 0.0v 309.505n 0.0v 319.495n 0.0v 319.505n 0.0v 329.495n 0.0v 329.505n 0.0v 339.495n 0.0v 339.505n 0.0v 349.495n 0.0v 349.505n 0.0v 359.495n 0.0v 359.505n 0.0v 369.495n 0.0v 369.505n 0.0v 379.495n 0.0v 379.505n 0.0v 389.495n 0.0v 389.505n 1.8v 399.495n 1.8v 399.505n 0.0v 409.495n 0.0v 409.505n 0.0v 419.495n 0.0v 419.505n 0.0v 429.495n 0.0v 429.505n 1.8v 439.495n 1.8v 439.505n 1.8v 449.495n 1.8v 449.505n 1.8v 459.495n 1.8v 459.505n 0.0v 469.495n 0.0v 469.505n 0.0v 479.495n 0.0v 479.505n 0.0v 489.495n 0.0v 489.505n 0.0v 499.495n 0.0v 499.505n 1.8v 509.495n 1.8v 509.505n 1.8v 519.495n 1.8v 519.505n 0.0v 529.495n 0.0v 529.505n 0.0v 539.495n 0.0v 539.505n 1.8v 549.495n 1.8v 549.505n 1.8v 559.495n 1.8v 559.505n 0.0v 569.495n 0.0v 569.505n 0.0v 579.495n 0.0v 579.505n 0.0v 589.495n 0.0v 589.505n 0.0v 599.495n 0.0v 599.505n 1.8v 609.495n 1.8v 609.505n 1.8v 619.495n 1.8v 619.505n 1.8v 629.495n 1.8v 629.505n 1.8v 639.495n 1.8v 639.505n 1.8v 649.495n 1.8v 649.505n 1.8v 659.495n 1.8v 659.505n 0.0v 669.495n 0.0v 669.505n 0.0v 679.495n 0.0v 679.505n 0.0v 689.495n 0.0v 689.505n 1.8v 699.495n 1.8v 699.505n 1.8v 709.495n 1.8v 709.505n 1.8v 719.495n 1.8v 719.505n 1.8v 729.495n 1.8v 729.505n 0.0v 739.495n 0.0v 739.505n 1.8v 749.495n 1.8v 749.505n 0.0v 759.495n 0.0v 759.505n 0.0v 769.495n 0.0v 769.505n 1.8v 779.495n 1.8v 779.505n 1.8v 789.495n 1.8v 789.505n 1.8v 799.495n 1.8v 799.505n 1.8v 809.495n 1.8v 809.505n 1.8v 819.495n 1.8v 819.505n 0.0v 829.495n 0.0v 829.505n 0.0v 839.495n 0.0v 839.505n 1.8v 849.495n 1.8v 849.505n 1.8v 859.495n 1.8v 859.505n 1.8v 869.495n 1.8v 869.505n 1.8v 879.495n 1.8v 879.505n 1.8v 889.495n 1.8v 889.505n 0.0v 899.495n 0.0v 899.505n 0.0v 909.495n 0.0v 909.505n 0.0v 919.495n 0.0v 919.505n 0.0v 929.495n 0.0v 929.505n 0.0v 939.495n 0.0v 939.505n 0.0v 949.495n 0.0v 949.505n 0.0v 959.495n 0.0v 959.505n 0.0v 969.495n 0.0v 969.505n 0.0v 979.495n 0.0v 979.505n 0.0v 989.495n 0.0v 989.505n 0.0v 999.495n 0.0v 999.505n 0.0v 1009.495n 0.0v 1009.505n 0.0v 1019.495n 0.0v 1019.505n 0.0v 1029.495n 0.0v 1029.505n 1.8v 1039.495n 1.8v 1039.505n 1.8v 1049.495n 1.8v 1049.505n 1.8v 1059.495n 1.8v 1059.505n 1.8v 1069.495n 1.8v 1069.505n 0.0v 1079.495n 0.0v 1079.505n 0.0v 1089.495n 0.0v 1089.505n 0.0v 1099.495n 0.0v 1099.505n 0.0v 1109.495n 0.0v 1109.505n 0.0v 1119.495n 0.0v 1119.505n 0.0v 1129.495n 0.0v 1129.505n 0.0v 1139.495n 0.0v 1139.505n 0.0v 1149.495n 0.0v 1149.505n 0.0v 1159.495n 0.0v 1159.505n 0.0v 1169.495n 0.0v 1169.505n 0.0v 1179.495n 0.0v 1179.505n 0.0v 1189.495n 0.0v 1189.505n 0.0v 1199.495n 0.0v 1199.505n 1.8v 1209.495n 1.8v 1209.505n 0.0v 1219.495n 0.0v 1219.505n 0.0v 1229.495n 0.0v 1229.505n 0.0v 1239.495n 0.0v 1239.505n 1.8v 1249.495n 1.8v 1249.505n 1.8v 1259.495n 1.8v 1259.505n 1.8v 1269.495n 1.8v 1269.505n 1.8v 1279.495n 1.8v 1279.505n 1.8v 1289.495n 1.8v 1289.505n 1.8v 1299.495n 1.8v 1299.505n 0.0v 1309.495n 0.0v 1309.505n 1.8v 1319.495n 1.8v 1319.505n 1.8v 1329.495n 1.8v 1329.505n 0.0v 1339.495n 0.0v 1339.505n 0.0v 1349.495n 0.0v 1349.505n 1.8v 1359.495n 1.8v 1359.505n 1.8v 1369.495n 1.8v 1369.505n 1.8v 1379.495n 1.8v 1379.505n 0.0v 1389.495n 0.0v 1389.505n 0.0v 1399.495n 0.0v 1399.505n 0.0v 1409.495n 0.0v 1409.505n 1.8v 1419.495n 1.8v 1419.505n 0.0v 1429.495n 0.0v 1429.505n 0.0v 1439.495n 0.0v 1439.505n 0.0v 1449.495n 0.0v 1449.505n 0.0v 1459.495n 0.0v 1459.505n 0.0v 1469.495n 0.0v 1469.505n 1.8v 1479.495n 1.8v 1479.505n 0.0v 1489.495n 0.0v 1489.505n 0.0v 1499.495n 0.0v 1499.505n 0.0v 1509.495n 0.0v 1509.505n 0.0v 1519.495n 0.0v 1519.505n 0.0v 1529.495n 0.0v 1529.505n 0.0v 1539.495n 0.0v 1539.505n 1.8v 1549.495n 1.8v 1549.505n 1.8v 1559.495n 1.8v 1559.505n 1.8v 1569.495n 1.8v 1569.505n 1.8v 1579.495n 1.8v 1579.505n 1.8v 1589.495n 1.8v 1589.505n 0.0v 1599.495n 0.0v 1599.505n 0.0v 1609.495n 0.0v 1609.505n 0.0v 1619.495n 0.0v 1619.505n 0.0v 1629.495n 0.0v 1629.505n 1.8v 1639.495n 1.8v 1639.505n 1.8v 1649.495n 1.8v 1649.505n 1.8v 1659.495n 1.8v 1659.505n 1.8v 1669.495n 1.8v 1669.505n 1.8v 1679.495n 1.8v 1679.505n 1.8v 1689.495n 1.8v 1689.505n 1.8v 1699.495n 1.8v 1699.505n 1.8v 1709.495n 1.8v 1709.505n 1.8v 1719.495n 1.8v 1719.505n 1.8v 1729.495n 1.8v 1729.505n 1.8v 1739.495n 1.8v 1739.505n 0.0v 1749.495n 0.0v 1749.505n 0.0v 1759.495n 0.0v 1759.505n 0.0v 1769.495n 0.0v 1769.505n 1.8v 1779.495n 1.8v 1779.505n 1.8v 1789.495n 1.8v 1789.505n 1.8v 1799.495n 1.8v 1799.505n 0.0v 1809.495n 0.0v 1809.505n 1.8v 1819.495n 1.8v 1819.505n 1.8v 1829.495n 1.8v 1829.505n 1.8v 1839.495n 1.8v 1839.505n 0.0v 1849.495n 0.0v 1849.505n 0.0v 1859.495n 0.0v 1859.505n 0.0v 1869.495n 0.0v 1869.505n 0.0v 1879.495n 0.0v 1879.505n 1.8v 1889.495n 1.8v 1889.505n 1.8v 1899.495n 1.8v 1899.505n 0.0v 1909.495n 0.0v 1909.505n 0.0v 1919.495n 0.0v 1919.505n 0.0v 1929.495n 0.0v 1929.505n 0.0v 1939.495n 0.0v 1939.505n 0.0v 1949.495n 0.0v 1949.505n 0.0v 1959.495n 0.0v 1959.505n 0.0v 1969.495n 0.0v 1969.505n 1.8v 1979.495n 1.8v 1979.505n 0.0v 1989.495n 0.0v 1989.505n 1.8v 1999.495n 1.8v 1999.505n 1.8v 2009.495n 1.8v 2009.505n 1.8v 2019.495n 1.8v 2019.505n 1.8v 2029.495n 1.8v 2029.505n 1.8v 2039.495n 1.8v 2039.505n 1.8v 2049.495n 1.8v 2049.505n 1.8v )
* (time, data): [(0, 0), (10, 0), (20, 0), (30, 0), (40, 1), (50, 1), (60, 1), (70, 1), (80, 1), (90, 1), (100, 0), (110, 0), (120, 0), (130, 0), (140, 0), (150, 0), (160, 0), (170, 0), (180, 0), (190, 1), (200, 1), (210, 1), (220, 1), (230, 0), (240, 0), (250, 0), (260, 0), (270, 0), (280, 0), (290, 0), (300, 0), (310, 1), (320, 1), (330, 1), (340, 1), (350, 1), (360, 1), (370, 0), (380, 0), (390, 0), (400, 1), (410, 1), (420, 1), (430, 0), (440, 0), (450, 0), (460, 1), (470, 1), (480, 1), (490, 1), (500, 0), (510, 0), (520, 1), (530, 1), (540, 0), (550, 0), (560, 0), (570, 0), (580, 1), (590, 0), (600, 0), (610, 0), (620, 0), (630, 0), (640, 0), (650, 0), (660, 0), (670, 0), (680, 1), (690, 0), (700, 0), (710, 0), (720, 0), (730, 0), (740, 0), (750, 0), (760, 1), (770, 0), (780, 0), (790, 0), (800, 0), (810, 0), (820, 0), (830, 1), (840, 0), (850, 0), (860, 0), (870, 0), (880, 0), (890, 0), (900, 0), (910, 0), (920, 0), (930, 0), (940, 0), (950, 1), (960, 1), (970, 1), (980, 1), (990, 1), (1000, 1), (1010, 0), (1020, 0), (1030, 0), (1040, 0), (1050, 0), (1060, 0), (1070, 0), (1080, 0), (1090, 0), (1100, 0), (1110, 1), (1120, 1), (1130, 1), (1140, 1), (1150, 1), (1160, 1), (1170, 1), (1180, 1), (1190, 1), (1200, 0), (1210, 0), (1220, 1), (1230, 1), (1240, 0), (1250, 0), (1260, 0), (1270, 0), (1280, 0), (1290, 0), (1300, 1), (1310, 0), (1320, 0), (1330, 1), (1340, 1), (1350, 0), (1360, 0), (1370, 0), (1380, 0), (1390, 0), (1400, 0), (1410, 0), (1420, 1), (1430, 1), (1440, 1), (1450, 1), (1460, 1), (1470, 0), (1480, 1), (1490, 1), (1500, 1), (1510, 1), (1520, 1), (1530, 1), (1540, 0), (1550, 0), (1560, 0), (1570, 0), (1580, 0), (1590, 1), (1600, 1), (1610, 0), (1620, 1), (1630, 0), (1640, 0), (1650, 0), (1660, 0), (1670, 0), (1680, 0), (1690, 0), (1700, 0), (1710, 0), (1720, 0), (1730, 0), (1740, 1), (1750, 1), (1760, 1), (1770, 0), (1780, 0), (1790, 0), (1800, 1), (1810, 0), (1820, 0), (1830, 0), (1840, 0), (1850, 1), (1860, 1), (1870, 1), (1880, 0), (1890, 0), (1900, 1), (1910, 1), (1920, 1), (1930, 1), (1940, 1), (1950, 1), (1960, 1), (1970, 0), (1980, 0), (1990, 0), (2000, 0), (2010, 0), (2020, 0), (2030, 0), (2040, 0), (2050, 0)]
Va1_1  a1_1  0 PWL (0n 0.0v 9.495n 0.0v 9.505n 0.0v 19.495n 0.0v 19.505n 0.0v 29.495n 0.0v 29.505n 0.0v 39.495n 0.0v 39.505n 1.8v 49.495n 1.8v 49.505n 1.8v 59.495n 1.8v 59.505n 1.8v 69.495n 1.8v 69.505n 1.8v 79.495n 1.8v 79.505n 1.8v 89.495n 1.8v 89.505n 1.8v 99.495n 1.8v 99.505n 0.0v 109.495n 0.0v 109.505n 0.0v 119.495n 0.0v 119.505n 0.0v 129.495n 0.0v 129.505n 0.0v 139.495n 0.0v 139.505n 0.0v 149.495n 0.0v 149.505n 0.0v 159.495n 0.0v 159.505n 0.0v 169.495n 0.0v 169.505n 0.0v 179.495n 0.0v 179.505n 0.0v 189.495n 0.0v 189.505n 1.8v 199.495n 1.8v 199.505n 1.8v 209.495n 1.8v 209.505n 1.8v 219.495n 1.8v 219.505n 1.8v 229.495n 1.8v 229.505n 0.0v 239.495n 0.0v 239.505n 0.0v 249.495n 0.0v 249.505n 0.0v 259.495n 0.0v 259.505n 0.0v 269.495n 0.0v 269.505n 0.0v 279.495n 0.0v 279.505n 0.0v 289.495n 0.0v 289.505n 0.0v 299.495n 0.0v 299.505n 0.0v 309.495n 0.0v 309.505n 1.8v 319.495n 1.8v 319.505n 1.8v 329.495n 1.8v 329.505n 1.8v 339.495n 1.8v 339.505n 1.8v 349.495n 1.8v 349.505n 1.8v 359.495n 1.8v 359.505n 1.8v 369.495n 1.8v 369.505n 0.0v 379.495n 0.0v 379.505n 0.0v 389.495n 0.0v 389.505n 0.0v 399.495n 0.0v 399.505n 1.8v 409.495n 1.8v 409.505n 1.8v 419.495n 1.8v 419.505n 1.8v 429.495n 1.8v 429.505n 0.0v 439.495n 0.0v 439.505n 0.0v 449.495n 0.0v 449.505n 0.0v 459.495n 0.0v 459.505n 1.8v 469.495n 1.8v 469.505n 1.8v 479.495n 1.8v 479.505n 1.8v 489.495n 1.8v 489.505n 1.8v 499.495n 1.8v 499.505n 0.0v 509.495n 0.0v 509.505n 0.0v 519.495n 0.0v 519.505n 1.8v 529.495n 1.8v 529.505n 1.8v 539.495n 1.8v 539.505n 0.0v 549.495n 0.0v 549.505n 0.0v 559.495n 0.0v 559.505n 0.0v 569.495n 0.0v 569.505n 0.0v 579.495n 0.0v 579.505n 1.8v 589.495n 1.8v 589.505n 0.0v 599.495n 0.0v 599.505n 0.0v 609.495n 0.0v 609.505n 0.0v 619.495n 0.0v 619.505n 0.0v 629.495n 0.0v 629.505n 0.0v 639.495n 0.0v 639.505n 0.0v 649.495n 0.0v 649.505n 0.0v 659.495n 0.0v 659.505n 0.0v 669.495n 0.0v 669.505n 0.0v 679.495n 0.0v 679.505n 1.8v 689.495n 1.8v 689.505n 0.0v 699.495n 0.0v 699.505n 0.0v 709.495n 0.0v 709.505n 0.0v 719.495n 0.0v 719.505n 0.0v 729.495n 0.0v 729.505n 0.0v 739.495n 0.0v 739.505n 0.0v 749.495n 0.0v 749.505n 0.0v 759.495n 0.0v 759.505n 1.8v 769.495n 1.8v 769.505n 0.0v 779.495n 0.0v 779.505n 0.0v 789.495n 0.0v 789.505n 0.0v 799.495n 0.0v 799.505n 0.0v 809.495n 0.0v 809.505n 0.0v 819.495n 0.0v 819.505n 0.0v 829.495n 0.0v 829.505n 1.8v 839.495n 1.8v 839.505n 0.0v 849.495n 0.0v 849.505n 0.0v 859.495n 0.0v 859.505n 0.0v 869.495n 0.0v 869.505n 0.0v 879.495n 0.0v 879.505n 0.0v 889.495n 0.0v 889.505n 0.0v 899.495n 0.0v 899.505n 0.0v 909.495n 0.0v 909.505n 0.0v 919.495n 0.0v 919.505n 0.0v 929.495n 0.0v 929.505n 0.0v 939.495n 0.0v 939.505n 0.0v 949.495n 0.0v 949.505n 1.8v 959.495n 1.8v 959.505n 1.8v 969.495n 1.8v 969.505n 1.8v 979.495n 1.8v 979.505n 1.8v 989.495n 1.8v 989.505n 1.8v 999.495n 1.8v 999.505n 1.8v 1009.495n 1.8v 1009.505n 0.0v 1019.495n 0.0v 1019.505n 0.0v 1029.495n 0.0v 1029.505n 0.0v 1039.495n 0.0v 1039.505n 0.0v 1049.495n 0.0v 1049.505n 0.0v 1059.495n 0.0v 1059.505n 0.0v 1069.495n 0.0v 1069.505n 0.0v 1079.495n 0.0v 1079.505n 0.0v 1089.495n 0.0v 1089.505n 0.0v 1099.495n 0.0v 1099.505n 0.0v 1109.495n 0.0v 1109.505n 1.8v 1119.495n 1.8v 1119.505n 1.8v 1129.495n 1.8v 1129.505n 1.8v 1139.495n 1.8v 1139.505n 1.8v 1149.495n 1.8v 1149.505n 1.8v 1159.495n 1.8v 1159.505n 1.8v 1169.495n 1.8v 1169.505n 1.8v 1179.495n 1.8v 1179.505n 1.8v 1189.495n 1.8v 1189.505n 1.8v 1199.495n 1.8v 1199.505n 0.0v 1209.495n 0.0v 1209.505n 0.0v 1219.495n 0.0v 1219.505n 1.8v 1229.495n 1.8v 1229.505n 1.8v 1239.495n 1.8v 1239.505n 0.0v 1249.495n 0.0v 1249.505n 0.0v 1259.495n 0.0v 1259.505n 0.0v 1269.495n 0.0v 1269.505n 0.0v 1279.495n 0.0v 1279.505n 0.0v 1289.495n 0.0v 1289.505n 0.0v 1299.495n 0.0v 1299.505n 1.8v 1309.495n 1.8v 1309.505n 0.0v 1319.495n 0.0v 1319.505n 0.0v 1329.495n 0.0v 1329.505n 1.8v 1339.495n 1.8v 1339.505n 1.8v 1349.495n 1.8v 1349.505n 0.0v 1359.495n 0.0v 1359.505n 0.0v 1369.495n 0.0v 1369.505n 0.0v 1379.495n 0.0v 1379.505n 0.0v 1389.495n 0.0v 1389.505n 0.0v 1399.495n 0.0v 1399.505n 0.0v 1409.495n 0.0v 1409.505n 0.0v 1419.495n 0.0v 1419.505n 1.8v 1429.495n 1.8v 1429.505n 1.8v 1439.495n 1.8v 1439.505n 1.8v 1449.495n 1.8v 1449.505n 1.8v 1459.495n 1.8v 1459.505n 1.8v 1469.495n 1.8v 1469.505n 0.0v 1479.495n 0.0v 1479.505n 1.8v 1489.495n 1.8v 1489.505n 1.8v 1499.495n 1.8v 1499.505n 1.8v 1509.495n 1.8v 1509.505n 1.8v 1519.495n 1.8v 1519.505n 1.8v 1529.495n 1.8v 1529.505n 1.8v 1539.495n 1.8v 1539.505n 0.0v 1549.495n 0.0v 1549.505n 0.0v 1559.495n 0.0v 1559.505n 0.0v 1569.495n 0.0v 1569.505n 0.0v 1579.495n 0.0v 1579.505n 0.0v 1589.495n 0.0v 1589.505n 1.8v 1599.495n 1.8v 1599.505n 1.8v 1609.495n 1.8v 1609.505n 0.0v 1619.495n 0.0v 1619.505n 1.8v 1629.495n 1.8v 1629.505n 0.0v 1639.495n 0.0v 1639.505n 0.0v 1649.495n 0.0v 1649.505n 0.0v 1659.495n 0.0v 1659.505n 0.0v 1669.495n 0.0v 1669.505n 0.0v 1679.495n 0.0v 1679.505n 0.0v 1689.495n 0.0v 1689.505n 0.0v 1699.495n 0.0v 1699.505n 0.0v 1709.495n 0.0v 1709.505n 0.0v 1719.495n 0.0v 1719.505n 0.0v 1729.495n 0.0v 1729.505n 0.0v 1739.495n 0.0v 1739.505n 1.8v 1749.495n 1.8v 1749.505n 1.8v 1759.495n 1.8v 1759.505n 1.8v 1769.495n 1.8v 1769.505n 0.0v 1779.495n 0.0v 1779.505n 0.0v 1789.495n 0.0v 1789.505n 0.0v 1799.495n 0.0v 1799.505n 1.8v 1809.495n 1.8v 1809.505n 0.0v 1819.495n 0.0v 1819.505n 0.0v 1829.495n 0.0v 1829.505n 0.0v 1839.495n 0.0v 1839.505n 0.0v 1849.495n 0.0v 1849.505n 1.8v 1859.495n 1.8v 1859.505n 1.8v 1869.495n 1.8v 1869.505n 1.8v 1879.495n 1.8v 1879.505n 0.0v 1889.495n 0.0v 1889.505n 0.0v 1899.495n 0.0v 1899.505n 1.8v 1909.495n 1.8v 1909.505n 1.8v 1919.495n 1.8v 1919.505n 1.8v 1929.495n 1.8v 1929.505n 1.8v 1939.495n 1.8v 1939.505n 1.8v 1949.495n 1.8v 1949.505n 1.8v 1959.495n 1.8v 1959.505n 1.8v 1969.495n 1.8v 1969.505n 0.0v 1979.495n 0.0v 1979.505n 0.0v 1989.495n 0.0v 1989.505n 0.0v 1999.495n 0.0v 1999.505n 0.0v 2009.495n 0.0v 2009.505n 0.0v 2019.495n 0.0v 2019.505n 0.0v 2029.495n 0.0v 2029.505n 0.0v 2039.495n 0.0v 2039.505n 0.0v 2049.495n 0.0v 2049.505n 0.0v )
* (time, data): [(0, 0), (10, 0), (20, 0), (30, 0), (40, 1), (50, 1), (60, 1), (70, 1), (80, 1), (90, 1), (100, 0), (110, 0), (120, 0), (130, 0), (140, 0), (150, 0), (160, 0), (170, 0), (180, 0), (190, 1), (200, 1), (210, 1), (220, 1), (230, 0), (240, 0), (250, 0), (260, 0), (270, 0), (280, 0), (290, 0), (300, 0), (310, 1), (320, 1), (330, 1), (340, 1), (350, 1), (360, 1), (370, 0), (380, 0), (390, 1), (400, 1), (410, 1), (420, 1), (430, 0), (440, 1), (450, 1), (460, 1), (470, 1), (480, 1), (490, 1), (500, 0), (510, 0), (520, 1), (530, 1), (540, 0), (550, 0), (560, 0), (570, 0), (580, 1), (590, 0), (600, 1), (610, 1), (620, 1), (630, 1), (640, 1), (650, 1), (660, 0), (670, 0), (680, 1), (690, 1), (700, 0), (710, 1), (720, 1), (730, 0), (740, 0), (750, 0), (760, 1), (770, 1), (780, 1), (790, 1), (800, 1), (810, 1), (820, 0), (830, 1), (840, 1), (850, 1), (860, 1), (870, 1), (880, 1), (890, 0), (900, 0), (910, 0), (920, 0), (930, 0), (940, 0), (950, 1), (960, 1), (970, 1), (980, 1), (990, 1), (1000, 1), (1010, 0), (1020, 0), (1030, 1), (1040, 1), (1050, 1), (1060, 1), (1070, 0), (1080, 0), (1090, 0), (1100, 0), (1110, 1), (1120, 1), (1130, 1), (1140, 1), (1150, 1), (1160, 1), (1170, 1), (1180, 1), (1190, 1), (1200, 1), (1210, 0), (1220, 1), (1230, 1), (1240, 1), (1250, 1), (1260, 1), (1270, 1), (1280, 1), (1290, 1), (1300, 1), (1310, 0), (1320, 0), (1330, 1), (1340, 1), (1350, 1), (1360, 0), (1370, 0), (1380, 0), (1390, 0), (1400, 0), (1410, 1), (1420, 1), (1430, 1), (1440, 1), (1450, 1), (1460, 1), (1470, 1), (1480, 1), (1490, 1), (1500, 1), (1510, 1), (1520, 1), (1530, 1), (1540, 0), (1550, 1), (1560, 1), (1570, 1), (1580, 1), (1590, 1), (1600, 1), (1610, 0), (1620, 1), (1630, 0), (1640, 0), (1650, 0), (1660, 0), (1670, 0), (1680, 0), (1690, 0), (1700, 0), (1710, 0), (1720, 0), (1730, 1), (1740, 1), (1750, 1), (1760, 1), (1770, 1), (1780, 1), (1790, 1), (1800, 1), (1810, 0), (1820, 0), (1830, 0), (1840, 0), (1850, 1), (1860, 1), (1870, 1), (1880, 1), (1890, 1), (1900, 1), (1910, 1), (1920, 1), (1930, 1), (1940, 1), (1950, 1), (1960, 1), (1970, 0), (1980, 0), (1990, 1), (2000, 1), (2010, 1), (2020, 1), (2030, 1), (2040, 1), (2050, 1)]
Va1_2  a1_2  0 PWL (0n 0.0v 9.495n 0.0v 9.505n 0.0v 19.495n 0.0v 19.505n 0.0v 29.495n 0.0v 29.505n 0.0v 39.495n 0.0v 39.505n 1.8v 49.495n 1.8v 49.505n 1.8v 59.495n 1.8v 59.505n 1.8v 69.495n 1.8v 69.505n 1.8v 79.495n 1.8v 79.505n 1.8v 89.495n 1.8v 89.505n 1.8v 99.495n 1.8v 99.505n 0.0v 109.495n 0.0v 109.505n 0.0v 119.495n 0.0v 119.505n 0.0v 129.495n 0.0v 129.505n 0.0v 139.495n 0.0v 139.505n 0.0v 149.495n 0.0v 149.505n 0.0v 159.495n 0.0v 159.505n 0.0v 169.495n 0.0v 169.505n 0.0v 179.495n 0.0v 179.505n 0.0v 189.495n 0.0v 189.505n 1.8v 199.495n 1.8v 199.505n 1.8v 209.495n 1.8v 209.505n 1.8v 219.495n 1.8v 219.505n 1.8v 229.495n 1.8v 229.505n 0.0v 239.495n 0.0v 239.505n 0.0v 249.495n 0.0v 249.505n 0.0v 259.495n 0.0v 259.505n 0.0v 269.495n 0.0v 269.505n 0.0v 279.495n 0.0v 279.505n 0.0v 289.495n 0.0v 289.505n 0.0v 299.495n 0.0v 299.505n 0.0v 309.495n 0.0v 309.505n 1.8v 319.495n 1.8v 319.505n 1.8v 329.495n 1.8v 329.505n 1.8v 339.495n 1.8v 339.505n 1.8v 349.495n 1.8v 349.505n 1.8v 359.495n 1.8v 359.505n 1.8v 369.495n 1.8v 369.505n 0.0v 379.495n 0.0v 379.505n 0.0v 389.495n 0.0v 389.505n 1.8v 399.495n 1.8v 399.505n 1.8v 409.495n 1.8v 409.505n 1.8v 419.495n 1.8v 419.505n 1.8v 429.495n 1.8v 429.505n 0.0v 439.495n 0.0v 439.505n 1.8v 449.495n 1.8v 449.505n 1.8v 459.495n 1.8v 459.505n 1.8v 469.495n 1.8v 469.505n 1.8v 479.495n 1.8v 479.505n 1.8v 489.495n 1.8v 489.505n 1.8v 499.495n 1.8v 499.505n 0.0v 509.495n 0.0v 509.505n 0.0v 519.495n 0.0v 519.505n 1.8v 529.495n 1.8v 529.505n 1.8v 539.495n 1.8v 539.505n 0.0v 549.495n 0.0v 549.505n 0.0v 559.495n 0.0v 559.505n 0.0v 569.495n 0.0v 569.505n 0.0v 579.495n 0.0v 579.505n 1.8v 589.495n 1.8v 589.505n 0.0v 599.495n 0.0v 599.505n 1.8v 609.495n 1.8v 609.505n 1.8v 619.495n 1.8v 619.505n 1.8v 629.495n 1.8v 629.505n 1.8v 639.495n 1.8v 639.505n 1.8v 649.495n 1.8v 649.505n 1.8v 659.495n 1.8v 659.505n 0.0v 669.495n 0.0v 669.505n 0.0v 679.495n 0.0v 679.505n 1.8v 689.495n 1.8v 689.505n 1.8v 699.495n 1.8v 699.505n 0.0v 709.495n 0.0v 709.505n 1.8v 719.495n 1.8v 719.505n 1.8v 729.495n 1.8v 729.505n 0.0v 739.495n 0.0v 739.505n 0.0v 749.495n 0.0v 749.505n 0.0v 759.495n 0.0v 759.505n 1.8v 769.495n 1.8v 769.505n 1.8v 779.495n 1.8v 779.505n 1.8v 789.495n 1.8v 789.505n 1.8v 799.495n 1.8v 799.505n 1.8v 809.495n 1.8v 809.505n 1.8v 819.495n 1.8v 819.505n 0.0v 829.495n 0.0v 829.505n 1.8v 839.495n 1.8v 839.505n 1.8v 849.495n 1.8v 849.505n 1.8v 859.495n 1.8v 859.505n 1.8v 869.495n 1.8v 869.505n 1.8v 879.495n 1.8v 879.505n 1.8v 889.495n 1.8v 889.505n 0.0v 899.495n 0.0v 899.505n 0.0v 909.495n 0.0v 909.505n 0.0v 919.495n 0.0v 919.505n 0.0v 929.495n 0.0v 929.505n 0.0v 939.495n 0.0v 939.505n 0.0v 949.495n 0.0v 949.505n 1.8v 959.495n 1.8v 959.505n 1.8v 969.495n 1.8v 969.505n 1.8v 979.495n 1.8v 979.505n 1.8v 989.495n 1.8v 989.505n 1.8v 999.495n 1.8v 999.505n 1.8v 1009.495n 1.8v 1009.505n 0.0v 1019.495n 0.0v 1019.505n 0.0v 1029.495n 0.0v 1029.505n 1.8v 1039.495n 1.8v 1039.505n 1.8v 1049.495n 1.8v 1049.505n 1.8v 1059.495n 1.8v 1059.505n 1.8v 1069.495n 1.8v 1069.505n 0.0v 1079.495n 0.0v 1079.505n 0.0v 1089.495n 0.0v 1089.505n 0.0v 1099.495n 0.0v 1099.505n 0.0v 1109.495n 0.0v 1109.505n 1.8v 1119.495n 1.8v 1119.505n 1.8v 1129.495n 1.8v 1129.505n 1.8v 1139.495n 1.8v 1139.505n 1.8v 1149.495n 1.8v 1149.505n 1.8v 1159.495n 1.8v 1159.505n 1.8v 1169.495n 1.8v 1169.505n 1.8v 1179.495n 1.8v 1179.505n 1.8v 1189.495n 1.8v 1189.505n 1.8v 1199.495n 1.8v 1199.505n 1.8v 1209.495n 1.8v 1209.505n 0.0v 1219.495n 0.0v 1219.505n 1.8v 1229.495n 1.8v 1229.505n 1.8v 1239.495n 1.8v 1239.505n 1.8v 1249.495n 1.8v 1249.505n 1.8v 1259.495n 1.8v 1259.505n 1.8v 1269.495n 1.8v 1269.505n 1.8v 1279.495n 1.8v 1279.505n 1.8v 1289.495n 1.8v 1289.505n 1.8v 1299.495n 1.8v 1299.505n 1.8v 1309.495n 1.8v 1309.505n 0.0v 1319.495n 0.0v 1319.505n 0.0v 1329.495n 0.0v 1329.505n 1.8v 1339.495n 1.8v 1339.505n 1.8v 1349.495n 1.8v 1349.505n 1.8v 1359.495n 1.8v 1359.505n 0.0v 1369.495n 0.0v 1369.505n 0.0v 1379.495n 0.0v 1379.505n 0.0v 1389.495n 0.0v 1389.505n 0.0v 1399.495n 0.0v 1399.505n 0.0v 1409.495n 0.0v 1409.505n 1.8v 1419.495n 1.8v 1419.505n 1.8v 1429.495n 1.8v 1429.505n 1.8v 1439.495n 1.8v 1439.505n 1.8v 1449.495n 1.8v 1449.505n 1.8v 1459.495n 1.8v 1459.505n 1.8v 1469.495n 1.8v 1469.505n 1.8v 1479.495n 1.8v 1479.505n 1.8v 1489.495n 1.8v 1489.505n 1.8v 1499.495n 1.8v 1499.505n 1.8v 1509.495n 1.8v 1509.505n 1.8v 1519.495n 1.8v 1519.505n 1.8v 1529.495n 1.8v 1529.505n 1.8v 1539.495n 1.8v 1539.505n 0.0v 1549.495n 0.0v 1549.505n 1.8v 1559.495n 1.8v 1559.505n 1.8v 1569.495n 1.8v 1569.505n 1.8v 1579.495n 1.8v 1579.505n 1.8v 1589.495n 1.8v 1589.505n 1.8v 1599.495n 1.8v 1599.505n 1.8v 1609.495n 1.8v 1609.505n 0.0v 1619.495n 0.0v 1619.505n 1.8v 1629.495n 1.8v 1629.505n 0.0v 1639.495n 0.0v 1639.505n 0.0v 1649.495n 0.0v 1649.505n 0.0v 1659.495n 0.0v 1659.505n 0.0v 1669.495n 0.0v 1669.505n 0.0v 1679.495n 0.0v 1679.505n 0.0v 1689.495n 0.0v 1689.505n 0.0v 1699.495n 0.0v 1699.505n 0.0v 1709.495n 0.0v 1709.505n 0.0v 1719.495n 0.0v 1719.505n 0.0v 1729.495n 0.0v 1729.505n 1.8v 1739.495n 1.8v 1739.505n 1.8v 1749.495n 1.8v 1749.505n 1.8v 1759.495n 1.8v 1759.505n 1.8v 1769.495n 1.8v 1769.505n 1.8v 1779.495n 1.8v 1779.505n 1.8v 1789.495n 1.8v 1789.505n 1.8v 1799.495n 1.8v 1799.505n 1.8v 1809.495n 1.8v 1809.505n 0.0v 1819.495n 0.0v 1819.505n 0.0v 1829.495n 0.0v 1829.505n 0.0v 1839.495n 0.0v 1839.505n 0.0v 1849.495n 0.0v 1849.505n 1.8v 1859.495n 1.8v 1859.505n 1.8v 1869.495n 1.8v 1869.505n 1.8v 1879.495n 1.8v 1879.505n 1.8v 1889.495n 1.8v 1889.505n 1.8v 1899.495n 1.8v 1899.505n 1.8v 1909.495n 1.8v 1909.505n 1.8v 1919.495n 1.8v 1919.505n 1.8v 1929.495n 1.8v 1929.505n 1.8v 1939.495n 1.8v 1939.505n 1.8v 1949.495n 1.8v 1949.505n 1.8v 1959.495n 1.8v 1959.505n 1.8v 1969.495n 1.8v 1969.505n 0.0v 1979.495n 0.0v 1979.505n 0.0v 1989.495n 0.0v 1989.505n 1.8v 1999.495n 1.8v 1999.505n 1.8v 2009.495n 1.8v 2009.505n 1.8v 2019.495n 1.8v 2019.505n 1.8v 2029.495n 1.8v 2029.505n 1.8v 2039.495n 1.8v 2039.505n 1.8v 2049.495n 1.8v 2049.505n 1.8v )
* (time, data): [(0, 0), (10, 0), (20, 0), (30, 0), (40, 1), (50, 1), (60, 1), (70, 1), (80, 1), (90, 1), (100, 0), (110, 0), (120, 0), (130, 0), (140, 0), (150, 0), (160, 0), (170, 0), (180, 0), (190, 1), (200, 1), (210, 1), (220, 1), (230, 0), (240, 0), (250, 0), (260, 0), (270, 0), (280, 0), (290, 0), (300, 0), (310, 1), (320, 1), (330, 1), (340, 1), (350, 1), (360, 1), (370, 0), (380, 0), (390, 1), (400, 1), (410, 1), (420, 1), (430, 0), (440, 1), (450, 1), (460, 1), (470, 1), (480, 1), (490, 1), (500, 0), (510, 0), (520, 1), (530, 1), (540, 0), (550, 0), (560, 0), (570, 0), (580, 1), (590, 0), (600, 1), (610, 1), (620, 1), (630, 1), (640, 1), (650, 1), (660, 0), (670, 0), (680, 1), (690, 1), (700, 0), (710, 1), (720, 1), (730, 0), (740, 0), (750, 0), (760, 1), (770, 1), (780, 1), (790, 1), (800, 1), (810, 1), (820, 0), (830, 1), (840, 1), (850, 1), (860, 1), (870, 1), (880, 1), (890, 0), (900, 0), (910, 0), (920, 0), (930, 0), (940, 0), (950, 1), (960, 1), (970, 1), (980, 1), (990, 1), (1000, 1), (1010, 0), (1020, 0), (1030, 1), (1040, 1), (1050, 1), (1060, 1), (1070, 0), (1080, 0), (1090, 0), (1100, 0), (1110, 1), (1120, 1), (1130, 1), (1140, 1), (1150, 1), (1160, 1), (1170, 1), (1180, 1), (1190, 1), (1200, 1), (1210, 0), (1220, 1), (1230, 1), (1240, 1), (1250, 1), (1260, 1), (1270, 1), (1280, 1), (1290, 1), (1300, 1), (1310, 0), (1320, 0), (1330, 1), (1340, 1), (1350, 1), (1360, 0), (1370, 0), (1380, 0), (1390, 0), (1400, 0), (1410, 1), (1420, 1), (1430, 1), (1440, 1), (1450, 1), (1460, 1), (1470, 1), (1480, 1), (1490, 1), (1500, 1), (1510, 1), (1520, 1), (1530, 1), (1540, 0), (1550, 1), (1560, 1), (1570, 1), (1580, 1), (1590, 1), (1600, 1), (1610, 0), (1620, 1), (1630, 0), (1640, 0), (1650, 0), (1660, 0), (1670, 0), (1680, 0), (1690, 0), (1700, 0), (1710, 0), (1720, 0), (1730, 1), (1740, 1), (1750, 1), (1760, 1), (1770, 1), (1780, 1), (1790, 1), (1800, 1), (1810, 0), (1820, 0), (1830, 0), (1840, 0), (1850, 1), (1860, 1), (1870, 1), (1880, 1), (1890, 1), (1900, 1), (1910, 1), (1920, 1), (1930, 1), (1940, 1), (1950, 1), (1960, 1), (1970, 0), (1980, 0), (1990, 1), (2000, 1), (2010, 1), (2020, 1), (2030, 1), (2040, 1), (2050, 1)]
Va1_3  a1_3  0 PWL (0n 0.0v 9.495n 0.0v 9.505n 0.0v 19.495n 0.0v 19.505n 0.0v 29.495n 0.0v 29.505n 0.0v 39.495n 0.0v 39.505n 1.8v 49.495n 1.8v 49.505n 1.8v 59.495n 1.8v 59.505n 1.8v 69.495n 1.8v 69.505n 1.8v 79.495n 1.8v 79.505n 1.8v 89.495n 1.8v 89.505n 1.8v 99.495n 1.8v 99.505n 0.0v 109.495n 0.0v 109.505n 0.0v 119.495n 0.0v 119.505n 0.0v 129.495n 0.0v 129.505n 0.0v 139.495n 0.0v 139.505n 0.0v 149.495n 0.0v 149.505n 0.0v 159.495n 0.0v 159.505n 0.0v 169.495n 0.0v 169.505n 0.0v 179.495n 0.0v 179.505n 0.0v 189.495n 0.0v 189.505n 1.8v 199.495n 1.8v 199.505n 1.8v 209.495n 1.8v 209.505n 1.8v 219.495n 1.8v 219.505n 1.8v 229.495n 1.8v 229.505n 0.0v 239.495n 0.0v 239.505n 0.0v 249.495n 0.0v 249.505n 0.0v 259.495n 0.0v 259.505n 0.0v 269.495n 0.0v 269.505n 0.0v 279.495n 0.0v 279.505n 0.0v 289.495n 0.0v 289.505n 0.0v 299.495n 0.0v 299.505n 0.0v 309.495n 0.0v 309.505n 1.8v 319.495n 1.8v 319.505n 1.8v 329.495n 1.8v 329.505n 1.8v 339.495n 1.8v 339.505n 1.8v 349.495n 1.8v 349.505n 1.8v 359.495n 1.8v 359.505n 1.8v 369.495n 1.8v 369.505n 0.0v 379.495n 0.0v 379.505n 0.0v 389.495n 0.0v 389.505n 1.8v 399.495n 1.8v 399.505n 1.8v 409.495n 1.8v 409.505n 1.8v 419.495n 1.8v 419.505n 1.8v 429.495n 1.8v 429.505n 0.0v 439.495n 0.0v 439.505n 1.8v 449.495n 1.8v 449.505n 1.8v 459.495n 1.8v 459.505n 1.8v 469.495n 1.8v 469.505n 1.8v 479.495n 1.8v 479.505n 1.8v 489.495n 1.8v 489.505n 1.8v 499.495n 1.8v 499.505n 0.0v 509.495n 0.0v 509.505n 0.0v 519.495n 0.0v 519.505n 1.8v 529.495n 1.8v 529.505n 1.8v 539.495n 1.8v 539.505n 0.0v 549.495n 0.0v 549.505n 0.0v 559.495n 0.0v 559.505n 0.0v 569.495n 0.0v 569.505n 0.0v 579.495n 0.0v 579.505n 1.8v 589.495n 1.8v 589.505n 0.0v 599.495n 0.0v 599.505n 1.8v 609.495n 1.8v 609.505n 1.8v 619.495n 1.8v 619.505n 1.8v 629.495n 1.8v 629.505n 1.8v 639.495n 1.8v 639.505n 1.8v 649.495n 1.8v 649.505n 1.8v 659.495n 1.8v 659.505n 0.0v 669.495n 0.0v 669.505n 0.0v 679.495n 0.0v 679.505n 1.8v 689.495n 1.8v 689.505n 1.8v 699.495n 1.8v 699.505n 0.0v 709.495n 0.0v 709.505n 1.8v 719.495n 1.8v 719.505n 1.8v 729.495n 1.8v 729.505n 0.0v 739.495n 0.0v 739.505n 0.0v 749.495n 0.0v 749.505n 0.0v 759.495n 0.0v 759.505n 1.8v 769.495n 1.8v 769.505n 1.8v 779.495n 1.8v 779.505n 1.8v 789.495n 1.8v 789.505n 1.8v 799.495n 1.8v 799.505n 1.8v 809.495n 1.8v 809.505n 1.8v 819.495n 1.8v 819.505n 0.0v 829.495n 0.0v 829.505n 1.8v 839.495n 1.8v 839.505n 1.8v 849.495n 1.8v 849.505n 1.8v 859.495n 1.8v 859.505n 1.8v 869.495n 1.8v 869.505n 1.8v 879.495n 1.8v 879.505n 1.8v 889.495n 1.8v 889.505n 0.0v 899.495n 0.0v 899.505n 0.0v 909.495n 0.0v 909.505n 0.0v 919.495n 0.0v 919.505n 0.0v 929.495n 0.0v 929.505n 0.0v 939.495n 0.0v 939.505n 0.0v 949.495n 0.0v 949.505n 1.8v 959.495n 1.8v 959.505n 1.8v 969.495n 1.8v 969.505n 1.8v 979.495n 1.8v 979.505n 1.8v 989.495n 1.8v 989.505n 1.8v 999.495n 1.8v 999.505n 1.8v 1009.495n 1.8v 1009.505n 0.0v 1019.495n 0.0v 1019.505n 0.0v 1029.495n 0.0v 1029.505n 1.8v 1039.495n 1.8v 1039.505n 1.8v 1049.495n 1.8v 1049.505n 1.8v 1059.495n 1.8v 1059.505n 1.8v 1069.495n 1.8v 1069.505n 0.0v 1079.495n 0.0v 1079.505n 0.0v 1089.495n 0.0v 1089.505n 0.0v 1099.495n 0.0v 1099.505n 0.0v 1109.495n 0.0v 1109.505n 1.8v 1119.495n 1.8v 1119.505n 1.8v 1129.495n 1.8v 1129.505n 1.8v 1139.495n 1.8v 1139.505n 1.8v 1149.495n 1.8v 1149.505n 1.8v 1159.495n 1.8v 1159.505n 1.8v 1169.495n 1.8v 1169.505n 1.8v 1179.495n 1.8v 1179.505n 1.8v 1189.495n 1.8v 1189.505n 1.8v 1199.495n 1.8v 1199.505n 1.8v 1209.495n 1.8v 1209.505n 0.0v 1219.495n 0.0v 1219.505n 1.8v 1229.495n 1.8v 1229.505n 1.8v 1239.495n 1.8v 1239.505n 1.8v 1249.495n 1.8v 1249.505n 1.8v 1259.495n 1.8v 1259.505n 1.8v 1269.495n 1.8v 1269.505n 1.8v 1279.495n 1.8v 1279.505n 1.8v 1289.495n 1.8v 1289.505n 1.8v 1299.495n 1.8v 1299.505n 1.8v 1309.495n 1.8v 1309.505n 0.0v 1319.495n 0.0v 1319.505n 0.0v 1329.495n 0.0v 1329.505n 1.8v 1339.495n 1.8v 1339.505n 1.8v 1349.495n 1.8v 1349.505n 1.8v 1359.495n 1.8v 1359.505n 0.0v 1369.495n 0.0v 1369.505n 0.0v 1379.495n 0.0v 1379.505n 0.0v 1389.495n 0.0v 1389.505n 0.0v 1399.495n 0.0v 1399.505n 0.0v 1409.495n 0.0v 1409.505n 1.8v 1419.495n 1.8v 1419.505n 1.8v 1429.495n 1.8v 1429.505n 1.8v 1439.495n 1.8v 1439.505n 1.8v 1449.495n 1.8v 1449.505n 1.8v 1459.495n 1.8v 1459.505n 1.8v 1469.495n 1.8v 1469.505n 1.8v 1479.495n 1.8v 1479.505n 1.8v 1489.495n 1.8v 1489.505n 1.8v 1499.495n 1.8v 1499.505n 1.8v 1509.495n 1.8v 1509.505n 1.8v 1519.495n 1.8v 1519.505n 1.8v 1529.495n 1.8v 1529.505n 1.8v 1539.495n 1.8v 1539.505n 0.0v 1549.495n 0.0v 1549.505n 1.8v 1559.495n 1.8v 1559.505n 1.8v 1569.495n 1.8v 1569.505n 1.8v 1579.495n 1.8v 1579.505n 1.8v 1589.495n 1.8v 1589.505n 1.8v 1599.495n 1.8v 1599.505n 1.8v 1609.495n 1.8v 1609.505n 0.0v 1619.495n 0.0v 1619.505n 1.8v 1629.495n 1.8v 1629.505n 0.0v 1639.495n 0.0v 1639.505n 0.0v 1649.495n 0.0v 1649.505n 0.0v 1659.495n 0.0v 1659.505n 0.0v 1669.495n 0.0v 1669.505n 0.0v 1679.495n 0.0v 1679.505n 0.0v 1689.495n 0.0v 1689.505n 0.0v 1699.495n 0.0v 1699.505n 0.0v 1709.495n 0.0v 1709.505n 0.0v 1719.495n 0.0v 1719.505n 0.0v 1729.495n 0.0v 1729.505n 1.8v 1739.495n 1.8v 1739.505n 1.8v 1749.495n 1.8v 1749.505n 1.8v 1759.495n 1.8v 1759.505n 1.8v 1769.495n 1.8v 1769.505n 1.8v 1779.495n 1.8v 1779.505n 1.8v 1789.495n 1.8v 1789.505n 1.8v 1799.495n 1.8v 1799.505n 1.8v 1809.495n 1.8v 1809.505n 0.0v 1819.495n 0.0v 1819.505n 0.0v 1829.495n 0.0v 1829.505n 0.0v 1839.495n 0.0v 1839.505n 0.0v 1849.495n 0.0v 1849.505n 1.8v 1859.495n 1.8v 1859.505n 1.8v 1869.495n 1.8v 1869.505n 1.8v 1879.495n 1.8v 1879.505n 1.8v 1889.495n 1.8v 1889.505n 1.8v 1899.495n 1.8v 1899.505n 1.8v 1909.495n 1.8v 1909.505n 1.8v 1919.495n 1.8v 1919.505n 1.8v 1929.495n 1.8v 1929.505n 1.8v 1939.495n 1.8v 1939.505n 1.8v 1949.495n 1.8v 1949.505n 1.8v 1959.495n 1.8v 1959.505n 1.8v 1969.495n 1.8v 1969.505n 0.0v 1979.495n 0.0v 1979.505n 0.0v 1989.495n 0.0v 1989.505n 1.8v 1999.495n 1.8v 1999.505n 1.8v 2009.495n 1.8v 2009.505n 1.8v 2019.495n 1.8v 2019.505n 1.8v 2029.495n 1.8v 2029.505n 1.8v 2039.495n 1.8v 2039.505n 1.8v 2049.495n 1.8v 2049.505n 1.8v )
* (time, data): [(0, 0), (10, 0), (20, 0), (30, 0), (40, 1), (50, 1), (60, 1), (70, 1), (80, 1), (90, 1), (100, 0), (110, 0), (120, 0), (130, 0), (140, 0), (150, 0), (160, 0), (170, 0), (180, 0), (190, 1), (200, 1), (210, 1), (220, 1), (230, 0), (240, 0), (250, 0), (260, 0), (270, 0), (280, 0), (290, 0), (300, 0), (310, 1), (320, 1), (330, 1), (340, 1), (350, 1), (360, 1), (370, 0), (380, 0), (390, 1), (400, 1), (410, 1), (420, 1), (430, 0), (440, 1), (450, 1), (460, 1), (470, 1), (480, 1), (490, 1), (500, 0), (510, 0), (520, 1), (530, 1), (540, 0), (550, 0), (560, 0), (570, 0), (580, 1), (590, 0), (600, 1), (610, 1), (620, 1), (630, 1), (640, 1), (650, 1), (660, 0), (670, 0), (680, 1), (690, 1), (700, 0), (710, 1), (720, 1), (730, 0), (740, 0), (750, 0), (760, 1), (770, 1), (780, 1), (790, 1), (800, 1), (810, 1), (820, 0), (830, 1), (840, 1), (850, 1), (860, 1), (870, 1), (880, 1), (890, 0), (900, 0), (910, 0), (920, 0), (930, 0), (940, 0), (950, 1), (960, 1), (970, 1), (980, 1), (990, 1), (1000, 1), (1010, 0), (1020, 0), (1030, 1), (1040, 1), (1050, 1), (1060, 1), (1070, 0), (1080, 0), (1090, 0), (1100, 0), (1110, 1), (1120, 1), (1130, 1), (1140, 1), (1150, 1), (1160, 1), (1170, 1), (1180, 1), (1190, 1), (1200, 1), (1210, 0), (1220, 1), (1230, 1), (1240, 1), (1250, 1), (1260, 1), (1270, 1), (1280, 1), (1290, 1), (1300, 1), (1310, 0), (1320, 0), (1330, 1), (1340, 1), (1350, 1), (1360, 0), (1370, 0), (1380, 0), (1390, 0), (1400, 0), (1410, 1), (1420, 1), (1430, 1), (1440, 1), (1450, 1), (1460, 1), (1470, 1), (1480, 1), (1490, 1), (1500, 1), (1510, 1), (1520, 1), (1530, 1), (1540, 0), (1550, 1), (1560, 1), (1570, 1), (1580, 1), (1590, 1), (1600, 1), (1610, 0), (1620, 1), (1630, 0), (1640, 0), (1650, 0), (1660, 0), (1670, 0), (1680, 0), (1690, 0), (1700, 0), (1710, 0), (1720, 0), (1730, 1), (1740, 1), (1750, 1), (1760, 1), (1770, 1), (1780, 1), (1790, 1), (1800, 1), (1810, 0), (1820, 0), (1830, 0), (1840, 0), (1850, 1), (1860, 1), (1870, 1), (1880, 1), (1890, 1), (1900, 1), (1910, 1), (1920, 1), (1930, 1), (1940, 1), (1950, 1), (1960, 1), (1970, 0), (1980, 0), (1990, 1), (2000, 1), (2010, 1), (2020, 1), (2030, 1), (2040, 1), (2050, 1)]
Va1_4  a1_4  0 PWL (0n 0.0v 9.495n 0.0v 9.505n 0.0v 19.495n 0.0v 19.505n 0.0v 29.495n 0.0v 29.505n 0.0v 39.495n 0.0v 39.505n 1.8v 49.495n 1.8v 49.505n 1.8v 59.495n 1.8v 59.505n 1.8v 69.495n 1.8v 69.505n 1.8v 79.495n 1.8v 79.505n 1.8v 89.495n 1.8v 89.505n 1.8v 99.495n 1.8v 99.505n 0.0v 109.495n 0.0v 109.505n 0.0v 119.495n 0.0v 119.505n 0.0v 129.495n 0.0v 129.505n 0.0v 139.495n 0.0v 139.505n 0.0v 149.495n 0.0v 149.505n 0.0v 159.495n 0.0v 159.505n 0.0v 169.495n 0.0v 169.505n 0.0v 179.495n 0.0v 179.505n 0.0v 189.495n 0.0v 189.505n 1.8v 199.495n 1.8v 199.505n 1.8v 209.495n 1.8v 209.505n 1.8v 219.495n 1.8v 219.505n 1.8v 229.495n 1.8v 229.505n 0.0v 239.495n 0.0v 239.505n 0.0v 249.495n 0.0v 249.505n 0.0v 259.495n 0.0v 259.505n 0.0v 269.495n 0.0v 269.505n 0.0v 279.495n 0.0v 279.505n 0.0v 289.495n 0.0v 289.505n 0.0v 299.495n 0.0v 299.505n 0.0v 309.495n 0.0v 309.505n 1.8v 319.495n 1.8v 319.505n 1.8v 329.495n 1.8v 329.505n 1.8v 339.495n 1.8v 339.505n 1.8v 349.495n 1.8v 349.505n 1.8v 359.495n 1.8v 359.505n 1.8v 369.495n 1.8v 369.505n 0.0v 379.495n 0.0v 379.505n 0.0v 389.495n 0.0v 389.505n 1.8v 399.495n 1.8v 399.505n 1.8v 409.495n 1.8v 409.505n 1.8v 419.495n 1.8v 419.505n 1.8v 429.495n 1.8v 429.505n 0.0v 439.495n 0.0v 439.505n 1.8v 449.495n 1.8v 449.505n 1.8v 459.495n 1.8v 459.505n 1.8v 469.495n 1.8v 469.505n 1.8v 479.495n 1.8v 479.505n 1.8v 489.495n 1.8v 489.505n 1.8v 499.495n 1.8v 499.505n 0.0v 509.495n 0.0v 509.505n 0.0v 519.495n 0.0v 519.505n 1.8v 529.495n 1.8v 529.505n 1.8v 539.495n 1.8v 539.505n 0.0v 549.495n 0.0v 549.505n 0.0v 559.495n 0.0v 559.505n 0.0v 569.495n 0.0v 569.505n 0.0v 579.495n 0.0v 579.505n 1.8v 589.495n 1.8v 589.505n 0.0v 599.495n 0.0v 599.505n 1.8v 609.495n 1.8v 609.505n 1.8v 619.495n 1.8v 619.505n 1.8v 629.495n 1.8v 629.505n 1.8v 639.495n 1.8v 639.505n 1.8v 649.495n 1.8v 649.505n 1.8v 659.495n 1.8v 659.505n 0.0v 669.495n 0.0v 669.505n 0.0v 679.495n 0.0v 679.505n 1.8v 689.495n 1.8v 689.505n 1.8v 699.495n 1.8v 699.505n 0.0v 709.495n 0.0v 709.505n 1.8v 719.495n 1.8v 719.505n 1.8v 729.495n 1.8v 729.505n 0.0v 739.495n 0.0v 739.505n 0.0v 749.495n 0.0v 749.505n 0.0v 759.495n 0.0v 759.505n 1.8v 769.495n 1.8v 769.505n 1.8v 779.495n 1.8v 779.505n 1.8v 789.495n 1.8v 789.505n 1.8v 799.495n 1.8v 799.505n 1.8v 809.495n 1.8v 809.505n 1.8v 819.495n 1.8v 819.505n 0.0v 829.495n 0.0v 829.505n 1.8v 839.495n 1.8v 839.505n 1.8v 849.495n 1.8v 849.505n 1.8v 859.495n 1.8v 859.505n 1.8v 869.495n 1.8v 869.505n 1.8v 879.495n 1.8v 879.505n 1.8v 889.495n 1.8v 889.505n 0.0v 899.495n 0.0v 899.505n 0.0v 909.495n 0.0v 909.505n 0.0v 919.495n 0.0v 919.505n 0.0v 929.495n 0.0v 929.505n 0.0v 939.495n 0.0v 939.505n 0.0v 949.495n 0.0v 949.505n 1.8v 959.495n 1.8v 959.505n 1.8v 969.495n 1.8v 969.505n 1.8v 979.495n 1.8v 979.505n 1.8v 989.495n 1.8v 989.505n 1.8v 999.495n 1.8v 999.505n 1.8v 1009.495n 1.8v 1009.505n 0.0v 1019.495n 0.0v 1019.505n 0.0v 1029.495n 0.0v 1029.505n 1.8v 1039.495n 1.8v 1039.505n 1.8v 1049.495n 1.8v 1049.505n 1.8v 1059.495n 1.8v 1059.505n 1.8v 1069.495n 1.8v 1069.505n 0.0v 1079.495n 0.0v 1079.505n 0.0v 1089.495n 0.0v 1089.505n 0.0v 1099.495n 0.0v 1099.505n 0.0v 1109.495n 0.0v 1109.505n 1.8v 1119.495n 1.8v 1119.505n 1.8v 1129.495n 1.8v 1129.505n 1.8v 1139.495n 1.8v 1139.505n 1.8v 1149.495n 1.8v 1149.505n 1.8v 1159.495n 1.8v 1159.505n 1.8v 1169.495n 1.8v 1169.505n 1.8v 1179.495n 1.8v 1179.505n 1.8v 1189.495n 1.8v 1189.505n 1.8v 1199.495n 1.8v 1199.505n 1.8v 1209.495n 1.8v 1209.505n 0.0v 1219.495n 0.0v 1219.505n 1.8v 1229.495n 1.8v 1229.505n 1.8v 1239.495n 1.8v 1239.505n 1.8v 1249.495n 1.8v 1249.505n 1.8v 1259.495n 1.8v 1259.505n 1.8v 1269.495n 1.8v 1269.505n 1.8v 1279.495n 1.8v 1279.505n 1.8v 1289.495n 1.8v 1289.505n 1.8v 1299.495n 1.8v 1299.505n 1.8v 1309.495n 1.8v 1309.505n 0.0v 1319.495n 0.0v 1319.505n 0.0v 1329.495n 0.0v 1329.505n 1.8v 1339.495n 1.8v 1339.505n 1.8v 1349.495n 1.8v 1349.505n 1.8v 1359.495n 1.8v 1359.505n 0.0v 1369.495n 0.0v 1369.505n 0.0v 1379.495n 0.0v 1379.505n 0.0v 1389.495n 0.0v 1389.505n 0.0v 1399.495n 0.0v 1399.505n 0.0v 1409.495n 0.0v 1409.505n 1.8v 1419.495n 1.8v 1419.505n 1.8v 1429.495n 1.8v 1429.505n 1.8v 1439.495n 1.8v 1439.505n 1.8v 1449.495n 1.8v 1449.505n 1.8v 1459.495n 1.8v 1459.505n 1.8v 1469.495n 1.8v 1469.505n 1.8v 1479.495n 1.8v 1479.505n 1.8v 1489.495n 1.8v 1489.505n 1.8v 1499.495n 1.8v 1499.505n 1.8v 1509.495n 1.8v 1509.505n 1.8v 1519.495n 1.8v 1519.505n 1.8v 1529.495n 1.8v 1529.505n 1.8v 1539.495n 1.8v 1539.505n 0.0v 1549.495n 0.0v 1549.505n 1.8v 1559.495n 1.8v 1559.505n 1.8v 1569.495n 1.8v 1569.505n 1.8v 1579.495n 1.8v 1579.505n 1.8v 1589.495n 1.8v 1589.505n 1.8v 1599.495n 1.8v 1599.505n 1.8v 1609.495n 1.8v 1609.505n 0.0v 1619.495n 0.0v 1619.505n 1.8v 1629.495n 1.8v 1629.505n 0.0v 1639.495n 0.0v 1639.505n 0.0v 1649.495n 0.0v 1649.505n 0.0v 1659.495n 0.0v 1659.505n 0.0v 1669.495n 0.0v 1669.505n 0.0v 1679.495n 0.0v 1679.505n 0.0v 1689.495n 0.0v 1689.505n 0.0v 1699.495n 0.0v 1699.505n 0.0v 1709.495n 0.0v 1709.505n 0.0v 1719.495n 0.0v 1719.505n 0.0v 1729.495n 0.0v 1729.505n 1.8v 1739.495n 1.8v 1739.505n 1.8v 1749.495n 1.8v 1749.505n 1.8v 1759.495n 1.8v 1759.505n 1.8v 1769.495n 1.8v 1769.505n 1.8v 1779.495n 1.8v 1779.505n 1.8v 1789.495n 1.8v 1789.505n 1.8v 1799.495n 1.8v 1799.505n 1.8v 1809.495n 1.8v 1809.505n 0.0v 1819.495n 0.0v 1819.505n 0.0v 1829.495n 0.0v 1829.505n 0.0v 1839.495n 0.0v 1839.505n 0.0v 1849.495n 0.0v 1849.505n 1.8v 1859.495n 1.8v 1859.505n 1.8v 1869.495n 1.8v 1869.505n 1.8v 1879.495n 1.8v 1879.505n 1.8v 1889.495n 1.8v 1889.505n 1.8v 1899.495n 1.8v 1899.505n 1.8v 1909.495n 1.8v 1909.505n 1.8v 1919.495n 1.8v 1919.505n 1.8v 1929.495n 1.8v 1929.505n 1.8v 1939.495n 1.8v 1939.505n 1.8v 1949.495n 1.8v 1949.505n 1.8v 1959.495n 1.8v 1959.505n 1.8v 1969.495n 1.8v 1969.505n 0.0v 1979.495n 0.0v 1979.505n 0.0v 1989.495n 0.0v 1989.505n 1.8v 1999.495n 1.8v 1999.505n 1.8v 2009.495n 1.8v 2009.505n 1.8v 2019.495n 1.8v 2019.505n 1.8v 2029.495n 1.8v 2029.505n 1.8v 2039.495n 1.8v 2039.505n 1.8v 2049.495n 1.8v 2049.505n 1.8v )
* (time, data): [(0, 0), (10, 0), (20, 0), (30, 0), (40, 1), (50, 1), (60, 1), (70, 1), (80, 1), (90, 1), (100, 0), (110, 0), (120, 0), (130, 0), (140, 0), (150, 0), (160, 0), (170, 0), (180, 0), (190, 1), (200, 1), (210, 1), (220, 1), (230, 0), (240, 0), (250, 0), (260, 0), (270, 0), (280, 0), (290, 0), (300, 0), (310, 1), (320, 1), (330, 1), (340, 1), (350, 1), (360, 1), (370, 0), (380, 0), (390, 1), (400, 1), (410, 1), (420, 1), (430, 0), (440, 1), (450, 1), (460, 1), (470, 1), (480, 1), (490, 1), (500, 0), (510, 0), (520, 1), (530, 1), (540, 0), (550, 0), (560, 0), (570, 0), (580, 1), (590, 0), (600, 1), (610, 1), (620, 1), (630, 1), (640, 1), (650, 1), (660, 0), (670, 0), (680, 1), (690, 1), (700, 0), (710, 1), (720, 1), (730, 0), (740, 0), (750, 0), (760, 1), (770, 1), (780, 1), (790, 1), (800, 1), (810, 1), (820, 0), (830, 1), (840, 1), (850, 1), (860, 1), (870, 1), (880, 1), (890, 0), (900, 0), (910, 0), (920, 0), (930, 0), (940, 0), (950, 1), (960, 1), (970, 1), (980, 1), (990, 1), (1000, 1), (1010, 0), (1020, 0), (1030, 1), (1040, 1), (1050, 1), (1060, 1), (1070, 0), (1080, 0), (1090, 0), (1100, 0), (1110, 1), (1120, 1), (1130, 1), (1140, 1), (1150, 1), (1160, 1), (1170, 1), (1180, 1), (1190, 1), (1200, 1), (1210, 0), (1220, 1), (1230, 1), (1240, 1), (1250, 1), (1260, 1), (1270, 1), (1280, 1), (1290, 1), (1300, 1), (1310, 0), (1320, 0), (1330, 1), (1340, 1), (1350, 1), (1360, 0), (1370, 0), (1380, 0), (1390, 0), (1400, 0), (1410, 1), (1420, 1), (1430, 1), (1440, 1), (1450, 1), (1460, 1), (1470, 1), (1480, 1), (1490, 1), (1500, 1), (1510, 1), (1520, 1), (1530, 1), (1540, 0), (1550, 1), (1560, 1), (1570, 1), (1580, 1), (1590, 1), (1600, 1), (1610, 0), (1620, 1), (1630, 0), (1640, 0), (1650, 0), (1660, 0), (1670, 0), (1680, 0), (1690, 0), (1700, 0), (1710, 0), (1720, 0), (1730, 1), (1740, 1), (1750, 1), (1760, 1), (1770, 1), (1780, 1), (1790, 1), (1800, 1), (1810, 0), (1820, 0), (1830, 0), (1840, 0), (1850, 1), (1860, 1), (1870, 1), (1880, 1), (1890, 1), (1900, 1), (1910, 1), (1920, 1), (1930, 1), (1940, 1), (1950, 1), (1960, 1), (1970, 0), (1980, 0), (1990, 1), (2000, 1), (2010, 1), (2020, 1), (2030, 1), (2040, 1), (2050, 1)]
Va1_5  a1_5  0 PWL (0n 0.0v 9.495n 0.0v 9.505n 0.0v 19.495n 0.0v 19.505n 0.0v 29.495n 0.0v 29.505n 0.0v 39.495n 0.0v 39.505n 1.8v 49.495n 1.8v 49.505n 1.8v 59.495n 1.8v 59.505n 1.8v 69.495n 1.8v 69.505n 1.8v 79.495n 1.8v 79.505n 1.8v 89.495n 1.8v 89.505n 1.8v 99.495n 1.8v 99.505n 0.0v 109.495n 0.0v 109.505n 0.0v 119.495n 0.0v 119.505n 0.0v 129.495n 0.0v 129.505n 0.0v 139.495n 0.0v 139.505n 0.0v 149.495n 0.0v 149.505n 0.0v 159.495n 0.0v 159.505n 0.0v 169.495n 0.0v 169.505n 0.0v 179.495n 0.0v 179.505n 0.0v 189.495n 0.0v 189.505n 1.8v 199.495n 1.8v 199.505n 1.8v 209.495n 1.8v 209.505n 1.8v 219.495n 1.8v 219.505n 1.8v 229.495n 1.8v 229.505n 0.0v 239.495n 0.0v 239.505n 0.0v 249.495n 0.0v 249.505n 0.0v 259.495n 0.0v 259.505n 0.0v 269.495n 0.0v 269.505n 0.0v 279.495n 0.0v 279.505n 0.0v 289.495n 0.0v 289.505n 0.0v 299.495n 0.0v 299.505n 0.0v 309.495n 0.0v 309.505n 1.8v 319.495n 1.8v 319.505n 1.8v 329.495n 1.8v 329.505n 1.8v 339.495n 1.8v 339.505n 1.8v 349.495n 1.8v 349.505n 1.8v 359.495n 1.8v 359.505n 1.8v 369.495n 1.8v 369.505n 0.0v 379.495n 0.0v 379.505n 0.0v 389.495n 0.0v 389.505n 1.8v 399.495n 1.8v 399.505n 1.8v 409.495n 1.8v 409.505n 1.8v 419.495n 1.8v 419.505n 1.8v 429.495n 1.8v 429.505n 0.0v 439.495n 0.0v 439.505n 1.8v 449.495n 1.8v 449.505n 1.8v 459.495n 1.8v 459.505n 1.8v 469.495n 1.8v 469.505n 1.8v 479.495n 1.8v 479.505n 1.8v 489.495n 1.8v 489.505n 1.8v 499.495n 1.8v 499.505n 0.0v 509.495n 0.0v 509.505n 0.0v 519.495n 0.0v 519.505n 1.8v 529.495n 1.8v 529.505n 1.8v 539.495n 1.8v 539.505n 0.0v 549.495n 0.0v 549.505n 0.0v 559.495n 0.0v 559.505n 0.0v 569.495n 0.0v 569.505n 0.0v 579.495n 0.0v 579.505n 1.8v 589.495n 1.8v 589.505n 0.0v 599.495n 0.0v 599.505n 1.8v 609.495n 1.8v 609.505n 1.8v 619.495n 1.8v 619.505n 1.8v 629.495n 1.8v 629.505n 1.8v 639.495n 1.8v 639.505n 1.8v 649.495n 1.8v 649.505n 1.8v 659.495n 1.8v 659.505n 0.0v 669.495n 0.0v 669.505n 0.0v 679.495n 0.0v 679.505n 1.8v 689.495n 1.8v 689.505n 1.8v 699.495n 1.8v 699.505n 0.0v 709.495n 0.0v 709.505n 1.8v 719.495n 1.8v 719.505n 1.8v 729.495n 1.8v 729.505n 0.0v 739.495n 0.0v 739.505n 0.0v 749.495n 0.0v 749.505n 0.0v 759.495n 0.0v 759.505n 1.8v 769.495n 1.8v 769.505n 1.8v 779.495n 1.8v 779.505n 1.8v 789.495n 1.8v 789.505n 1.8v 799.495n 1.8v 799.505n 1.8v 809.495n 1.8v 809.505n 1.8v 819.495n 1.8v 819.505n 0.0v 829.495n 0.0v 829.505n 1.8v 839.495n 1.8v 839.505n 1.8v 849.495n 1.8v 849.505n 1.8v 859.495n 1.8v 859.505n 1.8v 869.495n 1.8v 869.505n 1.8v 879.495n 1.8v 879.505n 1.8v 889.495n 1.8v 889.505n 0.0v 899.495n 0.0v 899.505n 0.0v 909.495n 0.0v 909.505n 0.0v 919.495n 0.0v 919.505n 0.0v 929.495n 0.0v 929.505n 0.0v 939.495n 0.0v 939.505n 0.0v 949.495n 0.0v 949.505n 1.8v 959.495n 1.8v 959.505n 1.8v 969.495n 1.8v 969.505n 1.8v 979.495n 1.8v 979.505n 1.8v 989.495n 1.8v 989.505n 1.8v 999.495n 1.8v 999.505n 1.8v 1009.495n 1.8v 1009.505n 0.0v 1019.495n 0.0v 1019.505n 0.0v 1029.495n 0.0v 1029.505n 1.8v 1039.495n 1.8v 1039.505n 1.8v 1049.495n 1.8v 1049.505n 1.8v 1059.495n 1.8v 1059.505n 1.8v 1069.495n 1.8v 1069.505n 0.0v 1079.495n 0.0v 1079.505n 0.0v 1089.495n 0.0v 1089.505n 0.0v 1099.495n 0.0v 1099.505n 0.0v 1109.495n 0.0v 1109.505n 1.8v 1119.495n 1.8v 1119.505n 1.8v 1129.495n 1.8v 1129.505n 1.8v 1139.495n 1.8v 1139.505n 1.8v 1149.495n 1.8v 1149.505n 1.8v 1159.495n 1.8v 1159.505n 1.8v 1169.495n 1.8v 1169.505n 1.8v 1179.495n 1.8v 1179.505n 1.8v 1189.495n 1.8v 1189.505n 1.8v 1199.495n 1.8v 1199.505n 1.8v 1209.495n 1.8v 1209.505n 0.0v 1219.495n 0.0v 1219.505n 1.8v 1229.495n 1.8v 1229.505n 1.8v 1239.495n 1.8v 1239.505n 1.8v 1249.495n 1.8v 1249.505n 1.8v 1259.495n 1.8v 1259.505n 1.8v 1269.495n 1.8v 1269.505n 1.8v 1279.495n 1.8v 1279.505n 1.8v 1289.495n 1.8v 1289.505n 1.8v 1299.495n 1.8v 1299.505n 1.8v 1309.495n 1.8v 1309.505n 0.0v 1319.495n 0.0v 1319.505n 0.0v 1329.495n 0.0v 1329.505n 1.8v 1339.495n 1.8v 1339.505n 1.8v 1349.495n 1.8v 1349.505n 1.8v 1359.495n 1.8v 1359.505n 0.0v 1369.495n 0.0v 1369.505n 0.0v 1379.495n 0.0v 1379.505n 0.0v 1389.495n 0.0v 1389.505n 0.0v 1399.495n 0.0v 1399.505n 0.0v 1409.495n 0.0v 1409.505n 1.8v 1419.495n 1.8v 1419.505n 1.8v 1429.495n 1.8v 1429.505n 1.8v 1439.495n 1.8v 1439.505n 1.8v 1449.495n 1.8v 1449.505n 1.8v 1459.495n 1.8v 1459.505n 1.8v 1469.495n 1.8v 1469.505n 1.8v 1479.495n 1.8v 1479.505n 1.8v 1489.495n 1.8v 1489.505n 1.8v 1499.495n 1.8v 1499.505n 1.8v 1509.495n 1.8v 1509.505n 1.8v 1519.495n 1.8v 1519.505n 1.8v 1529.495n 1.8v 1529.505n 1.8v 1539.495n 1.8v 1539.505n 0.0v 1549.495n 0.0v 1549.505n 1.8v 1559.495n 1.8v 1559.505n 1.8v 1569.495n 1.8v 1569.505n 1.8v 1579.495n 1.8v 1579.505n 1.8v 1589.495n 1.8v 1589.505n 1.8v 1599.495n 1.8v 1599.505n 1.8v 1609.495n 1.8v 1609.505n 0.0v 1619.495n 0.0v 1619.505n 1.8v 1629.495n 1.8v 1629.505n 0.0v 1639.495n 0.0v 1639.505n 0.0v 1649.495n 0.0v 1649.505n 0.0v 1659.495n 0.0v 1659.505n 0.0v 1669.495n 0.0v 1669.505n 0.0v 1679.495n 0.0v 1679.505n 0.0v 1689.495n 0.0v 1689.505n 0.0v 1699.495n 0.0v 1699.505n 0.0v 1709.495n 0.0v 1709.505n 0.0v 1719.495n 0.0v 1719.505n 0.0v 1729.495n 0.0v 1729.505n 1.8v 1739.495n 1.8v 1739.505n 1.8v 1749.495n 1.8v 1749.505n 1.8v 1759.495n 1.8v 1759.505n 1.8v 1769.495n 1.8v 1769.505n 1.8v 1779.495n 1.8v 1779.505n 1.8v 1789.495n 1.8v 1789.505n 1.8v 1799.495n 1.8v 1799.505n 1.8v 1809.495n 1.8v 1809.505n 0.0v 1819.495n 0.0v 1819.505n 0.0v 1829.495n 0.0v 1829.505n 0.0v 1839.495n 0.0v 1839.505n 0.0v 1849.495n 0.0v 1849.505n 1.8v 1859.495n 1.8v 1859.505n 1.8v 1869.495n 1.8v 1869.505n 1.8v 1879.495n 1.8v 1879.505n 1.8v 1889.495n 1.8v 1889.505n 1.8v 1899.495n 1.8v 1899.505n 1.8v 1909.495n 1.8v 1909.505n 1.8v 1919.495n 1.8v 1919.505n 1.8v 1929.495n 1.8v 1929.505n 1.8v 1939.495n 1.8v 1939.505n 1.8v 1949.495n 1.8v 1949.505n 1.8v 1959.495n 1.8v 1959.505n 1.8v 1969.495n 1.8v 1969.505n 0.0v 1979.495n 0.0v 1979.505n 0.0v 1989.495n 0.0v 1989.505n 1.8v 1999.495n 1.8v 1999.505n 1.8v 2009.495n 1.8v 2009.505n 1.8v 2019.495n 1.8v 2019.505n 1.8v 2029.495n 1.8v 2029.505n 1.8v 2039.495n 1.8v 2039.505n 1.8v 2049.495n 1.8v 2049.505n 1.8v )

 * Generation of control signals
* (time, data): [(0, 1), (10, 0), (20, 0), (30, 0), (40, 0), (50, 0), (60, 0), (70, 0), (80, 0), (90, 0), (100, 1), (110, 0), (120, 0), (130, 0), (140, 0), (150, 0), (160, 0), (170, 0), (180, 1), (190, 0), (200, 1), (210, 0), (220, 0), (230, 0), (240, 1), (250, 0), (260, 0), (270, 0), (280, 0), (290, 0), (300, 0), (310, 0), (320, 0), (330, 1), (340, 0), (350, 0), (360, 1), (370, 1), (380, 0), (390, 0), (400, 0), (410, 0), (420, 0), (430, 0), (440, 1), (450, 0), (460, 0), (470, 0), (480, 0), (490, 0), (500, 0), (510, 1), (520, 0), (530, 0), (540, 1), (550, 0), (560, 0), (570, 1), (580, 1), (590, 0), (600, 0), (610, 0), (620, 0), (630, 1), (640, 0), (650, 0), (660, 0), (670, 0), (680, 0), (690, 1), (700, 0), (710, 0), (720, 0), (730, 0), (740, 0), (750, 0), (760, 1), (770, 0), (780, 1), (790, 0), (800, 0), (810, 0), (820, 0), (830, 0), (840, 0), (850, 0), (860, 0), (870, 1), (880, 0), (890, 0), (900, 0), (910, 0), (920, 0), (930, 0), (940, 0), (950, 0), (960, 0), (970, 1), (980, 0), (990, 0), (1000, 1), (1010, 1), (1020, 0), (1030, 1), (1040, 1), (1050, 0), (1060, 1), (1070, 0), (1080, 0), (1090, 0), (1100, 0), (1110, 0), (1120, 1), (1130, 0), (1140, 1), (1150, 0), (1160, 1), (1170, 0), (1180, 0), (1190, 0), (1200, 0), (1210, 0), (1220, 0), (1230, 1), (1240, 0), (1250, 0), (1260, 0), (1270, 0), (1280, 0), (1290, 0), (1300, 1), (1310, 1), (1320, 0), (1330, 0), (1340, 1), (1350, 0), (1360, 0), (1370, 0), (1380, 0), (1390, 0), (1400, 0), (1410, 0), (1420, 0), (1430, 0), (1440, 0), (1450, 0), (1460, 0), (1470, 0), (1480, 0), (1490, 1), (1500, 0), (1510, 0), (1520, 1), (1530, 0), (1540, 1), (1550, 0), (1560, 0), (1570, 0), (1580, 0), (1590, 0), (1600, 0), (1610, 1), (1620, 0), (1630, 0), (1640, 0), (1650, 0), (1660, 1), (1670, 1), (1680, 0), (1690, 0), (1700, 0), (1710, 0), (1720, 0), (1730, 0), (1740, 0), (1750, 1), (1760, 0), (1770, 1), (1780, 0), (1790, 0), (1800, 0), (1810, 1), (1820, 0), (1830, 0), (1840, 1), (1850, 0), (1860, 0), (1870, 0), (1880, 0), (1890, 0), (1900, 1), (1910, 0), (1920, 0), (1930, 1), (1940, 0), (1950, 0), (1960, 0), (1970, 0), (1980, 1), (1990, 1), (2000, 1), (2010, 0), (2020, 0), (2030, 0), (2040, 0), (2050, 1)]
VCSB0 CSB0 0 PWL (0n 1.8v 9.495n 1.8v 9.505n 0.0v 19.495n 0.0v 19.505n 0.0v 29.495n 0.0v 29.505n 0.0v 39.495n 0.0v 39.505n 0.0v 49.495n 0.0v 49.505n 0.0v 59.495n 0.0v 59.505n 0.0v 69.495n 0.0v 69.505n 0.0v 79.495n 0.0v 79.505n 0.0v 89.495n 0.0v 89.505n 0.0v 99.495n 0.0v 99.505n 1.8v 109.495n 1.8v 109.505n 0.0v 119.495n 0.0v 119.505n 0.0v 129.495n 0.0v 129.505n 0.0v 139.495n 0.0v 139.505n 0.0v 149.495n 0.0v 149.505n 0.0v 159.495n 0.0v 159.505n 0.0v 169.495n 0.0v 169.505n 0.0v 179.495n 0.0v 179.505n 1.8v 189.495n 1.8v 189.505n 0.0v 199.495n 0.0v 199.505n 1.8v 209.495n 1.8v 209.505n 0.0v 219.495n 0.0v 219.505n 0.0v 229.495n 0.0v 229.505n 0.0v 239.495n 0.0v 239.505n 1.8v 249.495n 1.8v 249.505n 0.0v 259.495n 0.0v 259.505n 0.0v 269.495n 0.0v 269.505n 0.0v 279.495n 0.0v 279.505n 0.0v 289.495n 0.0v 289.505n 0.0v 299.495n 0.0v 299.505n 0.0v 309.495n 0.0v 309.505n 0.0v 319.495n 0.0v 319.505n 0.0v 329.495n 0.0v 329.505n 1.8v 339.495n 1.8v 339.505n 0.0v 349.495n 0.0v 349.505n 0.0v 359.495n 0.0v 359.505n 1.8v 369.495n 1.8v 369.505n 1.8v 379.495n 1.8v 379.505n 0.0v 389.495n 0.0v 389.505n 0.0v 399.495n 0.0v 399.505n 0.0v 409.495n 0.0v 409.505n 0.0v 419.495n 0.0v 419.505n 0.0v 429.495n 0.0v 429.505n 0.0v 439.495n 0.0v 439.505n 1.8v 449.495n 1.8v 449.505n 0.0v 459.495n 0.0v 459.505n 0.0v 469.495n 0.0v 469.505n 0.0v 479.495n 0.0v 479.505n 0.0v 489.495n 0.0v 489.505n 0.0v 499.495n 0.0v 499.505n 0.0v 509.495n 0.0v 509.505n 1.8v 519.495n 1.8v 519.505n 0.0v 529.495n 0.0v 529.505n 0.0v 539.495n 0.0v 539.505n 1.8v 549.495n 1.8v 549.505n 0.0v 559.495n 0.0v 559.505n 0.0v 569.495n 0.0v 569.505n 1.8v 579.495n 1.8v 579.505n 1.8v 589.495n 1.8v 589.505n 0.0v 599.495n 0.0v 599.505n 0.0v 609.495n 0.0v 609.505n 0.0v 619.495n 0.0v 619.505n 0.0v 629.495n 0.0v 629.505n 1.8v 639.495n 1.8v 639.505n 0.0v 649.495n 0.0v 649.505n 0.0v 659.495n 0.0v 659.505n 0.0v 669.495n 0.0v 669.505n 0.0v 679.495n 0.0v 679.505n 0.0v 689.495n 0.0v 689.505n 1.8v 699.495n 1.8v 699.505n 0.0v 709.495n 0.0v 709.505n 0.0v 719.495n 0.0v 719.505n 0.0v 729.495n 0.0v 729.505n 0.0v 739.495n 0.0v 739.505n 0.0v 749.495n 0.0v 749.505n 0.0v 759.495n 0.0v 759.505n 1.8v 769.495n 1.8v 769.505n 0.0v 779.495n 0.0v 779.505n 1.8v 789.495n 1.8v 789.505n 0.0v 799.495n 0.0v 799.505n 0.0v 809.495n 0.0v 809.505n 0.0v 819.495n 0.0v 819.505n 0.0v 829.495n 0.0v 829.505n 0.0v 839.495n 0.0v 839.505n 0.0v 849.495n 0.0v 849.505n 0.0v 859.495n 0.0v 859.505n 0.0v 869.495n 0.0v 869.505n 1.8v 879.495n 1.8v 879.505n 0.0v 889.495n 0.0v 889.505n 0.0v 899.495n 0.0v 899.505n 0.0v 909.495n 0.0v 909.505n 0.0v 919.495n 0.0v 919.505n 0.0v 929.495n 0.0v 929.505n 0.0v 939.495n 0.0v 939.505n 0.0v 949.495n 0.0v 949.505n 0.0v 959.495n 0.0v 959.505n 0.0v 969.495n 0.0v 969.505n 1.8v 979.495n 1.8v 979.505n 0.0v 989.495n 0.0v 989.505n 0.0v 999.495n 0.0v 999.505n 1.8v 1009.495n 1.8v 1009.505n 1.8v 1019.495n 1.8v 1019.505n 0.0v 1029.495n 0.0v 1029.505n 1.8v 1039.495n 1.8v 1039.505n 1.8v 1049.495n 1.8v 1049.505n 0.0v 1059.495n 0.0v 1059.505n 1.8v 1069.495n 1.8v 1069.505n 0.0v 1079.495n 0.0v 1079.505n 0.0v 1089.495n 0.0v 1089.505n 0.0v 1099.495n 0.0v 1099.505n 0.0v 1109.495n 0.0v 1109.505n 0.0v 1119.495n 0.0v 1119.505n 1.8v 1129.495n 1.8v 1129.505n 0.0v 1139.495n 0.0v 1139.505n 1.8v 1149.495n 1.8v 1149.505n 0.0v 1159.495n 0.0v 1159.505n 1.8v 1169.495n 1.8v 1169.505n 0.0v 1179.495n 0.0v 1179.505n 0.0v 1189.495n 0.0v 1189.505n 0.0v 1199.495n 0.0v 1199.505n 0.0v 1209.495n 0.0v 1209.505n 0.0v 1219.495n 0.0v 1219.505n 0.0v 1229.495n 0.0v 1229.505n 1.8v 1239.495n 1.8v 1239.505n 0.0v 1249.495n 0.0v 1249.505n 0.0v 1259.495n 0.0v 1259.505n 0.0v 1269.495n 0.0v 1269.505n 0.0v 1279.495n 0.0v 1279.505n 0.0v 1289.495n 0.0v 1289.505n 0.0v 1299.495n 0.0v 1299.505n 1.8v 1309.495n 1.8v 1309.505n 1.8v 1319.495n 1.8v 1319.505n 0.0v 1329.495n 0.0v 1329.505n 0.0v 1339.495n 0.0v 1339.505n 1.8v 1349.495n 1.8v 1349.505n 0.0v 1359.495n 0.0v 1359.505n 0.0v 1369.495n 0.0v 1369.505n 0.0v 1379.495n 0.0v 1379.505n 0.0v 1389.495n 0.0v 1389.505n 0.0v 1399.495n 0.0v 1399.505n 0.0v 1409.495n 0.0v 1409.505n 0.0v 1419.495n 0.0v 1419.505n 0.0v 1429.495n 0.0v 1429.505n 0.0v 1439.495n 0.0v 1439.505n 0.0v 1449.495n 0.0v 1449.505n 0.0v 1459.495n 0.0v 1459.505n 0.0v 1469.495n 0.0v 1469.505n 0.0v 1479.495n 0.0v 1479.505n 0.0v 1489.495n 0.0v 1489.505n 1.8v 1499.495n 1.8v 1499.505n 0.0v 1509.495n 0.0v 1509.505n 0.0v 1519.495n 0.0v 1519.505n 1.8v 1529.495n 1.8v 1529.505n 0.0v 1539.495n 0.0v 1539.505n 1.8v 1549.495n 1.8v 1549.505n 0.0v 1559.495n 0.0v 1559.505n 0.0v 1569.495n 0.0v 1569.505n 0.0v 1579.495n 0.0v 1579.505n 0.0v 1589.495n 0.0v 1589.505n 0.0v 1599.495n 0.0v 1599.505n 0.0v 1609.495n 0.0v 1609.505n 1.8v 1619.495n 1.8v 1619.505n 0.0v 1629.495n 0.0v 1629.505n 0.0v 1639.495n 0.0v 1639.505n 0.0v 1649.495n 0.0v 1649.505n 0.0v 1659.495n 0.0v 1659.505n 1.8v 1669.495n 1.8v 1669.505n 1.8v 1679.495n 1.8v 1679.505n 0.0v 1689.495n 0.0v 1689.505n 0.0v 1699.495n 0.0v 1699.505n 0.0v 1709.495n 0.0v 1709.505n 0.0v 1719.495n 0.0v 1719.505n 0.0v 1729.495n 0.0v 1729.505n 0.0v 1739.495n 0.0v 1739.505n 0.0v 1749.495n 0.0v 1749.505n 1.8v 1759.495n 1.8v 1759.505n 0.0v 1769.495n 0.0v 1769.505n 1.8v 1779.495n 1.8v 1779.505n 0.0v 1789.495n 0.0v 1789.505n 0.0v 1799.495n 0.0v 1799.505n 0.0v 1809.495n 0.0v 1809.505n 1.8v 1819.495n 1.8v 1819.505n 0.0v 1829.495n 0.0v 1829.505n 0.0v 1839.495n 0.0v 1839.505n 1.8v 1849.495n 1.8v 1849.505n 0.0v 1859.495n 0.0v 1859.505n 0.0v 1869.495n 0.0v 1869.505n 0.0v 1879.495n 0.0v 1879.505n 0.0v 1889.495n 0.0v 1889.505n 0.0v 1899.495n 0.0v 1899.505n 1.8v 1909.495n 1.8v 1909.505n 0.0v 1919.495n 0.0v 1919.505n 0.0v 1929.495n 0.0v 1929.505n 1.8v 1939.495n 1.8v 1939.505n 0.0v 1949.495n 0.0v 1949.505n 0.0v 1959.495n 0.0v 1959.505n 0.0v 1969.495n 0.0v 1969.505n 0.0v 1979.495n 0.0v 1979.505n 1.8v 1989.495n 1.8v 1989.505n 1.8v 1999.495n 1.8v 1999.505n 1.8v 2009.495n 1.8v 2009.505n 0.0v 2019.495n 0.0v 2019.505n 0.0v 2029.495n 0.0v 2029.505n 0.0v 2039.495n 0.0v 2039.505n 0.0v 2049.495n 0.0v 2049.505n 1.8v )
* (time, data): [(0, 1), (10, 1), (20, 1), (30, 1), (40, 0), (50, 0), (60, 1), (70, 1), (80, 1), (90, 1), (100, 0), (110, 1), (120, 1), (130, 1), (140, 1), (150, 1), (160, 0), (170, 0), (180, 0), (190, 0), (200, 1), (210, 1), (220, 0), (230, 0), (240, 0), (250, 0), (260, 1), (270, 0), (280, 1), (290, 0), (300, 0), (310, 0), (320, 1), (330, 1), (340, 1), (350, 1), (360, 1), (370, 0), (380, 1), (390, 0), (400, 0), (410, 1), (420, 1), (430, 0), (440, 0), (450, 1), (460, 0), (470, 1), (480, 1), (490, 1), (500, 0), (510, 1), (520, 0), (530, 1), (540, 0), (550, 1), (560, 0), (570, 1), (580, 0), (590, 0), (600, 0), (610, 1), (620, 1), (630, 1), (640, 1), (650, 1), (660, 0), (670, 1), (680, 0), (690, 0), (700, 0), (710, 0), (720, 1), (730, 0), (740, 0), (750, 0), (760, 0), (770, 0), (780, 0), (790, 1), (800, 1), (810, 0), (820, 0), (830, 0), (840, 0), (850, 1), (860, 0), (870, 1), (880, 1), (890, 0), (900, 1), (910, 0), (920, 1), (930, 1), (940, 1), (950, 0), (960, 1), (970, 1), (980, 1), (990, 1), (1000, 1), (1010, 0), (1020, 1), (1030, 0), (1040, 1), (1050, 1), (1060, 1), (1070, 0), (1080, 1), (1090, 1), (1100, 1), (1110, 0), (1120, 1), (1130, 1), (1140, 1), (1150, 1), (1160, 1), (1170, 1), (1180, 1), (1190, 1), (1200, 0), (1210, 0), (1220, 0), (1230, 0), (1240, 0), (1250, 1), (1260, 1), (1270, 1), (1280, 1), (1290, 1), (1300, 0), (1310, 0), (1320, 1), (1330, 0), (1340, 1), (1350, 0), (1360, 0), (1370, 1), (1380, 0), (1390, 1), (1400, 1), (1410, 0), (1420, 0), (1430, 1), (1440, 1), (1450, 1), (1460, 0), (1470, 0), (1480, 0), (1490, 1), (1500, 1), (1510, 0), (1520, 1), (1530, 1), (1540, 0), (1550, 0), (1560, 1), (1570, 1), (1580, 1), (1590, 0), (1600, 0), (1610, 0), (1620, 0), (1630, 0), (1640, 1), (1650, 1), (1660, 0), (1670, 1), (1680, 1), (1690, 1), (1700, 1), (1710, 1), (1720, 1), (1730, 0), (1740, 0), (1750, 1), (1760, 1), (1770, 0), (1780, 1), (1790, 1), (1800, 0), (1810, 0), (1820, 1), (1830, 1), (1840, 0), (1850, 0), (1860, 1), (1870, 1), (1880, 0), (1890, 1), (1900, 0), (1910, 1), (1920, 1), (1930, 1), (1940, 1), (1950, 1), (1960, 1), (1970, 0), (1980, 0), (1990, 0), (2000, 1), (2010, 1), (2020, 1), (2030, 1), (2040, 0), (2050, 1)]
VCSB1 CSB1 0 PWL (0n 1.8v 9.495n 1.8v 9.505n 1.8v 19.495n 1.8v 19.505n 1.8v 29.495n 1.8v 29.505n 1.8v 39.495n 1.8v 39.505n 0.0v 49.495n 0.0v 49.505n 0.0v 59.495n 0.0v 59.505n 1.8v 69.495n 1.8v 69.505n 1.8v 79.495n 1.8v 79.505n 1.8v 89.495n 1.8v 89.505n 1.8v 99.495n 1.8v 99.505n 0.0v 109.495n 0.0v 109.505n 1.8v 119.495n 1.8v 119.505n 1.8v 129.495n 1.8v 129.505n 1.8v 139.495n 1.8v 139.505n 1.8v 149.495n 1.8v 149.505n 1.8v 159.495n 1.8v 159.505n 0.0v 169.495n 0.0v 169.505n 0.0v 179.495n 0.0v 179.505n 0.0v 189.495n 0.0v 189.505n 0.0v 199.495n 0.0v 199.505n 1.8v 209.495n 1.8v 209.505n 1.8v 219.495n 1.8v 219.505n 0.0v 229.495n 0.0v 229.505n 0.0v 239.495n 0.0v 239.505n 0.0v 249.495n 0.0v 249.505n 0.0v 259.495n 0.0v 259.505n 1.8v 269.495n 1.8v 269.505n 0.0v 279.495n 0.0v 279.505n 1.8v 289.495n 1.8v 289.505n 0.0v 299.495n 0.0v 299.505n 0.0v 309.495n 0.0v 309.505n 0.0v 319.495n 0.0v 319.505n 1.8v 329.495n 1.8v 329.505n 1.8v 339.495n 1.8v 339.505n 1.8v 349.495n 1.8v 349.505n 1.8v 359.495n 1.8v 359.505n 1.8v 369.495n 1.8v 369.505n 0.0v 379.495n 0.0v 379.505n 1.8v 389.495n 1.8v 389.505n 0.0v 399.495n 0.0v 399.505n 0.0v 409.495n 0.0v 409.505n 1.8v 419.495n 1.8v 419.505n 1.8v 429.495n 1.8v 429.505n 0.0v 439.495n 0.0v 439.505n 0.0v 449.495n 0.0v 449.505n 1.8v 459.495n 1.8v 459.505n 0.0v 469.495n 0.0v 469.505n 1.8v 479.495n 1.8v 479.505n 1.8v 489.495n 1.8v 489.505n 1.8v 499.495n 1.8v 499.505n 0.0v 509.495n 0.0v 509.505n 1.8v 519.495n 1.8v 519.505n 0.0v 529.495n 0.0v 529.505n 1.8v 539.495n 1.8v 539.505n 0.0v 549.495n 0.0v 549.505n 1.8v 559.495n 1.8v 559.505n 0.0v 569.495n 0.0v 569.505n 1.8v 579.495n 1.8v 579.505n 0.0v 589.495n 0.0v 589.505n 0.0v 599.495n 0.0v 599.505n 0.0v 609.495n 0.0v 609.505n 1.8v 619.495n 1.8v 619.505n 1.8v 629.495n 1.8v 629.505n 1.8v 639.495n 1.8v 639.505n 1.8v 649.495n 1.8v 649.505n 1.8v 659.495n 1.8v 659.505n 0.0v 669.495n 0.0v 669.505n 1.8v 679.495n 1.8v 679.505n 0.0v 689.495n 0.0v 689.505n 0.0v 699.495n 0.0v 699.505n 0.0v 709.495n 0.0v 709.505n 0.0v 719.495n 0.0v 719.505n 1.8v 729.495n 1.8v 729.505n 0.0v 739.495n 0.0v 739.505n 0.0v 749.495n 0.0v 749.505n 0.0v 759.495n 0.0v 759.505n 0.0v 769.495n 0.0v 769.505n 0.0v 779.495n 0.0v 779.505n 0.0v 789.495n 0.0v 789.505n 1.8v 799.495n 1.8v 799.505n 1.8v 809.495n 1.8v 809.505n 0.0v 819.495n 0.0v 819.505n 0.0v 829.495n 0.0v 829.505n 0.0v 839.495n 0.0v 839.505n 0.0v 849.495n 0.0v 849.505n 1.8v 859.495n 1.8v 859.505n 0.0v 869.495n 0.0v 869.505n 1.8v 879.495n 1.8v 879.505n 1.8v 889.495n 1.8v 889.505n 0.0v 899.495n 0.0v 899.505n 1.8v 909.495n 1.8v 909.505n 0.0v 919.495n 0.0v 919.505n 1.8v 929.495n 1.8v 929.505n 1.8v 939.495n 1.8v 939.505n 1.8v 949.495n 1.8v 949.505n 0.0v 959.495n 0.0v 959.505n 1.8v 969.495n 1.8v 969.505n 1.8v 979.495n 1.8v 979.505n 1.8v 989.495n 1.8v 989.505n 1.8v 999.495n 1.8v 999.505n 1.8v 1009.495n 1.8v 1009.505n 0.0v 1019.495n 0.0v 1019.505n 1.8v 1029.495n 1.8v 1029.505n 0.0v 1039.495n 0.0v 1039.505n 1.8v 1049.495n 1.8v 1049.505n 1.8v 1059.495n 1.8v 1059.505n 1.8v 1069.495n 1.8v 1069.505n 0.0v 1079.495n 0.0v 1079.505n 1.8v 1089.495n 1.8v 1089.505n 1.8v 1099.495n 1.8v 1099.505n 1.8v 1109.495n 1.8v 1109.505n 0.0v 1119.495n 0.0v 1119.505n 1.8v 1129.495n 1.8v 1129.505n 1.8v 1139.495n 1.8v 1139.505n 1.8v 1149.495n 1.8v 1149.505n 1.8v 1159.495n 1.8v 1159.505n 1.8v 1169.495n 1.8v 1169.505n 1.8v 1179.495n 1.8v 1179.505n 1.8v 1189.495n 1.8v 1189.505n 1.8v 1199.495n 1.8v 1199.505n 0.0v 1209.495n 0.0v 1209.505n 0.0v 1219.495n 0.0v 1219.505n 0.0v 1229.495n 0.0v 1229.505n 0.0v 1239.495n 0.0v 1239.505n 0.0v 1249.495n 0.0v 1249.505n 1.8v 1259.495n 1.8v 1259.505n 1.8v 1269.495n 1.8v 1269.505n 1.8v 1279.495n 1.8v 1279.505n 1.8v 1289.495n 1.8v 1289.505n 1.8v 1299.495n 1.8v 1299.505n 0.0v 1309.495n 0.0v 1309.505n 0.0v 1319.495n 0.0v 1319.505n 1.8v 1329.495n 1.8v 1329.505n 0.0v 1339.495n 0.0v 1339.505n 1.8v 1349.495n 1.8v 1349.505n 0.0v 1359.495n 0.0v 1359.505n 0.0v 1369.495n 0.0v 1369.505n 1.8v 1379.495n 1.8v 1379.505n 0.0v 1389.495n 0.0v 1389.505n 1.8v 1399.495n 1.8v 1399.505n 1.8v 1409.495n 1.8v 1409.505n 0.0v 1419.495n 0.0v 1419.505n 0.0v 1429.495n 0.0v 1429.505n 1.8v 1439.495n 1.8v 1439.505n 1.8v 1449.495n 1.8v 1449.505n 1.8v 1459.495n 1.8v 1459.505n 0.0v 1469.495n 0.0v 1469.505n 0.0v 1479.495n 0.0v 1479.505n 0.0v 1489.495n 0.0v 1489.505n 1.8v 1499.495n 1.8v 1499.505n 1.8v 1509.495n 1.8v 1509.505n 0.0v 1519.495n 0.0v 1519.505n 1.8v 1529.495n 1.8v 1529.505n 1.8v 1539.495n 1.8v 1539.505n 0.0v 1549.495n 0.0v 1549.505n 0.0v 1559.495n 0.0v 1559.505n 1.8v 1569.495n 1.8v 1569.505n 1.8v 1579.495n 1.8v 1579.505n 1.8v 1589.495n 1.8v 1589.505n 0.0v 1599.495n 0.0v 1599.505n 0.0v 1609.495n 0.0v 1609.505n 0.0v 1619.495n 0.0v 1619.505n 0.0v 1629.495n 0.0v 1629.505n 0.0v 1639.495n 0.0v 1639.505n 1.8v 1649.495n 1.8v 1649.505n 1.8v 1659.495n 1.8v 1659.505n 0.0v 1669.495n 0.0v 1669.505n 1.8v 1679.495n 1.8v 1679.505n 1.8v 1689.495n 1.8v 1689.505n 1.8v 1699.495n 1.8v 1699.505n 1.8v 1709.495n 1.8v 1709.505n 1.8v 1719.495n 1.8v 1719.505n 1.8v 1729.495n 1.8v 1729.505n 0.0v 1739.495n 0.0v 1739.505n 0.0v 1749.495n 0.0v 1749.505n 1.8v 1759.495n 1.8v 1759.505n 1.8v 1769.495n 1.8v 1769.505n 0.0v 1779.495n 0.0v 1779.505n 1.8v 1789.495n 1.8v 1789.505n 1.8v 1799.495n 1.8v 1799.505n 0.0v 1809.495n 0.0v 1809.505n 0.0v 1819.495n 0.0v 1819.505n 1.8v 1829.495n 1.8v 1829.505n 1.8v 1839.495n 1.8v 1839.505n 0.0v 1849.495n 0.0v 1849.505n 0.0v 1859.495n 0.0v 1859.505n 1.8v 1869.495n 1.8v 1869.505n 1.8v 1879.495n 1.8v 1879.505n 0.0v 1889.495n 0.0v 1889.505n 1.8v 1899.495n 1.8v 1899.505n 0.0v 1909.495n 0.0v 1909.505n 1.8v 1919.495n 1.8v 1919.505n 1.8v 1929.495n 1.8v 1929.505n 1.8v 1939.495n 1.8v 1939.505n 1.8v 1949.495n 1.8v 1949.505n 1.8v 1959.495n 1.8v 1959.505n 1.8v 1969.495n 1.8v 1969.505n 0.0v 1979.495n 0.0v 1979.505n 0.0v 1989.495n 0.0v 1989.505n 0.0v 1999.495n 0.0v 1999.505n 1.8v 2009.495n 1.8v 2009.505n 1.8v 2019.495n 1.8v 2019.505n 1.8v 2029.495n 1.8v 2029.505n 1.8v 2039.495n 1.8v 2039.505n 0.0v 2049.495n 0.0v 2049.505n 1.8v )
* (time, data): [(0, 1), (10, 0), (20, 0), (30, 0), (40, 1), (50, 1), (60, 0), (70, 1), (80, 1), (90, 1), (100, 1), (110, 1), (120, 1), (130, 1), (140, 1), (150, 0), (160, 1), (170, 1), (180, 1), (190, 1), (200, 1), (210, 1), (220, 1), (230, 1), (240, 1), (250, 1), (260, 0), (270, 1), (280, 1), (290, 1), (300, 1), (310, 0), (320, 1), (330, 1), (340, 1), (350, 0), (360, 1), (370, 1), (380, 1), (390, 0), (400, 0), (410, 1), (420, 0), (430, 1), (440, 1), (450, 0), (460, 1), (470, 0), (480, 1), (490, 0), (500, 0), (510, 1), (520, 1), (530, 1), (540, 1), (550, 1), (560, 1), (570, 1), (580, 1), (590, 1), (600, 1), (610, 1), (620, 0), (630, 1), (640, 1), (650, 1), (660, 0), (670, 0), (680, 1), (690, 1), (700, 1), (710, 0), (720, 1), (730, 1), (740, 1), (750, 1), (760, 1), (770, 0), (780, 1), (790, 1), (800, 1), (810, 1), (820, 0), (830, 1), (840, 0), (850, 1), (860, 1), (870, 1), (880, 1), (890, 0), (900, 1), (910, 1), (920, 1), (930, 0), (940, 1), (950, 1), (960, 0), (970, 1), (980, 1), (990, 1), (1000, 1), (1010, 1), (1020, 1), (1030, 1), (1040, 1), (1050, 1), (1060, 1), (1070, 1), (1080, 0), (1090, 1), (1100, 1), (1110, 1), (1120, 1), (1130, 0), (1140, 1), (1150, 1), (1160, 1), (1170, 1), (1180, 1), (1190, 1), (1200, 1), (1210, 1), (1220, 1), (1230, 1), (1240, 1), (1250, 1), (1260, 0), (1270, 1), (1280, 0), (1290, 1), (1300, 1), (1310, 1), (1320, 1), (1330, 1), (1340, 1), (1350, 1), (1360, 1), (1370, 0), (1380, 1), (1390, 1), (1400, 0), (1410, 1), (1420, 1), (1430, 0), (1440, 1), (1450, 1), (1460, 1), (1470, 1), (1480, 0), (1490, 1), (1500, 0), (1510, 1), (1520, 1), (1530, 1), (1540, 1), (1550, 1), (1560, 1), (1570, 0), (1580, 0), (1590, 0), (1600, 1), (1610, 1), (1620, 0), (1630, 1), (1640, 1), (1650, 1), (1660, 1), (1670, 1), (1680, 1), (1690, 0), (1700, 1), (1710, 0), (1720, 1), (1730, 0), (1740, 0), (1750, 1), (1760, 1), (1770, 1), (1780, 1), (1790, 0), (1800, 1), (1810, 1), (1820, 1), (1830, 1), (1840, 1), (1850, 0), (1860, 0), (1870, 0), (1880, 0), (1890, 0), (1900, 1), (1910, 0), (1920, 1), (1930, 1), (1940, 1), (1950, 1), (1960, 1), (1970, 1), (1980, 1), (1990, 1), (2000, 1), (2010, 1), (2020, 1), (2030, 0), (2040, 1), (2050, 1)]
VWEB0 WEB0 0 PWL (0n 1.8v 9.495n 1.8v 9.505n 0.0v 19.495n 0.0v 19.505n 0.0v 29.495n 0.0v 29.505n 0.0v 39.495n 0.0v 39.505n 1.8v 49.495n 1.8v 49.505n 1.8v 59.495n 1.8v 59.505n 0.0v 69.495n 0.0v 69.505n 1.8v 79.495n 1.8v 79.505n 1.8v 89.495n 1.8v 89.505n 1.8v 99.495n 1.8v 99.505n 1.8v 109.495n 1.8v 109.505n 1.8v 119.495n 1.8v 119.505n 1.8v 129.495n 1.8v 129.505n 1.8v 139.495n 1.8v 139.505n 1.8v 149.495n 1.8v 149.505n 0.0v 159.495n 0.0v 159.505n 1.8v 169.495n 1.8v 169.505n 1.8v 179.495n 1.8v 179.505n 1.8v 189.495n 1.8v 189.505n 1.8v 199.495n 1.8v 199.505n 1.8v 209.495n 1.8v 209.505n 1.8v 219.495n 1.8v 219.505n 1.8v 229.495n 1.8v 229.505n 1.8v 239.495n 1.8v 239.505n 1.8v 249.495n 1.8v 249.505n 1.8v 259.495n 1.8v 259.505n 0.0v 269.495n 0.0v 269.505n 1.8v 279.495n 1.8v 279.505n 1.8v 289.495n 1.8v 289.505n 1.8v 299.495n 1.8v 299.505n 1.8v 309.495n 1.8v 309.505n 0.0v 319.495n 0.0v 319.505n 1.8v 329.495n 1.8v 329.505n 1.8v 339.495n 1.8v 339.505n 1.8v 349.495n 1.8v 349.505n 0.0v 359.495n 0.0v 359.505n 1.8v 369.495n 1.8v 369.505n 1.8v 379.495n 1.8v 379.505n 1.8v 389.495n 1.8v 389.505n 0.0v 399.495n 0.0v 399.505n 0.0v 409.495n 0.0v 409.505n 1.8v 419.495n 1.8v 419.505n 0.0v 429.495n 0.0v 429.505n 1.8v 439.495n 1.8v 439.505n 1.8v 449.495n 1.8v 449.505n 0.0v 459.495n 0.0v 459.505n 1.8v 469.495n 1.8v 469.505n 0.0v 479.495n 0.0v 479.505n 1.8v 489.495n 1.8v 489.505n 0.0v 499.495n 0.0v 499.505n 0.0v 509.495n 0.0v 509.505n 1.8v 519.495n 1.8v 519.505n 1.8v 529.495n 1.8v 529.505n 1.8v 539.495n 1.8v 539.505n 1.8v 549.495n 1.8v 549.505n 1.8v 559.495n 1.8v 559.505n 1.8v 569.495n 1.8v 569.505n 1.8v 579.495n 1.8v 579.505n 1.8v 589.495n 1.8v 589.505n 1.8v 599.495n 1.8v 599.505n 1.8v 609.495n 1.8v 609.505n 1.8v 619.495n 1.8v 619.505n 0.0v 629.495n 0.0v 629.505n 1.8v 639.495n 1.8v 639.505n 1.8v 649.495n 1.8v 649.505n 1.8v 659.495n 1.8v 659.505n 0.0v 669.495n 0.0v 669.505n 0.0v 679.495n 0.0v 679.505n 1.8v 689.495n 1.8v 689.505n 1.8v 699.495n 1.8v 699.505n 1.8v 709.495n 1.8v 709.505n 0.0v 719.495n 0.0v 719.505n 1.8v 729.495n 1.8v 729.505n 1.8v 739.495n 1.8v 739.505n 1.8v 749.495n 1.8v 749.505n 1.8v 759.495n 1.8v 759.505n 1.8v 769.495n 1.8v 769.505n 0.0v 779.495n 0.0v 779.505n 1.8v 789.495n 1.8v 789.505n 1.8v 799.495n 1.8v 799.505n 1.8v 809.495n 1.8v 809.505n 1.8v 819.495n 1.8v 819.505n 0.0v 829.495n 0.0v 829.505n 1.8v 839.495n 1.8v 839.505n 0.0v 849.495n 0.0v 849.505n 1.8v 859.495n 1.8v 859.505n 1.8v 869.495n 1.8v 869.505n 1.8v 879.495n 1.8v 879.505n 1.8v 889.495n 1.8v 889.505n 0.0v 899.495n 0.0v 899.505n 1.8v 909.495n 1.8v 909.505n 1.8v 919.495n 1.8v 919.505n 1.8v 929.495n 1.8v 929.505n 0.0v 939.495n 0.0v 939.505n 1.8v 949.495n 1.8v 949.505n 1.8v 959.495n 1.8v 959.505n 0.0v 969.495n 0.0v 969.505n 1.8v 979.495n 1.8v 979.505n 1.8v 989.495n 1.8v 989.505n 1.8v 999.495n 1.8v 999.505n 1.8v 1009.495n 1.8v 1009.505n 1.8v 1019.495n 1.8v 1019.505n 1.8v 1029.495n 1.8v 1029.505n 1.8v 1039.495n 1.8v 1039.505n 1.8v 1049.495n 1.8v 1049.505n 1.8v 1059.495n 1.8v 1059.505n 1.8v 1069.495n 1.8v 1069.505n 1.8v 1079.495n 1.8v 1079.505n 0.0v 1089.495n 0.0v 1089.505n 1.8v 1099.495n 1.8v 1099.505n 1.8v 1109.495n 1.8v 1109.505n 1.8v 1119.495n 1.8v 1119.505n 1.8v 1129.495n 1.8v 1129.505n 0.0v 1139.495n 0.0v 1139.505n 1.8v 1149.495n 1.8v 1149.505n 1.8v 1159.495n 1.8v 1159.505n 1.8v 1169.495n 1.8v 1169.505n 1.8v 1179.495n 1.8v 1179.505n 1.8v 1189.495n 1.8v 1189.505n 1.8v 1199.495n 1.8v 1199.505n 1.8v 1209.495n 1.8v 1209.505n 1.8v 1219.495n 1.8v 1219.505n 1.8v 1229.495n 1.8v 1229.505n 1.8v 1239.495n 1.8v 1239.505n 1.8v 1249.495n 1.8v 1249.505n 1.8v 1259.495n 1.8v 1259.505n 0.0v 1269.495n 0.0v 1269.505n 1.8v 1279.495n 1.8v 1279.505n 0.0v 1289.495n 0.0v 1289.505n 1.8v 1299.495n 1.8v 1299.505n 1.8v 1309.495n 1.8v 1309.505n 1.8v 1319.495n 1.8v 1319.505n 1.8v 1329.495n 1.8v 1329.505n 1.8v 1339.495n 1.8v 1339.505n 1.8v 1349.495n 1.8v 1349.505n 1.8v 1359.495n 1.8v 1359.505n 1.8v 1369.495n 1.8v 1369.505n 0.0v 1379.495n 0.0v 1379.505n 1.8v 1389.495n 1.8v 1389.505n 1.8v 1399.495n 1.8v 1399.505n 0.0v 1409.495n 0.0v 1409.505n 1.8v 1419.495n 1.8v 1419.505n 1.8v 1429.495n 1.8v 1429.505n 0.0v 1439.495n 0.0v 1439.505n 1.8v 1449.495n 1.8v 1449.505n 1.8v 1459.495n 1.8v 1459.505n 1.8v 1469.495n 1.8v 1469.505n 1.8v 1479.495n 1.8v 1479.505n 0.0v 1489.495n 0.0v 1489.505n 1.8v 1499.495n 1.8v 1499.505n 0.0v 1509.495n 0.0v 1509.505n 1.8v 1519.495n 1.8v 1519.505n 1.8v 1529.495n 1.8v 1529.505n 1.8v 1539.495n 1.8v 1539.505n 1.8v 1549.495n 1.8v 1549.505n 1.8v 1559.495n 1.8v 1559.505n 1.8v 1569.495n 1.8v 1569.505n 0.0v 1579.495n 0.0v 1579.505n 0.0v 1589.495n 0.0v 1589.505n 0.0v 1599.495n 0.0v 1599.505n 1.8v 1609.495n 1.8v 1609.505n 1.8v 1619.495n 1.8v 1619.505n 0.0v 1629.495n 0.0v 1629.505n 1.8v 1639.495n 1.8v 1639.505n 1.8v 1649.495n 1.8v 1649.505n 1.8v 1659.495n 1.8v 1659.505n 1.8v 1669.495n 1.8v 1669.505n 1.8v 1679.495n 1.8v 1679.505n 1.8v 1689.495n 1.8v 1689.505n 0.0v 1699.495n 0.0v 1699.505n 1.8v 1709.495n 1.8v 1709.505n 0.0v 1719.495n 0.0v 1719.505n 1.8v 1729.495n 1.8v 1729.505n 0.0v 1739.495n 0.0v 1739.505n 0.0v 1749.495n 0.0v 1749.505n 1.8v 1759.495n 1.8v 1759.505n 1.8v 1769.495n 1.8v 1769.505n 1.8v 1779.495n 1.8v 1779.505n 1.8v 1789.495n 1.8v 1789.505n 0.0v 1799.495n 0.0v 1799.505n 1.8v 1809.495n 1.8v 1809.505n 1.8v 1819.495n 1.8v 1819.505n 1.8v 1829.495n 1.8v 1829.505n 1.8v 1839.495n 1.8v 1839.505n 1.8v 1849.495n 1.8v 1849.505n 0.0v 1859.495n 0.0v 1859.505n 0.0v 1869.495n 0.0v 1869.505n 0.0v 1879.495n 0.0v 1879.505n 0.0v 1889.495n 0.0v 1889.505n 0.0v 1899.495n 0.0v 1899.505n 1.8v 1909.495n 1.8v 1909.505n 0.0v 1919.495n 0.0v 1919.505n 1.8v 1929.495n 1.8v 1929.505n 1.8v 1939.495n 1.8v 1939.505n 1.8v 1949.495n 1.8v 1949.505n 1.8v 1959.495n 1.8v 1959.505n 1.8v 1969.495n 1.8v 1969.505n 1.8v 1979.495n 1.8v 1979.505n 1.8v 1989.495n 1.8v 1989.505n 1.8v 1999.495n 1.8v 1999.505n 1.8v 2009.495n 1.8v 2009.505n 1.8v 2019.495n 1.8v 2019.505n 1.8v 2029.495n 1.8v 2029.505n 0.0v 2039.495n 0.0v 2039.505n 1.8v 2049.495n 1.8v 2049.505n 1.8v )
* PULSE: period=10
Vclk0 clk0 0 PULSE (0 1.8 9.995n 0.01n 0.01n 4.99n 10n)
* PULSE: period=10
Vclk1 clk1 0 PULSE (0 1.8 9.995n 0.01n 0.01n 4.99n 10n)

 * Generation of dout measurements
* CHECK dout0_0 vdout0_0ck4 = 1.8 time = 50
* CHECK dout0_1 vdout0_1ck4 = 0 time = 50
* CHECK dout0_2 vdout0_2ck4 = 1.8 time = 50
* CHECK dout0_3 vdout0_3ck4 = 1.8 time = 50
* CHECK dout0_4 vdout0_4ck4 = 0 time = 50
* CHECK dout0_5 vdout0_5ck4 = 1.8 time = 50
* CHECK dout0_6 vdout0_6ck4 = 0 time = 50
* CHECK dout0_7 vdout0_7ck4 = 0 time = 50
* CHECK dout0_8 vdout0_8ck4 = 0 time = 50
* CHECK dout0_9 vdout0_9ck4 = 0 time = 50
* CHECK dout0_10 vdout0_10ck4 = 1.8 time = 50
* CHECK dout0_11 vdout0_11ck4 = 1.8 time = 50
* CHECK dout0_12 vdout0_12ck4 = 0 time = 50
* CHECK dout0_13 vdout0_13ck4 = 0 time = 50
* CHECK dout0_14 vdout0_14ck4 = 1.8 time = 50
* CHECK dout0_15 vdout0_15ck4 = 0 time = 50
* CHECK dout0_16 vdout0_16ck4 = 0 time = 50
* CHECK dout0_17 vdout0_17ck4 = 0 time = 50
* CHECK dout0_18 vdout0_18ck4 = 0 time = 50
* CHECK dout0_19 vdout0_19ck4 = 0 time = 50
* CHECK dout0_20 vdout0_20ck4 = 1.8 time = 50
* CHECK dout0_21 vdout0_21ck4 = 1.8 time = 50
* CHECK dout0_22 vdout0_22ck4 = 1.8 time = 50
* CHECK dout0_23 vdout0_23ck4 = 1.8 time = 50
* CHECK dout0_24 vdout0_24ck4 = 0 time = 50
* CHECK dout0_25 vdout0_25ck4 = 0 time = 50
* CHECK dout0_26 vdout0_26ck4 = 1.8 time = 50
* CHECK dout0_27 vdout0_27ck4 = 0 time = 50
* CHECK dout0_28 vdout0_28ck4 = 0 time = 50
* CHECK dout0_29 vdout0_29ck4 = 0 time = 50
* CHECK dout0_30 vdout0_30ck4 = 1.8 time = 50
* CHECK dout0_31 vdout0_31ck4 = 0 time = 50
* CHECK dout0_32 vdout0_32ck4 = 1.8 time = 50
* CHECK dout0_33 vdout0_33ck4 = 0 time = 50
* CHECK dout0_34 vdout0_34ck4 = 1.8 time = 50
* CHECK dout0_35 vdout0_35ck4 = 0 time = 50
* CHECK dout0_36 vdout0_36ck4 = 1.8 time = 50
* CHECK dout0_37 vdout0_37ck4 = 1.8 time = 50
* CHECK dout0_38 vdout0_38ck4 = 1.8 time = 50
* CHECK dout0_39 vdout0_39ck4 = 1.8 time = 50
* CHECK dout0_40 vdout0_40ck4 = 0 time = 50
* CHECK dout0_41 vdout0_41ck4 = 0 time = 50
* CHECK dout0_42 vdout0_42ck4 = 0 time = 50
* CHECK dout0_43 vdout0_43ck4 = 0 time = 50
* CHECK dout0_44 vdout0_44ck4 = 1.8 time = 50
* CHECK dout0_45 vdout0_45ck4 = 0 time = 50
* CHECK dout0_46 vdout0_46ck4 = 0 time = 50
* CHECK dout0_47 vdout0_47ck4 = 1.8 time = 50
* CHECK dout0_48 vdout0_48ck4 = 1.8 time = 50
* CHECK dout0_49 vdout0_49ck4 = 0 time = 50
* CHECK dout0_50 vdout0_50ck4 = 1.8 time = 50
* CHECK dout0_51 vdout0_51ck4 = 0 time = 50
* CHECK dout0_52 vdout0_52ck4 = 1.8 time = 50
* CHECK dout0_53 vdout0_53ck4 = 1.8 time = 50
* CHECK dout0_54 vdout0_54ck4 = 1.8 time = 50
* CHECK dout0_55 vdout0_55ck4 = 1.8 time = 50
* CHECK dout0_56 vdout0_56ck4 = 1.8 time = 50
* CHECK dout0_57 vdout0_57ck4 = 1.8 time = 50
* CHECK dout0_58 vdout0_58ck4 = 0 time = 50
* CHECK dout0_59 vdout0_59ck4 = 1.8 time = 50
* CHECK dout0_60 vdout0_60ck4 = 0 time = 50
* CHECK dout0_61 vdout0_61ck4 = 0 time = 50
* CHECK dout0_62 vdout0_62ck4 = 0 time = 50
* CHECK dout0_63 vdout0_63ck4 = 0 time = 50
* CHECK dout1_0 vdout1_0ck4 = 1.8 time = 50
* CHECK dout1_1 vdout1_1ck4 = 0 time = 50
* CHECK dout1_2 vdout1_2ck4 = 1.8 time = 50
* CHECK dout1_3 vdout1_3ck4 = 1.8 time = 50
* CHECK dout1_4 vdout1_4ck4 = 0 time = 50
* CHECK dout1_5 vdout1_5ck4 = 1.8 time = 50
* CHECK dout1_6 vdout1_6ck4 = 0 time = 50
* CHECK dout1_7 vdout1_7ck4 = 0 time = 50
* CHECK dout1_8 vdout1_8ck4 = 0 time = 50
* CHECK dout1_9 vdout1_9ck4 = 0 time = 50
* CHECK dout1_10 vdout1_10ck4 = 1.8 time = 50
* CHECK dout1_11 vdout1_11ck4 = 1.8 time = 50
* CHECK dout1_12 vdout1_12ck4 = 0 time = 50
* CHECK dout1_13 vdout1_13ck4 = 0 time = 50
* CHECK dout1_14 vdout1_14ck4 = 1.8 time = 50
* CHECK dout1_15 vdout1_15ck4 = 0 time = 50
* CHECK dout1_16 vdout1_16ck4 = 0 time = 50
* CHECK dout1_17 vdout1_17ck4 = 0 time = 50
* CHECK dout1_18 vdout1_18ck4 = 0 time = 50
* CHECK dout1_19 vdout1_19ck4 = 0 time = 50
* CHECK dout1_20 vdout1_20ck4 = 1.8 time = 50
* CHECK dout1_21 vdout1_21ck4 = 1.8 time = 50
* CHECK dout1_22 vdout1_22ck4 = 1.8 time = 50
* CHECK dout1_23 vdout1_23ck4 = 1.8 time = 50
* CHECK dout1_24 vdout1_24ck4 = 0 time = 50
* CHECK dout1_25 vdout1_25ck4 = 0 time = 50
* CHECK dout1_26 vdout1_26ck4 = 1.8 time = 50
* CHECK dout1_27 vdout1_27ck4 = 0 time = 50
* CHECK dout1_28 vdout1_28ck4 = 0 time = 50
* CHECK dout1_29 vdout1_29ck4 = 0 time = 50
* CHECK dout1_30 vdout1_30ck4 = 1.8 time = 50
* CHECK dout1_31 vdout1_31ck4 = 0 time = 50
* CHECK dout1_32 vdout1_32ck4 = 1.8 time = 50
* CHECK dout1_33 vdout1_33ck4 = 0 time = 50
* CHECK dout1_34 vdout1_34ck4 = 1.8 time = 50
* CHECK dout1_35 vdout1_35ck4 = 0 time = 50
* CHECK dout1_36 vdout1_36ck4 = 1.8 time = 50
* CHECK dout1_37 vdout1_37ck4 = 1.8 time = 50
* CHECK dout1_38 vdout1_38ck4 = 1.8 time = 50
* CHECK dout1_39 vdout1_39ck4 = 1.8 time = 50
* CHECK dout1_40 vdout1_40ck4 = 0 time = 50
* CHECK dout1_41 vdout1_41ck4 = 0 time = 50
* CHECK dout1_42 vdout1_42ck4 = 0 time = 50
* CHECK dout1_43 vdout1_43ck4 = 0 time = 50
* CHECK dout1_44 vdout1_44ck4 = 1.8 time = 50
* CHECK dout1_45 vdout1_45ck4 = 0 time = 50
* CHECK dout1_46 vdout1_46ck4 = 0 time = 50
* CHECK dout1_47 vdout1_47ck4 = 1.8 time = 50
* CHECK dout1_48 vdout1_48ck4 = 1.8 time = 50
* CHECK dout1_49 vdout1_49ck4 = 0 time = 50
* CHECK dout1_50 vdout1_50ck4 = 1.8 time = 50
* CHECK dout1_51 vdout1_51ck4 = 0 time = 50
* CHECK dout1_52 vdout1_52ck4 = 1.8 time = 50
* CHECK dout1_53 vdout1_53ck4 = 1.8 time = 50
* CHECK dout1_54 vdout1_54ck4 = 1.8 time = 50
* CHECK dout1_55 vdout1_55ck4 = 1.8 time = 50
* CHECK dout1_56 vdout1_56ck4 = 1.8 time = 50
* CHECK dout1_57 vdout1_57ck4 = 1.8 time = 50
* CHECK dout1_58 vdout1_58ck4 = 0 time = 50
* CHECK dout1_59 vdout1_59ck4 = 1.8 time = 50
* CHECK dout1_60 vdout1_60ck4 = 0 time = 50
* CHECK dout1_61 vdout1_61ck4 = 0 time = 50
* CHECK dout1_62 vdout1_62ck4 = 0 time = 50
* CHECK dout1_63 vdout1_63ck4 = 0 time = 50
* CHECK dout0_0 vdout0_0ck5 = 1.8 time = 60
* CHECK dout0_1 vdout0_1ck5 = 0 time = 60
* CHECK dout0_2 vdout0_2ck5 = 1.8 time = 60
* CHECK dout0_3 vdout0_3ck5 = 1.8 time = 60
* CHECK dout0_4 vdout0_4ck5 = 1.8 time = 60
* CHECK dout0_5 vdout0_5ck5 = 1.8 time = 60
* CHECK dout0_6 vdout0_6ck5 = 0 time = 60
* CHECK dout0_7 vdout0_7ck5 = 1.8 time = 60
* CHECK dout0_8 vdout0_8ck5 = 0 time = 60
* CHECK dout0_9 vdout0_9ck5 = 0 time = 60
* CHECK dout0_10 vdout0_10ck5 = 0 time = 60
* CHECK dout0_11 vdout0_11ck5 = 0 time = 60
* CHECK dout0_12 vdout0_12ck5 = 0 time = 60
* CHECK dout0_13 vdout0_13ck5 = 1.8 time = 60
* CHECK dout0_14 vdout0_14ck5 = 1.8 time = 60
* CHECK dout0_15 vdout0_15ck5 = 1.8 time = 60
* CHECK dout0_16 vdout0_16ck5 = 1.8 time = 60
* CHECK dout0_17 vdout0_17ck5 = 0 time = 60
* CHECK dout0_18 vdout0_18ck5 = 0 time = 60
* CHECK dout0_19 vdout0_19ck5 = 0 time = 60
* CHECK dout0_20 vdout0_20ck5 = 0 time = 60
* CHECK dout0_21 vdout0_21ck5 = 0 time = 60
* CHECK dout0_22 vdout0_22ck5 = 1.8 time = 60
* CHECK dout0_23 vdout0_23ck5 = 1.8 time = 60
* CHECK dout0_24 vdout0_24ck5 = 0 time = 60
* CHECK dout0_25 vdout0_25ck5 = 0 time = 60
* CHECK dout0_26 vdout0_26ck5 = 0 time = 60
* CHECK dout0_27 vdout0_27ck5 = 1.8 time = 60
* CHECK dout0_28 vdout0_28ck5 = 1.8 time = 60
* CHECK dout0_29 vdout0_29ck5 = 0 time = 60
* CHECK dout0_30 vdout0_30ck5 = 0 time = 60
* CHECK dout0_31 vdout0_31ck5 = 0 time = 60
* CHECK dout0_32 vdout0_32ck5 = 1.8 time = 60
* CHECK dout0_33 vdout0_33ck5 = 1.8 time = 60
* CHECK dout0_34 vdout0_34ck5 = 1.8 time = 60
* CHECK dout0_35 vdout0_35ck5 = 0 time = 60
* CHECK dout0_36 vdout0_36ck5 = 1.8 time = 60
* CHECK dout0_37 vdout0_37ck5 = 1.8 time = 60
* CHECK dout0_38 vdout0_38ck5 = 0 time = 60
* CHECK dout0_39 vdout0_39ck5 = 0 time = 60
* CHECK dout0_40 vdout0_40ck5 = 0 time = 60
* CHECK dout0_41 vdout0_41ck5 = 0 time = 60
* CHECK dout0_42 vdout0_42ck5 = 0 time = 60
* CHECK dout0_43 vdout0_43ck5 = 1.8 time = 60
* CHECK dout0_44 vdout0_44ck5 = 1.8 time = 60
* CHECK dout0_45 vdout0_45ck5 = 1.8 time = 60
* CHECK dout0_46 vdout0_46ck5 = 1.8 time = 60
* CHECK dout0_47 vdout0_47ck5 = 0 time = 60
* CHECK dout0_48 vdout0_48ck5 = 1.8 time = 60
* CHECK dout0_49 vdout0_49ck5 = 1.8 time = 60
* CHECK dout0_50 vdout0_50ck5 = 0 time = 60
* CHECK dout0_51 vdout0_51ck5 = 0 time = 60
* CHECK dout0_52 vdout0_52ck5 = 0 time = 60
* CHECK dout0_53 vdout0_53ck5 = 0 time = 60
* CHECK dout0_54 vdout0_54ck5 = 1.8 time = 60
* CHECK dout0_55 vdout0_55ck5 = 1.8 time = 60
* CHECK dout0_56 vdout0_56ck5 = 0 time = 60
* CHECK dout0_57 vdout0_57ck5 = 0 time = 60
* CHECK dout0_58 vdout0_58ck5 = 1.8 time = 60
* CHECK dout0_59 vdout0_59ck5 = 0 time = 60
* CHECK dout0_60 vdout0_60ck5 = 0 time = 60
* CHECK dout0_61 vdout0_61ck5 = 0 time = 60
* CHECK dout0_62 vdout0_62ck5 = 1.8 time = 60
* CHECK dout0_63 vdout0_63ck5 = 1.8 time = 60
* CHECK dout1_0 vdout1_0ck5 = 1.8 time = 60
* CHECK dout1_1 vdout1_1ck5 = 0 time = 60
* CHECK dout1_2 vdout1_2ck5 = 1.8 time = 60
* CHECK dout1_3 vdout1_3ck5 = 1.8 time = 60
* CHECK dout1_4 vdout1_4ck5 = 0 time = 60
* CHECK dout1_5 vdout1_5ck5 = 1.8 time = 60
* CHECK dout1_6 vdout1_6ck5 = 0 time = 60
* CHECK dout1_7 vdout1_7ck5 = 0 time = 60
* CHECK dout1_8 vdout1_8ck5 = 0 time = 60
* CHECK dout1_9 vdout1_9ck5 = 0 time = 60
* CHECK dout1_10 vdout1_10ck5 = 1.8 time = 60
* CHECK dout1_11 vdout1_11ck5 = 1.8 time = 60
* CHECK dout1_12 vdout1_12ck5 = 0 time = 60
* CHECK dout1_13 vdout1_13ck5 = 0 time = 60
* CHECK dout1_14 vdout1_14ck5 = 1.8 time = 60
* CHECK dout1_15 vdout1_15ck5 = 0 time = 60
* CHECK dout1_16 vdout1_16ck5 = 0 time = 60
* CHECK dout1_17 vdout1_17ck5 = 0 time = 60
* CHECK dout1_18 vdout1_18ck5 = 0 time = 60
* CHECK dout1_19 vdout1_19ck5 = 0 time = 60
* CHECK dout1_20 vdout1_20ck5 = 1.8 time = 60
* CHECK dout1_21 vdout1_21ck5 = 1.8 time = 60
* CHECK dout1_22 vdout1_22ck5 = 1.8 time = 60
* CHECK dout1_23 vdout1_23ck5 = 1.8 time = 60
* CHECK dout1_24 vdout1_24ck5 = 0 time = 60
* CHECK dout1_25 vdout1_25ck5 = 0 time = 60
* CHECK dout1_26 vdout1_26ck5 = 1.8 time = 60
* CHECK dout1_27 vdout1_27ck5 = 0 time = 60
* CHECK dout1_28 vdout1_28ck5 = 0 time = 60
* CHECK dout1_29 vdout1_29ck5 = 0 time = 60
* CHECK dout1_30 vdout1_30ck5 = 1.8 time = 60
* CHECK dout1_31 vdout1_31ck5 = 0 time = 60
* CHECK dout1_32 vdout1_32ck5 = 1.8 time = 60
* CHECK dout1_33 vdout1_33ck5 = 0 time = 60
* CHECK dout1_34 vdout1_34ck5 = 1.8 time = 60
* CHECK dout1_35 vdout1_35ck5 = 0 time = 60
* CHECK dout1_36 vdout1_36ck5 = 1.8 time = 60
* CHECK dout1_37 vdout1_37ck5 = 1.8 time = 60
* CHECK dout1_38 vdout1_38ck5 = 1.8 time = 60
* CHECK dout1_39 vdout1_39ck5 = 1.8 time = 60
* CHECK dout1_40 vdout1_40ck5 = 0 time = 60
* CHECK dout1_41 vdout1_41ck5 = 0 time = 60
* CHECK dout1_42 vdout1_42ck5 = 0 time = 60
* CHECK dout1_43 vdout1_43ck5 = 0 time = 60
* CHECK dout1_44 vdout1_44ck5 = 1.8 time = 60
* CHECK dout1_45 vdout1_45ck5 = 0 time = 60
* CHECK dout1_46 vdout1_46ck5 = 0 time = 60
* CHECK dout1_47 vdout1_47ck5 = 1.8 time = 60
* CHECK dout1_48 vdout1_48ck5 = 1.8 time = 60
* CHECK dout1_49 vdout1_49ck5 = 0 time = 60
* CHECK dout1_50 vdout1_50ck5 = 1.8 time = 60
* CHECK dout1_51 vdout1_51ck5 = 0 time = 60
* CHECK dout1_52 vdout1_52ck5 = 1.8 time = 60
* CHECK dout1_53 vdout1_53ck5 = 1.8 time = 60
* CHECK dout1_54 vdout1_54ck5 = 1.8 time = 60
* CHECK dout1_55 vdout1_55ck5 = 1.8 time = 60
* CHECK dout1_56 vdout1_56ck5 = 1.8 time = 60
* CHECK dout1_57 vdout1_57ck5 = 1.8 time = 60
* CHECK dout1_58 vdout1_58ck5 = 0 time = 60
* CHECK dout1_59 vdout1_59ck5 = 1.8 time = 60
* CHECK dout1_60 vdout1_60ck5 = 0 time = 60
* CHECK dout1_61 vdout1_61ck5 = 0 time = 60
* CHECK dout1_62 vdout1_62ck5 = 0 time = 60
* CHECK dout1_63 vdout1_63ck5 = 0 time = 60
* CHECK dout0_0 vdout0_0ck7 = 1.8 time = 80
* CHECK dout0_1 vdout0_1ck7 = 0 time = 80
* CHECK dout0_2 vdout0_2ck7 = 1.8 time = 80
* CHECK dout0_3 vdout0_3ck7 = 1.8 time = 80
* CHECK dout0_4 vdout0_4ck7 = 1.8 time = 80
* CHECK dout0_5 vdout0_5ck7 = 1.8 time = 80
* CHECK dout0_6 vdout0_6ck7 = 0 time = 80
* CHECK dout0_7 vdout0_7ck7 = 1.8 time = 80
* CHECK dout0_8 vdout0_8ck7 = 0 time = 80
* CHECK dout0_9 vdout0_9ck7 = 0 time = 80
* CHECK dout0_10 vdout0_10ck7 = 0 time = 80
* CHECK dout0_11 vdout0_11ck7 = 0 time = 80
* CHECK dout0_12 vdout0_12ck7 = 0 time = 80
* CHECK dout0_13 vdout0_13ck7 = 1.8 time = 80
* CHECK dout0_14 vdout0_14ck7 = 1.8 time = 80
* CHECK dout0_15 vdout0_15ck7 = 1.8 time = 80
* CHECK dout0_16 vdout0_16ck7 = 1.8 time = 80
* CHECK dout0_17 vdout0_17ck7 = 0 time = 80
* CHECK dout0_18 vdout0_18ck7 = 0 time = 80
* CHECK dout0_19 vdout0_19ck7 = 0 time = 80
* CHECK dout0_20 vdout0_20ck7 = 0 time = 80
* CHECK dout0_21 vdout0_21ck7 = 0 time = 80
* CHECK dout0_22 vdout0_22ck7 = 1.8 time = 80
* CHECK dout0_23 vdout0_23ck7 = 1.8 time = 80
* CHECK dout0_24 vdout0_24ck7 = 0 time = 80
* CHECK dout0_25 vdout0_25ck7 = 0 time = 80
* CHECK dout0_26 vdout0_26ck7 = 0 time = 80
* CHECK dout0_27 vdout0_27ck7 = 1.8 time = 80
* CHECK dout0_28 vdout0_28ck7 = 1.8 time = 80
* CHECK dout0_29 vdout0_29ck7 = 0 time = 80
* CHECK dout0_30 vdout0_30ck7 = 0 time = 80
* CHECK dout0_31 vdout0_31ck7 = 0 time = 80
* CHECK dout0_32 vdout0_32ck7 = 1.8 time = 80
* CHECK dout0_33 vdout0_33ck7 = 1.8 time = 80
* CHECK dout0_34 vdout0_34ck7 = 1.8 time = 80
* CHECK dout0_35 vdout0_35ck7 = 0 time = 80
* CHECK dout0_36 vdout0_36ck7 = 1.8 time = 80
* CHECK dout0_37 vdout0_37ck7 = 1.8 time = 80
* CHECK dout0_38 vdout0_38ck7 = 0 time = 80
* CHECK dout0_39 vdout0_39ck7 = 0 time = 80
* CHECK dout0_40 vdout0_40ck7 = 0 time = 80
* CHECK dout0_41 vdout0_41ck7 = 0 time = 80
* CHECK dout0_42 vdout0_42ck7 = 0 time = 80
* CHECK dout0_43 vdout0_43ck7 = 1.8 time = 80
* CHECK dout0_44 vdout0_44ck7 = 1.8 time = 80
* CHECK dout0_45 vdout0_45ck7 = 1.8 time = 80
* CHECK dout0_46 vdout0_46ck7 = 1.8 time = 80
* CHECK dout0_47 vdout0_47ck7 = 0 time = 80
* CHECK dout0_48 vdout0_48ck7 = 1.8 time = 80
* CHECK dout0_49 vdout0_49ck7 = 1.8 time = 80
* CHECK dout0_50 vdout0_50ck7 = 0 time = 80
* CHECK dout0_51 vdout0_51ck7 = 0 time = 80
* CHECK dout0_52 vdout0_52ck7 = 0 time = 80
* CHECK dout0_53 vdout0_53ck7 = 0 time = 80
* CHECK dout0_54 vdout0_54ck7 = 1.8 time = 80
* CHECK dout0_55 vdout0_55ck7 = 1.8 time = 80
* CHECK dout0_56 vdout0_56ck7 = 0 time = 80
* CHECK dout0_57 vdout0_57ck7 = 0 time = 80
* CHECK dout0_58 vdout0_58ck7 = 1.8 time = 80
* CHECK dout0_59 vdout0_59ck7 = 0 time = 80
* CHECK dout0_60 vdout0_60ck7 = 0 time = 80
* CHECK dout0_61 vdout0_61ck7 = 0 time = 80
* CHECK dout0_62 vdout0_62ck7 = 1.8 time = 80
* CHECK dout0_63 vdout0_63ck7 = 1.8 time = 80
* CHECK dout0_0 vdout0_0ck8 = 1.8 time = 90
* CHECK dout0_1 vdout0_1ck8 = 0 time = 90
* CHECK dout0_2 vdout0_2ck8 = 1.8 time = 90
* CHECK dout0_3 vdout0_3ck8 = 1.8 time = 90
* CHECK dout0_4 vdout0_4ck8 = 1.8 time = 90
* CHECK dout0_5 vdout0_5ck8 = 1.8 time = 90
* CHECK dout0_6 vdout0_6ck8 = 0 time = 90
* CHECK dout0_7 vdout0_7ck8 = 1.8 time = 90
* CHECK dout0_8 vdout0_8ck8 = 0 time = 90
* CHECK dout0_9 vdout0_9ck8 = 0 time = 90
* CHECK dout0_10 vdout0_10ck8 = 0 time = 90
* CHECK dout0_11 vdout0_11ck8 = 0 time = 90
* CHECK dout0_12 vdout0_12ck8 = 0 time = 90
* CHECK dout0_13 vdout0_13ck8 = 1.8 time = 90
* CHECK dout0_14 vdout0_14ck8 = 1.8 time = 90
* CHECK dout0_15 vdout0_15ck8 = 1.8 time = 90
* CHECK dout0_16 vdout0_16ck8 = 1.8 time = 90
* CHECK dout0_17 vdout0_17ck8 = 0 time = 90
* CHECK dout0_18 vdout0_18ck8 = 0 time = 90
* CHECK dout0_19 vdout0_19ck8 = 0 time = 90
* CHECK dout0_20 vdout0_20ck8 = 0 time = 90
* CHECK dout0_21 vdout0_21ck8 = 0 time = 90
* CHECK dout0_22 vdout0_22ck8 = 1.8 time = 90
* CHECK dout0_23 vdout0_23ck8 = 1.8 time = 90
* CHECK dout0_24 vdout0_24ck8 = 0 time = 90
* CHECK dout0_25 vdout0_25ck8 = 0 time = 90
* CHECK dout0_26 vdout0_26ck8 = 0 time = 90
* CHECK dout0_27 vdout0_27ck8 = 1.8 time = 90
* CHECK dout0_28 vdout0_28ck8 = 1.8 time = 90
* CHECK dout0_29 vdout0_29ck8 = 0 time = 90
* CHECK dout0_30 vdout0_30ck8 = 0 time = 90
* CHECK dout0_31 vdout0_31ck8 = 0 time = 90
* CHECK dout0_32 vdout0_32ck8 = 1.8 time = 90
* CHECK dout0_33 vdout0_33ck8 = 1.8 time = 90
* CHECK dout0_34 vdout0_34ck8 = 1.8 time = 90
* CHECK dout0_35 vdout0_35ck8 = 0 time = 90
* CHECK dout0_36 vdout0_36ck8 = 1.8 time = 90
* CHECK dout0_37 vdout0_37ck8 = 1.8 time = 90
* CHECK dout0_38 vdout0_38ck8 = 0 time = 90
* CHECK dout0_39 vdout0_39ck8 = 0 time = 90
* CHECK dout0_40 vdout0_40ck8 = 0 time = 90
* CHECK dout0_41 vdout0_41ck8 = 0 time = 90
* CHECK dout0_42 vdout0_42ck8 = 0 time = 90
* CHECK dout0_43 vdout0_43ck8 = 1.8 time = 90
* CHECK dout0_44 vdout0_44ck8 = 1.8 time = 90
* CHECK dout0_45 vdout0_45ck8 = 1.8 time = 90
* CHECK dout0_46 vdout0_46ck8 = 1.8 time = 90
* CHECK dout0_47 vdout0_47ck8 = 0 time = 90
* CHECK dout0_48 vdout0_48ck8 = 1.8 time = 90
* CHECK dout0_49 vdout0_49ck8 = 1.8 time = 90
* CHECK dout0_50 vdout0_50ck8 = 0 time = 90
* CHECK dout0_51 vdout0_51ck8 = 0 time = 90
* CHECK dout0_52 vdout0_52ck8 = 0 time = 90
* CHECK dout0_53 vdout0_53ck8 = 0 time = 90
* CHECK dout0_54 vdout0_54ck8 = 1.8 time = 90
* CHECK dout0_55 vdout0_55ck8 = 1.8 time = 90
* CHECK dout0_56 vdout0_56ck8 = 0 time = 90
* CHECK dout0_57 vdout0_57ck8 = 0 time = 90
* CHECK dout0_58 vdout0_58ck8 = 1.8 time = 90
* CHECK dout0_59 vdout0_59ck8 = 0 time = 90
* CHECK dout0_60 vdout0_60ck8 = 0 time = 90
* CHECK dout0_61 vdout0_61ck8 = 0 time = 90
* CHECK dout0_62 vdout0_62ck8 = 1.8 time = 90
* CHECK dout0_63 vdout0_63ck8 = 1.8 time = 90
* CHECK dout0_0 vdout0_0ck9 = 1.8 time = 100
* CHECK dout0_1 vdout0_1ck9 = 0 time = 100
* CHECK dout0_2 vdout0_2ck9 = 1.8 time = 100
* CHECK dout0_3 vdout0_3ck9 = 1.8 time = 100
* CHECK dout0_4 vdout0_4ck9 = 1.8 time = 100
* CHECK dout0_5 vdout0_5ck9 = 1.8 time = 100
* CHECK dout0_6 vdout0_6ck9 = 0 time = 100
* CHECK dout0_7 vdout0_7ck9 = 1.8 time = 100
* CHECK dout0_8 vdout0_8ck9 = 0 time = 100
* CHECK dout0_9 vdout0_9ck9 = 0 time = 100
* CHECK dout0_10 vdout0_10ck9 = 0 time = 100
* CHECK dout0_11 vdout0_11ck9 = 0 time = 100
* CHECK dout0_12 vdout0_12ck9 = 0 time = 100
* CHECK dout0_13 vdout0_13ck9 = 1.8 time = 100
* CHECK dout0_14 vdout0_14ck9 = 1.8 time = 100
* CHECK dout0_15 vdout0_15ck9 = 1.8 time = 100
* CHECK dout0_16 vdout0_16ck9 = 1.8 time = 100
* CHECK dout0_17 vdout0_17ck9 = 0 time = 100
* CHECK dout0_18 vdout0_18ck9 = 0 time = 100
* CHECK dout0_19 vdout0_19ck9 = 0 time = 100
* CHECK dout0_20 vdout0_20ck9 = 0 time = 100
* CHECK dout0_21 vdout0_21ck9 = 0 time = 100
* CHECK dout0_22 vdout0_22ck9 = 1.8 time = 100
* CHECK dout0_23 vdout0_23ck9 = 1.8 time = 100
* CHECK dout0_24 vdout0_24ck9 = 0 time = 100
* CHECK dout0_25 vdout0_25ck9 = 0 time = 100
* CHECK dout0_26 vdout0_26ck9 = 0 time = 100
* CHECK dout0_27 vdout0_27ck9 = 1.8 time = 100
* CHECK dout0_28 vdout0_28ck9 = 1.8 time = 100
* CHECK dout0_29 vdout0_29ck9 = 0 time = 100
* CHECK dout0_30 vdout0_30ck9 = 0 time = 100
* CHECK dout0_31 vdout0_31ck9 = 0 time = 100
* CHECK dout0_32 vdout0_32ck9 = 1.8 time = 100
* CHECK dout0_33 vdout0_33ck9 = 1.8 time = 100
* CHECK dout0_34 vdout0_34ck9 = 1.8 time = 100
* CHECK dout0_35 vdout0_35ck9 = 0 time = 100
* CHECK dout0_36 vdout0_36ck9 = 1.8 time = 100
* CHECK dout0_37 vdout0_37ck9 = 1.8 time = 100
* CHECK dout0_38 vdout0_38ck9 = 0 time = 100
* CHECK dout0_39 vdout0_39ck9 = 0 time = 100
* CHECK dout0_40 vdout0_40ck9 = 0 time = 100
* CHECK dout0_41 vdout0_41ck9 = 0 time = 100
* CHECK dout0_42 vdout0_42ck9 = 0 time = 100
* CHECK dout0_43 vdout0_43ck9 = 1.8 time = 100
* CHECK dout0_44 vdout0_44ck9 = 1.8 time = 100
* CHECK dout0_45 vdout0_45ck9 = 1.8 time = 100
* CHECK dout0_46 vdout0_46ck9 = 1.8 time = 100
* CHECK dout0_47 vdout0_47ck9 = 0 time = 100
* CHECK dout0_48 vdout0_48ck9 = 1.8 time = 100
* CHECK dout0_49 vdout0_49ck9 = 1.8 time = 100
* CHECK dout0_50 vdout0_50ck9 = 0 time = 100
* CHECK dout0_51 vdout0_51ck9 = 0 time = 100
* CHECK dout0_52 vdout0_52ck9 = 0 time = 100
* CHECK dout0_53 vdout0_53ck9 = 0 time = 100
* CHECK dout0_54 vdout0_54ck9 = 1.8 time = 100
* CHECK dout0_55 vdout0_55ck9 = 1.8 time = 100
* CHECK dout0_56 vdout0_56ck9 = 0 time = 100
* CHECK dout0_57 vdout0_57ck9 = 0 time = 100
* CHECK dout0_58 vdout0_58ck9 = 1.8 time = 100
* CHECK dout0_59 vdout0_59ck9 = 0 time = 100
* CHECK dout0_60 vdout0_60ck9 = 0 time = 100
* CHECK dout0_61 vdout0_61ck9 = 0 time = 100
* CHECK dout0_62 vdout0_62ck9 = 1.8 time = 100
* CHECK dout0_63 vdout0_63ck9 = 1.8 time = 100
* CHECK dout1_0 vdout1_0ck10 = 1.8 time = 110
* CHECK dout1_1 vdout1_1ck10 = 1.8 time = 110
* CHECK dout1_2 vdout1_2ck10 = 1.8 time = 110
* CHECK dout1_3 vdout1_3ck10 = 0 time = 110
* CHECK dout1_4 vdout1_4ck10 = 1.8 time = 110
* CHECK dout1_5 vdout1_5ck10 = 0 time = 110
* CHECK dout1_6 vdout1_6ck10 = 0 time = 110
* CHECK dout1_7 vdout1_7ck10 = 1.8 time = 110
* CHECK dout1_8 vdout1_8ck10 = 1.8 time = 110
* CHECK dout1_9 vdout1_9ck10 = 1.8 time = 110
* CHECK dout1_10 vdout1_10ck10 = 1.8 time = 110
* CHECK dout1_11 vdout1_11ck10 = 1.8 time = 110
* CHECK dout1_12 vdout1_12ck10 = 1.8 time = 110
* CHECK dout1_13 vdout1_13ck10 = 1.8 time = 110
* CHECK dout1_14 vdout1_14ck10 = 0 time = 110
* CHECK dout1_15 vdout1_15ck10 = 0 time = 110
* CHECK dout1_16 vdout1_16ck10 = 1.8 time = 110
* CHECK dout1_17 vdout1_17ck10 = 1.8 time = 110
* CHECK dout1_18 vdout1_18ck10 = 0 time = 110
* CHECK dout1_19 vdout1_19ck10 = 1.8 time = 110
* CHECK dout1_20 vdout1_20ck10 = 0 time = 110
* CHECK dout1_21 vdout1_21ck10 = 1.8 time = 110
* CHECK dout1_22 vdout1_22ck10 = 1.8 time = 110
* CHECK dout1_23 vdout1_23ck10 = 0 time = 110
* CHECK dout1_24 vdout1_24ck10 = 0 time = 110
* CHECK dout1_25 vdout1_25ck10 = 1.8 time = 110
* CHECK dout1_26 vdout1_26ck10 = 1.8 time = 110
* CHECK dout1_27 vdout1_27ck10 = 0 time = 110
* CHECK dout1_28 vdout1_28ck10 = 1.8 time = 110
* CHECK dout1_29 vdout1_29ck10 = 1.8 time = 110
* CHECK dout1_30 vdout1_30ck10 = 0 time = 110
* CHECK dout1_31 vdout1_31ck10 = 0 time = 110
* CHECK dout1_32 vdout1_32ck10 = 1.8 time = 110
* CHECK dout1_33 vdout1_33ck10 = 1.8 time = 110
* CHECK dout1_34 vdout1_34ck10 = 1.8 time = 110
* CHECK dout1_35 vdout1_35ck10 = 1.8 time = 110
* CHECK dout1_36 vdout1_36ck10 = 0 time = 110
* CHECK dout1_37 vdout1_37ck10 = 0 time = 110
* CHECK dout1_38 vdout1_38ck10 = 0 time = 110
* CHECK dout1_39 vdout1_39ck10 = 0 time = 110
* CHECK dout1_40 vdout1_40ck10 = 1.8 time = 110
* CHECK dout1_41 vdout1_41ck10 = 0 time = 110
* CHECK dout1_42 vdout1_42ck10 = 0 time = 110
* CHECK dout1_43 vdout1_43ck10 = 1.8 time = 110
* CHECK dout1_44 vdout1_44ck10 = 0 time = 110
* CHECK dout1_45 vdout1_45ck10 = 1.8 time = 110
* CHECK dout1_46 vdout1_46ck10 = 0 time = 110
* CHECK dout1_47 vdout1_47ck10 = 1.8 time = 110
* CHECK dout1_48 vdout1_48ck10 = 0 time = 110
* CHECK dout1_49 vdout1_49ck10 = 1.8 time = 110
* CHECK dout1_50 vdout1_50ck10 = 1.8 time = 110
* CHECK dout1_51 vdout1_51ck10 = 1.8 time = 110
* CHECK dout1_52 vdout1_52ck10 = 0 time = 110
* CHECK dout1_53 vdout1_53ck10 = 1.8 time = 110
* CHECK dout1_54 vdout1_54ck10 = 0 time = 110
* CHECK dout1_55 vdout1_55ck10 = 1.8 time = 110
* CHECK dout1_56 vdout1_56ck10 = 1.8 time = 110
* CHECK dout1_57 vdout1_57ck10 = 0 time = 110
* CHECK dout1_58 vdout1_58ck10 = 1.8 time = 110
* CHECK dout1_59 vdout1_59ck10 = 1.8 time = 110
* CHECK dout1_60 vdout1_60ck10 = 1.8 time = 110
* CHECK dout1_61 vdout1_61ck10 = 1.8 time = 110
* CHECK dout1_62 vdout1_62ck10 = 0 time = 110
* CHECK dout1_63 vdout1_63ck10 = 0 time = 110
* CHECK dout0_0 vdout0_0ck11 = 1.8 time = 120
* CHECK dout0_1 vdout0_1ck11 = 1.8 time = 120
* CHECK dout0_2 vdout0_2ck11 = 1.8 time = 120
* CHECK dout0_3 vdout0_3ck11 = 0 time = 120
* CHECK dout0_4 vdout0_4ck11 = 1.8 time = 120
* CHECK dout0_5 vdout0_5ck11 = 0 time = 120
* CHECK dout0_6 vdout0_6ck11 = 0 time = 120
* CHECK dout0_7 vdout0_7ck11 = 1.8 time = 120
* CHECK dout0_8 vdout0_8ck11 = 1.8 time = 120
* CHECK dout0_9 vdout0_9ck11 = 1.8 time = 120
* CHECK dout0_10 vdout0_10ck11 = 1.8 time = 120
* CHECK dout0_11 vdout0_11ck11 = 1.8 time = 120
* CHECK dout0_12 vdout0_12ck11 = 1.8 time = 120
* CHECK dout0_13 vdout0_13ck11 = 1.8 time = 120
* CHECK dout0_14 vdout0_14ck11 = 0 time = 120
* CHECK dout0_15 vdout0_15ck11 = 0 time = 120
* CHECK dout0_16 vdout0_16ck11 = 1.8 time = 120
* CHECK dout0_17 vdout0_17ck11 = 1.8 time = 120
* CHECK dout0_18 vdout0_18ck11 = 0 time = 120
* CHECK dout0_19 vdout0_19ck11 = 1.8 time = 120
* CHECK dout0_20 vdout0_20ck11 = 0 time = 120
* CHECK dout0_21 vdout0_21ck11 = 1.8 time = 120
* CHECK dout0_22 vdout0_22ck11 = 1.8 time = 120
* CHECK dout0_23 vdout0_23ck11 = 0 time = 120
* CHECK dout0_24 vdout0_24ck11 = 0 time = 120
* CHECK dout0_25 vdout0_25ck11 = 1.8 time = 120
* CHECK dout0_26 vdout0_26ck11 = 1.8 time = 120
* CHECK dout0_27 vdout0_27ck11 = 0 time = 120
* CHECK dout0_28 vdout0_28ck11 = 1.8 time = 120
* CHECK dout0_29 vdout0_29ck11 = 1.8 time = 120
* CHECK dout0_30 vdout0_30ck11 = 0 time = 120
* CHECK dout0_31 vdout0_31ck11 = 0 time = 120
* CHECK dout0_32 vdout0_32ck11 = 1.8 time = 120
* CHECK dout0_33 vdout0_33ck11 = 1.8 time = 120
* CHECK dout0_34 vdout0_34ck11 = 1.8 time = 120
* CHECK dout0_35 vdout0_35ck11 = 1.8 time = 120
* CHECK dout0_36 vdout0_36ck11 = 0 time = 120
* CHECK dout0_37 vdout0_37ck11 = 0 time = 120
* CHECK dout0_38 vdout0_38ck11 = 0 time = 120
* CHECK dout0_39 vdout0_39ck11 = 0 time = 120
* CHECK dout0_40 vdout0_40ck11 = 1.8 time = 120
* CHECK dout0_41 vdout0_41ck11 = 0 time = 120
* CHECK dout0_42 vdout0_42ck11 = 0 time = 120
* CHECK dout0_43 vdout0_43ck11 = 1.8 time = 120
* CHECK dout0_44 vdout0_44ck11 = 0 time = 120
* CHECK dout0_45 vdout0_45ck11 = 1.8 time = 120
* CHECK dout0_46 vdout0_46ck11 = 0 time = 120
* CHECK dout0_47 vdout0_47ck11 = 1.8 time = 120
* CHECK dout0_48 vdout0_48ck11 = 0 time = 120
* CHECK dout0_49 vdout0_49ck11 = 1.8 time = 120
* CHECK dout0_50 vdout0_50ck11 = 1.8 time = 120
* CHECK dout0_51 vdout0_51ck11 = 1.8 time = 120
* CHECK dout0_52 vdout0_52ck11 = 0 time = 120
* CHECK dout0_53 vdout0_53ck11 = 1.8 time = 120
* CHECK dout0_54 vdout0_54ck11 = 0 time = 120
* CHECK dout0_55 vdout0_55ck11 = 1.8 time = 120
* CHECK dout0_56 vdout0_56ck11 = 1.8 time = 120
* CHECK dout0_57 vdout0_57ck11 = 0 time = 120
* CHECK dout0_58 vdout0_58ck11 = 1.8 time = 120
* CHECK dout0_59 vdout0_59ck11 = 1.8 time = 120
* CHECK dout0_60 vdout0_60ck11 = 1.8 time = 120
* CHECK dout0_61 vdout0_61ck11 = 1.8 time = 120
* CHECK dout0_62 vdout0_62ck11 = 0 time = 120
* CHECK dout0_63 vdout0_63ck11 = 0 time = 120
* CHECK dout0_0 vdout0_0ck12 = 1.8 time = 130
* CHECK dout0_1 vdout0_1ck12 = 0 time = 130
* CHECK dout0_2 vdout0_2ck12 = 1.8 time = 130
* CHECK dout0_3 vdout0_3ck12 = 1.8 time = 130
* CHECK dout0_4 vdout0_4ck12 = 0 time = 130
* CHECK dout0_5 vdout0_5ck12 = 1.8 time = 130
* CHECK dout0_6 vdout0_6ck12 = 0 time = 130
* CHECK dout0_7 vdout0_7ck12 = 0 time = 130
* CHECK dout0_8 vdout0_8ck12 = 0 time = 130
* CHECK dout0_9 vdout0_9ck12 = 0 time = 130
* CHECK dout0_10 vdout0_10ck12 = 1.8 time = 130
* CHECK dout0_11 vdout0_11ck12 = 1.8 time = 130
* CHECK dout0_12 vdout0_12ck12 = 0 time = 130
* CHECK dout0_13 vdout0_13ck12 = 0 time = 130
* CHECK dout0_14 vdout0_14ck12 = 1.8 time = 130
* CHECK dout0_15 vdout0_15ck12 = 0 time = 130
* CHECK dout0_16 vdout0_16ck12 = 0 time = 130
* CHECK dout0_17 vdout0_17ck12 = 0 time = 130
* CHECK dout0_18 vdout0_18ck12 = 0 time = 130
* CHECK dout0_19 vdout0_19ck12 = 0 time = 130
* CHECK dout0_20 vdout0_20ck12 = 1.8 time = 130
* CHECK dout0_21 vdout0_21ck12 = 1.8 time = 130
* CHECK dout0_22 vdout0_22ck12 = 1.8 time = 130
* CHECK dout0_23 vdout0_23ck12 = 1.8 time = 130
* CHECK dout0_24 vdout0_24ck12 = 0 time = 130
* CHECK dout0_25 vdout0_25ck12 = 0 time = 130
* CHECK dout0_26 vdout0_26ck12 = 1.8 time = 130
* CHECK dout0_27 vdout0_27ck12 = 0 time = 130
* CHECK dout0_28 vdout0_28ck12 = 0 time = 130
* CHECK dout0_29 vdout0_29ck12 = 0 time = 130
* CHECK dout0_30 vdout0_30ck12 = 1.8 time = 130
* CHECK dout0_31 vdout0_31ck12 = 0 time = 130
* CHECK dout0_32 vdout0_32ck12 = 1.8 time = 130
* CHECK dout0_33 vdout0_33ck12 = 0 time = 130
* CHECK dout0_34 vdout0_34ck12 = 1.8 time = 130
* CHECK dout0_35 vdout0_35ck12 = 0 time = 130
* CHECK dout0_36 vdout0_36ck12 = 1.8 time = 130
* CHECK dout0_37 vdout0_37ck12 = 1.8 time = 130
* CHECK dout0_38 vdout0_38ck12 = 1.8 time = 130
* CHECK dout0_39 vdout0_39ck12 = 1.8 time = 130
* CHECK dout0_40 vdout0_40ck12 = 0 time = 130
* CHECK dout0_41 vdout0_41ck12 = 0 time = 130
* CHECK dout0_42 vdout0_42ck12 = 0 time = 130
* CHECK dout0_43 vdout0_43ck12 = 0 time = 130
* CHECK dout0_44 vdout0_44ck12 = 1.8 time = 130
* CHECK dout0_45 vdout0_45ck12 = 0 time = 130
* CHECK dout0_46 vdout0_46ck12 = 0 time = 130
* CHECK dout0_47 vdout0_47ck12 = 1.8 time = 130
* CHECK dout0_48 vdout0_48ck12 = 1.8 time = 130
* CHECK dout0_49 vdout0_49ck12 = 0 time = 130
* CHECK dout0_50 vdout0_50ck12 = 1.8 time = 130
* CHECK dout0_51 vdout0_51ck12 = 0 time = 130
* CHECK dout0_52 vdout0_52ck12 = 1.8 time = 130
* CHECK dout0_53 vdout0_53ck12 = 1.8 time = 130
* CHECK dout0_54 vdout0_54ck12 = 1.8 time = 130
* CHECK dout0_55 vdout0_55ck12 = 1.8 time = 130
* CHECK dout0_56 vdout0_56ck12 = 1.8 time = 130
* CHECK dout0_57 vdout0_57ck12 = 1.8 time = 130
* CHECK dout0_58 vdout0_58ck12 = 0 time = 130
* CHECK dout0_59 vdout0_59ck12 = 1.8 time = 130
* CHECK dout0_60 vdout0_60ck12 = 0 time = 130
* CHECK dout0_61 vdout0_61ck12 = 0 time = 130
* CHECK dout0_62 vdout0_62ck12 = 0 time = 130
* CHECK dout0_63 vdout0_63ck12 = 0 time = 130
* CHECK dout0_0 vdout0_0ck13 = 1.8 time = 140
* CHECK dout0_1 vdout0_1ck13 = 0 time = 140
* CHECK dout0_2 vdout0_2ck13 = 1.8 time = 140
* CHECK dout0_3 vdout0_3ck13 = 1.8 time = 140
* CHECK dout0_4 vdout0_4ck13 = 1.8 time = 140
* CHECK dout0_5 vdout0_5ck13 = 1.8 time = 140
* CHECK dout0_6 vdout0_6ck13 = 0 time = 140
* CHECK dout0_7 vdout0_7ck13 = 1.8 time = 140
* CHECK dout0_8 vdout0_8ck13 = 0 time = 140
* CHECK dout0_9 vdout0_9ck13 = 0 time = 140
* CHECK dout0_10 vdout0_10ck13 = 0 time = 140
* CHECK dout0_11 vdout0_11ck13 = 0 time = 140
* CHECK dout0_12 vdout0_12ck13 = 0 time = 140
* CHECK dout0_13 vdout0_13ck13 = 1.8 time = 140
* CHECK dout0_14 vdout0_14ck13 = 1.8 time = 140
* CHECK dout0_15 vdout0_15ck13 = 1.8 time = 140
* CHECK dout0_16 vdout0_16ck13 = 1.8 time = 140
* CHECK dout0_17 vdout0_17ck13 = 0 time = 140
* CHECK dout0_18 vdout0_18ck13 = 0 time = 140
* CHECK dout0_19 vdout0_19ck13 = 0 time = 140
* CHECK dout0_20 vdout0_20ck13 = 0 time = 140
* CHECK dout0_21 vdout0_21ck13 = 0 time = 140
* CHECK dout0_22 vdout0_22ck13 = 1.8 time = 140
* CHECK dout0_23 vdout0_23ck13 = 1.8 time = 140
* CHECK dout0_24 vdout0_24ck13 = 0 time = 140
* CHECK dout0_25 vdout0_25ck13 = 0 time = 140
* CHECK dout0_26 vdout0_26ck13 = 0 time = 140
* CHECK dout0_27 vdout0_27ck13 = 1.8 time = 140
* CHECK dout0_28 vdout0_28ck13 = 1.8 time = 140
* CHECK dout0_29 vdout0_29ck13 = 0 time = 140
* CHECK dout0_30 vdout0_30ck13 = 0 time = 140
* CHECK dout0_31 vdout0_31ck13 = 0 time = 140
* CHECK dout0_32 vdout0_32ck13 = 1.8 time = 140
* CHECK dout0_33 vdout0_33ck13 = 1.8 time = 140
* CHECK dout0_34 vdout0_34ck13 = 1.8 time = 140
* CHECK dout0_35 vdout0_35ck13 = 0 time = 140
* CHECK dout0_36 vdout0_36ck13 = 1.8 time = 140
* CHECK dout0_37 vdout0_37ck13 = 1.8 time = 140
* CHECK dout0_38 vdout0_38ck13 = 0 time = 140
* CHECK dout0_39 vdout0_39ck13 = 0 time = 140
* CHECK dout0_40 vdout0_40ck13 = 0 time = 140
* CHECK dout0_41 vdout0_41ck13 = 0 time = 140
* CHECK dout0_42 vdout0_42ck13 = 0 time = 140
* CHECK dout0_43 vdout0_43ck13 = 1.8 time = 140
* CHECK dout0_44 vdout0_44ck13 = 1.8 time = 140
* CHECK dout0_45 vdout0_45ck13 = 1.8 time = 140
* CHECK dout0_46 vdout0_46ck13 = 1.8 time = 140
* CHECK dout0_47 vdout0_47ck13 = 0 time = 140
* CHECK dout0_48 vdout0_48ck13 = 1.8 time = 140
* CHECK dout0_49 vdout0_49ck13 = 1.8 time = 140
* CHECK dout0_50 vdout0_50ck13 = 0 time = 140
* CHECK dout0_51 vdout0_51ck13 = 0 time = 140
* CHECK dout0_52 vdout0_52ck13 = 0 time = 140
* CHECK dout0_53 vdout0_53ck13 = 0 time = 140
* CHECK dout0_54 vdout0_54ck13 = 1.8 time = 140
* CHECK dout0_55 vdout0_55ck13 = 1.8 time = 140
* CHECK dout0_56 vdout0_56ck13 = 0 time = 140
* CHECK dout0_57 vdout0_57ck13 = 0 time = 140
* CHECK dout0_58 vdout0_58ck13 = 1.8 time = 140
* CHECK dout0_59 vdout0_59ck13 = 0 time = 140
* CHECK dout0_60 vdout0_60ck13 = 0 time = 140
* CHECK dout0_61 vdout0_61ck13 = 0 time = 140
* CHECK dout0_62 vdout0_62ck13 = 1.8 time = 140
* CHECK dout0_63 vdout0_63ck13 = 1.8 time = 140
* CHECK dout0_0 vdout0_0ck14 = 1.8 time = 150
* CHECK dout0_1 vdout0_1ck14 = 0 time = 150
* CHECK dout0_2 vdout0_2ck14 = 1.8 time = 150
* CHECK dout0_3 vdout0_3ck14 = 1.8 time = 150
* CHECK dout0_4 vdout0_4ck14 = 0 time = 150
* CHECK dout0_5 vdout0_5ck14 = 1.8 time = 150
* CHECK dout0_6 vdout0_6ck14 = 0 time = 150
* CHECK dout0_7 vdout0_7ck14 = 0 time = 150
* CHECK dout0_8 vdout0_8ck14 = 0 time = 150
* CHECK dout0_9 vdout0_9ck14 = 0 time = 150
* CHECK dout0_10 vdout0_10ck14 = 1.8 time = 150
* CHECK dout0_11 vdout0_11ck14 = 1.8 time = 150
* CHECK dout0_12 vdout0_12ck14 = 0 time = 150
* CHECK dout0_13 vdout0_13ck14 = 0 time = 150
* CHECK dout0_14 vdout0_14ck14 = 1.8 time = 150
* CHECK dout0_15 vdout0_15ck14 = 0 time = 150
* CHECK dout0_16 vdout0_16ck14 = 0 time = 150
* CHECK dout0_17 vdout0_17ck14 = 0 time = 150
* CHECK dout0_18 vdout0_18ck14 = 0 time = 150
* CHECK dout0_19 vdout0_19ck14 = 0 time = 150
* CHECK dout0_20 vdout0_20ck14 = 1.8 time = 150
* CHECK dout0_21 vdout0_21ck14 = 1.8 time = 150
* CHECK dout0_22 vdout0_22ck14 = 1.8 time = 150
* CHECK dout0_23 vdout0_23ck14 = 1.8 time = 150
* CHECK dout0_24 vdout0_24ck14 = 0 time = 150
* CHECK dout0_25 vdout0_25ck14 = 0 time = 150
* CHECK dout0_26 vdout0_26ck14 = 1.8 time = 150
* CHECK dout0_27 vdout0_27ck14 = 0 time = 150
* CHECK dout0_28 vdout0_28ck14 = 0 time = 150
* CHECK dout0_29 vdout0_29ck14 = 0 time = 150
* CHECK dout0_30 vdout0_30ck14 = 1.8 time = 150
* CHECK dout0_31 vdout0_31ck14 = 0 time = 150
* CHECK dout0_32 vdout0_32ck14 = 1.8 time = 150
* CHECK dout0_33 vdout0_33ck14 = 0 time = 150
* CHECK dout0_34 vdout0_34ck14 = 1.8 time = 150
* CHECK dout0_35 vdout0_35ck14 = 0 time = 150
* CHECK dout0_36 vdout0_36ck14 = 1.8 time = 150
* CHECK dout0_37 vdout0_37ck14 = 1.8 time = 150
* CHECK dout0_38 vdout0_38ck14 = 1.8 time = 150
* CHECK dout0_39 vdout0_39ck14 = 1.8 time = 150
* CHECK dout0_40 vdout0_40ck14 = 0 time = 150
* CHECK dout0_41 vdout0_41ck14 = 0 time = 150
* CHECK dout0_42 vdout0_42ck14 = 0 time = 150
* CHECK dout0_43 vdout0_43ck14 = 0 time = 150
* CHECK dout0_44 vdout0_44ck14 = 1.8 time = 150
* CHECK dout0_45 vdout0_45ck14 = 0 time = 150
* CHECK dout0_46 vdout0_46ck14 = 0 time = 150
* CHECK dout0_47 vdout0_47ck14 = 1.8 time = 150
* CHECK dout0_48 vdout0_48ck14 = 1.8 time = 150
* CHECK dout0_49 vdout0_49ck14 = 0 time = 150
* CHECK dout0_50 vdout0_50ck14 = 1.8 time = 150
* CHECK dout0_51 vdout0_51ck14 = 0 time = 150
* CHECK dout0_52 vdout0_52ck14 = 1.8 time = 150
* CHECK dout0_53 vdout0_53ck14 = 1.8 time = 150
* CHECK dout0_54 vdout0_54ck14 = 1.8 time = 150
* CHECK dout0_55 vdout0_55ck14 = 1.8 time = 150
* CHECK dout0_56 vdout0_56ck14 = 1.8 time = 150
* CHECK dout0_57 vdout0_57ck14 = 1.8 time = 150
* CHECK dout0_58 vdout0_58ck14 = 0 time = 150
* CHECK dout0_59 vdout0_59ck14 = 1.8 time = 150
* CHECK dout0_60 vdout0_60ck14 = 0 time = 150
* CHECK dout0_61 vdout0_61ck14 = 0 time = 150
* CHECK dout0_62 vdout0_62ck14 = 0 time = 150
* CHECK dout0_63 vdout0_63ck14 = 0 time = 150
* CHECK dout0_0 vdout0_0ck16 = 0 time = 170
* CHECK dout0_1 vdout0_1ck16 = 1.8 time = 170
* CHECK dout0_2 vdout0_2ck16 = 0 time = 170
* CHECK dout0_3 vdout0_3ck16 = 0 time = 170
* CHECK dout0_4 vdout0_4ck16 = 0 time = 170
* CHECK dout0_5 vdout0_5ck16 = 1.8 time = 170
* CHECK dout0_6 vdout0_6ck16 = 1.8 time = 170
* CHECK dout0_7 vdout0_7ck16 = 0 time = 170
* CHECK dout0_8 vdout0_8ck16 = 1.8 time = 170
* CHECK dout0_9 vdout0_9ck16 = 1.8 time = 170
* CHECK dout0_10 vdout0_10ck16 = 0 time = 170
* CHECK dout0_11 vdout0_11ck16 = 0 time = 170
* CHECK dout0_12 vdout0_12ck16 = 0 time = 170
* CHECK dout0_13 vdout0_13ck16 = 1.8 time = 170
* CHECK dout0_14 vdout0_14ck16 = 1.8 time = 170
* CHECK dout0_15 vdout0_15ck16 = 0 time = 170
* CHECK dout0_16 vdout0_16ck16 = 0 time = 170
* CHECK dout0_17 vdout0_17ck16 = 1.8 time = 170
* CHECK dout0_18 vdout0_18ck16 = 0 time = 170
* CHECK dout0_19 vdout0_19ck16 = 0 time = 170
* CHECK dout0_20 vdout0_20ck16 = 0 time = 170
* CHECK dout0_21 vdout0_21ck16 = 1.8 time = 170
* CHECK dout0_22 vdout0_22ck16 = 0 time = 170
* CHECK dout0_23 vdout0_23ck16 = 0 time = 170
* CHECK dout0_24 vdout0_24ck16 = 1.8 time = 170
* CHECK dout0_25 vdout0_25ck16 = 1.8 time = 170
* CHECK dout0_26 vdout0_26ck16 = 0 time = 170
* CHECK dout0_27 vdout0_27ck16 = 1.8 time = 170
* CHECK dout0_28 vdout0_28ck16 = 1.8 time = 170
* CHECK dout0_29 vdout0_29ck16 = 1.8 time = 170
* CHECK dout0_30 vdout0_30ck16 = 0 time = 170
* CHECK dout0_31 vdout0_31ck16 = 1.8 time = 170
* CHECK dout0_32 vdout0_32ck16 = 1.8 time = 170
* CHECK dout0_33 vdout0_33ck16 = 0 time = 170
* CHECK dout0_34 vdout0_34ck16 = 0 time = 170
* CHECK dout0_35 vdout0_35ck16 = 0 time = 170
* CHECK dout0_36 vdout0_36ck16 = 1.8 time = 170
* CHECK dout0_37 vdout0_37ck16 = 1.8 time = 170
* CHECK dout0_38 vdout0_38ck16 = 0 time = 170
* CHECK dout0_39 vdout0_39ck16 = 0 time = 170
* CHECK dout0_40 vdout0_40ck16 = 0 time = 170
* CHECK dout0_41 vdout0_41ck16 = 0 time = 170
* CHECK dout0_42 vdout0_42ck16 = 1.8 time = 170
* CHECK dout0_43 vdout0_43ck16 = 0 time = 170
* CHECK dout0_44 vdout0_44ck16 = 1.8 time = 170
* CHECK dout0_45 vdout0_45ck16 = 1.8 time = 170
* CHECK dout0_46 vdout0_46ck16 = 1.8 time = 170
* CHECK dout0_47 vdout0_47ck16 = 0 time = 170
* CHECK dout0_48 vdout0_48ck16 = 0 time = 170
* CHECK dout0_49 vdout0_49ck16 = 0 time = 170
* CHECK dout0_50 vdout0_50ck16 = 0 time = 170
* CHECK dout0_51 vdout0_51ck16 = 0 time = 170
* CHECK dout0_52 vdout0_52ck16 = 1.8 time = 170
* CHECK dout0_53 vdout0_53ck16 = 0 time = 170
* CHECK dout0_54 vdout0_54ck16 = 0 time = 170
* CHECK dout0_55 vdout0_55ck16 = 0 time = 170
* CHECK dout0_56 vdout0_56ck16 = 1.8 time = 170
* CHECK dout0_57 vdout0_57ck16 = 0 time = 170
* CHECK dout0_58 vdout0_58ck16 = 0 time = 170
* CHECK dout0_59 vdout0_59ck16 = 1.8 time = 170
* CHECK dout0_60 vdout0_60ck16 = 0 time = 170
* CHECK dout0_61 vdout0_61ck16 = 0 time = 170
* CHECK dout0_62 vdout0_62ck16 = 0 time = 170
* CHECK dout0_63 vdout0_63ck16 = 1.8 time = 170
* CHECK dout1_0 vdout1_0ck16 = 1.8 time = 170
* CHECK dout1_1 vdout1_1ck16 = 1.8 time = 170
* CHECK dout1_2 vdout1_2ck16 = 1.8 time = 170
* CHECK dout1_3 vdout1_3ck16 = 0 time = 170
* CHECK dout1_4 vdout1_4ck16 = 1.8 time = 170
* CHECK dout1_5 vdout1_5ck16 = 0 time = 170
* CHECK dout1_6 vdout1_6ck16 = 0 time = 170
* CHECK dout1_7 vdout1_7ck16 = 1.8 time = 170
* CHECK dout1_8 vdout1_8ck16 = 1.8 time = 170
* CHECK dout1_9 vdout1_9ck16 = 1.8 time = 170
* CHECK dout1_10 vdout1_10ck16 = 1.8 time = 170
* CHECK dout1_11 vdout1_11ck16 = 1.8 time = 170
* CHECK dout1_12 vdout1_12ck16 = 1.8 time = 170
* CHECK dout1_13 vdout1_13ck16 = 1.8 time = 170
* CHECK dout1_14 vdout1_14ck16 = 0 time = 170
* CHECK dout1_15 vdout1_15ck16 = 0 time = 170
* CHECK dout1_16 vdout1_16ck16 = 1.8 time = 170
* CHECK dout1_17 vdout1_17ck16 = 1.8 time = 170
* CHECK dout1_18 vdout1_18ck16 = 0 time = 170
* CHECK dout1_19 vdout1_19ck16 = 1.8 time = 170
* CHECK dout1_20 vdout1_20ck16 = 0 time = 170
* CHECK dout1_21 vdout1_21ck16 = 1.8 time = 170
* CHECK dout1_22 vdout1_22ck16 = 1.8 time = 170
* CHECK dout1_23 vdout1_23ck16 = 0 time = 170
* CHECK dout1_24 vdout1_24ck16 = 0 time = 170
* CHECK dout1_25 vdout1_25ck16 = 1.8 time = 170
* CHECK dout1_26 vdout1_26ck16 = 1.8 time = 170
* CHECK dout1_27 vdout1_27ck16 = 0 time = 170
* CHECK dout1_28 vdout1_28ck16 = 1.8 time = 170
* CHECK dout1_29 vdout1_29ck16 = 1.8 time = 170
* CHECK dout1_30 vdout1_30ck16 = 0 time = 170
* CHECK dout1_31 vdout1_31ck16 = 0 time = 170
* CHECK dout1_32 vdout1_32ck16 = 1.8 time = 170
* CHECK dout1_33 vdout1_33ck16 = 1.8 time = 170
* CHECK dout1_34 vdout1_34ck16 = 1.8 time = 170
* CHECK dout1_35 vdout1_35ck16 = 1.8 time = 170
* CHECK dout1_36 vdout1_36ck16 = 0 time = 170
* CHECK dout1_37 vdout1_37ck16 = 0 time = 170
* CHECK dout1_38 vdout1_38ck16 = 0 time = 170
* CHECK dout1_39 vdout1_39ck16 = 0 time = 170
* CHECK dout1_40 vdout1_40ck16 = 1.8 time = 170
* CHECK dout1_41 vdout1_41ck16 = 0 time = 170
* CHECK dout1_42 vdout1_42ck16 = 0 time = 170
* CHECK dout1_43 vdout1_43ck16 = 1.8 time = 170
* CHECK dout1_44 vdout1_44ck16 = 0 time = 170
* CHECK dout1_45 vdout1_45ck16 = 1.8 time = 170
* CHECK dout1_46 vdout1_46ck16 = 0 time = 170
* CHECK dout1_47 vdout1_47ck16 = 1.8 time = 170
* CHECK dout1_48 vdout1_48ck16 = 0 time = 170
* CHECK dout1_49 vdout1_49ck16 = 1.8 time = 170
* CHECK dout1_50 vdout1_50ck16 = 1.8 time = 170
* CHECK dout1_51 vdout1_51ck16 = 1.8 time = 170
* CHECK dout1_52 vdout1_52ck16 = 0 time = 170
* CHECK dout1_53 vdout1_53ck16 = 1.8 time = 170
* CHECK dout1_54 vdout1_54ck16 = 0 time = 170
* CHECK dout1_55 vdout1_55ck16 = 1.8 time = 170
* CHECK dout1_56 vdout1_56ck16 = 1.8 time = 170
* CHECK dout1_57 vdout1_57ck16 = 0 time = 170
* CHECK dout1_58 vdout1_58ck16 = 1.8 time = 170
* CHECK dout1_59 vdout1_59ck16 = 1.8 time = 170
* CHECK dout1_60 vdout1_60ck16 = 1.8 time = 170
* CHECK dout1_61 vdout1_61ck16 = 1.8 time = 170
* CHECK dout1_62 vdout1_62ck16 = 0 time = 170
* CHECK dout1_63 vdout1_63ck16 = 0 time = 170
* CHECK dout0_0 vdout0_0ck17 = 0 time = 180
* CHECK dout0_1 vdout0_1ck17 = 1.8 time = 180
* CHECK dout0_2 vdout0_2ck17 = 0 time = 180
* CHECK dout0_3 vdout0_3ck17 = 0 time = 180
* CHECK dout0_4 vdout0_4ck17 = 0 time = 180
* CHECK dout0_5 vdout0_5ck17 = 1.8 time = 180
* CHECK dout0_6 vdout0_6ck17 = 1.8 time = 180
* CHECK dout0_7 vdout0_7ck17 = 0 time = 180
* CHECK dout0_8 vdout0_8ck17 = 1.8 time = 180
* CHECK dout0_9 vdout0_9ck17 = 1.8 time = 180
* CHECK dout0_10 vdout0_10ck17 = 0 time = 180
* CHECK dout0_11 vdout0_11ck17 = 0 time = 180
* CHECK dout0_12 vdout0_12ck17 = 0 time = 180
* CHECK dout0_13 vdout0_13ck17 = 1.8 time = 180
* CHECK dout0_14 vdout0_14ck17 = 1.8 time = 180
* CHECK dout0_15 vdout0_15ck17 = 0 time = 180
* CHECK dout0_16 vdout0_16ck17 = 0 time = 180
* CHECK dout0_17 vdout0_17ck17 = 1.8 time = 180
* CHECK dout0_18 vdout0_18ck17 = 0 time = 180
* CHECK dout0_19 vdout0_19ck17 = 0 time = 180
* CHECK dout0_20 vdout0_20ck17 = 0 time = 180
* CHECK dout0_21 vdout0_21ck17 = 1.8 time = 180
* CHECK dout0_22 vdout0_22ck17 = 0 time = 180
* CHECK dout0_23 vdout0_23ck17 = 0 time = 180
* CHECK dout0_24 vdout0_24ck17 = 1.8 time = 180
* CHECK dout0_25 vdout0_25ck17 = 1.8 time = 180
* CHECK dout0_26 vdout0_26ck17 = 0 time = 180
* CHECK dout0_27 vdout0_27ck17 = 1.8 time = 180
* CHECK dout0_28 vdout0_28ck17 = 1.8 time = 180
* CHECK dout0_29 vdout0_29ck17 = 1.8 time = 180
* CHECK dout0_30 vdout0_30ck17 = 0 time = 180
* CHECK dout0_31 vdout0_31ck17 = 1.8 time = 180
* CHECK dout0_32 vdout0_32ck17 = 1.8 time = 180
* CHECK dout0_33 vdout0_33ck17 = 0 time = 180
* CHECK dout0_34 vdout0_34ck17 = 0 time = 180
* CHECK dout0_35 vdout0_35ck17 = 0 time = 180
* CHECK dout0_36 vdout0_36ck17 = 1.8 time = 180
* CHECK dout0_37 vdout0_37ck17 = 1.8 time = 180
* CHECK dout0_38 vdout0_38ck17 = 0 time = 180
* CHECK dout0_39 vdout0_39ck17 = 0 time = 180
* CHECK dout0_40 vdout0_40ck17 = 0 time = 180
* CHECK dout0_41 vdout0_41ck17 = 0 time = 180
* CHECK dout0_42 vdout0_42ck17 = 1.8 time = 180
* CHECK dout0_43 vdout0_43ck17 = 0 time = 180
* CHECK dout0_44 vdout0_44ck17 = 1.8 time = 180
* CHECK dout0_45 vdout0_45ck17 = 1.8 time = 180
* CHECK dout0_46 vdout0_46ck17 = 1.8 time = 180
* CHECK dout0_47 vdout0_47ck17 = 0 time = 180
* CHECK dout0_48 vdout0_48ck17 = 0 time = 180
* CHECK dout0_49 vdout0_49ck17 = 0 time = 180
* CHECK dout0_50 vdout0_50ck17 = 0 time = 180
* CHECK dout0_51 vdout0_51ck17 = 0 time = 180
* CHECK dout0_52 vdout0_52ck17 = 1.8 time = 180
* CHECK dout0_53 vdout0_53ck17 = 0 time = 180
* CHECK dout0_54 vdout0_54ck17 = 0 time = 180
* CHECK dout0_55 vdout0_55ck17 = 0 time = 180
* CHECK dout0_56 vdout0_56ck17 = 1.8 time = 180
* CHECK dout0_57 vdout0_57ck17 = 0 time = 180
* CHECK dout0_58 vdout0_58ck17 = 0 time = 180
* CHECK dout0_59 vdout0_59ck17 = 1.8 time = 180
* CHECK dout0_60 vdout0_60ck17 = 0 time = 180
* CHECK dout0_61 vdout0_61ck17 = 0 time = 180
* CHECK dout0_62 vdout0_62ck17 = 0 time = 180
* CHECK dout0_63 vdout0_63ck17 = 1.8 time = 180
* CHECK dout1_0 vdout1_0ck17 = 1.8 time = 180
* CHECK dout1_1 vdout1_1ck17 = 1.8 time = 180
* CHECK dout1_2 vdout1_2ck17 = 1.8 time = 180
* CHECK dout1_3 vdout1_3ck17 = 0 time = 180
* CHECK dout1_4 vdout1_4ck17 = 1.8 time = 180
* CHECK dout1_5 vdout1_5ck17 = 0 time = 180
* CHECK dout1_6 vdout1_6ck17 = 0 time = 180
* CHECK dout1_7 vdout1_7ck17 = 1.8 time = 180
* CHECK dout1_8 vdout1_8ck17 = 1.8 time = 180
* CHECK dout1_9 vdout1_9ck17 = 1.8 time = 180
* CHECK dout1_10 vdout1_10ck17 = 1.8 time = 180
* CHECK dout1_11 vdout1_11ck17 = 1.8 time = 180
* CHECK dout1_12 vdout1_12ck17 = 1.8 time = 180
* CHECK dout1_13 vdout1_13ck17 = 1.8 time = 180
* CHECK dout1_14 vdout1_14ck17 = 0 time = 180
* CHECK dout1_15 vdout1_15ck17 = 0 time = 180
* CHECK dout1_16 vdout1_16ck17 = 1.8 time = 180
* CHECK dout1_17 vdout1_17ck17 = 1.8 time = 180
* CHECK dout1_18 vdout1_18ck17 = 0 time = 180
* CHECK dout1_19 vdout1_19ck17 = 1.8 time = 180
* CHECK dout1_20 vdout1_20ck17 = 0 time = 180
* CHECK dout1_21 vdout1_21ck17 = 1.8 time = 180
* CHECK dout1_22 vdout1_22ck17 = 1.8 time = 180
* CHECK dout1_23 vdout1_23ck17 = 0 time = 180
* CHECK dout1_24 vdout1_24ck17 = 0 time = 180
* CHECK dout1_25 vdout1_25ck17 = 1.8 time = 180
* CHECK dout1_26 vdout1_26ck17 = 1.8 time = 180
* CHECK dout1_27 vdout1_27ck17 = 0 time = 180
* CHECK dout1_28 vdout1_28ck17 = 1.8 time = 180
* CHECK dout1_29 vdout1_29ck17 = 1.8 time = 180
* CHECK dout1_30 vdout1_30ck17 = 0 time = 180
* CHECK dout1_31 vdout1_31ck17 = 0 time = 180
* CHECK dout1_32 vdout1_32ck17 = 1.8 time = 180
* CHECK dout1_33 vdout1_33ck17 = 1.8 time = 180
* CHECK dout1_34 vdout1_34ck17 = 1.8 time = 180
* CHECK dout1_35 vdout1_35ck17 = 1.8 time = 180
* CHECK dout1_36 vdout1_36ck17 = 0 time = 180
* CHECK dout1_37 vdout1_37ck17 = 0 time = 180
* CHECK dout1_38 vdout1_38ck17 = 0 time = 180
* CHECK dout1_39 vdout1_39ck17 = 0 time = 180
* CHECK dout1_40 vdout1_40ck17 = 1.8 time = 180
* CHECK dout1_41 vdout1_41ck17 = 0 time = 180
* CHECK dout1_42 vdout1_42ck17 = 0 time = 180
* CHECK dout1_43 vdout1_43ck17 = 1.8 time = 180
* CHECK dout1_44 vdout1_44ck17 = 0 time = 180
* CHECK dout1_45 vdout1_45ck17 = 1.8 time = 180
* CHECK dout1_46 vdout1_46ck17 = 0 time = 180
* CHECK dout1_47 vdout1_47ck17 = 1.8 time = 180
* CHECK dout1_48 vdout1_48ck17 = 0 time = 180
* CHECK dout1_49 vdout1_49ck17 = 1.8 time = 180
* CHECK dout1_50 vdout1_50ck17 = 1.8 time = 180
* CHECK dout1_51 vdout1_51ck17 = 1.8 time = 180
* CHECK dout1_52 vdout1_52ck17 = 0 time = 180
* CHECK dout1_53 vdout1_53ck17 = 1.8 time = 180
* CHECK dout1_54 vdout1_54ck17 = 0 time = 180
* CHECK dout1_55 vdout1_55ck17 = 1.8 time = 180
* CHECK dout1_56 vdout1_56ck17 = 1.8 time = 180
* CHECK dout1_57 vdout1_57ck17 = 0 time = 180
* CHECK dout1_58 vdout1_58ck17 = 1.8 time = 180
* CHECK dout1_59 vdout1_59ck17 = 1.8 time = 180
* CHECK dout1_60 vdout1_60ck17 = 1.8 time = 180
* CHECK dout1_61 vdout1_61ck17 = 1.8 time = 180
* CHECK dout1_62 vdout1_62ck17 = 0 time = 180
* CHECK dout1_63 vdout1_63ck17 = 0 time = 180
* CHECK dout1_0 vdout1_0ck18 = 1.8 time = 190
* CHECK dout1_1 vdout1_1ck18 = 0 time = 190
* CHECK dout1_2 vdout1_2ck18 = 1.8 time = 190
* CHECK dout1_3 vdout1_3ck18 = 1.8 time = 190
* CHECK dout1_4 vdout1_4ck18 = 1.8 time = 190
* CHECK dout1_5 vdout1_5ck18 = 1.8 time = 190
* CHECK dout1_6 vdout1_6ck18 = 0 time = 190
* CHECK dout1_7 vdout1_7ck18 = 1.8 time = 190
* CHECK dout1_8 vdout1_8ck18 = 0 time = 190
* CHECK dout1_9 vdout1_9ck18 = 0 time = 190
* CHECK dout1_10 vdout1_10ck18 = 0 time = 190
* CHECK dout1_11 vdout1_11ck18 = 0 time = 190
* CHECK dout1_12 vdout1_12ck18 = 0 time = 190
* CHECK dout1_13 vdout1_13ck18 = 1.8 time = 190
* CHECK dout1_14 vdout1_14ck18 = 1.8 time = 190
* CHECK dout1_15 vdout1_15ck18 = 1.8 time = 190
* CHECK dout1_16 vdout1_16ck18 = 1.8 time = 190
* CHECK dout1_17 vdout1_17ck18 = 0 time = 190
* CHECK dout1_18 vdout1_18ck18 = 0 time = 190
* CHECK dout1_19 vdout1_19ck18 = 0 time = 190
* CHECK dout1_20 vdout1_20ck18 = 0 time = 190
* CHECK dout1_21 vdout1_21ck18 = 0 time = 190
* CHECK dout1_22 vdout1_22ck18 = 1.8 time = 190
* CHECK dout1_23 vdout1_23ck18 = 1.8 time = 190
* CHECK dout1_24 vdout1_24ck18 = 0 time = 190
* CHECK dout1_25 vdout1_25ck18 = 0 time = 190
* CHECK dout1_26 vdout1_26ck18 = 0 time = 190
* CHECK dout1_27 vdout1_27ck18 = 1.8 time = 190
* CHECK dout1_28 vdout1_28ck18 = 1.8 time = 190
* CHECK dout1_29 vdout1_29ck18 = 0 time = 190
* CHECK dout1_30 vdout1_30ck18 = 0 time = 190
* CHECK dout1_31 vdout1_31ck18 = 0 time = 190
* CHECK dout1_32 vdout1_32ck18 = 1.8 time = 190
* CHECK dout1_33 vdout1_33ck18 = 1.8 time = 190
* CHECK dout1_34 vdout1_34ck18 = 1.8 time = 190
* CHECK dout1_35 vdout1_35ck18 = 0 time = 190
* CHECK dout1_36 vdout1_36ck18 = 1.8 time = 190
* CHECK dout1_37 vdout1_37ck18 = 1.8 time = 190
* CHECK dout1_38 vdout1_38ck18 = 0 time = 190
* CHECK dout1_39 vdout1_39ck18 = 0 time = 190
* CHECK dout1_40 vdout1_40ck18 = 0 time = 190
* CHECK dout1_41 vdout1_41ck18 = 0 time = 190
* CHECK dout1_42 vdout1_42ck18 = 0 time = 190
* CHECK dout1_43 vdout1_43ck18 = 1.8 time = 190
* CHECK dout1_44 vdout1_44ck18 = 1.8 time = 190
* CHECK dout1_45 vdout1_45ck18 = 1.8 time = 190
* CHECK dout1_46 vdout1_46ck18 = 1.8 time = 190
* CHECK dout1_47 vdout1_47ck18 = 0 time = 190
* CHECK dout1_48 vdout1_48ck18 = 1.8 time = 190
* CHECK dout1_49 vdout1_49ck18 = 1.8 time = 190
* CHECK dout1_50 vdout1_50ck18 = 0 time = 190
* CHECK dout1_51 vdout1_51ck18 = 0 time = 190
* CHECK dout1_52 vdout1_52ck18 = 0 time = 190
* CHECK dout1_53 vdout1_53ck18 = 0 time = 190
* CHECK dout1_54 vdout1_54ck18 = 1.8 time = 190
* CHECK dout1_55 vdout1_55ck18 = 1.8 time = 190
* CHECK dout1_56 vdout1_56ck18 = 0 time = 190
* CHECK dout1_57 vdout1_57ck18 = 0 time = 190
* CHECK dout1_58 vdout1_58ck18 = 1.8 time = 190
* CHECK dout1_59 vdout1_59ck18 = 0 time = 190
* CHECK dout1_60 vdout1_60ck18 = 0 time = 190
* CHECK dout1_61 vdout1_61ck18 = 0 time = 190
* CHECK dout1_62 vdout1_62ck18 = 1.8 time = 190
* CHECK dout1_63 vdout1_63ck18 = 1.8 time = 190
* CHECK dout0_0 vdout0_0ck19 = 0 time = 200
* CHECK dout0_1 vdout0_1ck19 = 1.8 time = 200
* CHECK dout0_2 vdout0_2ck19 = 0 time = 200
* CHECK dout0_3 vdout0_3ck19 = 0 time = 200
* CHECK dout0_4 vdout0_4ck19 = 0 time = 200
* CHECK dout0_5 vdout0_5ck19 = 1.8 time = 200
* CHECK dout0_6 vdout0_6ck19 = 1.8 time = 200
* CHECK dout0_7 vdout0_7ck19 = 0 time = 200
* CHECK dout0_8 vdout0_8ck19 = 1.8 time = 200
* CHECK dout0_9 vdout0_9ck19 = 1.8 time = 200
* CHECK dout0_10 vdout0_10ck19 = 0 time = 200
* CHECK dout0_11 vdout0_11ck19 = 0 time = 200
* CHECK dout0_12 vdout0_12ck19 = 0 time = 200
* CHECK dout0_13 vdout0_13ck19 = 1.8 time = 200
* CHECK dout0_14 vdout0_14ck19 = 1.8 time = 200
* CHECK dout0_15 vdout0_15ck19 = 0 time = 200
* CHECK dout0_16 vdout0_16ck19 = 0 time = 200
* CHECK dout0_17 vdout0_17ck19 = 1.8 time = 200
* CHECK dout0_18 vdout0_18ck19 = 0 time = 200
* CHECK dout0_19 vdout0_19ck19 = 0 time = 200
* CHECK dout0_20 vdout0_20ck19 = 0 time = 200
* CHECK dout0_21 vdout0_21ck19 = 1.8 time = 200
* CHECK dout0_22 vdout0_22ck19 = 0 time = 200
* CHECK dout0_23 vdout0_23ck19 = 0 time = 200
* CHECK dout0_24 vdout0_24ck19 = 1.8 time = 200
* CHECK dout0_25 vdout0_25ck19 = 1.8 time = 200
* CHECK dout0_26 vdout0_26ck19 = 0 time = 200
* CHECK dout0_27 vdout0_27ck19 = 1.8 time = 200
* CHECK dout0_28 vdout0_28ck19 = 1.8 time = 200
* CHECK dout0_29 vdout0_29ck19 = 1.8 time = 200
* CHECK dout0_30 vdout0_30ck19 = 0 time = 200
* CHECK dout0_31 vdout0_31ck19 = 1.8 time = 200
* CHECK dout0_32 vdout0_32ck19 = 1.8 time = 200
* CHECK dout0_33 vdout0_33ck19 = 0 time = 200
* CHECK dout0_34 vdout0_34ck19 = 0 time = 200
* CHECK dout0_35 vdout0_35ck19 = 0 time = 200
* CHECK dout0_36 vdout0_36ck19 = 1.8 time = 200
* CHECK dout0_37 vdout0_37ck19 = 1.8 time = 200
* CHECK dout0_38 vdout0_38ck19 = 0 time = 200
* CHECK dout0_39 vdout0_39ck19 = 0 time = 200
* CHECK dout0_40 vdout0_40ck19 = 0 time = 200
* CHECK dout0_41 vdout0_41ck19 = 0 time = 200
* CHECK dout0_42 vdout0_42ck19 = 1.8 time = 200
* CHECK dout0_43 vdout0_43ck19 = 0 time = 200
* CHECK dout0_44 vdout0_44ck19 = 1.8 time = 200
* CHECK dout0_45 vdout0_45ck19 = 1.8 time = 200
* CHECK dout0_46 vdout0_46ck19 = 1.8 time = 200
* CHECK dout0_47 vdout0_47ck19 = 0 time = 200
* CHECK dout0_48 vdout0_48ck19 = 0 time = 200
* CHECK dout0_49 vdout0_49ck19 = 0 time = 200
* CHECK dout0_50 vdout0_50ck19 = 0 time = 200
* CHECK dout0_51 vdout0_51ck19 = 0 time = 200
* CHECK dout0_52 vdout0_52ck19 = 1.8 time = 200
* CHECK dout0_53 vdout0_53ck19 = 0 time = 200
* CHECK dout0_54 vdout0_54ck19 = 0 time = 200
* CHECK dout0_55 vdout0_55ck19 = 0 time = 200
* CHECK dout0_56 vdout0_56ck19 = 1.8 time = 200
* CHECK dout0_57 vdout0_57ck19 = 0 time = 200
* CHECK dout0_58 vdout0_58ck19 = 0 time = 200
* CHECK dout0_59 vdout0_59ck19 = 1.8 time = 200
* CHECK dout0_60 vdout0_60ck19 = 0 time = 200
* CHECK dout0_61 vdout0_61ck19 = 0 time = 200
* CHECK dout0_62 vdout0_62ck19 = 0 time = 200
* CHECK dout0_63 vdout0_63ck19 = 1.8 time = 200
* CHECK dout1_0 vdout1_0ck19 = 0 time = 200
* CHECK dout1_1 vdout1_1ck19 = 1.8 time = 200
* CHECK dout1_2 vdout1_2ck19 = 0 time = 200
* CHECK dout1_3 vdout1_3ck19 = 0 time = 200
* CHECK dout1_4 vdout1_4ck19 = 0 time = 200
* CHECK dout1_5 vdout1_5ck19 = 1.8 time = 200
* CHECK dout1_6 vdout1_6ck19 = 1.8 time = 200
* CHECK dout1_7 vdout1_7ck19 = 0 time = 200
* CHECK dout1_8 vdout1_8ck19 = 1.8 time = 200
* CHECK dout1_9 vdout1_9ck19 = 1.8 time = 200
* CHECK dout1_10 vdout1_10ck19 = 0 time = 200
* CHECK dout1_11 vdout1_11ck19 = 0 time = 200
* CHECK dout1_12 vdout1_12ck19 = 0 time = 200
* CHECK dout1_13 vdout1_13ck19 = 1.8 time = 200
* CHECK dout1_14 vdout1_14ck19 = 1.8 time = 200
* CHECK dout1_15 vdout1_15ck19 = 0 time = 200
* CHECK dout1_16 vdout1_16ck19 = 0 time = 200
* CHECK dout1_17 vdout1_17ck19 = 1.8 time = 200
* CHECK dout1_18 vdout1_18ck19 = 0 time = 200
* CHECK dout1_19 vdout1_19ck19 = 0 time = 200
* CHECK dout1_20 vdout1_20ck19 = 0 time = 200
* CHECK dout1_21 vdout1_21ck19 = 1.8 time = 200
* CHECK dout1_22 vdout1_22ck19 = 0 time = 200
* CHECK dout1_23 vdout1_23ck19 = 0 time = 200
* CHECK dout1_24 vdout1_24ck19 = 1.8 time = 200
* CHECK dout1_25 vdout1_25ck19 = 1.8 time = 200
* CHECK dout1_26 vdout1_26ck19 = 0 time = 200
* CHECK dout1_27 vdout1_27ck19 = 1.8 time = 200
* CHECK dout1_28 vdout1_28ck19 = 1.8 time = 200
* CHECK dout1_29 vdout1_29ck19 = 1.8 time = 200
* CHECK dout1_30 vdout1_30ck19 = 0 time = 200
* CHECK dout1_31 vdout1_31ck19 = 1.8 time = 200
* CHECK dout1_32 vdout1_32ck19 = 1.8 time = 200
* CHECK dout1_33 vdout1_33ck19 = 0 time = 200
* CHECK dout1_34 vdout1_34ck19 = 0 time = 200
* CHECK dout1_35 vdout1_35ck19 = 0 time = 200
* CHECK dout1_36 vdout1_36ck19 = 1.8 time = 200
* CHECK dout1_37 vdout1_37ck19 = 1.8 time = 200
* CHECK dout1_38 vdout1_38ck19 = 0 time = 200
* CHECK dout1_39 vdout1_39ck19 = 0 time = 200
* CHECK dout1_40 vdout1_40ck19 = 0 time = 200
* CHECK dout1_41 vdout1_41ck19 = 0 time = 200
* CHECK dout1_42 vdout1_42ck19 = 1.8 time = 200
* CHECK dout1_43 vdout1_43ck19 = 0 time = 200
* CHECK dout1_44 vdout1_44ck19 = 1.8 time = 200
* CHECK dout1_45 vdout1_45ck19 = 1.8 time = 200
* CHECK dout1_46 vdout1_46ck19 = 1.8 time = 200
* CHECK dout1_47 vdout1_47ck19 = 0 time = 200
* CHECK dout1_48 vdout1_48ck19 = 0 time = 200
* CHECK dout1_49 vdout1_49ck19 = 0 time = 200
* CHECK dout1_50 vdout1_50ck19 = 0 time = 200
* CHECK dout1_51 vdout1_51ck19 = 0 time = 200
* CHECK dout1_52 vdout1_52ck19 = 1.8 time = 200
* CHECK dout1_53 vdout1_53ck19 = 0 time = 200
* CHECK dout1_54 vdout1_54ck19 = 0 time = 200
* CHECK dout1_55 vdout1_55ck19 = 0 time = 200
* CHECK dout1_56 vdout1_56ck19 = 1.8 time = 200
* CHECK dout1_57 vdout1_57ck19 = 0 time = 200
* CHECK dout1_58 vdout1_58ck19 = 0 time = 200
* CHECK dout1_59 vdout1_59ck19 = 1.8 time = 200
* CHECK dout1_60 vdout1_60ck19 = 0 time = 200
* CHECK dout1_61 vdout1_61ck19 = 0 time = 200
* CHECK dout1_62 vdout1_62ck19 = 0 time = 200
* CHECK dout1_63 vdout1_63ck19 = 1.8 time = 200
* CHECK dout0_0 vdout0_0ck21 = 1.8 time = 220
* CHECK dout0_1 vdout0_1ck21 = 0 time = 220
* CHECK dout0_2 vdout0_2ck21 = 1.8 time = 220
* CHECK dout0_3 vdout0_3ck21 = 1.8 time = 220
* CHECK dout0_4 vdout0_4ck21 = 1.8 time = 220
* CHECK dout0_5 vdout0_5ck21 = 1.8 time = 220
* CHECK dout0_6 vdout0_6ck21 = 0 time = 220
* CHECK dout0_7 vdout0_7ck21 = 1.8 time = 220
* CHECK dout0_8 vdout0_8ck21 = 0 time = 220
* CHECK dout0_9 vdout0_9ck21 = 0 time = 220
* CHECK dout0_10 vdout0_10ck21 = 0 time = 220
* CHECK dout0_11 vdout0_11ck21 = 0 time = 220
* CHECK dout0_12 vdout0_12ck21 = 0 time = 220
* CHECK dout0_13 vdout0_13ck21 = 1.8 time = 220
* CHECK dout0_14 vdout0_14ck21 = 1.8 time = 220
* CHECK dout0_15 vdout0_15ck21 = 1.8 time = 220
* CHECK dout0_16 vdout0_16ck21 = 1.8 time = 220
* CHECK dout0_17 vdout0_17ck21 = 0 time = 220
* CHECK dout0_18 vdout0_18ck21 = 0 time = 220
* CHECK dout0_19 vdout0_19ck21 = 0 time = 220
* CHECK dout0_20 vdout0_20ck21 = 0 time = 220
* CHECK dout0_21 vdout0_21ck21 = 0 time = 220
* CHECK dout0_22 vdout0_22ck21 = 1.8 time = 220
* CHECK dout0_23 vdout0_23ck21 = 1.8 time = 220
* CHECK dout0_24 vdout0_24ck21 = 0 time = 220
* CHECK dout0_25 vdout0_25ck21 = 0 time = 220
* CHECK dout0_26 vdout0_26ck21 = 0 time = 220
* CHECK dout0_27 vdout0_27ck21 = 1.8 time = 220
* CHECK dout0_28 vdout0_28ck21 = 1.8 time = 220
* CHECK dout0_29 vdout0_29ck21 = 0 time = 220
* CHECK dout0_30 vdout0_30ck21 = 0 time = 220
* CHECK dout0_31 vdout0_31ck21 = 0 time = 220
* CHECK dout0_32 vdout0_32ck21 = 1.8 time = 220
* CHECK dout0_33 vdout0_33ck21 = 1.8 time = 220
* CHECK dout0_34 vdout0_34ck21 = 1.8 time = 220
* CHECK dout0_35 vdout0_35ck21 = 0 time = 220
* CHECK dout0_36 vdout0_36ck21 = 1.8 time = 220
* CHECK dout0_37 vdout0_37ck21 = 1.8 time = 220
* CHECK dout0_38 vdout0_38ck21 = 0 time = 220
* CHECK dout0_39 vdout0_39ck21 = 0 time = 220
* CHECK dout0_40 vdout0_40ck21 = 0 time = 220
* CHECK dout0_41 vdout0_41ck21 = 0 time = 220
* CHECK dout0_42 vdout0_42ck21 = 0 time = 220
* CHECK dout0_43 vdout0_43ck21 = 1.8 time = 220
* CHECK dout0_44 vdout0_44ck21 = 1.8 time = 220
* CHECK dout0_45 vdout0_45ck21 = 1.8 time = 220
* CHECK dout0_46 vdout0_46ck21 = 1.8 time = 220
* CHECK dout0_47 vdout0_47ck21 = 0 time = 220
* CHECK dout0_48 vdout0_48ck21 = 1.8 time = 220
* CHECK dout0_49 vdout0_49ck21 = 1.8 time = 220
* CHECK dout0_50 vdout0_50ck21 = 0 time = 220
* CHECK dout0_51 vdout0_51ck21 = 0 time = 220
* CHECK dout0_52 vdout0_52ck21 = 0 time = 220
* CHECK dout0_53 vdout0_53ck21 = 0 time = 220
* CHECK dout0_54 vdout0_54ck21 = 1.8 time = 220
* CHECK dout0_55 vdout0_55ck21 = 1.8 time = 220
* CHECK dout0_56 vdout0_56ck21 = 0 time = 220
* CHECK dout0_57 vdout0_57ck21 = 0 time = 220
* CHECK dout0_58 vdout0_58ck21 = 1.8 time = 220
* CHECK dout0_59 vdout0_59ck21 = 0 time = 220
* CHECK dout0_60 vdout0_60ck21 = 0 time = 220
* CHECK dout0_61 vdout0_61ck21 = 0 time = 220
* CHECK dout0_62 vdout0_62ck21 = 1.8 time = 220
* CHECK dout0_63 vdout0_63ck21 = 1.8 time = 220
* CHECK dout0_0 vdout0_0ck22 = 0 time = 230
* CHECK dout0_1 vdout0_1ck22 = 1.8 time = 230
* CHECK dout0_2 vdout0_2ck22 = 0 time = 230
* CHECK dout0_3 vdout0_3ck22 = 0 time = 230
* CHECK dout0_4 vdout0_4ck22 = 0 time = 230
* CHECK dout0_5 vdout0_5ck22 = 1.8 time = 230
* CHECK dout0_6 vdout0_6ck22 = 1.8 time = 230
* CHECK dout0_7 vdout0_7ck22 = 0 time = 230
* CHECK dout0_8 vdout0_8ck22 = 1.8 time = 230
* CHECK dout0_9 vdout0_9ck22 = 1.8 time = 230
* CHECK dout0_10 vdout0_10ck22 = 0 time = 230
* CHECK dout0_11 vdout0_11ck22 = 0 time = 230
* CHECK dout0_12 vdout0_12ck22 = 0 time = 230
* CHECK dout0_13 vdout0_13ck22 = 1.8 time = 230
* CHECK dout0_14 vdout0_14ck22 = 1.8 time = 230
* CHECK dout0_15 vdout0_15ck22 = 0 time = 230
* CHECK dout0_16 vdout0_16ck22 = 0 time = 230
* CHECK dout0_17 vdout0_17ck22 = 1.8 time = 230
* CHECK dout0_18 vdout0_18ck22 = 0 time = 230
* CHECK dout0_19 vdout0_19ck22 = 0 time = 230
* CHECK dout0_20 vdout0_20ck22 = 0 time = 230
* CHECK dout0_21 vdout0_21ck22 = 1.8 time = 230
* CHECK dout0_22 vdout0_22ck22 = 0 time = 230
* CHECK dout0_23 vdout0_23ck22 = 0 time = 230
* CHECK dout0_24 vdout0_24ck22 = 1.8 time = 230
* CHECK dout0_25 vdout0_25ck22 = 1.8 time = 230
* CHECK dout0_26 vdout0_26ck22 = 0 time = 230
* CHECK dout0_27 vdout0_27ck22 = 1.8 time = 230
* CHECK dout0_28 vdout0_28ck22 = 1.8 time = 230
* CHECK dout0_29 vdout0_29ck22 = 1.8 time = 230
* CHECK dout0_30 vdout0_30ck22 = 0 time = 230
* CHECK dout0_31 vdout0_31ck22 = 1.8 time = 230
* CHECK dout0_32 vdout0_32ck22 = 1.8 time = 230
* CHECK dout0_33 vdout0_33ck22 = 0 time = 230
* CHECK dout0_34 vdout0_34ck22 = 0 time = 230
* CHECK dout0_35 vdout0_35ck22 = 0 time = 230
* CHECK dout0_36 vdout0_36ck22 = 1.8 time = 230
* CHECK dout0_37 vdout0_37ck22 = 1.8 time = 230
* CHECK dout0_38 vdout0_38ck22 = 0 time = 230
* CHECK dout0_39 vdout0_39ck22 = 0 time = 230
* CHECK dout0_40 vdout0_40ck22 = 0 time = 230
* CHECK dout0_41 vdout0_41ck22 = 0 time = 230
* CHECK dout0_42 vdout0_42ck22 = 1.8 time = 230
* CHECK dout0_43 vdout0_43ck22 = 0 time = 230
* CHECK dout0_44 vdout0_44ck22 = 1.8 time = 230
* CHECK dout0_45 vdout0_45ck22 = 1.8 time = 230
* CHECK dout0_46 vdout0_46ck22 = 1.8 time = 230
* CHECK dout0_47 vdout0_47ck22 = 0 time = 230
* CHECK dout0_48 vdout0_48ck22 = 0 time = 230
* CHECK dout0_49 vdout0_49ck22 = 0 time = 230
* CHECK dout0_50 vdout0_50ck22 = 0 time = 230
* CHECK dout0_51 vdout0_51ck22 = 0 time = 230
* CHECK dout0_52 vdout0_52ck22 = 1.8 time = 230
* CHECK dout0_53 vdout0_53ck22 = 0 time = 230
* CHECK dout0_54 vdout0_54ck22 = 0 time = 230
* CHECK dout0_55 vdout0_55ck22 = 0 time = 230
* CHECK dout0_56 vdout0_56ck22 = 1.8 time = 230
* CHECK dout0_57 vdout0_57ck22 = 0 time = 230
* CHECK dout0_58 vdout0_58ck22 = 0 time = 230
* CHECK dout0_59 vdout0_59ck22 = 1.8 time = 230
* CHECK dout0_60 vdout0_60ck22 = 0 time = 230
* CHECK dout0_61 vdout0_61ck22 = 0 time = 230
* CHECK dout0_62 vdout0_62ck22 = 0 time = 230
* CHECK dout0_63 vdout0_63ck22 = 1.8 time = 230
* CHECK dout1_0 vdout1_0ck22 = 0 time = 230
* CHECK dout1_1 vdout1_1ck22 = 1.8 time = 230
* CHECK dout1_2 vdout1_2ck22 = 0 time = 230
* CHECK dout1_3 vdout1_3ck22 = 0 time = 230
* CHECK dout1_4 vdout1_4ck22 = 0 time = 230
* CHECK dout1_5 vdout1_5ck22 = 1.8 time = 230
* CHECK dout1_6 vdout1_6ck22 = 1.8 time = 230
* CHECK dout1_7 vdout1_7ck22 = 0 time = 230
* CHECK dout1_8 vdout1_8ck22 = 1.8 time = 230
* CHECK dout1_9 vdout1_9ck22 = 1.8 time = 230
* CHECK dout1_10 vdout1_10ck22 = 0 time = 230
* CHECK dout1_11 vdout1_11ck22 = 0 time = 230
* CHECK dout1_12 vdout1_12ck22 = 0 time = 230
* CHECK dout1_13 vdout1_13ck22 = 1.8 time = 230
* CHECK dout1_14 vdout1_14ck22 = 1.8 time = 230
* CHECK dout1_15 vdout1_15ck22 = 0 time = 230
* CHECK dout1_16 vdout1_16ck22 = 0 time = 230
* CHECK dout1_17 vdout1_17ck22 = 1.8 time = 230
* CHECK dout1_18 vdout1_18ck22 = 0 time = 230
* CHECK dout1_19 vdout1_19ck22 = 0 time = 230
* CHECK dout1_20 vdout1_20ck22 = 0 time = 230
* CHECK dout1_21 vdout1_21ck22 = 1.8 time = 230
* CHECK dout1_22 vdout1_22ck22 = 0 time = 230
* CHECK dout1_23 vdout1_23ck22 = 0 time = 230
* CHECK dout1_24 vdout1_24ck22 = 1.8 time = 230
* CHECK dout1_25 vdout1_25ck22 = 1.8 time = 230
* CHECK dout1_26 vdout1_26ck22 = 0 time = 230
* CHECK dout1_27 vdout1_27ck22 = 1.8 time = 230
* CHECK dout1_28 vdout1_28ck22 = 1.8 time = 230
* CHECK dout1_29 vdout1_29ck22 = 1.8 time = 230
* CHECK dout1_30 vdout1_30ck22 = 0 time = 230
* CHECK dout1_31 vdout1_31ck22 = 1.8 time = 230
* CHECK dout1_32 vdout1_32ck22 = 1.8 time = 230
* CHECK dout1_33 vdout1_33ck22 = 0 time = 230
* CHECK dout1_34 vdout1_34ck22 = 0 time = 230
* CHECK dout1_35 vdout1_35ck22 = 0 time = 230
* CHECK dout1_36 vdout1_36ck22 = 1.8 time = 230
* CHECK dout1_37 vdout1_37ck22 = 1.8 time = 230
* CHECK dout1_38 vdout1_38ck22 = 0 time = 230
* CHECK dout1_39 vdout1_39ck22 = 0 time = 230
* CHECK dout1_40 vdout1_40ck22 = 0 time = 230
* CHECK dout1_41 vdout1_41ck22 = 0 time = 230
* CHECK dout1_42 vdout1_42ck22 = 1.8 time = 230
* CHECK dout1_43 vdout1_43ck22 = 0 time = 230
* CHECK dout1_44 vdout1_44ck22 = 1.8 time = 230
* CHECK dout1_45 vdout1_45ck22 = 1.8 time = 230
* CHECK dout1_46 vdout1_46ck22 = 1.8 time = 230
* CHECK dout1_47 vdout1_47ck22 = 0 time = 230
* CHECK dout1_48 vdout1_48ck22 = 0 time = 230
* CHECK dout1_49 vdout1_49ck22 = 0 time = 230
* CHECK dout1_50 vdout1_50ck22 = 0 time = 230
* CHECK dout1_51 vdout1_51ck22 = 0 time = 230
* CHECK dout1_52 vdout1_52ck22 = 1.8 time = 230
* CHECK dout1_53 vdout1_53ck22 = 0 time = 230
* CHECK dout1_54 vdout1_54ck22 = 0 time = 230
* CHECK dout1_55 vdout1_55ck22 = 0 time = 230
* CHECK dout1_56 vdout1_56ck22 = 1.8 time = 230
* CHECK dout1_57 vdout1_57ck22 = 0 time = 230
* CHECK dout1_58 vdout1_58ck22 = 0 time = 230
* CHECK dout1_59 vdout1_59ck22 = 1.8 time = 230
* CHECK dout1_60 vdout1_60ck22 = 0 time = 230
* CHECK dout1_61 vdout1_61ck22 = 0 time = 230
* CHECK dout1_62 vdout1_62ck22 = 0 time = 230
* CHECK dout1_63 vdout1_63ck22 = 1.8 time = 230
* CHECK dout0_0 vdout0_0ck23 = 1.8 time = 240
* CHECK dout0_1 vdout0_1ck23 = 0 time = 240
* CHECK dout0_2 vdout0_2ck23 = 1.8 time = 240
* CHECK dout0_3 vdout0_3ck23 = 1.8 time = 240
* CHECK dout0_4 vdout0_4ck23 = 1.8 time = 240
* CHECK dout0_5 vdout0_5ck23 = 1.8 time = 240
* CHECK dout0_6 vdout0_6ck23 = 0 time = 240
* CHECK dout0_7 vdout0_7ck23 = 1.8 time = 240
* CHECK dout0_8 vdout0_8ck23 = 0 time = 240
* CHECK dout0_9 vdout0_9ck23 = 0 time = 240
* CHECK dout0_10 vdout0_10ck23 = 0 time = 240
* CHECK dout0_11 vdout0_11ck23 = 0 time = 240
* CHECK dout0_12 vdout0_12ck23 = 0 time = 240
* CHECK dout0_13 vdout0_13ck23 = 1.8 time = 240
* CHECK dout0_14 vdout0_14ck23 = 1.8 time = 240
* CHECK dout0_15 vdout0_15ck23 = 1.8 time = 240
* CHECK dout0_16 vdout0_16ck23 = 1.8 time = 240
* CHECK dout0_17 vdout0_17ck23 = 0 time = 240
* CHECK dout0_18 vdout0_18ck23 = 0 time = 240
* CHECK dout0_19 vdout0_19ck23 = 0 time = 240
* CHECK dout0_20 vdout0_20ck23 = 0 time = 240
* CHECK dout0_21 vdout0_21ck23 = 0 time = 240
* CHECK dout0_22 vdout0_22ck23 = 1.8 time = 240
* CHECK dout0_23 vdout0_23ck23 = 1.8 time = 240
* CHECK dout0_24 vdout0_24ck23 = 0 time = 240
* CHECK dout0_25 vdout0_25ck23 = 0 time = 240
* CHECK dout0_26 vdout0_26ck23 = 0 time = 240
* CHECK dout0_27 vdout0_27ck23 = 1.8 time = 240
* CHECK dout0_28 vdout0_28ck23 = 1.8 time = 240
* CHECK dout0_29 vdout0_29ck23 = 0 time = 240
* CHECK dout0_30 vdout0_30ck23 = 0 time = 240
* CHECK dout0_31 vdout0_31ck23 = 0 time = 240
* CHECK dout0_32 vdout0_32ck23 = 1.8 time = 240
* CHECK dout0_33 vdout0_33ck23 = 1.8 time = 240
* CHECK dout0_34 vdout0_34ck23 = 1.8 time = 240
* CHECK dout0_35 vdout0_35ck23 = 0 time = 240
* CHECK dout0_36 vdout0_36ck23 = 1.8 time = 240
* CHECK dout0_37 vdout0_37ck23 = 1.8 time = 240
* CHECK dout0_38 vdout0_38ck23 = 0 time = 240
* CHECK dout0_39 vdout0_39ck23 = 0 time = 240
* CHECK dout0_40 vdout0_40ck23 = 0 time = 240
* CHECK dout0_41 vdout0_41ck23 = 0 time = 240
* CHECK dout0_42 vdout0_42ck23 = 0 time = 240
* CHECK dout0_43 vdout0_43ck23 = 1.8 time = 240
* CHECK dout0_44 vdout0_44ck23 = 1.8 time = 240
* CHECK dout0_45 vdout0_45ck23 = 1.8 time = 240
* CHECK dout0_46 vdout0_46ck23 = 1.8 time = 240
* CHECK dout0_47 vdout0_47ck23 = 0 time = 240
* CHECK dout0_48 vdout0_48ck23 = 1.8 time = 240
* CHECK dout0_49 vdout0_49ck23 = 1.8 time = 240
* CHECK dout0_50 vdout0_50ck23 = 0 time = 240
* CHECK dout0_51 vdout0_51ck23 = 0 time = 240
* CHECK dout0_52 vdout0_52ck23 = 0 time = 240
* CHECK dout0_53 vdout0_53ck23 = 0 time = 240
* CHECK dout0_54 vdout0_54ck23 = 1.8 time = 240
* CHECK dout0_55 vdout0_55ck23 = 1.8 time = 240
* CHECK dout0_56 vdout0_56ck23 = 0 time = 240
* CHECK dout0_57 vdout0_57ck23 = 0 time = 240
* CHECK dout0_58 vdout0_58ck23 = 1.8 time = 240
* CHECK dout0_59 vdout0_59ck23 = 0 time = 240
* CHECK dout0_60 vdout0_60ck23 = 0 time = 240
* CHECK dout0_61 vdout0_61ck23 = 0 time = 240
* CHECK dout0_62 vdout0_62ck23 = 1.8 time = 240
* CHECK dout0_63 vdout0_63ck23 = 1.8 time = 240
* CHECK dout1_0 vdout1_0ck23 = 1.8 time = 240
* CHECK dout1_1 vdout1_1ck23 = 1.8 time = 240
* CHECK dout1_2 vdout1_2ck23 = 1.8 time = 240
* CHECK dout1_3 vdout1_3ck23 = 0 time = 240
* CHECK dout1_4 vdout1_4ck23 = 1.8 time = 240
* CHECK dout1_5 vdout1_5ck23 = 0 time = 240
* CHECK dout1_6 vdout1_6ck23 = 0 time = 240
* CHECK dout1_7 vdout1_7ck23 = 1.8 time = 240
* CHECK dout1_8 vdout1_8ck23 = 1.8 time = 240
* CHECK dout1_9 vdout1_9ck23 = 1.8 time = 240
* CHECK dout1_10 vdout1_10ck23 = 1.8 time = 240
* CHECK dout1_11 vdout1_11ck23 = 1.8 time = 240
* CHECK dout1_12 vdout1_12ck23 = 1.8 time = 240
* CHECK dout1_13 vdout1_13ck23 = 1.8 time = 240
* CHECK dout1_14 vdout1_14ck23 = 0 time = 240
* CHECK dout1_15 vdout1_15ck23 = 0 time = 240
* CHECK dout1_16 vdout1_16ck23 = 1.8 time = 240
* CHECK dout1_17 vdout1_17ck23 = 1.8 time = 240
* CHECK dout1_18 vdout1_18ck23 = 0 time = 240
* CHECK dout1_19 vdout1_19ck23 = 1.8 time = 240
* CHECK dout1_20 vdout1_20ck23 = 0 time = 240
* CHECK dout1_21 vdout1_21ck23 = 1.8 time = 240
* CHECK dout1_22 vdout1_22ck23 = 1.8 time = 240
* CHECK dout1_23 vdout1_23ck23 = 0 time = 240
* CHECK dout1_24 vdout1_24ck23 = 0 time = 240
* CHECK dout1_25 vdout1_25ck23 = 1.8 time = 240
* CHECK dout1_26 vdout1_26ck23 = 1.8 time = 240
* CHECK dout1_27 vdout1_27ck23 = 0 time = 240
* CHECK dout1_28 vdout1_28ck23 = 1.8 time = 240
* CHECK dout1_29 vdout1_29ck23 = 1.8 time = 240
* CHECK dout1_30 vdout1_30ck23 = 0 time = 240
* CHECK dout1_31 vdout1_31ck23 = 0 time = 240
* CHECK dout1_32 vdout1_32ck23 = 1.8 time = 240
* CHECK dout1_33 vdout1_33ck23 = 1.8 time = 240
* CHECK dout1_34 vdout1_34ck23 = 1.8 time = 240
* CHECK dout1_35 vdout1_35ck23 = 1.8 time = 240
* CHECK dout1_36 vdout1_36ck23 = 0 time = 240
* CHECK dout1_37 vdout1_37ck23 = 0 time = 240
* CHECK dout1_38 vdout1_38ck23 = 0 time = 240
* CHECK dout1_39 vdout1_39ck23 = 0 time = 240
* CHECK dout1_40 vdout1_40ck23 = 1.8 time = 240
* CHECK dout1_41 vdout1_41ck23 = 0 time = 240
* CHECK dout1_42 vdout1_42ck23 = 0 time = 240
* CHECK dout1_43 vdout1_43ck23 = 1.8 time = 240
* CHECK dout1_44 vdout1_44ck23 = 0 time = 240
* CHECK dout1_45 vdout1_45ck23 = 1.8 time = 240
* CHECK dout1_46 vdout1_46ck23 = 0 time = 240
* CHECK dout1_47 vdout1_47ck23 = 1.8 time = 240
* CHECK dout1_48 vdout1_48ck23 = 0 time = 240
* CHECK dout1_49 vdout1_49ck23 = 1.8 time = 240
* CHECK dout1_50 vdout1_50ck23 = 1.8 time = 240
* CHECK dout1_51 vdout1_51ck23 = 1.8 time = 240
* CHECK dout1_52 vdout1_52ck23 = 0 time = 240
* CHECK dout1_53 vdout1_53ck23 = 1.8 time = 240
* CHECK dout1_54 vdout1_54ck23 = 0 time = 240
* CHECK dout1_55 vdout1_55ck23 = 1.8 time = 240
* CHECK dout1_56 vdout1_56ck23 = 1.8 time = 240
* CHECK dout1_57 vdout1_57ck23 = 0 time = 240
* CHECK dout1_58 vdout1_58ck23 = 1.8 time = 240
* CHECK dout1_59 vdout1_59ck23 = 1.8 time = 240
* CHECK dout1_60 vdout1_60ck23 = 1.8 time = 240
* CHECK dout1_61 vdout1_61ck23 = 1.8 time = 240
* CHECK dout1_62 vdout1_62ck23 = 0 time = 240
* CHECK dout1_63 vdout1_63ck23 = 0 time = 240
* CHECK dout1_0 vdout1_0ck24 = 1.8 time = 250
* CHECK dout1_1 vdout1_1ck24 = 0 time = 250
* CHECK dout1_2 vdout1_2ck24 = 1.8 time = 250
* CHECK dout1_3 vdout1_3ck24 = 1.8 time = 250
* CHECK dout1_4 vdout1_4ck24 = 1.8 time = 250
* CHECK dout1_5 vdout1_5ck24 = 1.8 time = 250
* CHECK dout1_6 vdout1_6ck24 = 0 time = 250
* CHECK dout1_7 vdout1_7ck24 = 1.8 time = 250
* CHECK dout1_8 vdout1_8ck24 = 0 time = 250
* CHECK dout1_9 vdout1_9ck24 = 0 time = 250
* CHECK dout1_10 vdout1_10ck24 = 0 time = 250
* CHECK dout1_11 vdout1_11ck24 = 0 time = 250
* CHECK dout1_12 vdout1_12ck24 = 0 time = 250
* CHECK dout1_13 vdout1_13ck24 = 1.8 time = 250
* CHECK dout1_14 vdout1_14ck24 = 1.8 time = 250
* CHECK dout1_15 vdout1_15ck24 = 1.8 time = 250
* CHECK dout1_16 vdout1_16ck24 = 1.8 time = 250
* CHECK dout1_17 vdout1_17ck24 = 0 time = 250
* CHECK dout1_18 vdout1_18ck24 = 0 time = 250
* CHECK dout1_19 vdout1_19ck24 = 0 time = 250
* CHECK dout1_20 vdout1_20ck24 = 0 time = 250
* CHECK dout1_21 vdout1_21ck24 = 0 time = 250
* CHECK dout1_22 vdout1_22ck24 = 1.8 time = 250
* CHECK dout1_23 vdout1_23ck24 = 1.8 time = 250
* CHECK dout1_24 vdout1_24ck24 = 0 time = 250
* CHECK dout1_25 vdout1_25ck24 = 0 time = 250
* CHECK dout1_26 vdout1_26ck24 = 0 time = 250
* CHECK dout1_27 vdout1_27ck24 = 1.8 time = 250
* CHECK dout1_28 vdout1_28ck24 = 1.8 time = 250
* CHECK dout1_29 vdout1_29ck24 = 0 time = 250
* CHECK dout1_30 vdout1_30ck24 = 0 time = 250
* CHECK dout1_31 vdout1_31ck24 = 0 time = 250
* CHECK dout1_32 vdout1_32ck24 = 1.8 time = 250
* CHECK dout1_33 vdout1_33ck24 = 1.8 time = 250
* CHECK dout1_34 vdout1_34ck24 = 1.8 time = 250
* CHECK dout1_35 vdout1_35ck24 = 0 time = 250
* CHECK dout1_36 vdout1_36ck24 = 1.8 time = 250
* CHECK dout1_37 vdout1_37ck24 = 1.8 time = 250
* CHECK dout1_38 vdout1_38ck24 = 0 time = 250
* CHECK dout1_39 vdout1_39ck24 = 0 time = 250
* CHECK dout1_40 vdout1_40ck24 = 0 time = 250
* CHECK dout1_41 vdout1_41ck24 = 0 time = 250
* CHECK dout1_42 vdout1_42ck24 = 0 time = 250
* CHECK dout1_43 vdout1_43ck24 = 1.8 time = 250
* CHECK dout1_44 vdout1_44ck24 = 1.8 time = 250
* CHECK dout1_45 vdout1_45ck24 = 1.8 time = 250
* CHECK dout1_46 vdout1_46ck24 = 1.8 time = 250
* CHECK dout1_47 vdout1_47ck24 = 0 time = 250
* CHECK dout1_48 vdout1_48ck24 = 1.8 time = 250
* CHECK dout1_49 vdout1_49ck24 = 1.8 time = 250
* CHECK dout1_50 vdout1_50ck24 = 0 time = 250
* CHECK dout1_51 vdout1_51ck24 = 0 time = 250
* CHECK dout1_52 vdout1_52ck24 = 0 time = 250
* CHECK dout1_53 vdout1_53ck24 = 0 time = 250
* CHECK dout1_54 vdout1_54ck24 = 1.8 time = 250
* CHECK dout1_55 vdout1_55ck24 = 1.8 time = 250
* CHECK dout1_56 vdout1_56ck24 = 0 time = 250
* CHECK dout1_57 vdout1_57ck24 = 0 time = 250
* CHECK dout1_58 vdout1_58ck24 = 1.8 time = 250
* CHECK dout1_59 vdout1_59ck24 = 0 time = 250
* CHECK dout1_60 vdout1_60ck24 = 0 time = 250
* CHECK dout1_61 vdout1_61ck24 = 0 time = 250
* CHECK dout1_62 vdout1_62ck24 = 1.8 time = 250
* CHECK dout1_63 vdout1_63ck24 = 1.8 time = 250
* CHECK dout0_0 vdout0_0ck25 = 0 time = 260
* CHECK dout0_1 vdout0_1ck25 = 1.8 time = 260
* CHECK dout0_2 vdout0_2ck25 = 0 time = 260
* CHECK dout0_3 vdout0_3ck25 = 0 time = 260
* CHECK dout0_4 vdout0_4ck25 = 0 time = 260
* CHECK dout0_5 vdout0_5ck25 = 1.8 time = 260
* CHECK dout0_6 vdout0_6ck25 = 1.8 time = 260
* CHECK dout0_7 vdout0_7ck25 = 0 time = 260
* CHECK dout0_8 vdout0_8ck25 = 1.8 time = 260
* CHECK dout0_9 vdout0_9ck25 = 1.8 time = 260
* CHECK dout0_10 vdout0_10ck25 = 0 time = 260
* CHECK dout0_11 vdout0_11ck25 = 0 time = 260
* CHECK dout0_12 vdout0_12ck25 = 0 time = 260
* CHECK dout0_13 vdout0_13ck25 = 1.8 time = 260
* CHECK dout0_14 vdout0_14ck25 = 1.8 time = 260
* CHECK dout0_15 vdout0_15ck25 = 0 time = 260
* CHECK dout0_16 vdout0_16ck25 = 0 time = 260
* CHECK dout0_17 vdout0_17ck25 = 1.8 time = 260
* CHECK dout0_18 vdout0_18ck25 = 0 time = 260
* CHECK dout0_19 vdout0_19ck25 = 0 time = 260
* CHECK dout0_20 vdout0_20ck25 = 0 time = 260
* CHECK dout0_21 vdout0_21ck25 = 1.8 time = 260
* CHECK dout0_22 vdout0_22ck25 = 0 time = 260
* CHECK dout0_23 vdout0_23ck25 = 0 time = 260
* CHECK dout0_24 vdout0_24ck25 = 1.8 time = 260
* CHECK dout0_25 vdout0_25ck25 = 1.8 time = 260
* CHECK dout0_26 vdout0_26ck25 = 0 time = 260
* CHECK dout0_27 vdout0_27ck25 = 1.8 time = 260
* CHECK dout0_28 vdout0_28ck25 = 1.8 time = 260
* CHECK dout0_29 vdout0_29ck25 = 1.8 time = 260
* CHECK dout0_30 vdout0_30ck25 = 0 time = 260
* CHECK dout0_31 vdout0_31ck25 = 1.8 time = 260
* CHECK dout0_32 vdout0_32ck25 = 1.8 time = 260
* CHECK dout0_33 vdout0_33ck25 = 0 time = 260
* CHECK dout0_34 vdout0_34ck25 = 0 time = 260
* CHECK dout0_35 vdout0_35ck25 = 0 time = 260
* CHECK dout0_36 vdout0_36ck25 = 1.8 time = 260
* CHECK dout0_37 vdout0_37ck25 = 1.8 time = 260
* CHECK dout0_38 vdout0_38ck25 = 0 time = 260
* CHECK dout0_39 vdout0_39ck25 = 0 time = 260
* CHECK dout0_40 vdout0_40ck25 = 0 time = 260
* CHECK dout0_41 vdout0_41ck25 = 0 time = 260
* CHECK dout0_42 vdout0_42ck25 = 1.8 time = 260
* CHECK dout0_43 vdout0_43ck25 = 0 time = 260
* CHECK dout0_44 vdout0_44ck25 = 1.8 time = 260
* CHECK dout0_45 vdout0_45ck25 = 1.8 time = 260
* CHECK dout0_46 vdout0_46ck25 = 1.8 time = 260
* CHECK dout0_47 vdout0_47ck25 = 0 time = 260
* CHECK dout0_48 vdout0_48ck25 = 0 time = 260
* CHECK dout0_49 vdout0_49ck25 = 0 time = 260
* CHECK dout0_50 vdout0_50ck25 = 0 time = 260
* CHECK dout0_51 vdout0_51ck25 = 0 time = 260
* CHECK dout0_52 vdout0_52ck25 = 1.8 time = 260
* CHECK dout0_53 vdout0_53ck25 = 0 time = 260
* CHECK dout0_54 vdout0_54ck25 = 0 time = 260
* CHECK dout0_55 vdout0_55ck25 = 0 time = 260
* CHECK dout0_56 vdout0_56ck25 = 1.8 time = 260
* CHECK dout0_57 vdout0_57ck25 = 0 time = 260
* CHECK dout0_58 vdout0_58ck25 = 0 time = 260
* CHECK dout0_59 vdout0_59ck25 = 1.8 time = 260
* CHECK dout0_60 vdout0_60ck25 = 0 time = 260
* CHECK dout0_61 vdout0_61ck25 = 0 time = 260
* CHECK dout0_62 vdout0_62ck25 = 0 time = 260
* CHECK dout0_63 vdout0_63ck25 = 1.8 time = 260
* CHECK dout1_0 vdout1_0ck25 = 1.8 time = 260
* CHECK dout1_1 vdout1_1ck25 = 1.8 time = 260
* CHECK dout1_2 vdout1_2ck25 = 1.8 time = 260
* CHECK dout1_3 vdout1_3ck25 = 0 time = 260
* CHECK dout1_4 vdout1_4ck25 = 1.8 time = 260
* CHECK dout1_5 vdout1_5ck25 = 0 time = 260
* CHECK dout1_6 vdout1_6ck25 = 0 time = 260
* CHECK dout1_7 vdout1_7ck25 = 1.8 time = 260
* CHECK dout1_8 vdout1_8ck25 = 1.8 time = 260
* CHECK dout1_9 vdout1_9ck25 = 1.8 time = 260
* CHECK dout1_10 vdout1_10ck25 = 1.8 time = 260
* CHECK dout1_11 vdout1_11ck25 = 1.8 time = 260
* CHECK dout1_12 vdout1_12ck25 = 1.8 time = 260
* CHECK dout1_13 vdout1_13ck25 = 1.8 time = 260
* CHECK dout1_14 vdout1_14ck25 = 0 time = 260
* CHECK dout1_15 vdout1_15ck25 = 0 time = 260
* CHECK dout1_16 vdout1_16ck25 = 1.8 time = 260
* CHECK dout1_17 vdout1_17ck25 = 1.8 time = 260
* CHECK dout1_18 vdout1_18ck25 = 0 time = 260
* CHECK dout1_19 vdout1_19ck25 = 1.8 time = 260
* CHECK dout1_20 vdout1_20ck25 = 0 time = 260
* CHECK dout1_21 vdout1_21ck25 = 1.8 time = 260
* CHECK dout1_22 vdout1_22ck25 = 1.8 time = 260
* CHECK dout1_23 vdout1_23ck25 = 0 time = 260
* CHECK dout1_24 vdout1_24ck25 = 0 time = 260
* CHECK dout1_25 vdout1_25ck25 = 1.8 time = 260
* CHECK dout1_26 vdout1_26ck25 = 1.8 time = 260
* CHECK dout1_27 vdout1_27ck25 = 0 time = 260
* CHECK dout1_28 vdout1_28ck25 = 1.8 time = 260
* CHECK dout1_29 vdout1_29ck25 = 1.8 time = 260
* CHECK dout1_30 vdout1_30ck25 = 0 time = 260
* CHECK dout1_31 vdout1_31ck25 = 0 time = 260
* CHECK dout1_32 vdout1_32ck25 = 1.8 time = 260
* CHECK dout1_33 vdout1_33ck25 = 1.8 time = 260
* CHECK dout1_34 vdout1_34ck25 = 1.8 time = 260
* CHECK dout1_35 vdout1_35ck25 = 1.8 time = 260
* CHECK dout1_36 vdout1_36ck25 = 0 time = 260
* CHECK dout1_37 vdout1_37ck25 = 0 time = 260
* CHECK dout1_38 vdout1_38ck25 = 0 time = 260
* CHECK dout1_39 vdout1_39ck25 = 0 time = 260
* CHECK dout1_40 vdout1_40ck25 = 1.8 time = 260
* CHECK dout1_41 vdout1_41ck25 = 0 time = 260
* CHECK dout1_42 vdout1_42ck25 = 0 time = 260
* CHECK dout1_43 vdout1_43ck25 = 1.8 time = 260
* CHECK dout1_44 vdout1_44ck25 = 0 time = 260
* CHECK dout1_45 vdout1_45ck25 = 1.8 time = 260
* CHECK dout1_46 vdout1_46ck25 = 0 time = 260
* CHECK dout1_47 vdout1_47ck25 = 1.8 time = 260
* CHECK dout1_48 vdout1_48ck25 = 0 time = 260
* CHECK dout1_49 vdout1_49ck25 = 1.8 time = 260
* CHECK dout1_50 vdout1_50ck25 = 1.8 time = 260
* CHECK dout1_51 vdout1_51ck25 = 1.8 time = 260
* CHECK dout1_52 vdout1_52ck25 = 0 time = 260
* CHECK dout1_53 vdout1_53ck25 = 1.8 time = 260
* CHECK dout1_54 vdout1_54ck25 = 0 time = 260
* CHECK dout1_55 vdout1_55ck25 = 1.8 time = 260
* CHECK dout1_56 vdout1_56ck25 = 1.8 time = 260
* CHECK dout1_57 vdout1_57ck25 = 0 time = 260
* CHECK dout1_58 vdout1_58ck25 = 1.8 time = 260
* CHECK dout1_59 vdout1_59ck25 = 1.8 time = 260
* CHECK dout1_60 vdout1_60ck25 = 1.8 time = 260
* CHECK dout1_61 vdout1_61ck25 = 1.8 time = 260
* CHECK dout1_62 vdout1_62ck25 = 0 time = 260
* CHECK dout1_63 vdout1_63ck25 = 0 time = 260
* CHECK dout0_0 vdout0_0ck27 = 0 time = 280
* CHECK dout0_1 vdout0_1ck27 = 1.8 time = 280
* CHECK dout0_2 vdout0_2ck27 = 0 time = 280
* CHECK dout0_3 vdout0_3ck27 = 0 time = 280
* CHECK dout0_4 vdout0_4ck27 = 0 time = 280
* CHECK dout0_5 vdout0_5ck27 = 1.8 time = 280
* CHECK dout0_6 vdout0_6ck27 = 1.8 time = 280
* CHECK dout0_7 vdout0_7ck27 = 0 time = 280
* CHECK dout0_8 vdout0_8ck27 = 1.8 time = 280
* CHECK dout0_9 vdout0_9ck27 = 1.8 time = 280
* CHECK dout0_10 vdout0_10ck27 = 0 time = 280
* CHECK dout0_11 vdout0_11ck27 = 0 time = 280
* CHECK dout0_12 vdout0_12ck27 = 0 time = 280
* CHECK dout0_13 vdout0_13ck27 = 1.8 time = 280
* CHECK dout0_14 vdout0_14ck27 = 1.8 time = 280
* CHECK dout0_15 vdout0_15ck27 = 0 time = 280
* CHECK dout0_16 vdout0_16ck27 = 0 time = 280
* CHECK dout0_17 vdout0_17ck27 = 1.8 time = 280
* CHECK dout0_18 vdout0_18ck27 = 0 time = 280
* CHECK dout0_19 vdout0_19ck27 = 0 time = 280
* CHECK dout0_20 vdout0_20ck27 = 0 time = 280
* CHECK dout0_21 vdout0_21ck27 = 1.8 time = 280
* CHECK dout0_22 vdout0_22ck27 = 0 time = 280
* CHECK dout0_23 vdout0_23ck27 = 0 time = 280
* CHECK dout0_24 vdout0_24ck27 = 1.8 time = 280
* CHECK dout0_25 vdout0_25ck27 = 1.8 time = 280
* CHECK dout0_26 vdout0_26ck27 = 0 time = 280
* CHECK dout0_27 vdout0_27ck27 = 1.8 time = 280
* CHECK dout0_28 vdout0_28ck27 = 1.8 time = 280
* CHECK dout0_29 vdout0_29ck27 = 1.8 time = 280
* CHECK dout0_30 vdout0_30ck27 = 0 time = 280
* CHECK dout0_31 vdout0_31ck27 = 1.8 time = 280
* CHECK dout0_32 vdout0_32ck27 = 1.8 time = 280
* CHECK dout0_33 vdout0_33ck27 = 0 time = 280
* CHECK dout0_34 vdout0_34ck27 = 0 time = 280
* CHECK dout0_35 vdout0_35ck27 = 0 time = 280
* CHECK dout0_36 vdout0_36ck27 = 1.8 time = 280
* CHECK dout0_37 vdout0_37ck27 = 1.8 time = 280
* CHECK dout0_38 vdout0_38ck27 = 0 time = 280
* CHECK dout0_39 vdout0_39ck27 = 0 time = 280
* CHECK dout0_40 vdout0_40ck27 = 0 time = 280
* CHECK dout0_41 vdout0_41ck27 = 0 time = 280
* CHECK dout0_42 vdout0_42ck27 = 1.8 time = 280
* CHECK dout0_43 vdout0_43ck27 = 0 time = 280
* CHECK dout0_44 vdout0_44ck27 = 1.8 time = 280
* CHECK dout0_45 vdout0_45ck27 = 1.8 time = 280
* CHECK dout0_46 vdout0_46ck27 = 1.8 time = 280
* CHECK dout0_47 vdout0_47ck27 = 0 time = 280
* CHECK dout0_48 vdout0_48ck27 = 0 time = 280
* CHECK dout0_49 vdout0_49ck27 = 0 time = 280
* CHECK dout0_50 vdout0_50ck27 = 0 time = 280
* CHECK dout0_51 vdout0_51ck27 = 0 time = 280
* CHECK dout0_52 vdout0_52ck27 = 1.8 time = 280
* CHECK dout0_53 vdout0_53ck27 = 0 time = 280
* CHECK dout0_54 vdout0_54ck27 = 0 time = 280
* CHECK dout0_55 vdout0_55ck27 = 0 time = 280
* CHECK dout0_56 vdout0_56ck27 = 1.8 time = 280
* CHECK dout0_57 vdout0_57ck27 = 0 time = 280
* CHECK dout0_58 vdout0_58ck27 = 0 time = 280
* CHECK dout0_59 vdout0_59ck27 = 1.8 time = 280
* CHECK dout0_60 vdout0_60ck27 = 0 time = 280
* CHECK dout0_61 vdout0_61ck27 = 0 time = 280
* CHECK dout0_62 vdout0_62ck27 = 0 time = 280
* CHECK dout0_63 vdout0_63ck27 = 1.8 time = 280
* CHECK dout1_0 vdout1_0ck27 = 1.8 time = 280
* CHECK dout1_1 vdout1_1ck27 = 0 time = 280
* CHECK dout1_2 vdout1_2ck27 = 1.8 time = 280
* CHECK dout1_3 vdout1_3ck27 = 1.8 time = 280
* CHECK dout1_4 vdout1_4ck27 = 1.8 time = 280
* CHECK dout1_5 vdout1_5ck27 = 1.8 time = 280
* CHECK dout1_6 vdout1_6ck27 = 0 time = 280
* CHECK dout1_7 vdout1_7ck27 = 1.8 time = 280
* CHECK dout1_8 vdout1_8ck27 = 0 time = 280
* CHECK dout1_9 vdout1_9ck27 = 0 time = 280
* CHECK dout1_10 vdout1_10ck27 = 0 time = 280
* CHECK dout1_11 vdout1_11ck27 = 0 time = 280
* CHECK dout1_12 vdout1_12ck27 = 0 time = 280
* CHECK dout1_13 vdout1_13ck27 = 1.8 time = 280
* CHECK dout1_14 vdout1_14ck27 = 1.8 time = 280
* CHECK dout1_15 vdout1_15ck27 = 1.8 time = 280
* CHECK dout1_16 vdout1_16ck27 = 1.8 time = 280
* CHECK dout1_17 vdout1_17ck27 = 0 time = 280
* CHECK dout1_18 vdout1_18ck27 = 0 time = 280
* CHECK dout1_19 vdout1_19ck27 = 0 time = 280
* CHECK dout1_20 vdout1_20ck27 = 0 time = 280
* CHECK dout1_21 vdout1_21ck27 = 0 time = 280
* CHECK dout1_22 vdout1_22ck27 = 1.8 time = 280
* CHECK dout1_23 vdout1_23ck27 = 1.8 time = 280
* CHECK dout1_24 vdout1_24ck27 = 0 time = 280
* CHECK dout1_25 vdout1_25ck27 = 0 time = 280
* CHECK dout1_26 vdout1_26ck27 = 0 time = 280
* CHECK dout1_27 vdout1_27ck27 = 1.8 time = 280
* CHECK dout1_28 vdout1_28ck27 = 1.8 time = 280
* CHECK dout1_29 vdout1_29ck27 = 0 time = 280
* CHECK dout1_30 vdout1_30ck27 = 0 time = 280
* CHECK dout1_31 vdout1_31ck27 = 0 time = 280
* CHECK dout1_32 vdout1_32ck27 = 1.8 time = 280
* CHECK dout1_33 vdout1_33ck27 = 1.8 time = 280
* CHECK dout1_34 vdout1_34ck27 = 1.8 time = 280
* CHECK dout1_35 vdout1_35ck27 = 0 time = 280
* CHECK dout1_36 vdout1_36ck27 = 1.8 time = 280
* CHECK dout1_37 vdout1_37ck27 = 1.8 time = 280
* CHECK dout1_38 vdout1_38ck27 = 0 time = 280
* CHECK dout1_39 vdout1_39ck27 = 0 time = 280
* CHECK dout1_40 vdout1_40ck27 = 0 time = 280
* CHECK dout1_41 vdout1_41ck27 = 0 time = 280
* CHECK dout1_42 vdout1_42ck27 = 0 time = 280
* CHECK dout1_43 vdout1_43ck27 = 1.8 time = 280
* CHECK dout1_44 vdout1_44ck27 = 1.8 time = 280
* CHECK dout1_45 vdout1_45ck27 = 1.8 time = 280
* CHECK dout1_46 vdout1_46ck27 = 1.8 time = 280
* CHECK dout1_47 vdout1_47ck27 = 0 time = 280
* CHECK dout1_48 vdout1_48ck27 = 1.8 time = 280
* CHECK dout1_49 vdout1_49ck27 = 1.8 time = 280
* CHECK dout1_50 vdout1_50ck27 = 0 time = 280
* CHECK dout1_51 vdout1_51ck27 = 0 time = 280
* CHECK dout1_52 vdout1_52ck27 = 0 time = 280
* CHECK dout1_53 vdout1_53ck27 = 0 time = 280
* CHECK dout1_54 vdout1_54ck27 = 1.8 time = 280
* CHECK dout1_55 vdout1_55ck27 = 1.8 time = 280
* CHECK dout1_56 vdout1_56ck27 = 0 time = 280
* CHECK dout1_57 vdout1_57ck27 = 0 time = 280
* CHECK dout1_58 vdout1_58ck27 = 1.8 time = 280
* CHECK dout1_59 vdout1_59ck27 = 0 time = 280
* CHECK dout1_60 vdout1_60ck27 = 0 time = 280
* CHECK dout1_61 vdout1_61ck27 = 0 time = 280
* CHECK dout1_62 vdout1_62ck27 = 1.8 time = 280
* CHECK dout1_63 vdout1_63ck27 = 1.8 time = 280
* CHECK dout0_0 vdout0_0ck28 = 1.8 time = 290
* CHECK dout0_1 vdout0_1ck28 = 1.8 time = 290
* CHECK dout0_2 vdout0_2ck28 = 0 time = 290
* CHECK dout0_3 vdout0_3ck28 = 0 time = 290
* CHECK dout0_4 vdout0_4ck28 = 1.8 time = 290
* CHECK dout0_5 vdout0_5ck28 = 0 time = 290
* CHECK dout0_6 vdout0_6ck28 = 0 time = 290
* CHECK dout0_7 vdout0_7ck28 = 1.8 time = 290
* CHECK dout0_8 vdout0_8ck28 = 0 time = 290
* CHECK dout0_9 vdout0_9ck28 = 1.8 time = 290
* CHECK dout0_10 vdout0_10ck28 = 1.8 time = 290
* CHECK dout0_11 vdout0_11ck28 = 0 time = 290
* CHECK dout0_12 vdout0_12ck28 = 1.8 time = 290
* CHECK dout0_13 vdout0_13ck28 = 1.8 time = 290
* CHECK dout0_14 vdout0_14ck28 = 0 time = 290
* CHECK dout0_15 vdout0_15ck28 = 1.8 time = 290
* CHECK dout0_16 vdout0_16ck28 = 0 time = 290
* CHECK dout0_17 vdout0_17ck28 = 0 time = 290
* CHECK dout0_18 vdout0_18ck28 = 1.8 time = 290
* CHECK dout0_19 vdout0_19ck28 = 1.8 time = 290
* CHECK dout0_20 vdout0_20ck28 = 1.8 time = 290
* CHECK dout0_21 vdout0_21ck28 = 0 time = 290
* CHECK dout0_22 vdout0_22ck28 = 0 time = 290
* CHECK dout0_23 vdout0_23ck28 = 0 time = 290
* CHECK dout0_24 vdout0_24ck28 = 1.8 time = 290
* CHECK dout0_25 vdout0_25ck28 = 0 time = 290
* CHECK dout0_26 vdout0_26ck28 = 1.8 time = 290
* CHECK dout0_27 vdout0_27ck28 = 0 time = 290
* CHECK dout0_28 vdout0_28ck28 = 0 time = 290
* CHECK dout0_29 vdout0_29ck28 = 0 time = 290
* CHECK dout0_30 vdout0_30ck28 = 1.8 time = 290
* CHECK dout0_31 vdout0_31ck28 = 0 time = 290
* CHECK dout0_32 vdout0_32ck28 = 0 time = 290
* CHECK dout0_33 vdout0_33ck28 = 0 time = 290
* CHECK dout0_34 vdout0_34ck28 = 1.8 time = 290
* CHECK dout0_35 vdout0_35ck28 = 1.8 time = 290
* CHECK dout0_36 vdout0_36ck28 = 0 time = 290
* CHECK dout0_37 vdout0_37ck28 = 1.8 time = 290
* CHECK dout0_38 vdout0_38ck28 = 0 time = 290
* CHECK dout0_39 vdout0_39ck28 = 0 time = 290
* CHECK dout0_40 vdout0_40ck28 = 0 time = 290
* CHECK dout0_41 vdout0_41ck28 = 0 time = 290
* CHECK dout0_42 vdout0_42ck28 = 0 time = 290
* CHECK dout0_43 vdout0_43ck28 = 0 time = 290
* CHECK dout0_44 vdout0_44ck28 = 0 time = 290
* CHECK dout0_45 vdout0_45ck28 = 0 time = 290
* CHECK dout0_46 vdout0_46ck28 = 1.8 time = 290
* CHECK dout0_47 vdout0_47ck28 = 0 time = 290
* CHECK dout0_48 vdout0_48ck28 = 0 time = 290
* CHECK dout0_49 vdout0_49ck28 = 0 time = 290
* CHECK dout0_50 vdout0_50ck28 = 1.8 time = 290
* CHECK dout0_51 vdout0_51ck28 = 1.8 time = 290
* CHECK dout0_52 vdout0_52ck28 = 1.8 time = 290
* CHECK dout0_53 vdout0_53ck28 = 0 time = 290
* CHECK dout0_54 vdout0_54ck28 = 1.8 time = 290
* CHECK dout0_55 vdout0_55ck28 = 1.8 time = 290
* CHECK dout0_56 vdout0_56ck28 = 1.8 time = 290
* CHECK dout0_57 vdout0_57ck28 = 1.8 time = 290
* CHECK dout0_58 vdout0_58ck28 = 0 time = 290
* CHECK dout0_59 vdout0_59ck28 = 0 time = 290
* CHECK dout0_60 vdout0_60ck28 = 1.8 time = 290
* CHECK dout0_61 vdout0_61ck28 = 0 time = 290
* CHECK dout0_62 vdout0_62ck28 = 1.8 time = 290
* CHECK dout0_63 vdout0_63ck28 = 1.8 time = 290
* CHECK dout0_0 vdout0_0ck29 = 1.8 time = 300
* CHECK dout0_1 vdout0_1ck29 = 0 time = 300
* CHECK dout0_2 vdout0_2ck29 = 1.8 time = 300
* CHECK dout0_3 vdout0_3ck29 = 1.8 time = 300
* CHECK dout0_4 vdout0_4ck29 = 1.8 time = 300
* CHECK dout0_5 vdout0_5ck29 = 1.8 time = 300
* CHECK dout0_6 vdout0_6ck29 = 0 time = 300
* CHECK dout0_7 vdout0_7ck29 = 1.8 time = 300
* CHECK dout0_8 vdout0_8ck29 = 0 time = 300
* CHECK dout0_9 vdout0_9ck29 = 0 time = 300
* CHECK dout0_10 vdout0_10ck29 = 0 time = 300
* CHECK dout0_11 vdout0_11ck29 = 0 time = 300
* CHECK dout0_12 vdout0_12ck29 = 0 time = 300
* CHECK dout0_13 vdout0_13ck29 = 1.8 time = 300
* CHECK dout0_14 vdout0_14ck29 = 1.8 time = 300
* CHECK dout0_15 vdout0_15ck29 = 1.8 time = 300
* CHECK dout0_16 vdout0_16ck29 = 1.8 time = 300
* CHECK dout0_17 vdout0_17ck29 = 0 time = 300
* CHECK dout0_18 vdout0_18ck29 = 0 time = 300
* CHECK dout0_19 vdout0_19ck29 = 0 time = 300
* CHECK dout0_20 vdout0_20ck29 = 0 time = 300
* CHECK dout0_21 vdout0_21ck29 = 0 time = 300
* CHECK dout0_22 vdout0_22ck29 = 1.8 time = 300
* CHECK dout0_23 vdout0_23ck29 = 1.8 time = 300
* CHECK dout0_24 vdout0_24ck29 = 0 time = 300
* CHECK dout0_25 vdout0_25ck29 = 0 time = 300
* CHECK dout0_26 vdout0_26ck29 = 0 time = 300
* CHECK dout0_27 vdout0_27ck29 = 1.8 time = 300
* CHECK dout0_28 vdout0_28ck29 = 1.8 time = 300
* CHECK dout0_29 vdout0_29ck29 = 0 time = 300
* CHECK dout0_30 vdout0_30ck29 = 0 time = 300
* CHECK dout0_31 vdout0_31ck29 = 0 time = 300
* CHECK dout0_32 vdout0_32ck29 = 1.8 time = 300
* CHECK dout0_33 vdout0_33ck29 = 1.8 time = 300
* CHECK dout0_34 vdout0_34ck29 = 1.8 time = 300
* CHECK dout0_35 vdout0_35ck29 = 0 time = 300
* CHECK dout0_36 vdout0_36ck29 = 1.8 time = 300
* CHECK dout0_37 vdout0_37ck29 = 1.8 time = 300
* CHECK dout0_38 vdout0_38ck29 = 0 time = 300
* CHECK dout0_39 vdout0_39ck29 = 0 time = 300
* CHECK dout0_40 vdout0_40ck29 = 0 time = 300
* CHECK dout0_41 vdout0_41ck29 = 0 time = 300
* CHECK dout0_42 vdout0_42ck29 = 0 time = 300
* CHECK dout0_43 vdout0_43ck29 = 1.8 time = 300
* CHECK dout0_44 vdout0_44ck29 = 1.8 time = 300
* CHECK dout0_45 vdout0_45ck29 = 1.8 time = 300
* CHECK dout0_46 vdout0_46ck29 = 1.8 time = 300
* CHECK dout0_47 vdout0_47ck29 = 0 time = 300
* CHECK dout0_48 vdout0_48ck29 = 1.8 time = 300
* CHECK dout0_49 vdout0_49ck29 = 1.8 time = 300
* CHECK dout0_50 vdout0_50ck29 = 0 time = 300
* CHECK dout0_51 vdout0_51ck29 = 0 time = 300
* CHECK dout0_52 vdout0_52ck29 = 0 time = 300
* CHECK dout0_53 vdout0_53ck29 = 0 time = 300
* CHECK dout0_54 vdout0_54ck29 = 1.8 time = 300
* CHECK dout0_55 vdout0_55ck29 = 1.8 time = 300
* CHECK dout0_56 vdout0_56ck29 = 0 time = 300
* CHECK dout0_57 vdout0_57ck29 = 0 time = 300
* CHECK dout0_58 vdout0_58ck29 = 1.8 time = 300
* CHECK dout0_59 vdout0_59ck29 = 0 time = 300
* CHECK dout0_60 vdout0_60ck29 = 0 time = 300
* CHECK dout0_61 vdout0_61ck29 = 0 time = 300
* CHECK dout0_62 vdout0_62ck29 = 1.8 time = 300
* CHECK dout0_63 vdout0_63ck29 = 1.8 time = 300
* CHECK dout1_0 vdout1_0ck29 = 1.8 time = 300
* CHECK dout1_1 vdout1_1ck29 = 1.8 time = 300
* CHECK dout1_2 vdout1_2ck29 = 0 time = 300
* CHECK dout1_3 vdout1_3ck29 = 0 time = 300
* CHECK dout1_4 vdout1_4ck29 = 1.8 time = 300
* CHECK dout1_5 vdout1_5ck29 = 0 time = 300
* CHECK dout1_6 vdout1_6ck29 = 0 time = 300
* CHECK dout1_7 vdout1_7ck29 = 1.8 time = 300
* CHECK dout1_8 vdout1_8ck29 = 0 time = 300
* CHECK dout1_9 vdout1_9ck29 = 1.8 time = 300
* CHECK dout1_10 vdout1_10ck29 = 1.8 time = 300
* CHECK dout1_11 vdout1_11ck29 = 0 time = 300
* CHECK dout1_12 vdout1_12ck29 = 1.8 time = 300
* CHECK dout1_13 vdout1_13ck29 = 1.8 time = 300
* CHECK dout1_14 vdout1_14ck29 = 0 time = 300
* CHECK dout1_15 vdout1_15ck29 = 1.8 time = 300
* CHECK dout1_16 vdout1_16ck29 = 0 time = 300
* CHECK dout1_17 vdout1_17ck29 = 0 time = 300
* CHECK dout1_18 vdout1_18ck29 = 1.8 time = 300
* CHECK dout1_19 vdout1_19ck29 = 1.8 time = 300
* CHECK dout1_20 vdout1_20ck29 = 1.8 time = 300
* CHECK dout1_21 vdout1_21ck29 = 0 time = 300
* CHECK dout1_22 vdout1_22ck29 = 0 time = 300
* CHECK dout1_23 vdout1_23ck29 = 0 time = 300
* CHECK dout1_24 vdout1_24ck29 = 1.8 time = 300
* CHECK dout1_25 vdout1_25ck29 = 0 time = 300
* CHECK dout1_26 vdout1_26ck29 = 1.8 time = 300
* CHECK dout1_27 vdout1_27ck29 = 0 time = 300
* CHECK dout1_28 vdout1_28ck29 = 0 time = 300
* CHECK dout1_29 vdout1_29ck29 = 0 time = 300
* CHECK dout1_30 vdout1_30ck29 = 1.8 time = 300
* CHECK dout1_31 vdout1_31ck29 = 0 time = 300
* CHECK dout1_32 vdout1_32ck29 = 0 time = 300
* CHECK dout1_33 vdout1_33ck29 = 0 time = 300
* CHECK dout1_34 vdout1_34ck29 = 1.8 time = 300
* CHECK dout1_35 vdout1_35ck29 = 1.8 time = 300
* CHECK dout1_36 vdout1_36ck29 = 0 time = 300
* CHECK dout1_37 vdout1_37ck29 = 1.8 time = 300
* CHECK dout1_38 vdout1_38ck29 = 0 time = 300
* CHECK dout1_39 vdout1_39ck29 = 0 time = 300
* CHECK dout1_40 vdout1_40ck29 = 0 time = 300
* CHECK dout1_41 vdout1_41ck29 = 0 time = 300
* CHECK dout1_42 vdout1_42ck29 = 0 time = 300
* CHECK dout1_43 vdout1_43ck29 = 0 time = 300
* CHECK dout1_44 vdout1_44ck29 = 0 time = 300
* CHECK dout1_45 vdout1_45ck29 = 0 time = 300
* CHECK dout1_46 vdout1_46ck29 = 1.8 time = 300
* CHECK dout1_47 vdout1_47ck29 = 0 time = 300
* CHECK dout1_48 vdout1_48ck29 = 0 time = 300
* CHECK dout1_49 vdout1_49ck29 = 0 time = 300
* CHECK dout1_50 vdout1_50ck29 = 1.8 time = 300
* CHECK dout1_51 vdout1_51ck29 = 1.8 time = 300
* CHECK dout1_52 vdout1_52ck29 = 1.8 time = 300
* CHECK dout1_53 vdout1_53ck29 = 0 time = 300
* CHECK dout1_54 vdout1_54ck29 = 1.8 time = 300
* CHECK dout1_55 vdout1_55ck29 = 1.8 time = 300
* CHECK dout1_56 vdout1_56ck29 = 1.8 time = 300
* CHECK dout1_57 vdout1_57ck29 = 1.8 time = 300
* CHECK dout1_58 vdout1_58ck29 = 0 time = 300
* CHECK dout1_59 vdout1_59ck29 = 0 time = 300
* CHECK dout1_60 vdout1_60ck29 = 1.8 time = 300
* CHECK dout1_61 vdout1_61ck29 = 0 time = 300
* CHECK dout1_62 vdout1_62ck29 = 1.8 time = 300
* CHECK dout1_63 vdout1_63ck29 = 1.8 time = 300
* CHECK dout0_0 vdout0_0ck30 = 0 time = 310
* CHECK dout0_1 vdout0_1ck30 = 1.8 time = 310
* CHECK dout0_2 vdout0_2ck30 = 0 time = 310
* CHECK dout0_3 vdout0_3ck30 = 0 time = 310
* CHECK dout0_4 vdout0_4ck30 = 0 time = 310
* CHECK dout0_5 vdout0_5ck30 = 1.8 time = 310
* CHECK dout0_6 vdout0_6ck30 = 1.8 time = 310
* CHECK dout0_7 vdout0_7ck30 = 0 time = 310
* CHECK dout0_8 vdout0_8ck30 = 1.8 time = 310
* CHECK dout0_9 vdout0_9ck30 = 1.8 time = 310
* CHECK dout0_10 vdout0_10ck30 = 0 time = 310
* CHECK dout0_11 vdout0_11ck30 = 0 time = 310
* CHECK dout0_12 vdout0_12ck30 = 0 time = 310
* CHECK dout0_13 vdout0_13ck30 = 1.8 time = 310
* CHECK dout0_14 vdout0_14ck30 = 1.8 time = 310
* CHECK dout0_15 vdout0_15ck30 = 0 time = 310
* CHECK dout0_16 vdout0_16ck30 = 0 time = 310
* CHECK dout0_17 vdout0_17ck30 = 1.8 time = 310
* CHECK dout0_18 vdout0_18ck30 = 0 time = 310
* CHECK dout0_19 vdout0_19ck30 = 0 time = 310
* CHECK dout0_20 vdout0_20ck30 = 0 time = 310
* CHECK dout0_21 vdout0_21ck30 = 1.8 time = 310
* CHECK dout0_22 vdout0_22ck30 = 0 time = 310
* CHECK dout0_23 vdout0_23ck30 = 0 time = 310
* CHECK dout0_24 vdout0_24ck30 = 1.8 time = 310
* CHECK dout0_25 vdout0_25ck30 = 1.8 time = 310
* CHECK dout0_26 vdout0_26ck30 = 0 time = 310
* CHECK dout0_27 vdout0_27ck30 = 1.8 time = 310
* CHECK dout0_28 vdout0_28ck30 = 1.8 time = 310
* CHECK dout0_29 vdout0_29ck30 = 1.8 time = 310
* CHECK dout0_30 vdout0_30ck30 = 0 time = 310
* CHECK dout0_31 vdout0_31ck30 = 1.8 time = 310
* CHECK dout0_32 vdout0_32ck30 = 1.8 time = 310
* CHECK dout0_33 vdout0_33ck30 = 0 time = 310
* CHECK dout0_34 vdout0_34ck30 = 0 time = 310
* CHECK dout0_35 vdout0_35ck30 = 0 time = 310
* CHECK dout0_36 vdout0_36ck30 = 1.8 time = 310
* CHECK dout0_37 vdout0_37ck30 = 1.8 time = 310
* CHECK dout0_38 vdout0_38ck30 = 0 time = 310
* CHECK dout0_39 vdout0_39ck30 = 0 time = 310
* CHECK dout0_40 vdout0_40ck30 = 0 time = 310
* CHECK dout0_41 vdout0_41ck30 = 0 time = 310
* CHECK dout0_42 vdout0_42ck30 = 1.8 time = 310
* CHECK dout0_43 vdout0_43ck30 = 0 time = 310
* CHECK dout0_44 vdout0_44ck30 = 1.8 time = 310
* CHECK dout0_45 vdout0_45ck30 = 1.8 time = 310
* CHECK dout0_46 vdout0_46ck30 = 1.8 time = 310
* CHECK dout0_47 vdout0_47ck30 = 0 time = 310
* CHECK dout0_48 vdout0_48ck30 = 0 time = 310
* CHECK dout0_49 vdout0_49ck30 = 0 time = 310
* CHECK dout0_50 vdout0_50ck30 = 0 time = 310
* CHECK dout0_51 vdout0_51ck30 = 0 time = 310
* CHECK dout0_52 vdout0_52ck30 = 1.8 time = 310
* CHECK dout0_53 vdout0_53ck30 = 0 time = 310
* CHECK dout0_54 vdout0_54ck30 = 0 time = 310
* CHECK dout0_55 vdout0_55ck30 = 0 time = 310
* CHECK dout0_56 vdout0_56ck30 = 1.8 time = 310
* CHECK dout0_57 vdout0_57ck30 = 0 time = 310
* CHECK dout0_58 vdout0_58ck30 = 0 time = 310
* CHECK dout0_59 vdout0_59ck30 = 1.8 time = 310
* CHECK dout0_60 vdout0_60ck30 = 0 time = 310
* CHECK dout0_61 vdout0_61ck30 = 0 time = 310
* CHECK dout0_62 vdout0_62ck30 = 0 time = 310
* CHECK dout0_63 vdout0_63ck30 = 1.8 time = 310
* CHECK dout1_0 vdout1_0ck30 = 1.8 time = 310
* CHECK dout1_1 vdout1_1ck30 = 0 time = 310
* CHECK dout1_2 vdout1_2ck30 = 1.8 time = 310
* CHECK dout1_3 vdout1_3ck30 = 1.8 time = 310
* CHECK dout1_4 vdout1_4ck30 = 1.8 time = 310
* CHECK dout1_5 vdout1_5ck30 = 1.8 time = 310
* CHECK dout1_6 vdout1_6ck30 = 0 time = 310
* CHECK dout1_7 vdout1_7ck30 = 1.8 time = 310
* CHECK dout1_8 vdout1_8ck30 = 0 time = 310
* CHECK dout1_9 vdout1_9ck30 = 0 time = 310
* CHECK dout1_10 vdout1_10ck30 = 0 time = 310
* CHECK dout1_11 vdout1_11ck30 = 0 time = 310
* CHECK dout1_12 vdout1_12ck30 = 0 time = 310
* CHECK dout1_13 vdout1_13ck30 = 1.8 time = 310
* CHECK dout1_14 vdout1_14ck30 = 1.8 time = 310
* CHECK dout1_15 vdout1_15ck30 = 1.8 time = 310
* CHECK dout1_16 vdout1_16ck30 = 1.8 time = 310
* CHECK dout1_17 vdout1_17ck30 = 0 time = 310
* CHECK dout1_18 vdout1_18ck30 = 0 time = 310
* CHECK dout1_19 vdout1_19ck30 = 0 time = 310
* CHECK dout1_20 vdout1_20ck30 = 0 time = 310
* CHECK dout1_21 vdout1_21ck30 = 0 time = 310
* CHECK dout1_22 vdout1_22ck30 = 1.8 time = 310
* CHECK dout1_23 vdout1_23ck30 = 1.8 time = 310
* CHECK dout1_24 vdout1_24ck30 = 0 time = 310
* CHECK dout1_25 vdout1_25ck30 = 0 time = 310
* CHECK dout1_26 vdout1_26ck30 = 0 time = 310
* CHECK dout1_27 vdout1_27ck30 = 1.8 time = 310
* CHECK dout1_28 vdout1_28ck30 = 1.8 time = 310
* CHECK dout1_29 vdout1_29ck30 = 0 time = 310
* CHECK dout1_30 vdout1_30ck30 = 0 time = 310
* CHECK dout1_31 vdout1_31ck30 = 0 time = 310
* CHECK dout1_32 vdout1_32ck30 = 1.8 time = 310
* CHECK dout1_33 vdout1_33ck30 = 1.8 time = 310
* CHECK dout1_34 vdout1_34ck30 = 1.8 time = 310
* CHECK dout1_35 vdout1_35ck30 = 0 time = 310
* CHECK dout1_36 vdout1_36ck30 = 1.8 time = 310
* CHECK dout1_37 vdout1_37ck30 = 1.8 time = 310
* CHECK dout1_38 vdout1_38ck30 = 0 time = 310
* CHECK dout1_39 vdout1_39ck30 = 0 time = 310
* CHECK dout1_40 vdout1_40ck30 = 0 time = 310
* CHECK dout1_41 vdout1_41ck30 = 0 time = 310
* CHECK dout1_42 vdout1_42ck30 = 0 time = 310
* CHECK dout1_43 vdout1_43ck30 = 1.8 time = 310
* CHECK dout1_44 vdout1_44ck30 = 1.8 time = 310
* CHECK dout1_45 vdout1_45ck30 = 1.8 time = 310
* CHECK dout1_46 vdout1_46ck30 = 1.8 time = 310
* CHECK dout1_47 vdout1_47ck30 = 0 time = 310
* CHECK dout1_48 vdout1_48ck30 = 1.8 time = 310
* CHECK dout1_49 vdout1_49ck30 = 1.8 time = 310
* CHECK dout1_50 vdout1_50ck30 = 0 time = 310
* CHECK dout1_51 vdout1_51ck30 = 0 time = 310
* CHECK dout1_52 vdout1_52ck30 = 0 time = 310
* CHECK dout1_53 vdout1_53ck30 = 0 time = 310
* CHECK dout1_54 vdout1_54ck30 = 1.8 time = 310
* CHECK dout1_55 vdout1_55ck30 = 1.8 time = 310
* CHECK dout1_56 vdout1_56ck30 = 0 time = 310
* CHECK dout1_57 vdout1_57ck30 = 0 time = 310
* CHECK dout1_58 vdout1_58ck30 = 1.8 time = 310
* CHECK dout1_59 vdout1_59ck30 = 0 time = 310
* CHECK dout1_60 vdout1_60ck30 = 0 time = 310
* CHECK dout1_61 vdout1_61ck30 = 0 time = 310
* CHECK dout1_62 vdout1_62ck30 = 1.8 time = 310
* CHECK dout1_63 vdout1_63ck30 = 1.8 time = 310
* CHECK dout1_0 vdout1_0ck31 = 0 time = 320
* CHECK dout1_1 vdout1_1ck31 = 1.8 time = 320
* CHECK dout1_2 vdout1_2ck31 = 0 time = 320
* CHECK dout1_3 vdout1_3ck31 = 0 time = 320
* CHECK dout1_4 vdout1_4ck31 = 0 time = 320
* CHECK dout1_5 vdout1_5ck31 = 1.8 time = 320
* CHECK dout1_6 vdout1_6ck31 = 1.8 time = 320
* CHECK dout1_7 vdout1_7ck31 = 0 time = 320
* CHECK dout1_8 vdout1_8ck31 = 1.8 time = 320
* CHECK dout1_9 vdout1_9ck31 = 1.8 time = 320
* CHECK dout1_10 vdout1_10ck31 = 0 time = 320
* CHECK dout1_11 vdout1_11ck31 = 0 time = 320
* CHECK dout1_12 vdout1_12ck31 = 0 time = 320
* CHECK dout1_13 vdout1_13ck31 = 1.8 time = 320
* CHECK dout1_14 vdout1_14ck31 = 1.8 time = 320
* CHECK dout1_15 vdout1_15ck31 = 0 time = 320
* CHECK dout1_16 vdout1_16ck31 = 0 time = 320
* CHECK dout1_17 vdout1_17ck31 = 1.8 time = 320
* CHECK dout1_18 vdout1_18ck31 = 0 time = 320
* CHECK dout1_19 vdout1_19ck31 = 0 time = 320
* CHECK dout1_20 vdout1_20ck31 = 0 time = 320
* CHECK dout1_21 vdout1_21ck31 = 1.8 time = 320
* CHECK dout1_22 vdout1_22ck31 = 0 time = 320
* CHECK dout1_23 vdout1_23ck31 = 0 time = 320
* CHECK dout1_24 vdout1_24ck31 = 1.8 time = 320
* CHECK dout1_25 vdout1_25ck31 = 1.8 time = 320
* CHECK dout1_26 vdout1_26ck31 = 0 time = 320
* CHECK dout1_27 vdout1_27ck31 = 1.8 time = 320
* CHECK dout1_28 vdout1_28ck31 = 1.8 time = 320
* CHECK dout1_29 vdout1_29ck31 = 1.8 time = 320
* CHECK dout1_30 vdout1_30ck31 = 0 time = 320
* CHECK dout1_31 vdout1_31ck31 = 1.8 time = 320
* CHECK dout1_32 vdout1_32ck31 = 1.8 time = 320
* CHECK dout1_33 vdout1_33ck31 = 0 time = 320
* CHECK dout1_34 vdout1_34ck31 = 0 time = 320
* CHECK dout1_35 vdout1_35ck31 = 0 time = 320
* CHECK dout1_36 vdout1_36ck31 = 1.8 time = 320
* CHECK dout1_37 vdout1_37ck31 = 1.8 time = 320
* CHECK dout1_38 vdout1_38ck31 = 0 time = 320
* CHECK dout1_39 vdout1_39ck31 = 0 time = 320
* CHECK dout1_40 vdout1_40ck31 = 0 time = 320
* CHECK dout1_41 vdout1_41ck31 = 0 time = 320
* CHECK dout1_42 vdout1_42ck31 = 1.8 time = 320
* CHECK dout1_43 vdout1_43ck31 = 0 time = 320
* CHECK dout1_44 vdout1_44ck31 = 1.8 time = 320
* CHECK dout1_45 vdout1_45ck31 = 1.8 time = 320
* CHECK dout1_46 vdout1_46ck31 = 1.8 time = 320
* CHECK dout1_47 vdout1_47ck31 = 0 time = 320
* CHECK dout1_48 vdout1_48ck31 = 0 time = 320
* CHECK dout1_49 vdout1_49ck31 = 0 time = 320
* CHECK dout1_50 vdout1_50ck31 = 0 time = 320
* CHECK dout1_51 vdout1_51ck31 = 0 time = 320
* CHECK dout1_52 vdout1_52ck31 = 1.8 time = 320
* CHECK dout1_53 vdout1_53ck31 = 0 time = 320
* CHECK dout1_54 vdout1_54ck31 = 0 time = 320
* CHECK dout1_55 vdout1_55ck31 = 0 time = 320
* CHECK dout1_56 vdout1_56ck31 = 1.8 time = 320
* CHECK dout1_57 vdout1_57ck31 = 0 time = 320
* CHECK dout1_58 vdout1_58ck31 = 0 time = 320
* CHECK dout1_59 vdout1_59ck31 = 1.8 time = 320
* CHECK dout1_60 vdout1_60ck31 = 0 time = 320
* CHECK dout1_61 vdout1_61ck31 = 0 time = 320
* CHECK dout1_62 vdout1_62ck31 = 0 time = 320
* CHECK dout1_63 vdout1_63ck31 = 1.8 time = 320
* CHECK dout0_0 vdout0_0ck32 = 1.8 time = 330
* CHECK dout0_1 vdout0_1ck32 = 1.8 time = 330
* CHECK dout0_2 vdout0_2ck32 = 0 time = 330
* CHECK dout0_3 vdout0_3ck32 = 0 time = 330
* CHECK dout0_4 vdout0_4ck32 = 1.8 time = 330
* CHECK dout0_5 vdout0_5ck32 = 0 time = 330
* CHECK dout0_6 vdout0_6ck32 = 0 time = 330
* CHECK dout0_7 vdout0_7ck32 = 1.8 time = 330
* CHECK dout0_8 vdout0_8ck32 = 0 time = 330
* CHECK dout0_9 vdout0_9ck32 = 1.8 time = 330
* CHECK dout0_10 vdout0_10ck32 = 1.8 time = 330
* CHECK dout0_11 vdout0_11ck32 = 0 time = 330
* CHECK dout0_12 vdout0_12ck32 = 1.8 time = 330
* CHECK dout0_13 vdout0_13ck32 = 1.8 time = 330
* CHECK dout0_14 vdout0_14ck32 = 0 time = 330
* CHECK dout0_15 vdout0_15ck32 = 1.8 time = 330
* CHECK dout0_16 vdout0_16ck32 = 0 time = 330
* CHECK dout0_17 vdout0_17ck32 = 0 time = 330
* CHECK dout0_18 vdout0_18ck32 = 1.8 time = 330
* CHECK dout0_19 vdout0_19ck32 = 1.8 time = 330
* CHECK dout0_20 vdout0_20ck32 = 1.8 time = 330
* CHECK dout0_21 vdout0_21ck32 = 0 time = 330
* CHECK dout0_22 vdout0_22ck32 = 0 time = 330
* CHECK dout0_23 vdout0_23ck32 = 0 time = 330
* CHECK dout0_24 vdout0_24ck32 = 1.8 time = 330
* CHECK dout0_25 vdout0_25ck32 = 0 time = 330
* CHECK dout0_26 vdout0_26ck32 = 1.8 time = 330
* CHECK dout0_27 vdout0_27ck32 = 0 time = 330
* CHECK dout0_28 vdout0_28ck32 = 0 time = 330
* CHECK dout0_29 vdout0_29ck32 = 0 time = 330
* CHECK dout0_30 vdout0_30ck32 = 1.8 time = 330
* CHECK dout0_31 vdout0_31ck32 = 0 time = 330
* CHECK dout0_32 vdout0_32ck32 = 0 time = 330
* CHECK dout0_33 vdout0_33ck32 = 0 time = 330
* CHECK dout0_34 vdout0_34ck32 = 1.8 time = 330
* CHECK dout0_35 vdout0_35ck32 = 1.8 time = 330
* CHECK dout0_36 vdout0_36ck32 = 0 time = 330
* CHECK dout0_37 vdout0_37ck32 = 1.8 time = 330
* CHECK dout0_38 vdout0_38ck32 = 0 time = 330
* CHECK dout0_39 vdout0_39ck32 = 0 time = 330
* CHECK dout0_40 vdout0_40ck32 = 0 time = 330
* CHECK dout0_41 vdout0_41ck32 = 0 time = 330
* CHECK dout0_42 vdout0_42ck32 = 0 time = 330
* CHECK dout0_43 vdout0_43ck32 = 0 time = 330
* CHECK dout0_44 vdout0_44ck32 = 0 time = 330
* CHECK dout0_45 vdout0_45ck32 = 0 time = 330
* CHECK dout0_46 vdout0_46ck32 = 1.8 time = 330
* CHECK dout0_47 vdout0_47ck32 = 0 time = 330
* CHECK dout0_48 vdout0_48ck32 = 0 time = 330
* CHECK dout0_49 vdout0_49ck32 = 0 time = 330
* CHECK dout0_50 vdout0_50ck32 = 1.8 time = 330
* CHECK dout0_51 vdout0_51ck32 = 1.8 time = 330
* CHECK dout0_52 vdout0_52ck32 = 1.8 time = 330
* CHECK dout0_53 vdout0_53ck32 = 0 time = 330
* CHECK dout0_54 vdout0_54ck32 = 1.8 time = 330
* CHECK dout0_55 vdout0_55ck32 = 1.8 time = 330
* CHECK dout0_56 vdout0_56ck32 = 1.8 time = 330
* CHECK dout0_57 vdout0_57ck32 = 1.8 time = 330
* CHECK dout0_58 vdout0_58ck32 = 0 time = 330
* CHECK dout0_59 vdout0_59ck32 = 0 time = 330
* CHECK dout0_60 vdout0_60ck32 = 1.8 time = 330
* CHECK dout0_61 vdout0_61ck32 = 0 time = 330
* CHECK dout0_62 vdout0_62ck32 = 1.8 time = 330
* CHECK dout0_63 vdout0_63ck32 = 1.8 time = 330
* CHECK dout0_0 vdout0_0ck34 = 0 time = 350
* CHECK dout0_1 vdout0_1ck34 = 1.8 time = 350
* CHECK dout0_2 vdout0_2ck34 = 1.8 time = 350
* CHECK dout0_3 vdout0_3ck34 = 0 time = 350
* CHECK dout0_4 vdout0_4ck34 = 1.8 time = 350
* CHECK dout0_5 vdout0_5ck34 = 0 time = 350
* CHECK dout0_6 vdout0_6ck34 = 1.8 time = 350
* CHECK dout0_7 vdout0_7ck34 = 1.8 time = 350
* CHECK dout0_8 vdout0_8ck34 = 1.8 time = 350
* CHECK dout0_9 vdout0_9ck34 = 0 time = 350
* CHECK dout0_10 vdout0_10ck34 = 1.8 time = 350
* CHECK dout0_11 vdout0_11ck34 = 0 time = 350
* CHECK dout0_12 vdout0_12ck34 = 1.8 time = 350
* CHECK dout0_13 vdout0_13ck34 = 1.8 time = 350
* CHECK dout0_14 vdout0_14ck34 = 0 time = 350
* CHECK dout0_15 vdout0_15ck34 = 1.8 time = 350
* CHECK dout0_16 vdout0_16ck34 = 1.8 time = 350
* CHECK dout0_17 vdout0_17ck34 = 1.8 time = 350
* CHECK dout0_18 vdout0_18ck34 = 0 time = 350
* CHECK dout0_19 vdout0_19ck34 = 0 time = 350
* CHECK dout0_20 vdout0_20ck34 = 0 time = 350
* CHECK dout0_21 vdout0_21ck34 = 0 time = 350
* CHECK dout0_22 vdout0_22ck34 = 1.8 time = 350
* CHECK dout0_23 vdout0_23ck34 = 1.8 time = 350
* CHECK dout0_24 vdout0_24ck34 = 0 time = 350
* CHECK dout0_25 vdout0_25ck34 = 0 time = 350
* CHECK dout0_26 vdout0_26ck34 = 0 time = 350
* CHECK dout0_27 vdout0_27ck34 = 0 time = 350
* CHECK dout0_28 vdout0_28ck34 = 1.8 time = 350
* CHECK dout0_29 vdout0_29ck34 = 1.8 time = 350
* CHECK dout0_30 vdout0_30ck34 = 0 time = 350
* CHECK dout0_31 vdout0_31ck34 = 0 time = 350
* CHECK dout0_32 vdout0_32ck34 = 0 time = 350
* CHECK dout0_33 vdout0_33ck34 = 1.8 time = 350
* CHECK dout0_34 vdout0_34ck34 = 1.8 time = 350
* CHECK dout0_35 vdout0_35ck34 = 1.8 time = 350
* CHECK dout0_36 vdout0_36ck34 = 0 time = 350
* CHECK dout0_37 vdout0_37ck34 = 1.8 time = 350
* CHECK dout0_38 vdout0_38ck34 = 0 time = 350
* CHECK dout0_39 vdout0_39ck34 = 0 time = 350
* CHECK dout0_40 vdout0_40ck34 = 0 time = 350
* CHECK dout0_41 vdout0_41ck34 = 0 time = 350
* CHECK dout0_42 vdout0_42ck34 = 0 time = 350
* CHECK dout0_43 vdout0_43ck34 = 0 time = 350
* CHECK dout0_44 vdout0_44ck34 = 0 time = 350
* CHECK dout0_45 vdout0_45ck34 = 1.8 time = 350
* CHECK dout0_46 vdout0_46ck34 = 0 time = 350
* CHECK dout0_47 vdout0_47ck34 = 1.8 time = 350
* CHECK dout0_48 vdout0_48ck34 = 1.8 time = 350
* CHECK dout0_49 vdout0_49ck34 = 1.8 time = 350
* CHECK dout0_50 vdout0_50ck34 = 1.8 time = 350
* CHECK dout0_51 vdout0_51ck34 = 1.8 time = 350
* CHECK dout0_52 vdout0_52ck34 = 0 time = 350
* CHECK dout0_53 vdout0_53ck34 = 1.8 time = 350
* CHECK dout0_54 vdout0_54ck34 = 0 time = 350
* CHECK dout0_55 vdout0_55ck34 = 1.8 time = 350
* CHECK dout0_56 vdout0_56ck34 = 1.8 time = 350
* CHECK dout0_57 vdout0_57ck34 = 0 time = 350
* CHECK dout0_58 vdout0_58ck34 = 1.8 time = 350
* CHECK dout0_59 vdout0_59ck34 = 1.8 time = 350
* CHECK dout0_60 vdout0_60ck34 = 1.8 time = 350
* CHECK dout0_61 vdout0_61ck34 = 1.8 time = 350
* CHECK dout0_62 vdout0_62ck34 = 0 time = 350
* CHECK dout0_63 vdout0_63ck34 = 0 time = 350
* CHECK dout1_0 vdout1_0ck37 = 0 time = 380
* CHECK dout1_1 vdout1_1ck37 = 1.8 time = 380
* CHECK dout1_2 vdout1_2ck37 = 1.8 time = 380
* CHECK dout1_3 vdout1_3ck37 = 0 time = 380
* CHECK dout1_4 vdout1_4ck37 = 1.8 time = 380
* CHECK dout1_5 vdout1_5ck37 = 0 time = 380
* CHECK dout1_6 vdout1_6ck37 = 1.8 time = 380
* CHECK dout1_7 vdout1_7ck37 = 1.8 time = 380
* CHECK dout1_8 vdout1_8ck37 = 1.8 time = 380
* CHECK dout1_9 vdout1_9ck37 = 0 time = 380
* CHECK dout1_10 vdout1_10ck37 = 1.8 time = 380
* CHECK dout1_11 vdout1_11ck37 = 0 time = 380
* CHECK dout1_12 vdout1_12ck37 = 1.8 time = 380
* CHECK dout1_13 vdout1_13ck37 = 1.8 time = 380
* CHECK dout1_14 vdout1_14ck37 = 0 time = 380
* CHECK dout1_15 vdout1_15ck37 = 1.8 time = 380
* CHECK dout1_16 vdout1_16ck37 = 1.8 time = 380
* CHECK dout1_17 vdout1_17ck37 = 1.8 time = 380
* CHECK dout1_18 vdout1_18ck37 = 0 time = 380
* CHECK dout1_19 vdout1_19ck37 = 0 time = 380
* CHECK dout1_20 vdout1_20ck37 = 0 time = 380
* CHECK dout1_21 vdout1_21ck37 = 0 time = 380
* CHECK dout1_22 vdout1_22ck37 = 1.8 time = 380
* CHECK dout1_23 vdout1_23ck37 = 1.8 time = 380
* CHECK dout1_24 vdout1_24ck37 = 0 time = 380
* CHECK dout1_25 vdout1_25ck37 = 0 time = 380
* CHECK dout1_26 vdout1_26ck37 = 0 time = 380
* CHECK dout1_27 vdout1_27ck37 = 0 time = 380
* CHECK dout1_28 vdout1_28ck37 = 1.8 time = 380
* CHECK dout1_29 vdout1_29ck37 = 1.8 time = 380
* CHECK dout1_30 vdout1_30ck37 = 0 time = 380
* CHECK dout1_31 vdout1_31ck37 = 0 time = 380
* CHECK dout1_32 vdout1_32ck37 = 0 time = 380
* CHECK dout1_33 vdout1_33ck37 = 1.8 time = 380
* CHECK dout1_34 vdout1_34ck37 = 1.8 time = 380
* CHECK dout1_35 vdout1_35ck37 = 1.8 time = 380
* CHECK dout1_36 vdout1_36ck37 = 0 time = 380
* CHECK dout1_37 vdout1_37ck37 = 1.8 time = 380
* CHECK dout1_38 vdout1_38ck37 = 0 time = 380
* CHECK dout1_39 vdout1_39ck37 = 0 time = 380
* CHECK dout1_40 vdout1_40ck37 = 0 time = 380
* CHECK dout1_41 vdout1_41ck37 = 0 time = 380
* CHECK dout1_42 vdout1_42ck37 = 0 time = 380
* CHECK dout1_43 vdout1_43ck37 = 0 time = 380
* CHECK dout1_44 vdout1_44ck37 = 0 time = 380
* CHECK dout1_45 vdout1_45ck37 = 1.8 time = 380
* CHECK dout1_46 vdout1_46ck37 = 0 time = 380
* CHECK dout1_47 vdout1_47ck37 = 1.8 time = 380
* CHECK dout1_48 vdout1_48ck37 = 1.8 time = 380
* CHECK dout1_49 vdout1_49ck37 = 1.8 time = 380
* CHECK dout1_50 vdout1_50ck37 = 1.8 time = 380
* CHECK dout1_51 vdout1_51ck37 = 1.8 time = 380
* CHECK dout1_52 vdout1_52ck37 = 0 time = 380
* CHECK dout1_53 vdout1_53ck37 = 1.8 time = 380
* CHECK dout1_54 vdout1_54ck37 = 0 time = 380
* CHECK dout1_55 vdout1_55ck37 = 1.8 time = 380
* CHECK dout1_56 vdout1_56ck37 = 1.8 time = 380
* CHECK dout1_57 vdout1_57ck37 = 0 time = 380
* CHECK dout1_58 vdout1_58ck37 = 1.8 time = 380
* CHECK dout1_59 vdout1_59ck37 = 1.8 time = 380
* CHECK dout1_60 vdout1_60ck37 = 1.8 time = 380
* CHECK dout1_61 vdout1_61ck37 = 1.8 time = 380
* CHECK dout1_62 vdout1_62ck37 = 0 time = 380
* CHECK dout1_63 vdout1_63ck37 = 0 time = 380
* CHECK dout0_0 vdout0_0ck38 = 1.8 time = 390
* CHECK dout0_1 vdout0_1ck38 = 1.8 time = 390
* CHECK dout0_2 vdout0_2ck38 = 0 time = 390
* CHECK dout0_3 vdout0_3ck38 = 0 time = 390
* CHECK dout0_4 vdout0_4ck38 = 1.8 time = 390
* CHECK dout0_5 vdout0_5ck38 = 0 time = 390
* CHECK dout0_6 vdout0_6ck38 = 0 time = 390
* CHECK dout0_7 vdout0_7ck38 = 1.8 time = 390
* CHECK dout0_8 vdout0_8ck38 = 0 time = 390
* CHECK dout0_9 vdout0_9ck38 = 1.8 time = 390
* CHECK dout0_10 vdout0_10ck38 = 1.8 time = 390
* CHECK dout0_11 vdout0_11ck38 = 0 time = 390
* CHECK dout0_12 vdout0_12ck38 = 1.8 time = 390
* CHECK dout0_13 vdout0_13ck38 = 1.8 time = 390
* CHECK dout0_14 vdout0_14ck38 = 0 time = 390
* CHECK dout0_15 vdout0_15ck38 = 1.8 time = 390
* CHECK dout0_16 vdout0_16ck38 = 0 time = 390
* CHECK dout0_17 vdout0_17ck38 = 0 time = 390
* CHECK dout0_18 vdout0_18ck38 = 1.8 time = 390
* CHECK dout0_19 vdout0_19ck38 = 1.8 time = 390
* CHECK dout0_20 vdout0_20ck38 = 1.8 time = 390
* CHECK dout0_21 vdout0_21ck38 = 0 time = 390
* CHECK dout0_22 vdout0_22ck38 = 0 time = 390
* CHECK dout0_23 vdout0_23ck38 = 0 time = 390
* CHECK dout0_24 vdout0_24ck38 = 1.8 time = 390
* CHECK dout0_25 vdout0_25ck38 = 0 time = 390
* CHECK dout0_26 vdout0_26ck38 = 1.8 time = 390
* CHECK dout0_27 vdout0_27ck38 = 0 time = 390
* CHECK dout0_28 vdout0_28ck38 = 0 time = 390
* CHECK dout0_29 vdout0_29ck38 = 0 time = 390
* CHECK dout0_30 vdout0_30ck38 = 1.8 time = 390
* CHECK dout0_31 vdout0_31ck38 = 0 time = 390
* CHECK dout0_32 vdout0_32ck38 = 0 time = 390
* CHECK dout0_33 vdout0_33ck38 = 0 time = 390
* CHECK dout0_34 vdout0_34ck38 = 1.8 time = 390
* CHECK dout0_35 vdout0_35ck38 = 1.8 time = 390
* CHECK dout0_36 vdout0_36ck38 = 0 time = 390
* CHECK dout0_37 vdout0_37ck38 = 1.8 time = 390
* CHECK dout0_38 vdout0_38ck38 = 0 time = 390
* CHECK dout0_39 vdout0_39ck38 = 0 time = 390
* CHECK dout0_40 vdout0_40ck38 = 0 time = 390
* CHECK dout0_41 vdout0_41ck38 = 0 time = 390
* CHECK dout0_42 vdout0_42ck38 = 0 time = 390
* CHECK dout0_43 vdout0_43ck38 = 0 time = 390
* CHECK dout0_44 vdout0_44ck38 = 0 time = 390
* CHECK dout0_45 vdout0_45ck38 = 0 time = 390
* CHECK dout0_46 vdout0_46ck38 = 1.8 time = 390
* CHECK dout0_47 vdout0_47ck38 = 0 time = 390
* CHECK dout0_48 vdout0_48ck38 = 0 time = 390
* CHECK dout0_49 vdout0_49ck38 = 0 time = 390
* CHECK dout0_50 vdout0_50ck38 = 1.8 time = 390
* CHECK dout0_51 vdout0_51ck38 = 1.8 time = 390
* CHECK dout0_52 vdout0_52ck38 = 1.8 time = 390
* CHECK dout0_53 vdout0_53ck38 = 0 time = 390
* CHECK dout0_54 vdout0_54ck38 = 1.8 time = 390
* CHECK dout0_55 vdout0_55ck38 = 1.8 time = 390
* CHECK dout0_56 vdout0_56ck38 = 1.8 time = 390
* CHECK dout0_57 vdout0_57ck38 = 1.8 time = 390
* CHECK dout0_58 vdout0_58ck38 = 0 time = 390
* CHECK dout0_59 vdout0_59ck38 = 0 time = 390
* CHECK dout0_60 vdout0_60ck38 = 1.8 time = 390
* CHECK dout0_61 vdout0_61ck38 = 0 time = 390
* CHECK dout0_62 vdout0_62ck38 = 1.8 time = 390
* CHECK dout0_63 vdout0_63ck38 = 1.8 time = 390
* CHECK dout1_0 vdout1_0ck39 = 0 time = 400
* CHECK dout1_1 vdout1_1ck39 = 1.8 time = 400
* CHECK dout1_2 vdout1_2ck39 = 1.8 time = 400
* CHECK dout1_3 vdout1_3ck39 = 0 time = 400
* CHECK dout1_4 vdout1_4ck39 = 1.8 time = 400
* CHECK dout1_5 vdout1_5ck39 = 0 time = 400
* CHECK dout1_6 vdout1_6ck39 = 0 time = 400
* CHECK dout1_7 vdout1_7ck39 = 0 time = 400
* CHECK dout1_8 vdout1_8ck39 = 0 time = 400
* CHECK dout1_9 vdout1_9ck39 = 1.8 time = 400
* CHECK dout1_10 vdout1_10ck39 = 1.8 time = 400
* CHECK dout1_11 vdout1_11ck39 = 1.8 time = 400
* CHECK dout1_12 vdout1_12ck39 = 1.8 time = 400
* CHECK dout1_13 vdout1_13ck39 = 1.8 time = 400
* CHECK dout1_14 vdout1_14ck39 = 1.8 time = 400
* CHECK dout1_15 vdout1_15ck39 = 0 time = 400
* CHECK dout1_16 vdout1_16ck39 = 0 time = 400
* CHECK dout1_17 vdout1_17ck39 = 1.8 time = 400
* CHECK dout1_18 vdout1_18ck39 = 1.8 time = 400
* CHECK dout1_19 vdout1_19ck39 = 0 time = 400
* CHECK dout1_20 vdout1_20ck39 = 1.8 time = 400
* CHECK dout1_21 vdout1_21ck39 = 0 time = 400
* CHECK dout1_22 vdout1_22ck39 = 0 time = 400
* CHECK dout1_23 vdout1_23ck39 = 1.8 time = 400
* CHECK dout1_24 vdout1_24ck39 = 1.8 time = 400
* CHECK dout1_25 vdout1_25ck39 = 0 time = 400
* CHECK dout1_26 vdout1_26ck39 = 0 time = 400
* CHECK dout1_27 vdout1_27ck39 = 1.8 time = 400
* CHECK dout1_28 vdout1_28ck39 = 1.8 time = 400
* CHECK dout1_29 vdout1_29ck39 = 0 time = 400
* CHECK dout1_30 vdout1_30ck39 = 1.8 time = 400
* CHECK dout1_31 vdout1_31ck39 = 0 time = 400
* CHECK dout1_32 vdout1_32ck39 = 0 time = 400
* CHECK dout1_33 vdout1_33ck39 = 1.8 time = 400
* CHECK dout1_34 vdout1_34ck39 = 1.8 time = 400
* CHECK dout1_35 vdout1_35ck39 = 0 time = 400
* CHECK dout1_36 vdout1_36ck39 = 0 time = 400
* CHECK dout1_37 vdout1_37ck39 = 1.8 time = 400
* CHECK dout1_38 vdout1_38ck39 = 0 time = 400
* CHECK dout1_39 vdout1_39ck39 = 0 time = 400
* CHECK dout1_40 vdout1_40ck39 = 0 time = 400
* CHECK dout1_41 vdout1_41ck39 = 0 time = 400
* CHECK dout1_42 vdout1_42ck39 = 1.8 time = 400
* CHECK dout1_43 vdout1_43ck39 = 1.8 time = 400
* CHECK dout1_44 vdout1_44ck39 = 0 time = 400
* CHECK dout1_45 vdout1_45ck39 = 0 time = 400
* CHECK dout1_46 vdout1_46ck39 = 1.8 time = 400
* CHECK dout1_47 vdout1_47ck39 = 1.8 time = 400
* CHECK dout1_48 vdout1_48ck39 = 0 time = 400
* CHECK dout1_49 vdout1_49ck39 = 0 time = 400
* CHECK dout1_50 vdout1_50ck39 = 0 time = 400
* CHECK dout1_51 vdout1_51ck39 = 1.8 time = 400
* CHECK dout1_52 vdout1_52ck39 = 0 time = 400
* CHECK dout1_53 vdout1_53ck39 = 1.8 time = 400
* CHECK dout1_54 vdout1_54ck39 = 1.8 time = 400
* CHECK dout1_55 vdout1_55ck39 = 1.8 time = 400
* CHECK dout1_56 vdout1_56ck39 = 0 time = 400
* CHECK dout1_57 vdout1_57ck39 = 1.8 time = 400
* CHECK dout1_58 vdout1_58ck39 = 1.8 time = 400
* CHECK dout1_59 vdout1_59ck39 = 0 time = 400
* CHECK dout1_60 vdout1_60ck39 = 0 time = 400
* CHECK dout1_61 vdout1_61ck39 = 0 time = 400
* CHECK dout1_62 vdout1_62ck39 = 1.8 time = 400
* CHECK dout1_63 vdout1_63ck39 = 0 time = 400
* CHECK dout1_0 vdout1_0ck40 = 0 time = 410
* CHECK dout1_1 vdout1_1ck40 = 1.8 time = 410
* CHECK dout1_2 vdout1_2ck40 = 0 time = 410
* CHECK dout1_3 vdout1_3ck40 = 0 time = 410
* CHECK dout1_4 vdout1_4ck40 = 0 time = 410
* CHECK dout1_5 vdout1_5ck40 = 1.8 time = 410
* CHECK dout1_6 vdout1_6ck40 = 1.8 time = 410
* CHECK dout1_7 vdout1_7ck40 = 0 time = 410
* CHECK dout1_8 vdout1_8ck40 = 1.8 time = 410
* CHECK dout1_9 vdout1_9ck40 = 1.8 time = 410
* CHECK dout1_10 vdout1_10ck40 = 0 time = 410
* CHECK dout1_11 vdout1_11ck40 = 0 time = 410
* CHECK dout1_12 vdout1_12ck40 = 0 time = 410
* CHECK dout1_13 vdout1_13ck40 = 1.8 time = 410
* CHECK dout1_14 vdout1_14ck40 = 1.8 time = 410
* CHECK dout1_15 vdout1_15ck40 = 0 time = 410
* CHECK dout1_16 vdout1_16ck40 = 0 time = 410
* CHECK dout1_17 vdout1_17ck40 = 1.8 time = 410
* CHECK dout1_18 vdout1_18ck40 = 0 time = 410
* CHECK dout1_19 vdout1_19ck40 = 0 time = 410
* CHECK dout1_20 vdout1_20ck40 = 0 time = 410
* CHECK dout1_21 vdout1_21ck40 = 1.8 time = 410
* CHECK dout1_22 vdout1_22ck40 = 0 time = 410
* CHECK dout1_23 vdout1_23ck40 = 0 time = 410
* CHECK dout1_24 vdout1_24ck40 = 1.8 time = 410
* CHECK dout1_25 vdout1_25ck40 = 1.8 time = 410
* CHECK dout1_26 vdout1_26ck40 = 0 time = 410
* CHECK dout1_27 vdout1_27ck40 = 1.8 time = 410
* CHECK dout1_28 vdout1_28ck40 = 1.8 time = 410
* CHECK dout1_29 vdout1_29ck40 = 1.8 time = 410
* CHECK dout1_30 vdout1_30ck40 = 0 time = 410
* CHECK dout1_31 vdout1_31ck40 = 1.8 time = 410
* CHECK dout1_32 vdout1_32ck40 = 1.8 time = 410
* CHECK dout1_33 vdout1_33ck40 = 0 time = 410
* CHECK dout1_34 vdout1_34ck40 = 0 time = 410
* CHECK dout1_35 vdout1_35ck40 = 0 time = 410
* CHECK dout1_36 vdout1_36ck40 = 1.8 time = 410
* CHECK dout1_37 vdout1_37ck40 = 1.8 time = 410
* CHECK dout1_38 vdout1_38ck40 = 0 time = 410
* CHECK dout1_39 vdout1_39ck40 = 0 time = 410
* CHECK dout1_40 vdout1_40ck40 = 0 time = 410
* CHECK dout1_41 vdout1_41ck40 = 0 time = 410
* CHECK dout1_42 vdout1_42ck40 = 1.8 time = 410
* CHECK dout1_43 vdout1_43ck40 = 0 time = 410
* CHECK dout1_44 vdout1_44ck40 = 1.8 time = 410
* CHECK dout1_45 vdout1_45ck40 = 1.8 time = 410
* CHECK dout1_46 vdout1_46ck40 = 1.8 time = 410
* CHECK dout1_47 vdout1_47ck40 = 0 time = 410
* CHECK dout1_48 vdout1_48ck40 = 0 time = 410
* CHECK dout1_49 vdout1_49ck40 = 0 time = 410
* CHECK dout1_50 vdout1_50ck40 = 0 time = 410
* CHECK dout1_51 vdout1_51ck40 = 0 time = 410
* CHECK dout1_52 vdout1_52ck40 = 1.8 time = 410
* CHECK dout1_53 vdout1_53ck40 = 0 time = 410
* CHECK dout1_54 vdout1_54ck40 = 0 time = 410
* CHECK dout1_55 vdout1_55ck40 = 0 time = 410
* CHECK dout1_56 vdout1_56ck40 = 1.8 time = 410
* CHECK dout1_57 vdout1_57ck40 = 0 time = 410
* CHECK dout1_58 vdout1_58ck40 = 0 time = 410
* CHECK dout1_59 vdout1_59ck40 = 1.8 time = 410
* CHECK dout1_60 vdout1_60ck40 = 0 time = 410
* CHECK dout1_61 vdout1_61ck40 = 0 time = 410
* CHECK dout1_62 vdout1_62ck40 = 0 time = 410
* CHECK dout1_63 vdout1_63ck40 = 1.8 time = 410
* CHECK dout0_0 vdout0_0ck41 = 0 time = 420
* CHECK dout0_1 vdout0_1ck41 = 1.8 time = 420
* CHECK dout0_2 vdout0_2ck41 = 0 time = 420
* CHECK dout0_3 vdout0_3ck41 = 0 time = 420
* CHECK dout0_4 vdout0_4ck41 = 0 time = 420
* CHECK dout0_5 vdout0_5ck41 = 1.8 time = 420
* CHECK dout0_6 vdout0_6ck41 = 1.8 time = 420
* CHECK dout0_7 vdout0_7ck41 = 0 time = 420
* CHECK dout0_8 vdout0_8ck41 = 1.8 time = 420
* CHECK dout0_9 vdout0_9ck41 = 1.8 time = 420
* CHECK dout0_10 vdout0_10ck41 = 0 time = 420
* CHECK dout0_11 vdout0_11ck41 = 0 time = 420
* CHECK dout0_12 vdout0_12ck41 = 0 time = 420
* CHECK dout0_13 vdout0_13ck41 = 1.8 time = 420
* CHECK dout0_14 vdout0_14ck41 = 1.8 time = 420
* CHECK dout0_15 vdout0_15ck41 = 0 time = 420
* CHECK dout0_16 vdout0_16ck41 = 0 time = 420
* CHECK dout0_17 vdout0_17ck41 = 1.8 time = 420
* CHECK dout0_18 vdout0_18ck41 = 0 time = 420
* CHECK dout0_19 vdout0_19ck41 = 0 time = 420
* CHECK dout0_20 vdout0_20ck41 = 0 time = 420
* CHECK dout0_21 vdout0_21ck41 = 1.8 time = 420
* CHECK dout0_22 vdout0_22ck41 = 0 time = 420
* CHECK dout0_23 vdout0_23ck41 = 0 time = 420
* CHECK dout0_24 vdout0_24ck41 = 1.8 time = 420
* CHECK dout0_25 vdout0_25ck41 = 1.8 time = 420
* CHECK dout0_26 vdout0_26ck41 = 0 time = 420
* CHECK dout0_27 vdout0_27ck41 = 1.8 time = 420
* CHECK dout0_28 vdout0_28ck41 = 1.8 time = 420
* CHECK dout0_29 vdout0_29ck41 = 1.8 time = 420
* CHECK dout0_30 vdout0_30ck41 = 0 time = 420
* CHECK dout0_31 vdout0_31ck41 = 1.8 time = 420
* CHECK dout0_32 vdout0_32ck41 = 1.8 time = 420
* CHECK dout0_33 vdout0_33ck41 = 0 time = 420
* CHECK dout0_34 vdout0_34ck41 = 0 time = 420
* CHECK dout0_35 vdout0_35ck41 = 0 time = 420
* CHECK dout0_36 vdout0_36ck41 = 1.8 time = 420
* CHECK dout0_37 vdout0_37ck41 = 1.8 time = 420
* CHECK dout0_38 vdout0_38ck41 = 0 time = 420
* CHECK dout0_39 vdout0_39ck41 = 0 time = 420
* CHECK dout0_40 vdout0_40ck41 = 0 time = 420
* CHECK dout0_41 vdout0_41ck41 = 0 time = 420
* CHECK dout0_42 vdout0_42ck41 = 1.8 time = 420
* CHECK dout0_43 vdout0_43ck41 = 0 time = 420
* CHECK dout0_44 vdout0_44ck41 = 1.8 time = 420
* CHECK dout0_45 vdout0_45ck41 = 1.8 time = 420
* CHECK dout0_46 vdout0_46ck41 = 1.8 time = 420
* CHECK dout0_47 vdout0_47ck41 = 0 time = 420
* CHECK dout0_48 vdout0_48ck41 = 0 time = 420
* CHECK dout0_49 vdout0_49ck41 = 0 time = 420
* CHECK dout0_50 vdout0_50ck41 = 0 time = 420
* CHECK dout0_51 vdout0_51ck41 = 0 time = 420
* CHECK dout0_52 vdout0_52ck41 = 1.8 time = 420
* CHECK dout0_53 vdout0_53ck41 = 0 time = 420
* CHECK dout0_54 vdout0_54ck41 = 0 time = 420
* CHECK dout0_55 vdout0_55ck41 = 0 time = 420
* CHECK dout0_56 vdout0_56ck41 = 1.8 time = 420
* CHECK dout0_57 vdout0_57ck41 = 0 time = 420
* CHECK dout0_58 vdout0_58ck41 = 0 time = 420
* CHECK dout0_59 vdout0_59ck41 = 1.8 time = 420
* CHECK dout0_60 vdout0_60ck41 = 0 time = 420
* CHECK dout0_61 vdout0_61ck41 = 0 time = 420
* CHECK dout0_62 vdout0_62ck41 = 0 time = 420
* CHECK dout0_63 vdout0_63ck41 = 1.8 time = 420
* CHECK dout0_0 vdout0_0ck43 = 1.8 time = 440
* CHECK dout0_1 vdout0_1ck43 = 0 time = 440
* CHECK dout0_2 vdout0_2ck43 = 0 time = 440
* CHECK dout0_3 vdout0_3ck43 = 1.8 time = 440
* CHECK dout0_4 vdout0_4ck43 = 0 time = 440
* CHECK dout0_5 vdout0_5ck43 = 1.8 time = 440
* CHECK dout0_6 vdout0_6ck43 = 0 time = 440
* CHECK dout0_7 vdout0_7ck43 = 0 time = 440
* CHECK dout0_8 vdout0_8ck43 = 0 time = 440
* CHECK dout0_9 vdout0_9ck43 = 1.8 time = 440
* CHECK dout0_10 vdout0_10ck43 = 0 time = 440
* CHECK dout0_11 vdout0_11ck43 = 0 time = 440
* CHECK dout0_12 vdout0_12ck43 = 1.8 time = 440
* CHECK dout0_13 vdout0_13ck43 = 1.8 time = 440
* CHECK dout0_14 vdout0_14ck43 = 1.8 time = 440
* CHECK dout0_15 vdout0_15ck43 = 1.8 time = 440
* CHECK dout0_16 vdout0_16ck43 = 1.8 time = 440
* CHECK dout0_17 vdout0_17ck43 = 1.8 time = 440
* CHECK dout0_18 vdout0_18ck43 = 0 time = 440
* CHECK dout0_19 vdout0_19ck43 = 0 time = 440
* CHECK dout0_20 vdout0_20ck43 = 0 time = 440
* CHECK dout0_21 vdout0_21ck43 = 0 time = 440
* CHECK dout0_22 vdout0_22ck43 = 1.8 time = 440
* CHECK dout0_23 vdout0_23ck43 = 1.8 time = 440
* CHECK dout0_24 vdout0_24ck43 = 1.8 time = 440
* CHECK dout0_25 vdout0_25ck43 = 0 time = 440
* CHECK dout0_26 vdout0_26ck43 = 1.8 time = 440
* CHECK dout0_27 vdout0_27ck43 = 1.8 time = 440
* CHECK dout0_28 vdout0_28ck43 = 1.8 time = 440
* CHECK dout0_29 vdout0_29ck43 = 0 time = 440
* CHECK dout0_30 vdout0_30ck43 = 1.8 time = 440
* CHECK dout0_31 vdout0_31ck43 = 1.8 time = 440
* CHECK dout0_32 vdout0_32ck43 = 1.8 time = 440
* CHECK dout0_33 vdout0_33ck43 = 1.8 time = 440
* CHECK dout0_34 vdout0_34ck43 = 1.8 time = 440
* CHECK dout0_35 vdout0_35ck43 = 0 time = 440
* CHECK dout0_36 vdout0_36ck43 = 1.8 time = 440
* CHECK dout0_37 vdout0_37ck43 = 1.8 time = 440
* CHECK dout0_38 vdout0_38ck43 = 0 time = 440
* CHECK dout0_39 vdout0_39ck43 = 1.8 time = 440
* CHECK dout0_40 vdout0_40ck43 = 0 time = 440
* CHECK dout0_41 vdout0_41ck43 = 0 time = 440
* CHECK dout0_42 vdout0_42ck43 = 1.8 time = 440
* CHECK dout0_43 vdout0_43ck43 = 1.8 time = 440
* CHECK dout0_44 vdout0_44ck43 = 1.8 time = 440
* CHECK dout0_45 vdout0_45ck43 = 1.8 time = 440
* CHECK dout0_46 vdout0_46ck43 = 0 time = 440
* CHECK dout0_47 vdout0_47ck43 = 0 time = 440
* CHECK dout0_48 vdout0_48ck43 = 1.8 time = 440
* CHECK dout0_49 vdout0_49ck43 = 0 time = 440
* CHECK dout0_50 vdout0_50ck43 = 1.8 time = 440
* CHECK dout0_51 vdout0_51ck43 = 0 time = 440
* CHECK dout0_52 vdout0_52ck43 = 0 time = 440
* CHECK dout0_53 vdout0_53ck43 = 1.8 time = 440
* CHECK dout0_54 vdout0_54ck43 = 0 time = 440
* CHECK dout0_55 vdout0_55ck43 = 0 time = 440
* CHECK dout0_56 vdout0_56ck43 = 0 time = 440
* CHECK dout0_57 vdout0_57ck43 = 0 time = 440
* CHECK dout0_58 vdout0_58ck43 = 1.8 time = 440
* CHECK dout0_59 vdout0_59ck43 = 1.8 time = 440
* CHECK dout0_60 vdout0_60ck43 = 0 time = 440
* CHECK dout0_61 vdout0_61ck43 = 0 time = 440
* CHECK dout0_62 vdout0_62ck43 = 0 time = 440
* CHECK dout0_63 vdout0_63ck43 = 1.8 time = 440
* CHECK dout1_0 vdout1_0ck43 = 1.8 time = 440
* CHECK dout1_1 vdout1_1ck43 = 0 time = 440
* CHECK dout1_2 vdout1_2ck43 = 0 time = 440
* CHECK dout1_3 vdout1_3ck43 = 1.8 time = 440
* CHECK dout1_4 vdout1_4ck43 = 0 time = 440
* CHECK dout1_5 vdout1_5ck43 = 1.8 time = 440
* CHECK dout1_6 vdout1_6ck43 = 0 time = 440
* CHECK dout1_7 vdout1_7ck43 = 0 time = 440
* CHECK dout1_8 vdout1_8ck43 = 0 time = 440
* CHECK dout1_9 vdout1_9ck43 = 1.8 time = 440
* CHECK dout1_10 vdout1_10ck43 = 0 time = 440
* CHECK dout1_11 vdout1_11ck43 = 0 time = 440
* CHECK dout1_12 vdout1_12ck43 = 1.8 time = 440
* CHECK dout1_13 vdout1_13ck43 = 1.8 time = 440
* CHECK dout1_14 vdout1_14ck43 = 1.8 time = 440
* CHECK dout1_15 vdout1_15ck43 = 1.8 time = 440
* CHECK dout1_16 vdout1_16ck43 = 1.8 time = 440
* CHECK dout1_17 vdout1_17ck43 = 1.8 time = 440
* CHECK dout1_18 vdout1_18ck43 = 0 time = 440
* CHECK dout1_19 vdout1_19ck43 = 0 time = 440
* CHECK dout1_20 vdout1_20ck43 = 0 time = 440
* CHECK dout1_21 vdout1_21ck43 = 0 time = 440
* CHECK dout1_22 vdout1_22ck43 = 1.8 time = 440
* CHECK dout1_23 vdout1_23ck43 = 1.8 time = 440
* CHECK dout1_24 vdout1_24ck43 = 1.8 time = 440
* CHECK dout1_25 vdout1_25ck43 = 0 time = 440
* CHECK dout1_26 vdout1_26ck43 = 1.8 time = 440
* CHECK dout1_27 vdout1_27ck43 = 1.8 time = 440
* CHECK dout1_28 vdout1_28ck43 = 1.8 time = 440
* CHECK dout1_29 vdout1_29ck43 = 0 time = 440
* CHECK dout1_30 vdout1_30ck43 = 1.8 time = 440
* CHECK dout1_31 vdout1_31ck43 = 1.8 time = 440
* CHECK dout1_32 vdout1_32ck43 = 1.8 time = 440
* CHECK dout1_33 vdout1_33ck43 = 1.8 time = 440
* CHECK dout1_34 vdout1_34ck43 = 1.8 time = 440
* CHECK dout1_35 vdout1_35ck43 = 0 time = 440
* CHECK dout1_36 vdout1_36ck43 = 1.8 time = 440
* CHECK dout1_37 vdout1_37ck43 = 1.8 time = 440
* CHECK dout1_38 vdout1_38ck43 = 0 time = 440
* CHECK dout1_39 vdout1_39ck43 = 1.8 time = 440
* CHECK dout1_40 vdout1_40ck43 = 0 time = 440
* CHECK dout1_41 vdout1_41ck43 = 0 time = 440
* CHECK dout1_42 vdout1_42ck43 = 1.8 time = 440
* CHECK dout1_43 vdout1_43ck43 = 1.8 time = 440
* CHECK dout1_44 vdout1_44ck43 = 1.8 time = 440
* CHECK dout1_45 vdout1_45ck43 = 1.8 time = 440
* CHECK dout1_46 vdout1_46ck43 = 0 time = 440
* CHECK dout1_47 vdout1_47ck43 = 0 time = 440
* CHECK dout1_48 vdout1_48ck43 = 1.8 time = 440
* CHECK dout1_49 vdout1_49ck43 = 0 time = 440
* CHECK dout1_50 vdout1_50ck43 = 1.8 time = 440
* CHECK dout1_51 vdout1_51ck43 = 0 time = 440
* CHECK dout1_52 vdout1_52ck43 = 0 time = 440
* CHECK dout1_53 vdout1_53ck43 = 1.8 time = 440
* CHECK dout1_54 vdout1_54ck43 = 0 time = 440
* CHECK dout1_55 vdout1_55ck43 = 0 time = 440
* CHECK dout1_56 vdout1_56ck43 = 0 time = 440
* CHECK dout1_57 vdout1_57ck43 = 0 time = 440
* CHECK dout1_58 vdout1_58ck43 = 1.8 time = 440
* CHECK dout1_59 vdout1_59ck43 = 1.8 time = 440
* CHECK dout1_60 vdout1_60ck43 = 0 time = 440
* CHECK dout1_61 vdout1_61ck43 = 0 time = 440
* CHECK dout1_62 vdout1_62ck43 = 0 time = 440
* CHECK dout1_63 vdout1_63ck43 = 1.8 time = 440
* CHECK dout1_0 vdout1_0ck44 = 1.8 time = 450
* CHECK dout1_1 vdout1_1ck44 = 1.8 time = 450
* CHECK dout1_2 vdout1_2ck44 = 1.8 time = 450
* CHECK dout1_3 vdout1_3ck44 = 1.8 time = 450
* CHECK dout1_4 vdout1_4ck44 = 0 time = 450
* CHECK dout1_5 vdout1_5ck44 = 0 time = 450
* CHECK dout1_6 vdout1_6ck44 = 1.8 time = 450
* CHECK dout1_7 vdout1_7ck44 = 0 time = 450
* CHECK dout1_8 vdout1_8ck44 = 0 time = 450
* CHECK dout1_9 vdout1_9ck44 = 0 time = 450
* CHECK dout1_10 vdout1_10ck44 = 0 time = 450
* CHECK dout1_11 vdout1_11ck44 = 1.8 time = 450
* CHECK dout1_12 vdout1_12ck44 = 0 time = 450
* CHECK dout1_13 vdout1_13ck44 = 1.8 time = 450
* CHECK dout1_14 vdout1_14ck44 = 1.8 time = 450
* CHECK dout1_15 vdout1_15ck44 = 1.8 time = 450
* CHECK dout1_16 vdout1_16ck44 = 0 time = 450
* CHECK dout1_17 vdout1_17ck44 = 0 time = 450
* CHECK dout1_18 vdout1_18ck44 = 1.8 time = 450
* CHECK dout1_19 vdout1_19ck44 = 0 time = 450
* CHECK dout1_20 vdout1_20ck44 = 1.8 time = 450
* CHECK dout1_21 vdout1_21ck44 = 1.8 time = 450
* CHECK dout1_22 vdout1_22ck44 = 1.8 time = 450
* CHECK dout1_23 vdout1_23ck44 = 1.8 time = 450
* CHECK dout1_24 vdout1_24ck44 = 0 time = 450
* CHECK dout1_25 vdout1_25ck44 = 1.8 time = 450
* CHECK dout1_26 vdout1_26ck44 = 1.8 time = 450
* CHECK dout1_27 vdout1_27ck44 = 1.8 time = 450
* CHECK dout1_28 vdout1_28ck44 = 1.8 time = 450
* CHECK dout1_29 vdout1_29ck44 = 0 time = 450
* CHECK dout1_30 vdout1_30ck44 = 1.8 time = 450
* CHECK dout1_31 vdout1_31ck44 = 0 time = 450
* CHECK dout1_32 vdout1_32ck44 = 0 time = 450
* CHECK dout1_33 vdout1_33ck44 = 0 time = 450
* CHECK dout1_34 vdout1_34ck44 = 1.8 time = 450
* CHECK dout1_35 vdout1_35ck44 = 1.8 time = 450
* CHECK dout1_36 vdout1_36ck44 = 0 time = 450
* CHECK dout1_37 vdout1_37ck44 = 0 time = 450
* CHECK dout1_38 vdout1_38ck44 = 0 time = 450
* CHECK dout1_39 vdout1_39ck44 = 0 time = 450
* CHECK dout1_40 vdout1_40ck44 = 0 time = 450
* CHECK dout1_41 vdout1_41ck44 = 1.8 time = 450
* CHECK dout1_42 vdout1_42ck44 = 1.8 time = 450
* CHECK dout1_43 vdout1_43ck44 = 1.8 time = 450
* CHECK dout1_44 vdout1_44ck44 = 0 time = 450
* CHECK dout1_45 vdout1_45ck44 = 0 time = 450
* CHECK dout1_46 vdout1_46ck44 = 0 time = 450
* CHECK dout1_47 vdout1_47ck44 = 1.8 time = 450
* CHECK dout1_48 vdout1_48ck44 = 0 time = 450
* CHECK dout1_49 vdout1_49ck44 = 0 time = 450
* CHECK dout1_50 vdout1_50ck44 = 1.8 time = 450
* CHECK dout1_51 vdout1_51ck44 = 0 time = 450
* CHECK dout1_52 vdout1_52ck44 = 0 time = 450
* CHECK dout1_53 vdout1_53ck44 = 1.8 time = 450
* CHECK dout1_54 vdout1_54ck44 = 1.8 time = 450
* CHECK dout1_55 vdout1_55ck44 = 1.8 time = 450
* CHECK dout1_56 vdout1_56ck44 = 1.8 time = 450
* CHECK dout1_57 vdout1_57ck44 = 1.8 time = 450
* CHECK dout1_58 vdout1_58ck44 = 0 time = 450
* CHECK dout1_59 vdout1_59ck44 = 1.8 time = 450
* CHECK dout1_60 vdout1_60ck44 = 0 time = 450
* CHECK dout1_61 vdout1_61ck44 = 0 time = 450
* CHECK dout1_62 vdout1_62ck44 = 0 time = 450
* CHECK dout1_63 vdout1_63ck44 = 0 time = 450
* CHECK dout0_0 vdout0_0ck46 = 1.8 time = 470
* CHECK dout0_1 vdout0_1ck46 = 1.8 time = 470
* CHECK dout0_2 vdout0_2ck46 = 1.8 time = 470
* CHECK dout0_3 vdout0_3ck46 = 1.8 time = 470
* CHECK dout0_4 vdout0_4ck46 = 0 time = 470
* CHECK dout0_5 vdout0_5ck46 = 0 time = 470
* CHECK dout0_6 vdout0_6ck46 = 1.8 time = 470
* CHECK dout0_7 vdout0_7ck46 = 0 time = 470
* CHECK dout0_8 vdout0_8ck46 = 0 time = 470
* CHECK dout0_9 vdout0_9ck46 = 0 time = 470
* CHECK dout0_10 vdout0_10ck46 = 0 time = 470
* CHECK dout0_11 vdout0_11ck46 = 1.8 time = 470
* CHECK dout0_12 vdout0_12ck46 = 0 time = 470
* CHECK dout0_13 vdout0_13ck46 = 1.8 time = 470
* CHECK dout0_14 vdout0_14ck46 = 1.8 time = 470
* CHECK dout0_15 vdout0_15ck46 = 1.8 time = 470
* CHECK dout0_16 vdout0_16ck46 = 0 time = 470
* CHECK dout0_17 vdout0_17ck46 = 0 time = 470
* CHECK dout0_18 vdout0_18ck46 = 1.8 time = 470
* CHECK dout0_19 vdout0_19ck46 = 0 time = 470
* CHECK dout0_20 vdout0_20ck46 = 1.8 time = 470
* CHECK dout0_21 vdout0_21ck46 = 1.8 time = 470
* CHECK dout0_22 vdout0_22ck46 = 1.8 time = 470
* CHECK dout0_23 vdout0_23ck46 = 1.8 time = 470
* CHECK dout0_24 vdout0_24ck46 = 0 time = 470
* CHECK dout0_25 vdout0_25ck46 = 1.8 time = 470
* CHECK dout0_26 vdout0_26ck46 = 1.8 time = 470
* CHECK dout0_27 vdout0_27ck46 = 1.8 time = 470
* CHECK dout0_28 vdout0_28ck46 = 1.8 time = 470
* CHECK dout0_29 vdout0_29ck46 = 0 time = 470
* CHECK dout0_30 vdout0_30ck46 = 1.8 time = 470
* CHECK dout0_31 vdout0_31ck46 = 0 time = 470
* CHECK dout0_32 vdout0_32ck46 = 0 time = 470
* CHECK dout0_33 vdout0_33ck46 = 0 time = 470
* CHECK dout0_34 vdout0_34ck46 = 1.8 time = 470
* CHECK dout0_35 vdout0_35ck46 = 1.8 time = 470
* CHECK dout0_36 vdout0_36ck46 = 0 time = 470
* CHECK dout0_37 vdout0_37ck46 = 0 time = 470
* CHECK dout0_38 vdout0_38ck46 = 0 time = 470
* CHECK dout0_39 vdout0_39ck46 = 0 time = 470
* CHECK dout0_40 vdout0_40ck46 = 0 time = 470
* CHECK dout0_41 vdout0_41ck46 = 1.8 time = 470
* CHECK dout0_42 vdout0_42ck46 = 1.8 time = 470
* CHECK dout0_43 vdout0_43ck46 = 1.8 time = 470
* CHECK dout0_44 vdout0_44ck46 = 0 time = 470
* CHECK dout0_45 vdout0_45ck46 = 0 time = 470
* CHECK dout0_46 vdout0_46ck46 = 0 time = 470
* CHECK dout0_47 vdout0_47ck46 = 1.8 time = 470
* CHECK dout0_48 vdout0_48ck46 = 0 time = 470
* CHECK dout0_49 vdout0_49ck46 = 0 time = 470
* CHECK dout0_50 vdout0_50ck46 = 1.8 time = 470
* CHECK dout0_51 vdout0_51ck46 = 0 time = 470
* CHECK dout0_52 vdout0_52ck46 = 0 time = 470
* CHECK dout0_53 vdout0_53ck46 = 1.8 time = 470
* CHECK dout0_54 vdout0_54ck46 = 1.8 time = 470
* CHECK dout0_55 vdout0_55ck46 = 1.8 time = 470
* CHECK dout0_56 vdout0_56ck46 = 1.8 time = 470
* CHECK dout0_57 vdout0_57ck46 = 1.8 time = 470
* CHECK dout0_58 vdout0_58ck46 = 0 time = 470
* CHECK dout0_59 vdout0_59ck46 = 1.8 time = 470
* CHECK dout0_60 vdout0_60ck46 = 0 time = 470
* CHECK dout0_61 vdout0_61ck46 = 0 time = 470
* CHECK dout0_62 vdout0_62ck46 = 0 time = 470
* CHECK dout0_63 vdout0_63ck46 = 0 time = 470
* CHECK dout1_0 vdout1_0ck46 = 0 time = 470
* CHECK dout1_1 vdout1_1ck46 = 1.8 time = 470
* CHECK dout1_2 vdout1_2ck46 = 0 time = 470
* CHECK dout1_3 vdout1_3ck46 = 0 time = 470
* CHECK dout1_4 vdout1_4ck46 = 0 time = 470
* CHECK dout1_5 vdout1_5ck46 = 1.8 time = 470
* CHECK dout1_6 vdout1_6ck46 = 1.8 time = 470
* CHECK dout1_7 vdout1_7ck46 = 0 time = 470
* CHECK dout1_8 vdout1_8ck46 = 1.8 time = 470
* CHECK dout1_9 vdout1_9ck46 = 1.8 time = 470
* CHECK dout1_10 vdout1_10ck46 = 0 time = 470
* CHECK dout1_11 vdout1_11ck46 = 0 time = 470
* CHECK dout1_12 vdout1_12ck46 = 0 time = 470
* CHECK dout1_13 vdout1_13ck46 = 1.8 time = 470
* CHECK dout1_14 vdout1_14ck46 = 1.8 time = 470
* CHECK dout1_15 vdout1_15ck46 = 0 time = 470
* CHECK dout1_16 vdout1_16ck46 = 0 time = 470
* CHECK dout1_17 vdout1_17ck46 = 1.8 time = 470
* CHECK dout1_18 vdout1_18ck46 = 0 time = 470
* CHECK dout1_19 vdout1_19ck46 = 0 time = 470
* CHECK dout1_20 vdout1_20ck46 = 0 time = 470
* CHECK dout1_21 vdout1_21ck46 = 1.8 time = 470
* CHECK dout1_22 vdout1_22ck46 = 0 time = 470
* CHECK dout1_23 vdout1_23ck46 = 0 time = 470
* CHECK dout1_24 vdout1_24ck46 = 1.8 time = 470
* CHECK dout1_25 vdout1_25ck46 = 1.8 time = 470
* CHECK dout1_26 vdout1_26ck46 = 0 time = 470
* CHECK dout1_27 vdout1_27ck46 = 1.8 time = 470
* CHECK dout1_28 vdout1_28ck46 = 1.8 time = 470
* CHECK dout1_29 vdout1_29ck46 = 1.8 time = 470
* CHECK dout1_30 vdout1_30ck46 = 0 time = 470
* CHECK dout1_31 vdout1_31ck46 = 1.8 time = 470
* CHECK dout1_32 vdout1_32ck46 = 1.8 time = 470
* CHECK dout1_33 vdout1_33ck46 = 0 time = 470
* CHECK dout1_34 vdout1_34ck46 = 0 time = 470
* CHECK dout1_35 vdout1_35ck46 = 0 time = 470
* CHECK dout1_36 vdout1_36ck46 = 1.8 time = 470
* CHECK dout1_37 vdout1_37ck46 = 1.8 time = 470
* CHECK dout1_38 vdout1_38ck46 = 0 time = 470
* CHECK dout1_39 vdout1_39ck46 = 0 time = 470
* CHECK dout1_40 vdout1_40ck46 = 0 time = 470
* CHECK dout1_41 vdout1_41ck46 = 0 time = 470
* CHECK dout1_42 vdout1_42ck46 = 1.8 time = 470
* CHECK dout1_43 vdout1_43ck46 = 0 time = 470
* CHECK dout1_44 vdout1_44ck46 = 1.8 time = 470
* CHECK dout1_45 vdout1_45ck46 = 1.8 time = 470
* CHECK dout1_46 vdout1_46ck46 = 1.8 time = 470
* CHECK dout1_47 vdout1_47ck46 = 0 time = 470
* CHECK dout1_48 vdout1_48ck46 = 0 time = 470
* CHECK dout1_49 vdout1_49ck46 = 0 time = 470
* CHECK dout1_50 vdout1_50ck46 = 0 time = 470
* CHECK dout1_51 vdout1_51ck46 = 0 time = 470
* CHECK dout1_52 vdout1_52ck46 = 1.8 time = 470
* CHECK dout1_53 vdout1_53ck46 = 0 time = 470
* CHECK dout1_54 vdout1_54ck46 = 0 time = 470
* CHECK dout1_55 vdout1_55ck46 = 0 time = 470
* CHECK dout1_56 vdout1_56ck46 = 1.8 time = 470
* CHECK dout1_57 vdout1_57ck46 = 0 time = 470
* CHECK dout1_58 vdout1_58ck46 = 0 time = 470
* CHECK dout1_59 vdout1_59ck46 = 1.8 time = 470
* CHECK dout1_60 vdout1_60ck46 = 0 time = 470
* CHECK dout1_61 vdout1_61ck46 = 0 time = 470
* CHECK dout1_62 vdout1_62ck46 = 0 time = 470
* CHECK dout1_63 vdout1_63ck46 = 1.8 time = 470
* CHECK dout0_0 vdout0_0ck48 = 0 time = 490
* CHECK dout0_1 vdout0_1ck48 = 1.8 time = 490
* CHECK dout0_2 vdout0_2ck48 = 0 time = 490
* CHECK dout0_3 vdout0_3ck48 = 0 time = 490
* CHECK dout0_4 vdout0_4ck48 = 0 time = 490
* CHECK dout0_5 vdout0_5ck48 = 1.8 time = 490
* CHECK dout0_6 vdout0_6ck48 = 1.8 time = 490
* CHECK dout0_7 vdout0_7ck48 = 0 time = 490
* CHECK dout0_8 vdout0_8ck48 = 1.8 time = 490
* CHECK dout0_9 vdout0_9ck48 = 1.8 time = 490
* CHECK dout0_10 vdout0_10ck48 = 0 time = 490
* CHECK dout0_11 vdout0_11ck48 = 0 time = 490
* CHECK dout0_12 vdout0_12ck48 = 0 time = 490
* CHECK dout0_13 vdout0_13ck48 = 1.8 time = 490
* CHECK dout0_14 vdout0_14ck48 = 1.8 time = 490
* CHECK dout0_15 vdout0_15ck48 = 0 time = 490
* CHECK dout0_16 vdout0_16ck48 = 0 time = 490
* CHECK dout0_17 vdout0_17ck48 = 1.8 time = 490
* CHECK dout0_18 vdout0_18ck48 = 0 time = 490
* CHECK dout0_19 vdout0_19ck48 = 0 time = 490
* CHECK dout0_20 vdout0_20ck48 = 0 time = 490
* CHECK dout0_21 vdout0_21ck48 = 1.8 time = 490
* CHECK dout0_22 vdout0_22ck48 = 0 time = 490
* CHECK dout0_23 vdout0_23ck48 = 0 time = 490
* CHECK dout0_24 vdout0_24ck48 = 1.8 time = 490
* CHECK dout0_25 vdout0_25ck48 = 1.8 time = 490
* CHECK dout0_26 vdout0_26ck48 = 0 time = 490
* CHECK dout0_27 vdout0_27ck48 = 1.8 time = 490
* CHECK dout0_28 vdout0_28ck48 = 1.8 time = 490
* CHECK dout0_29 vdout0_29ck48 = 1.8 time = 490
* CHECK dout0_30 vdout0_30ck48 = 0 time = 490
* CHECK dout0_31 vdout0_31ck48 = 1.8 time = 490
* CHECK dout0_32 vdout0_32ck48 = 1.8 time = 490
* CHECK dout0_33 vdout0_33ck48 = 0 time = 490
* CHECK dout0_34 vdout0_34ck48 = 0 time = 490
* CHECK dout0_35 vdout0_35ck48 = 0 time = 490
* CHECK dout0_36 vdout0_36ck48 = 1.8 time = 490
* CHECK dout0_37 vdout0_37ck48 = 1.8 time = 490
* CHECK dout0_38 vdout0_38ck48 = 0 time = 490
* CHECK dout0_39 vdout0_39ck48 = 0 time = 490
* CHECK dout0_40 vdout0_40ck48 = 0 time = 490
* CHECK dout0_41 vdout0_41ck48 = 0 time = 490
* CHECK dout0_42 vdout0_42ck48 = 1.8 time = 490
* CHECK dout0_43 vdout0_43ck48 = 0 time = 490
* CHECK dout0_44 vdout0_44ck48 = 1.8 time = 490
* CHECK dout0_45 vdout0_45ck48 = 1.8 time = 490
* CHECK dout0_46 vdout0_46ck48 = 1.8 time = 490
* CHECK dout0_47 vdout0_47ck48 = 0 time = 490
* CHECK dout0_48 vdout0_48ck48 = 0 time = 490
* CHECK dout0_49 vdout0_49ck48 = 0 time = 490
* CHECK dout0_50 vdout0_50ck48 = 0 time = 490
* CHECK dout0_51 vdout0_51ck48 = 0 time = 490
* CHECK dout0_52 vdout0_52ck48 = 1.8 time = 490
* CHECK dout0_53 vdout0_53ck48 = 0 time = 490
* CHECK dout0_54 vdout0_54ck48 = 0 time = 490
* CHECK dout0_55 vdout0_55ck48 = 0 time = 490
* CHECK dout0_56 vdout0_56ck48 = 1.8 time = 490
* CHECK dout0_57 vdout0_57ck48 = 0 time = 490
* CHECK dout0_58 vdout0_58ck48 = 0 time = 490
* CHECK dout0_59 vdout0_59ck48 = 1.8 time = 490
* CHECK dout0_60 vdout0_60ck48 = 0 time = 490
* CHECK dout0_61 vdout0_61ck48 = 0 time = 490
* CHECK dout0_62 vdout0_62ck48 = 0 time = 490
* CHECK dout0_63 vdout0_63ck48 = 1.8 time = 490
* CHECK dout1_0 vdout1_0ck50 = 1.8 time = 510
* CHECK dout1_1 vdout1_1ck50 = 0 time = 510
* CHECK dout1_2 vdout1_2ck50 = 0 time = 510
* CHECK dout1_3 vdout1_3ck50 = 1.8 time = 510
* CHECK dout1_4 vdout1_4ck50 = 1.8 time = 510
* CHECK dout1_5 vdout1_5ck50 = 1.8 time = 510
* CHECK dout1_6 vdout1_6ck50 = 1.8 time = 510
* CHECK dout1_7 vdout1_7ck50 = 1.8 time = 510
* CHECK dout1_8 vdout1_8ck50 = 1.8 time = 510
* CHECK dout1_9 vdout1_9ck50 = 0 time = 510
* CHECK dout1_10 vdout1_10ck50 = 0 time = 510
* CHECK dout1_11 vdout1_11ck50 = 0 time = 510
* CHECK dout1_12 vdout1_12ck50 = 1.8 time = 510
* CHECK dout1_13 vdout1_13ck50 = 1.8 time = 510
* CHECK dout1_14 vdout1_14ck50 = 0 time = 510
* CHECK dout1_15 vdout1_15ck50 = 0 time = 510
* CHECK dout1_16 vdout1_16ck50 = 0 time = 510
* CHECK dout1_17 vdout1_17ck50 = 1.8 time = 510
* CHECK dout1_18 vdout1_18ck50 = 1.8 time = 510
* CHECK dout1_19 vdout1_19ck50 = 1.8 time = 510
* CHECK dout1_20 vdout1_20ck50 = 1.8 time = 510
* CHECK dout1_21 vdout1_21ck50 = 1.8 time = 510
* CHECK dout1_22 vdout1_22ck50 = 0 time = 510
* CHECK dout1_23 vdout1_23ck50 = 1.8 time = 510
* CHECK dout1_24 vdout1_24ck50 = 1.8 time = 510
* CHECK dout1_25 vdout1_25ck50 = 0 time = 510
* CHECK dout1_26 vdout1_26ck50 = 0 time = 510
* CHECK dout1_27 vdout1_27ck50 = 1.8 time = 510
* CHECK dout1_28 vdout1_28ck50 = 0 time = 510
* CHECK dout1_29 vdout1_29ck50 = 0 time = 510
* CHECK dout1_30 vdout1_30ck50 = 1.8 time = 510
* CHECK dout1_31 vdout1_31ck50 = 0 time = 510
* CHECK dout1_32 vdout1_32ck50 = 0 time = 510
* CHECK dout1_33 vdout1_33ck50 = 0 time = 510
* CHECK dout1_34 vdout1_34ck50 = 0 time = 510
* CHECK dout1_35 vdout1_35ck50 = 0 time = 510
* CHECK dout1_36 vdout1_36ck50 = 1.8 time = 510
* CHECK dout1_37 vdout1_37ck50 = 1.8 time = 510
* CHECK dout1_38 vdout1_38ck50 = 0 time = 510
* CHECK dout1_39 vdout1_39ck50 = 0 time = 510
* CHECK dout1_40 vdout1_40ck50 = 1.8 time = 510
* CHECK dout1_41 vdout1_41ck50 = 1.8 time = 510
* CHECK dout1_42 vdout1_42ck50 = 0 time = 510
* CHECK dout1_43 vdout1_43ck50 = 1.8 time = 510
* CHECK dout1_44 vdout1_44ck50 = 1.8 time = 510
* CHECK dout1_45 vdout1_45ck50 = 0 time = 510
* CHECK dout1_46 vdout1_46ck50 = 1.8 time = 510
* CHECK dout1_47 vdout1_47ck50 = 1.8 time = 510
* CHECK dout1_48 vdout1_48ck50 = 1.8 time = 510
* CHECK dout1_49 vdout1_49ck50 = 0 time = 510
* CHECK dout1_50 vdout1_50ck50 = 1.8 time = 510
* CHECK dout1_51 vdout1_51ck50 = 1.8 time = 510
* CHECK dout1_52 vdout1_52ck50 = 0 time = 510
* CHECK dout1_53 vdout1_53ck50 = 0 time = 510
* CHECK dout1_54 vdout1_54ck50 = 1.8 time = 510
* CHECK dout1_55 vdout1_55ck50 = 1.8 time = 510
* CHECK dout1_56 vdout1_56ck50 = 1.8 time = 510
* CHECK dout1_57 vdout1_57ck50 = 0 time = 510
* CHECK dout1_58 vdout1_58ck50 = 0 time = 510
* CHECK dout1_59 vdout1_59ck50 = 1.8 time = 510
* CHECK dout1_60 vdout1_60ck50 = 1.8 time = 510
* CHECK dout1_61 vdout1_61ck50 = 0 time = 510
* CHECK dout1_62 vdout1_62ck50 = 0 time = 510
* CHECK dout1_63 vdout1_63ck50 = 0 time = 510
* CHECK dout0_0 vdout0_0ck52 = 0 time = 530
* CHECK dout0_1 vdout0_1ck52 = 1.8 time = 530
* CHECK dout0_2 vdout0_2ck52 = 0 time = 530
* CHECK dout0_3 vdout0_3ck52 = 0 time = 530
* CHECK dout0_4 vdout0_4ck52 = 0 time = 530
* CHECK dout0_5 vdout0_5ck52 = 1.8 time = 530
* CHECK dout0_6 vdout0_6ck52 = 1.8 time = 530
* CHECK dout0_7 vdout0_7ck52 = 0 time = 530
* CHECK dout0_8 vdout0_8ck52 = 1.8 time = 530
* CHECK dout0_9 vdout0_9ck52 = 1.8 time = 530
* CHECK dout0_10 vdout0_10ck52 = 0 time = 530
* CHECK dout0_11 vdout0_11ck52 = 0 time = 530
* CHECK dout0_12 vdout0_12ck52 = 0 time = 530
* CHECK dout0_13 vdout0_13ck52 = 1.8 time = 530
* CHECK dout0_14 vdout0_14ck52 = 1.8 time = 530
* CHECK dout0_15 vdout0_15ck52 = 0 time = 530
* CHECK dout0_16 vdout0_16ck52 = 0 time = 530
* CHECK dout0_17 vdout0_17ck52 = 1.8 time = 530
* CHECK dout0_18 vdout0_18ck52 = 0 time = 530
* CHECK dout0_19 vdout0_19ck52 = 0 time = 530
* CHECK dout0_20 vdout0_20ck52 = 0 time = 530
* CHECK dout0_21 vdout0_21ck52 = 1.8 time = 530
* CHECK dout0_22 vdout0_22ck52 = 0 time = 530
* CHECK dout0_23 vdout0_23ck52 = 0 time = 530
* CHECK dout0_24 vdout0_24ck52 = 1.8 time = 530
* CHECK dout0_25 vdout0_25ck52 = 1.8 time = 530
* CHECK dout0_26 vdout0_26ck52 = 0 time = 530
* CHECK dout0_27 vdout0_27ck52 = 1.8 time = 530
* CHECK dout0_28 vdout0_28ck52 = 1.8 time = 530
* CHECK dout0_29 vdout0_29ck52 = 1.8 time = 530
* CHECK dout0_30 vdout0_30ck52 = 0 time = 530
* CHECK dout0_31 vdout0_31ck52 = 1.8 time = 530
* CHECK dout0_32 vdout0_32ck52 = 1.8 time = 530
* CHECK dout0_33 vdout0_33ck52 = 0 time = 530
* CHECK dout0_34 vdout0_34ck52 = 0 time = 530
* CHECK dout0_35 vdout0_35ck52 = 0 time = 530
* CHECK dout0_36 vdout0_36ck52 = 1.8 time = 530
* CHECK dout0_37 vdout0_37ck52 = 1.8 time = 530
* CHECK dout0_38 vdout0_38ck52 = 0 time = 530
* CHECK dout0_39 vdout0_39ck52 = 0 time = 530
* CHECK dout0_40 vdout0_40ck52 = 0 time = 530
* CHECK dout0_41 vdout0_41ck52 = 0 time = 530
* CHECK dout0_42 vdout0_42ck52 = 1.8 time = 530
* CHECK dout0_43 vdout0_43ck52 = 0 time = 530
* CHECK dout0_44 vdout0_44ck52 = 1.8 time = 530
* CHECK dout0_45 vdout0_45ck52 = 1.8 time = 530
* CHECK dout0_46 vdout0_46ck52 = 1.8 time = 530
* CHECK dout0_47 vdout0_47ck52 = 0 time = 530
* CHECK dout0_48 vdout0_48ck52 = 0 time = 530
* CHECK dout0_49 vdout0_49ck52 = 0 time = 530
* CHECK dout0_50 vdout0_50ck52 = 0 time = 530
* CHECK dout0_51 vdout0_51ck52 = 0 time = 530
* CHECK dout0_52 vdout0_52ck52 = 1.8 time = 530
* CHECK dout0_53 vdout0_53ck52 = 0 time = 530
* CHECK dout0_54 vdout0_54ck52 = 0 time = 530
* CHECK dout0_55 vdout0_55ck52 = 0 time = 530
* CHECK dout0_56 vdout0_56ck52 = 1.8 time = 530
* CHECK dout0_57 vdout0_57ck52 = 0 time = 530
* CHECK dout0_58 vdout0_58ck52 = 0 time = 530
* CHECK dout0_59 vdout0_59ck52 = 1.8 time = 530
* CHECK dout0_60 vdout0_60ck52 = 0 time = 530
* CHECK dout0_61 vdout0_61ck52 = 0 time = 530
* CHECK dout0_62 vdout0_62ck52 = 0 time = 530
* CHECK dout0_63 vdout0_63ck52 = 1.8 time = 530
* CHECK dout1_0 vdout1_0ck52 = 0 time = 530
* CHECK dout1_1 vdout1_1ck52 = 1.8 time = 530
* CHECK dout1_2 vdout1_2ck52 = 0 time = 530
* CHECK dout1_3 vdout1_3ck52 = 0 time = 530
* CHECK dout1_4 vdout1_4ck52 = 0 time = 530
* CHECK dout1_5 vdout1_5ck52 = 1.8 time = 530
* CHECK dout1_6 vdout1_6ck52 = 1.8 time = 530
* CHECK dout1_7 vdout1_7ck52 = 0 time = 530
* CHECK dout1_8 vdout1_8ck52 = 1.8 time = 530
* CHECK dout1_9 vdout1_9ck52 = 1.8 time = 530
* CHECK dout1_10 vdout1_10ck52 = 0 time = 530
* CHECK dout1_11 vdout1_11ck52 = 0 time = 530
* CHECK dout1_12 vdout1_12ck52 = 0 time = 530
* CHECK dout1_13 vdout1_13ck52 = 1.8 time = 530
* CHECK dout1_14 vdout1_14ck52 = 1.8 time = 530
* CHECK dout1_15 vdout1_15ck52 = 0 time = 530
* CHECK dout1_16 vdout1_16ck52 = 0 time = 530
* CHECK dout1_17 vdout1_17ck52 = 1.8 time = 530
* CHECK dout1_18 vdout1_18ck52 = 0 time = 530
* CHECK dout1_19 vdout1_19ck52 = 0 time = 530
* CHECK dout1_20 vdout1_20ck52 = 0 time = 530
* CHECK dout1_21 vdout1_21ck52 = 1.8 time = 530
* CHECK dout1_22 vdout1_22ck52 = 0 time = 530
* CHECK dout1_23 vdout1_23ck52 = 0 time = 530
* CHECK dout1_24 vdout1_24ck52 = 1.8 time = 530
* CHECK dout1_25 vdout1_25ck52 = 1.8 time = 530
* CHECK dout1_26 vdout1_26ck52 = 0 time = 530
* CHECK dout1_27 vdout1_27ck52 = 1.8 time = 530
* CHECK dout1_28 vdout1_28ck52 = 1.8 time = 530
* CHECK dout1_29 vdout1_29ck52 = 1.8 time = 530
* CHECK dout1_30 vdout1_30ck52 = 0 time = 530
* CHECK dout1_31 vdout1_31ck52 = 1.8 time = 530
* CHECK dout1_32 vdout1_32ck52 = 1.8 time = 530
* CHECK dout1_33 vdout1_33ck52 = 0 time = 530
* CHECK dout1_34 vdout1_34ck52 = 0 time = 530
* CHECK dout1_35 vdout1_35ck52 = 0 time = 530
* CHECK dout1_36 vdout1_36ck52 = 1.8 time = 530
* CHECK dout1_37 vdout1_37ck52 = 1.8 time = 530
* CHECK dout1_38 vdout1_38ck52 = 0 time = 530
* CHECK dout1_39 vdout1_39ck52 = 0 time = 530
* CHECK dout1_40 vdout1_40ck52 = 0 time = 530
* CHECK dout1_41 vdout1_41ck52 = 0 time = 530
* CHECK dout1_42 vdout1_42ck52 = 1.8 time = 530
* CHECK dout1_43 vdout1_43ck52 = 0 time = 530
* CHECK dout1_44 vdout1_44ck52 = 1.8 time = 530
* CHECK dout1_45 vdout1_45ck52 = 1.8 time = 530
* CHECK dout1_46 vdout1_46ck52 = 1.8 time = 530
* CHECK dout1_47 vdout1_47ck52 = 0 time = 530
* CHECK dout1_48 vdout1_48ck52 = 0 time = 530
* CHECK dout1_49 vdout1_49ck52 = 0 time = 530
* CHECK dout1_50 vdout1_50ck52 = 0 time = 530
* CHECK dout1_51 vdout1_51ck52 = 0 time = 530
* CHECK dout1_52 vdout1_52ck52 = 1.8 time = 530
* CHECK dout1_53 vdout1_53ck52 = 0 time = 530
* CHECK dout1_54 vdout1_54ck52 = 0 time = 530
* CHECK dout1_55 vdout1_55ck52 = 0 time = 530
* CHECK dout1_56 vdout1_56ck52 = 1.8 time = 530
* CHECK dout1_57 vdout1_57ck52 = 0 time = 530
* CHECK dout1_58 vdout1_58ck52 = 0 time = 530
* CHECK dout1_59 vdout1_59ck52 = 1.8 time = 530
* CHECK dout1_60 vdout1_60ck52 = 0 time = 530
* CHECK dout1_61 vdout1_61ck52 = 0 time = 530
* CHECK dout1_62 vdout1_62ck52 = 0 time = 530
* CHECK dout1_63 vdout1_63ck52 = 1.8 time = 530
* CHECK dout0_0 vdout0_0ck53 = 1.8 time = 540
* CHECK dout0_1 vdout0_1ck53 = 0 time = 540
* CHECK dout0_2 vdout0_2ck53 = 0 time = 540
* CHECK dout0_3 vdout0_3ck53 = 1.8 time = 540
* CHECK dout0_4 vdout0_4ck53 = 1.8 time = 540
* CHECK dout0_5 vdout0_5ck53 = 1.8 time = 540
* CHECK dout0_6 vdout0_6ck53 = 1.8 time = 540
* CHECK dout0_7 vdout0_7ck53 = 1.8 time = 540
* CHECK dout0_8 vdout0_8ck53 = 1.8 time = 540
* CHECK dout0_9 vdout0_9ck53 = 0 time = 540
* CHECK dout0_10 vdout0_10ck53 = 0 time = 540
* CHECK dout0_11 vdout0_11ck53 = 0 time = 540
* CHECK dout0_12 vdout0_12ck53 = 1.8 time = 540
* CHECK dout0_13 vdout0_13ck53 = 1.8 time = 540
* CHECK dout0_14 vdout0_14ck53 = 0 time = 540
* CHECK dout0_15 vdout0_15ck53 = 0 time = 540
* CHECK dout0_16 vdout0_16ck53 = 0 time = 540
* CHECK dout0_17 vdout0_17ck53 = 1.8 time = 540
* CHECK dout0_18 vdout0_18ck53 = 1.8 time = 540
* CHECK dout0_19 vdout0_19ck53 = 1.8 time = 540
* CHECK dout0_20 vdout0_20ck53 = 1.8 time = 540
* CHECK dout0_21 vdout0_21ck53 = 1.8 time = 540
* CHECK dout0_22 vdout0_22ck53 = 0 time = 540
* CHECK dout0_23 vdout0_23ck53 = 1.8 time = 540
* CHECK dout0_24 vdout0_24ck53 = 1.8 time = 540
* CHECK dout0_25 vdout0_25ck53 = 0 time = 540
* CHECK dout0_26 vdout0_26ck53 = 0 time = 540
* CHECK dout0_27 vdout0_27ck53 = 1.8 time = 540
* CHECK dout0_28 vdout0_28ck53 = 0 time = 540
* CHECK dout0_29 vdout0_29ck53 = 0 time = 540
* CHECK dout0_30 vdout0_30ck53 = 1.8 time = 540
* CHECK dout0_31 vdout0_31ck53 = 0 time = 540
* CHECK dout0_32 vdout0_32ck53 = 0 time = 540
* CHECK dout0_33 vdout0_33ck53 = 0 time = 540
* CHECK dout0_34 vdout0_34ck53 = 0 time = 540
* CHECK dout0_35 vdout0_35ck53 = 0 time = 540
* CHECK dout0_36 vdout0_36ck53 = 1.8 time = 540
* CHECK dout0_37 vdout0_37ck53 = 1.8 time = 540
* CHECK dout0_38 vdout0_38ck53 = 0 time = 540
* CHECK dout0_39 vdout0_39ck53 = 0 time = 540
* CHECK dout0_40 vdout0_40ck53 = 1.8 time = 540
* CHECK dout0_41 vdout0_41ck53 = 1.8 time = 540
* CHECK dout0_42 vdout0_42ck53 = 0 time = 540
* CHECK dout0_43 vdout0_43ck53 = 1.8 time = 540
* CHECK dout0_44 vdout0_44ck53 = 1.8 time = 540
* CHECK dout0_45 vdout0_45ck53 = 0 time = 540
* CHECK dout0_46 vdout0_46ck53 = 1.8 time = 540
* CHECK dout0_47 vdout0_47ck53 = 1.8 time = 540
* CHECK dout0_48 vdout0_48ck53 = 1.8 time = 540
* CHECK dout0_49 vdout0_49ck53 = 0 time = 540
* CHECK dout0_50 vdout0_50ck53 = 1.8 time = 540
* CHECK dout0_51 vdout0_51ck53 = 1.8 time = 540
* CHECK dout0_52 vdout0_52ck53 = 0 time = 540
* CHECK dout0_53 vdout0_53ck53 = 0 time = 540
* CHECK dout0_54 vdout0_54ck53 = 1.8 time = 540
* CHECK dout0_55 vdout0_55ck53 = 1.8 time = 540
* CHECK dout0_56 vdout0_56ck53 = 1.8 time = 540
* CHECK dout0_57 vdout0_57ck53 = 0 time = 540
* CHECK dout0_58 vdout0_58ck53 = 0 time = 540
* CHECK dout0_59 vdout0_59ck53 = 1.8 time = 540
* CHECK dout0_60 vdout0_60ck53 = 1.8 time = 540
* CHECK dout0_61 vdout0_61ck53 = 0 time = 540
* CHECK dout0_62 vdout0_62ck53 = 0 time = 540
* CHECK dout0_63 vdout0_63ck53 = 0 time = 540
* CHECK dout1_0 vdout1_0ck54 = 1.8 time = 550
* CHECK dout1_1 vdout1_1ck54 = 0 time = 550
* CHECK dout1_2 vdout1_2ck54 = 0 time = 550
* CHECK dout1_3 vdout1_3ck54 = 1.8 time = 550
* CHECK dout1_4 vdout1_4ck54 = 1.8 time = 550
* CHECK dout1_5 vdout1_5ck54 = 1.8 time = 550
* CHECK dout1_6 vdout1_6ck54 = 1.8 time = 550
* CHECK dout1_7 vdout1_7ck54 = 1.8 time = 550
* CHECK dout1_8 vdout1_8ck54 = 1.8 time = 550
* CHECK dout1_9 vdout1_9ck54 = 0 time = 550
* CHECK dout1_10 vdout1_10ck54 = 0 time = 550
* CHECK dout1_11 vdout1_11ck54 = 0 time = 550
* CHECK dout1_12 vdout1_12ck54 = 1.8 time = 550
* CHECK dout1_13 vdout1_13ck54 = 1.8 time = 550
* CHECK dout1_14 vdout1_14ck54 = 0 time = 550
* CHECK dout1_15 vdout1_15ck54 = 0 time = 550
* CHECK dout1_16 vdout1_16ck54 = 0 time = 550
* CHECK dout1_17 vdout1_17ck54 = 1.8 time = 550
* CHECK dout1_18 vdout1_18ck54 = 1.8 time = 550
* CHECK dout1_19 vdout1_19ck54 = 1.8 time = 550
* CHECK dout1_20 vdout1_20ck54 = 1.8 time = 550
* CHECK dout1_21 vdout1_21ck54 = 1.8 time = 550
* CHECK dout1_22 vdout1_22ck54 = 0 time = 550
* CHECK dout1_23 vdout1_23ck54 = 1.8 time = 550
* CHECK dout1_24 vdout1_24ck54 = 1.8 time = 550
* CHECK dout1_25 vdout1_25ck54 = 0 time = 550
* CHECK dout1_26 vdout1_26ck54 = 0 time = 550
* CHECK dout1_27 vdout1_27ck54 = 1.8 time = 550
* CHECK dout1_28 vdout1_28ck54 = 0 time = 550
* CHECK dout1_29 vdout1_29ck54 = 0 time = 550
* CHECK dout1_30 vdout1_30ck54 = 1.8 time = 550
* CHECK dout1_31 vdout1_31ck54 = 0 time = 550
* CHECK dout1_32 vdout1_32ck54 = 0 time = 550
* CHECK dout1_33 vdout1_33ck54 = 0 time = 550
* CHECK dout1_34 vdout1_34ck54 = 0 time = 550
* CHECK dout1_35 vdout1_35ck54 = 0 time = 550
* CHECK dout1_36 vdout1_36ck54 = 1.8 time = 550
* CHECK dout1_37 vdout1_37ck54 = 1.8 time = 550
* CHECK dout1_38 vdout1_38ck54 = 0 time = 550
* CHECK dout1_39 vdout1_39ck54 = 0 time = 550
* CHECK dout1_40 vdout1_40ck54 = 1.8 time = 550
* CHECK dout1_41 vdout1_41ck54 = 1.8 time = 550
* CHECK dout1_42 vdout1_42ck54 = 0 time = 550
* CHECK dout1_43 vdout1_43ck54 = 1.8 time = 550
* CHECK dout1_44 vdout1_44ck54 = 1.8 time = 550
* CHECK dout1_45 vdout1_45ck54 = 0 time = 550
* CHECK dout1_46 vdout1_46ck54 = 1.8 time = 550
* CHECK dout1_47 vdout1_47ck54 = 1.8 time = 550
* CHECK dout1_48 vdout1_48ck54 = 1.8 time = 550
* CHECK dout1_49 vdout1_49ck54 = 0 time = 550
* CHECK dout1_50 vdout1_50ck54 = 1.8 time = 550
* CHECK dout1_51 vdout1_51ck54 = 1.8 time = 550
* CHECK dout1_52 vdout1_52ck54 = 0 time = 550
* CHECK dout1_53 vdout1_53ck54 = 0 time = 550
* CHECK dout1_54 vdout1_54ck54 = 1.8 time = 550
* CHECK dout1_55 vdout1_55ck54 = 1.8 time = 550
* CHECK dout1_56 vdout1_56ck54 = 1.8 time = 550
* CHECK dout1_57 vdout1_57ck54 = 0 time = 550
* CHECK dout1_58 vdout1_58ck54 = 0 time = 550
* CHECK dout1_59 vdout1_59ck54 = 1.8 time = 550
* CHECK dout1_60 vdout1_60ck54 = 1.8 time = 550
* CHECK dout1_61 vdout1_61ck54 = 0 time = 550
* CHECK dout1_62 vdout1_62ck54 = 0 time = 550
* CHECK dout1_63 vdout1_63ck54 = 0 time = 550
* CHECK dout0_0 vdout0_0ck55 = 1.8 time = 560
* CHECK dout0_1 vdout0_1ck55 = 0 time = 560
* CHECK dout0_2 vdout0_2ck55 = 0 time = 560
* CHECK dout0_3 vdout0_3ck55 = 1.8 time = 560
* CHECK dout0_4 vdout0_4ck55 = 1.8 time = 560
* CHECK dout0_5 vdout0_5ck55 = 1.8 time = 560
* CHECK dout0_6 vdout0_6ck55 = 1.8 time = 560
* CHECK dout0_7 vdout0_7ck55 = 1.8 time = 560
* CHECK dout0_8 vdout0_8ck55 = 1.8 time = 560
* CHECK dout0_9 vdout0_9ck55 = 0 time = 560
* CHECK dout0_10 vdout0_10ck55 = 0 time = 560
* CHECK dout0_11 vdout0_11ck55 = 0 time = 560
* CHECK dout0_12 vdout0_12ck55 = 1.8 time = 560
* CHECK dout0_13 vdout0_13ck55 = 1.8 time = 560
* CHECK dout0_14 vdout0_14ck55 = 0 time = 560
* CHECK dout0_15 vdout0_15ck55 = 0 time = 560
* CHECK dout0_16 vdout0_16ck55 = 0 time = 560
* CHECK dout0_17 vdout0_17ck55 = 1.8 time = 560
* CHECK dout0_18 vdout0_18ck55 = 1.8 time = 560
* CHECK dout0_19 vdout0_19ck55 = 1.8 time = 560
* CHECK dout0_20 vdout0_20ck55 = 1.8 time = 560
* CHECK dout0_21 vdout0_21ck55 = 1.8 time = 560
* CHECK dout0_22 vdout0_22ck55 = 0 time = 560
* CHECK dout0_23 vdout0_23ck55 = 1.8 time = 560
* CHECK dout0_24 vdout0_24ck55 = 1.8 time = 560
* CHECK dout0_25 vdout0_25ck55 = 0 time = 560
* CHECK dout0_26 vdout0_26ck55 = 0 time = 560
* CHECK dout0_27 vdout0_27ck55 = 1.8 time = 560
* CHECK dout0_28 vdout0_28ck55 = 0 time = 560
* CHECK dout0_29 vdout0_29ck55 = 0 time = 560
* CHECK dout0_30 vdout0_30ck55 = 1.8 time = 560
* CHECK dout0_31 vdout0_31ck55 = 0 time = 560
* CHECK dout0_32 vdout0_32ck55 = 0 time = 560
* CHECK dout0_33 vdout0_33ck55 = 0 time = 560
* CHECK dout0_34 vdout0_34ck55 = 0 time = 560
* CHECK dout0_35 vdout0_35ck55 = 0 time = 560
* CHECK dout0_36 vdout0_36ck55 = 1.8 time = 560
* CHECK dout0_37 vdout0_37ck55 = 1.8 time = 560
* CHECK dout0_38 vdout0_38ck55 = 0 time = 560
* CHECK dout0_39 vdout0_39ck55 = 0 time = 560
* CHECK dout0_40 vdout0_40ck55 = 1.8 time = 560
* CHECK dout0_41 vdout0_41ck55 = 1.8 time = 560
* CHECK dout0_42 vdout0_42ck55 = 0 time = 560
* CHECK dout0_43 vdout0_43ck55 = 1.8 time = 560
* CHECK dout0_44 vdout0_44ck55 = 1.8 time = 560
* CHECK dout0_45 vdout0_45ck55 = 0 time = 560
* CHECK dout0_46 vdout0_46ck55 = 1.8 time = 560
* CHECK dout0_47 vdout0_47ck55 = 1.8 time = 560
* CHECK dout0_48 vdout0_48ck55 = 1.8 time = 560
* CHECK dout0_49 vdout0_49ck55 = 0 time = 560
* CHECK dout0_50 vdout0_50ck55 = 1.8 time = 560
* CHECK dout0_51 vdout0_51ck55 = 1.8 time = 560
* CHECK dout0_52 vdout0_52ck55 = 0 time = 560
* CHECK dout0_53 vdout0_53ck55 = 0 time = 560
* CHECK dout0_54 vdout0_54ck55 = 1.8 time = 560
* CHECK dout0_55 vdout0_55ck55 = 1.8 time = 560
* CHECK dout0_56 vdout0_56ck55 = 1.8 time = 560
* CHECK dout0_57 vdout0_57ck55 = 0 time = 560
* CHECK dout0_58 vdout0_58ck55 = 0 time = 560
* CHECK dout0_59 vdout0_59ck55 = 1.8 time = 560
* CHECK dout0_60 vdout0_60ck55 = 1.8 time = 560
* CHECK dout0_61 vdout0_61ck55 = 0 time = 560
* CHECK dout0_62 vdout0_62ck55 = 0 time = 560
* CHECK dout0_63 vdout0_63ck55 = 0 time = 560
* CHECK dout0_0 vdout0_0ck56 = 1.8 time = 570
* CHECK dout0_1 vdout0_1ck56 = 0 time = 570
* CHECK dout0_2 vdout0_2ck56 = 0 time = 570
* CHECK dout0_3 vdout0_3ck56 = 1.8 time = 570
* CHECK dout0_4 vdout0_4ck56 = 1.8 time = 570
* CHECK dout0_5 vdout0_5ck56 = 1.8 time = 570
* CHECK dout0_6 vdout0_6ck56 = 1.8 time = 570
* CHECK dout0_7 vdout0_7ck56 = 1.8 time = 570
* CHECK dout0_8 vdout0_8ck56 = 1.8 time = 570
* CHECK dout0_9 vdout0_9ck56 = 0 time = 570
* CHECK dout0_10 vdout0_10ck56 = 0 time = 570
* CHECK dout0_11 vdout0_11ck56 = 0 time = 570
* CHECK dout0_12 vdout0_12ck56 = 1.8 time = 570
* CHECK dout0_13 vdout0_13ck56 = 1.8 time = 570
* CHECK dout0_14 vdout0_14ck56 = 0 time = 570
* CHECK dout0_15 vdout0_15ck56 = 0 time = 570
* CHECK dout0_16 vdout0_16ck56 = 0 time = 570
* CHECK dout0_17 vdout0_17ck56 = 1.8 time = 570
* CHECK dout0_18 vdout0_18ck56 = 1.8 time = 570
* CHECK dout0_19 vdout0_19ck56 = 1.8 time = 570
* CHECK dout0_20 vdout0_20ck56 = 1.8 time = 570
* CHECK dout0_21 vdout0_21ck56 = 1.8 time = 570
* CHECK dout0_22 vdout0_22ck56 = 0 time = 570
* CHECK dout0_23 vdout0_23ck56 = 1.8 time = 570
* CHECK dout0_24 vdout0_24ck56 = 1.8 time = 570
* CHECK dout0_25 vdout0_25ck56 = 0 time = 570
* CHECK dout0_26 vdout0_26ck56 = 0 time = 570
* CHECK dout0_27 vdout0_27ck56 = 1.8 time = 570
* CHECK dout0_28 vdout0_28ck56 = 0 time = 570
* CHECK dout0_29 vdout0_29ck56 = 0 time = 570
* CHECK dout0_30 vdout0_30ck56 = 1.8 time = 570
* CHECK dout0_31 vdout0_31ck56 = 0 time = 570
* CHECK dout0_32 vdout0_32ck56 = 0 time = 570
* CHECK dout0_33 vdout0_33ck56 = 0 time = 570
* CHECK dout0_34 vdout0_34ck56 = 0 time = 570
* CHECK dout0_35 vdout0_35ck56 = 0 time = 570
* CHECK dout0_36 vdout0_36ck56 = 1.8 time = 570
* CHECK dout0_37 vdout0_37ck56 = 1.8 time = 570
* CHECK dout0_38 vdout0_38ck56 = 0 time = 570
* CHECK dout0_39 vdout0_39ck56 = 0 time = 570
* CHECK dout0_40 vdout0_40ck56 = 1.8 time = 570
* CHECK dout0_41 vdout0_41ck56 = 1.8 time = 570
* CHECK dout0_42 vdout0_42ck56 = 0 time = 570
* CHECK dout0_43 vdout0_43ck56 = 1.8 time = 570
* CHECK dout0_44 vdout0_44ck56 = 1.8 time = 570
* CHECK dout0_45 vdout0_45ck56 = 0 time = 570
* CHECK dout0_46 vdout0_46ck56 = 1.8 time = 570
* CHECK dout0_47 vdout0_47ck56 = 1.8 time = 570
* CHECK dout0_48 vdout0_48ck56 = 1.8 time = 570
* CHECK dout0_49 vdout0_49ck56 = 0 time = 570
* CHECK dout0_50 vdout0_50ck56 = 1.8 time = 570
* CHECK dout0_51 vdout0_51ck56 = 1.8 time = 570
* CHECK dout0_52 vdout0_52ck56 = 0 time = 570
* CHECK dout0_53 vdout0_53ck56 = 0 time = 570
* CHECK dout0_54 vdout0_54ck56 = 1.8 time = 570
* CHECK dout0_55 vdout0_55ck56 = 1.8 time = 570
* CHECK dout0_56 vdout0_56ck56 = 1.8 time = 570
* CHECK dout0_57 vdout0_57ck56 = 0 time = 570
* CHECK dout0_58 vdout0_58ck56 = 0 time = 570
* CHECK dout0_59 vdout0_59ck56 = 1.8 time = 570
* CHECK dout0_60 vdout0_60ck56 = 1.8 time = 570
* CHECK dout0_61 vdout0_61ck56 = 0 time = 570
* CHECK dout0_62 vdout0_62ck56 = 0 time = 570
* CHECK dout0_63 vdout0_63ck56 = 0 time = 570
* CHECK dout1_0 vdout1_0ck56 = 1.8 time = 570
* CHECK dout1_1 vdout1_1ck56 = 1.8 time = 570
* CHECK dout1_2 vdout1_2ck56 = 1.8 time = 570
* CHECK dout1_3 vdout1_3ck56 = 1.8 time = 570
* CHECK dout1_4 vdout1_4ck56 = 0 time = 570
* CHECK dout1_5 vdout1_5ck56 = 1.8 time = 570
* CHECK dout1_6 vdout1_6ck56 = 0 time = 570
* CHECK dout1_7 vdout1_7ck56 = 1.8 time = 570
* CHECK dout1_8 vdout1_8ck56 = 1.8 time = 570
* CHECK dout1_9 vdout1_9ck56 = 0 time = 570
* CHECK dout1_10 vdout1_10ck56 = 1.8 time = 570
* CHECK dout1_11 vdout1_11ck56 = 1.8 time = 570
* CHECK dout1_12 vdout1_12ck56 = 0 time = 570
* CHECK dout1_13 vdout1_13ck56 = 1.8 time = 570
* CHECK dout1_14 vdout1_14ck56 = 1.8 time = 570
* CHECK dout1_15 vdout1_15ck56 = 0 time = 570
* CHECK dout1_16 vdout1_16ck56 = 1.8 time = 570
* CHECK dout1_17 vdout1_17ck56 = 1.8 time = 570
* CHECK dout1_18 vdout1_18ck56 = 1.8 time = 570
* CHECK dout1_19 vdout1_19ck56 = 1.8 time = 570
* CHECK dout1_20 vdout1_20ck56 = 1.8 time = 570
* CHECK dout1_21 vdout1_21ck56 = 1.8 time = 570
* CHECK dout1_22 vdout1_22ck56 = 0 time = 570
* CHECK dout1_23 vdout1_23ck56 = 1.8 time = 570
* CHECK dout1_24 vdout1_24ck56 = 1.8 time = 570
* CHECK dout1_25 vdout1_25ck56 = 0 time = 570
* CHECK dout1_26 vdout1_26ck56 = 0 time = 570
* CHECK dout1_27 vdout1_27ck56 = 1.8 time = 570
* CHECK dout1_28 vdout1_28ck56 = 0 time = 570
* CHECK dout1_29 vdout1_29ck56 = 0 time = 570
* CHECK dout1_30 vdout1_30ck56 = 1.8 time = 570
* CHECK dout1_31 vdout1_31ck56 = 1.8 time = 570
* CHECK dout1_32 vdout1_32ck56 = 0 time = 570
* CHECK dout1_33 vdout1_33ck56 = 0 time = 570
* CHECK dout1_34 vdout1_34ck56 = 1.8 time = 570
* CHECK dout1_35 vdout1_35ck56 = 0 time = 570
* CHECK dout1_36 vdout1_36ck56 = 0 time = 570
* CHECK dout1_37 vdout1_37ck56 = 1.8 time = 570
* CHECK dout1_38 vdout1_38ck56 = 0 time = 570
* CHECK dout1_39 vdout1_39ck56 = 0 time = 570
* CHECK dout1_40 vdout1_40ck56 = 0 time = 570
* CHECK dout1_41 vdout1_41ck56 = 1.8 time = 570
* CHECK dout1_42 vdout1_42ck56 = 0 time = 570
* CHECK dout1_43 vdout1_43ck56 = 0 time = 570
* CHECK dout1_44 vdout1_44ck56 = 0 time = 570
* CHECK dout1_45 vdout1_45ck56 = 1.8 time = 570
* CHECK dout1_46 vdout1_46ck56 = 1.8 time = 570
* CHECK dout1_47 vdout1_47ck56 = 0 time = 570
* CHECK dout1_48 vdout1_48ck56 = 0 time = 570
* CHECK dout1_49 vdout1_49ck56 = 1.8 time = 570
* CHECK dout1_50 vdout1_50ck56 = 1.8 time = 570
* CHECK dout1_51 vdout1_51ck56 = 0 time = 570
* CHECK dout1_52 vdout1_52ck56 = 1.8 time = 570
* CHECK dout1_53 vdout1_53ck56 = 0 time = 570
* CHECK dout1_54 vdout1_54ck56 = 0 time = 570
* CHECK dout1_55 vdout1_55ck56 = 0 time = 570
* CHECK dout1_56 vdout1_56ck56 = 1.8 time = 570
* CHECK dout1_57 vdout1_57ck56 = 1.8 time = 570
* CHECK dout1_58 vdout1_58ck56 = 0 time = 570
* CHECK dout1_59 vdout1_59ck56 = 0 time = 570
* CHECK dout1_60 vdout1_60ck56 = 1.8 time = 570
* CHECK dout1_61 vdout1_61ck56 = 0 time = 570
* CHECK dout1_62 vdout1_62ck56 = 0 time = 570
* CHECK dout1_63 vdout1_63ck56 = 1.8 time = 570
* CHECK dout1_0 vdout1_0ck58 = 0 time = 590
* CHECK dout1_1 vdout1_1ck58 = 1.8 time = 590
* CHECK dout1_2 vdout1_2ck58 = 0 time = 590
* CHECK dout1_3 vdout1_3ck58 = 0 time = 590
* CHECK dout1_4 vdout1_4ck58 = 0 time = 590
* CHECK dout1_5 vdout1_5ck58 = 1.8 time = 590
* CHECK dout1_6 vdout1_6ck58 = 1.8 time = 590
* CHECK dout1_7 vdout1_7ck58 = 0 time = 590
* CHECK dout1_8 vdout1_8ck58 = 1.8 time = 590
* CHECK dout1_9 vdout1_9ck58 = 1.8 time = 590
* CHECK dout1_10 vdout1_10ck58 = 0 time = 590
* CHECK dout1_11 vdout1_11ck58 = 0 time = 590
* CHECK dout1_12 vdout1_12ck58 = 0 time = 590
* CHECK dout1_13 vdout1_13ck58 = 1.8 time = 590
* CHECK dout1_14 vdout1_14ck58 = 1.8 time = 590
* CHECK dout1_15 vdout1_15ck58 = 0 time = 590
* CHECK dout1_16 vdout1_16ck58 = 0 time = 590
* CHECK dout1_17 vdout1_17ck58 = 1.8 time = 590
* CHECK dout1_18 vdout1_18ck58 = 0 time = 590
* CHECK dout1_19 vdout1_19ck58 = 0 time = 590
* CHECK dout1_20 vdout1_20ck58 = 0 time = 590
* CHECK dout1_21 vdout1_21ck58 = 1.8 time = 590
* CHECK dout1_22 vdout1_22ck58 = 0 time = 590
* CHECK dout1_23 vdout1_23ck58 = 0 time = 590
* CHECK dout1_24 vdout1_24ck58 = 1.8 time = 590
* CHECK dout1_25 vdout1_25ck58 = 1.8 time = 590
* CHECK dout1_26 vdout1_26ck58 = 0 time = 590
* CHECK dout1_27 vdout1_27ck58 = 1.8 time = 590
* CHECK dout1_28 vdout1_28ck58 = 1.8 time = 590
* CHECK dout1_29 vdout1_29ck58 = 1.8 time = 590
* CHECK dout1_30 vdout1_30ck58 = 0 time = 590
* CHECK dout1_31 vdout1_31ck58 = 1.8 time = 590
* CHECK dout1_32 vdout1_32ck58 = 1.8 time = 590
* CHECK dout1_33 vdout1_33ck58 = 0 time = 590
* CHECK dout1_34 vdout1_34ck58 = 0 time = 590
* CHECK dout1_35 vdout1_35ck58 = 0 time = 590
* CHECK dout1_36 vdout1_36ck58 = 1.8 time = 590
* CHECK dout1_37 vdout1_37ck58 = 1.8 time = 590
* CHECK dout1_38 vdout1_38ck58 = 0 time = 590
* CHECK dout1_39 vdout1_39ck58 = 0 time = 590
* CHECK dout1_40 vdout1_40ck58 = 0 time = 590
* CHECK dout1_41 vdout1_41ck58 = 0 time = 590
* CHECK dout1_42 vdout1_42ck58 = 1.8 time = 590
* CHECK dout1_43 vdout1_43ck58 = 0 time = 590
* CHECK dout1_44 vdout1_44ck58 = 1.8 time = 590
* CHECK dout1_45 vdout1_45ck58 = 1.8 time = 590
* CHECK dout1_46 vdout1_46ck58 = 1.8 time = 590
* CHECK dout1_47 vdout1_47ck58 = 0 time = 590
* CHECK dout1_48 vdout1_48ck58 = 0 time = 590
* CHECK dout1_49 vdout1_49ck58 = 0 time = 590
* CHECK dout1_50 vdout1_50ck58 = 0 time = 590
* CHECK dout1_51 vdout1_51ck58 = 0 time = 590
* CHECK dout1_52 vdout1_52ck58 = 1.8 time = 590
* CHECK dout1_53 vdout1_53ck58 = 0 time = 590
* CHECK dout1_54 vdout1_54ck58 = 0 time = 590
* CHECK dout1_55 vdout1_55ck58 = 0 time = 590
* CHECK dout1_56 vdout1_56ck58 = 1.8 time = 590
* CHECK dout1_57 vdout1_57ck58 = 0 time = 590
* CHECK dout1_58 vdout1_58ck58 = 0 time = 590
* CHECK dout1_59 vdout1_59ck58 = 1.8 time = 590
* CHECK dout1_60 vdout1_60ck58 = 0 time = 590
* CHECK dout1_61 vdout1_61ck58 = 0 time = 590
* CHECK dout1_62 vdout1_62ck58 = 0 time = 590
* CHECK dout1_63 vdout1_63ck58 = 1.8 time = 590
* CHECK dout0_0 vdout0_0ck59 = 1.8 time = 600
* CHECK dout0_1 vdout0_1ck59 = 1.8 time = 600
* CHECK dout0_2 vdout0_2ck59 = 1.8 time = 600
* CHECK dout0_3 vdout0_3ck59 = 1.8 time = 600
* CHECK dout0_4 vdout0_4ck59 = 0 time = 600
* CHECK dout0_5 vdout0_5ck59 = 1.8 time = 600
* CHECK dout0_6 vdout0_6ck59 = 0 time = 600
* CHECK dout0_7 vdout0_7ck59 = 1.8 time = 600
* CHECK dout0_8 vdout0_8ck59 = 1.8 time = 600
* CHECK dout0_9 vdout0_9ck59 = 0 time = 600
* CHECK dout0_10 vdout0_10ck59 = 1.8 time = 600
* CHECK dout0_11 vdout0_11ck59 = 1.8 time = 600
* CHECK dout0_12 vdout0_12ck59 = 0 time = 600
* CHECK dout0_13 vdout0_13ck59 = 1.8 time = 600
* CHECK dout0_14 vdout0_14ck59 = 1.8 time = 600
* CHECK dout0_15 vdout0_15ck59 = 0 time = 600
* CHECK dout0_16 vdout0_16ck59 = 1.8 time = 600
* CHECK dout0_17 vdout0_17ck59 = 1.8 time = 600
* CHECK dout0_18 vdout0_18ck59 = 1.8 time = 600
* CHECK dout0_19 vdout0_19ck59 = 1.8 time = 600
* CHECK dout0_20 vdout0_20ck59 = 1.8 time = 600
* CHECK dout0_21 vdout0_21ck59 = 1.8 time = 600
* CHECK dout0_22 vdout0_22ck59 = 0 time = 600
* CHECK dout0_23 vdout0_23ck59 = 1.8 time = 600
* CHECK dout0_24 vdout0_24ck59 = 1.8 time = 600
* CHECK dout0_25 vdout0_25ck59 = 0 time = 600
* CHECK dout0_26 vdout0_26ck59 = 0 time = 600
* CHECK dout0_27 vdout0_27ck59 = 1.8 time = 600
* CHECK dout0_28 vdout0_28ck59 = 0 time = 600
* CHECK dout0_29 vdout0_29ck59 = 0 time = 600
* CHECK dout0_30 vdout0_30ck59 = 1.8 time = 600
* CHECK dout0_31 vdout0_31ck59 = 1.8 time = 600
* CHECK dout0_32 vdout0_32ck59 = 0 time = 600
* CHECK dout0_33 vdout0_33ck59 = 0 time = 600
* CHECK dout0_34 vdout0_34ck59 = 1.8 time = 600
* CHECK dout0_35 vdout0_35ck59 = 0 time = 600
* CHECK dout0_36 vdout0_36ck59 = 0 time = 600
* CHECK dout0_37 vdout0_37ck59 = 1.8 time = 600
* CHECK dout0_38 vdout0_38ck59 = 0 time = 600
* CHECK dout0_39 vdout0_39ck59 = 0 time = 600
* CHECK dout0_40 vdout0_40ck59 = 0 time = 600
* CHECK dout0_41 vdout0_41ck59 = 1.8 time = 600
* CHECK dout0_42 vdout0_42ck59 = 0 time = 600
* CHECK dout0_43 vdout0_43ck59 = 0 time = 600
* CHECK dout0_44 vdout0_44ck59 = 0 time = 600
* CHECK dout0_45 vdout0_45ck59 = 1.8 time = 600
* CHECK dout0_46 vdout0_46ck59 = 1.8 time = 600
* CHECK dout0_47 vdout0_47ck59 = 0 time = 600
* CHECK dout0_48 vdout0_48ck59 = 0 time = 600
* CHECK dout0_49 vdout0_49ck59 = 1.8 time = 600
* CHECK dout0_50 vdout0_50ck59 = 1.8 time = 600
* CHECK dout0_51 vdout0_51ck59 = 0 time = 600
* CHECK dout0_52 vdout0_52ck59 = 1.8 time = 600
* CHECK dout0_53 vdout0_53ck59 = 0 time = 600
* CHECK dout0_54 vdout0_54ck59 = 0 time = 600
* CHECK dout0_55 vdout0_55ck59 = 0 time = 600
* CHECK dout0_56 vdout0_56ck59 = 1.8 time = 600
* CHECK dout0_57 vdout0_57ck59 = 1.8 time = 600
* CHECK dout0_58 vdout0_58ck59 = 0 time = 600
* CHECK dout0_59 vdout0_59ck59 = 0 time = 600
* CHECK dout0_60 vdout0_60ck59 = 1.8 time = 600
* CHECK dout0_61 vdout0_61ck59 = 0 time = 600
* CHECK dout0_62 vdout0_62ck59 = 0 time = 600
* CHECK dout0_63 vdout0_63ck59 = 1.8 time = 600
* CHECK dout1_0 vdout1_0ck59 = 1.8 time = 600
* CHECK dout1_1 vdout1_1ck59 = 1.8 time = 600
* CHECK dout1_2 vdout1_2ck59 = 1.8 time = 600
* CHECK dout1_3 vdout1_3ck59 = 1.8 time = 600
* CHECK dout1_4 vdout1_4ck59 = 0 time = 600
* CHECK dout1_5 vdout1_5ck59 = 1.8 time = 600
* CHECK dout1_6 vdout1_6ck59 = 0 time = 600
* CHECK dout1_7 vdout1_7ck59 = 1.8 time = 600
* CHECK dout1_8 vdout1_8ck59 = 1.8 time = 600
* CHECK dout1_9 vdout1_9ck59 = 0 time = 600
* CHECK dout1_10 vdout1_10ck59 = 1.8 time = 600
* CHECK dout1_11 vdout1_11ck59 = 1.8 time = 600
* CHECK dout1_12 vdout1_12ck59 = 0 time = 600
* CHECK dout1_13 vdout1_13ck59 = 1.8 time = 600
* CHECK dout1_14 vdout1_14ck59 = 1.8 time = 600
* CHECK dout1_15 vdout1_15ck59 = 0 time = 600
* CHECK dout1_16 vdout1_16ck59 = 1.8 time = 600
* CHECK dout1_17 vdout1_17ck59 = 1.8 time = 600
* CHECK dout1_18 vdout1_18ck59 = 1.8 time = 600
* CHECK dout1_19 vdout1_19ck59 = 1.8 time = 600
* CHECK dout1_20 vdout1_20ck59 = 1.8 time = 600
* CHECK dout1_21 vdout1_21ck59 = 1.8 time = 600
* CHECK dout1_22 vdout1_22ck59 = 0 time = 600
* CHECK dout1_23 vdout1_23ck59 = 1.8 time = 600
* CHECK dout1_24 vdout1_24ck59 = 1.8 time = 600
* CHECK dout1_25 vdout1_25ck59 = 0 time = 600
* CHECK dout1_26 vdout1_26ck59 = 0 time = 600
* CHECK dout1_27 vdout1_27ck59 = 1.8 time = 600
* CHECK dout1_28 vdout1_28ck59 = 0 time = 600
* CHECK dout1_29 vdout1_29ck59 = 0 time = 600
* CHECK dout1_30 vdout1_30ck59 = 1.8 time = 600
* CHECK dout1_31 vdout1_31ck59 = 1.8 time = 600
* CHECK dout1_32 vdout1_32ck59 = 0 time = 600
* CHECK dout1_33 vdout1_33ck59 = 0 time = 600
* CHECK dout1_34 vdout1_34ck59 = 1.8 time = 600
* CHECK dout1_35 vdout1_35ck59 = 0 time = 600
* CHECK dout1_36 vdout1_36ck59 = 0 time = 600
* CHECK dout1_37 vdout1_37ck59 = 1.8 time = 600
* CHECK dout1_38 vdout1_38ck59 = 0 time = 600
* CHECK dout1_39 vdout1_39ck59 = 0 time = 600
* CHECK dout1_40 vdout1_40ck59 = 0 time = 600
* CHECK dout1_41 vdout1_41ck59 = 1.8 time = 600
* CHECK dout1_42 vdout1_42ck59 = 0 time = 600
* CHECK dout1_43 vdout1_43ck59 = 0 time = 600
* CHECK dout1_44 vdout1_44ck59 = 0 time = 600
* CHECK dout1_45 vdout1_45ck59 = 1.8 time = 600
* CHECK dout1_46 vdout1_46ck59 = 1.8 time = 600
* CHECK dout1_47 vdout1_47ck59 = 0 time = 600
* CHECK dout1_48 vdout1_48ck59 = 0 time = 600
* CHECK dout1_49 vdout1_49ck59 = 1.8 time = 600
* CHECK dout1_50 vdout1_50ck59 = 1.8 time = 600
* CHECK dout1_51 vdout1_51ck59 = 0 time = 600
* CHECK dout1_52 vdout1_52ck59 = 1.8 time = 600
* CHECK dout1_53 vdout1_53ck59 = 0 time = 600
* CHECK dout1_54 vdout1_54ck59 = 0 time = 600
* CHECK dout1_55 vdout1_55ck59 = 0 time = 600
* CHECK dout1_56 vdout1_56ck59 = 1.8 time = 600
* CHECK dout1_57 vdout1_57ck59 = 1.8 time = 600
* CHECK dout1_58 vdout1_58ck59 = 0 time = 600
* CHECK dout1_59 vdout1_59ck59 = 0 time = 600
* CHECK dout1_60 vdout1_60ck59 = 1.8 time = 600
* CHECK dout1_61 vdout1_61ck59 = 0 time = 600
* CHECK dout1_62 vdout1_62ck59 = 0 time = 600
* CHECK dout1_63 vdout1_63ck59 = 1.8 time = 600
* CHECK dout0_0 vdout0_0ck60 = 0 time = 610
* CHECK dout0_1 vdout0_1ck60 = 0 time = 610
* CHECK dout0_2 vdout0_2ck60 = 1.8 time = 610
* CHECK dout0_3 vdout0_3ck60 = 1.8 time = 610
* CHECK dout0_4 vdout0_4ck60 = 0 time = 610
* CHECK dout0_5 vdout0_5ck60 = 0 time = 610
* CHECK dout0_6 vdout0_6ck60 = 0 time = 610
* CHECK dout0_7 vdout0_7ck60 = 1.8 time = 610
* CHECK dout0_8 vdout0_8ck60 = 1.8 time = 610
* CHECK dout0_9 vdout0_9ck60 = 1.8 time = 610
* CHECK dout0_10 vdout0_10ck60 = 0 time = 610
* CHECK dout0_11 vdout0_11ck60 = 1.8 time = 610
* CHECK dout0_12 vdout0_12ck60 = 0 time = 610
* CHECK dout0_13 vdout0_13ck60 = 1.8 time = 610
* CHECK dout0_14 vdout0_14ck60 = 1.8 time = 610
* CHECK dout0_15 vdout0_15ck60 = 1.8 time = 610
* CHECK dout0_16 vdout0_16ck60 = 1.8 time = 610
* CHECK dout0_17 vdout0_17ck60 = 0 time = 610
* CHECK dout0_18 vdout0_18ck60 = 1.8 time = 610
* CHECK dout0_19 vdout0_19ck60 = 1.8 time = 610
* CHECK dout0_20 vdout0_20ck60 = 0 time = 610
* CHECK dout0_21 vdout0_21ck60 = 0 time = 610
* CHECK dout0_22 vdout0_22ck60 = 1.8 time = 610
* CHECK dout0_23 vdout0_23ck60 = 0 time = 610
* CHECK dout0_24 vdout0_24ck60 = 1.8 time = 610
* CHECK dout0_25 vdout0_25ck60 = 0 time = 610
* CHECK dout0_26 vdout0_26ck60 = 0 time = 610
* CHECK dout0_27 vdout0_27ck60 = 0 time = 610
* CHECK dout0_28 vdout0_28ck60 = 1.8 time = 610
* CHECK dout0_29 vdout0_29ck60 = 1.8 time = 610
* CHECK dout0_30 vdout0_30ck60 = 0 time = 610
* CHECK dout0_31 vdout0_31ck60 = 1.8 time = 610
* CHECK dout0_32 vdout0_32ck60 = 1.8 time = 610
* CHECK dout0_33 vdout0_33ck60 = 0 time = 610
* CHECK dout0_34 vdout0_34ck60 = 0 time = 610
* CHECK dout0_35 vdout0_35ck60 = 1.8 time = 610
* CHECK dout0_36 vdout0_36ck60 = 0 time = 610
* CHECK dout0_37 vdout0_37ck60 = 1.8 time = 610
* CHECK dout0_38 vdout0_38ck60 = 0 time = 610
* CHECK dout0_39 vdout0_39ck60 = 0 time = 610
* CHECK dout0_40 vdout0_40ck60 = 1.8 time = 610
* CHECK dout0_41 vdout0_41ck60 = 1.8 time = 610
* CHECK dout0_42 vdout0_42ck60 = 1.8 time = 610
* CHECK dout0_43 vdout0_43ck60 = 1.8 time = 610
* CHECK dout0_44 vdout0_44ck60 = 0 time = 610
* CHECK dout0_45 vdout0_45ck60 = 0 time = 610
* CHECK dout0_46 vdout0_46ck60 = 0 time = 610
* CHECK dout0_47 vdout0_47ck60 = 0 time = 610
* CHECK dout0_48 vdout0_48ck60 = 0 time = 610
* CHECK dout0_49 vdout0_49ck60 = 0 time = 610
* CHECK dout0_50 vdout0_50ck60 = 1.8 time = 610
* CHECK dout0_51 vdout0_51ck60 = 1.8 time = 610
* CHECK dout0_52 vdout0_52ck60 = 1.8 time = 610
* CHECK dout0_53 vdout0_53ck60 = 1.8 time = 610
* CHECK dout0_54 vdout0_54ck60 = 1.8 time = 610
* CHECK dout0_55 vdout0_55ck60 = 1.8 time = 610
* CHECK dout0_56 vdout0_56ck60 = 1.8 time = 610
* CHECK dout0_57 vdout0_57ck60 = 0 time = 610
* CHECK dout0_58 vdout0_58ck60 = 0 time = 610
* CHECK dout0_59 vdout0_59ck60 = 1.8 time = 610
* CHECK dout0_60 vdout0_60ck60 = 0 time = 610
* CHECK dout0_61 vdout0_61ck60 = 0 time = 610
* CHECK dout0_62 vdout0_62ck60 = 1.8 time = 610
* CHECK dout0_63 vdout0_63ck60 = 0 time = 610
* CHECK dout1_0 vdout1_0ck60 = 0 time = 610
* CHECK dout1_1 vdout1_1ck60 = 0 time = 610
* CHECK dout1_2 vdout1_2ck60 = 1.8 time = 610
* CHECK dout1_3 vdout1_3ck60 = 1.8 time = 610
* CHECK dout1_4 vdout1_4ck60 = 0 time = 610
* CHECK dout1_5 vdout1_5ck60 = 0 time = 610
* CHECK dout1_6 vdout1_6ck60 = 0 time = 610
* CHECK dout1_7 vdout1_7ck60 = 1.8 time = 610
* CHECK dout1_8 vdout1_8ck60 = 1.8 time = 610
* CHECK dout1_9 vdout1_9ck60 = 1.8 time = 610
* CHECK dout1_10 vdout1_10ck60 = 0 time = 610
* CHECK dout1_11 vdout1_11ck60 = 1.8 time = 610
* CHECK dout1_12 vdout1_12ck60 = 0 time = 610
* CHECK dout1_13 vdout1_13ck60 = 1.8 time = 610
* CHECK dout1_14 vdout1_14ck60 = 1.8 time = 610
* CHECK dout1_15 vdout1_15ck60 = 1.8 time = 610
* CHECK dout1_16 vdout1_16ck60 = 1.8 time = 610
* CHECK dout1_17 vdout1_17ck60 = 0 time = 610
* CHECK dout1_18 vdout1_18ck60 = 1.8 time = 610
* CHECK dout1_19 vdout1_19ck60 = 1.8 time = 610
* CHECK dout1_20 vdout1_20ck60 = 0 time = 610
* CHECK dout1_21 vdout1_21ck60 = 0 time = 610
* CHECK dout1_22 vdout1_22ck60 = 1.8 time = 610
* CHECK dout1_23 vdout1_23ck60 = 0 time = 610
* CHECK dout1_24 vdout1_24ck60 = 1.8 time = 610
* CHECK dout1_25 vdout1_25ck60 = 0 time = 610
* CHECK dout1_26 vdout1_26ck60 = 0 time = 610
* CHECK dout1_27 vdout1_27ck60 = 0 time = 610
* CHECK dout1_28 vdout1_28ck60 = 1.8 time = 610
* CHECK dout1_29 vdout1_29ck60 = 1.8 time = 610
* CHECK dout1_30 vdout1_30ck60 = 0 time = 610
* CHECK dout1_31 vdout1_31ck60 = 1.8 time = 610
* CHECK dout1_32 vdout1_32ck60 = 1.8 time = 610
* CHECK dout1_33 vdout1_33ck60 = 0 time = 610
* CHECK dout1_34 vdout1_34ck60 = 0 time = 610
* CHECK dout1_35 vdout1_35ck60 = 1.8 time = 610
* CHECK dout1_36 vdout1_36ck60 = 0 time = 610
* CHECK dout1_37 vdout1_37ck60 = 1.8 time = 610
* CHECK dout1_38 vdout1_38ck60 = 0 time = 610
* CHECK dout1_39 vdout1_39ck60 = 0 time = 610
* CHECK dout1_40 vdout1_40ck60 = 1.8 time = 610
* CHECK dout1_41 vdout1_41ck60 = 1.8 time = 610
* CHECK dout1_42 vdout1_42ck60 = 1.8 time = 610
* CHECK dout1_43 vdout1_43ck60 = 1.8 time = 610
* CHECK dout1_44 vdout1_44ck60 = 0 time = 610
* CHECK dout1_45 vdout1_45ck60 = 0 time = 610
* CHECK dout1_46 vdout1_46ck60 = 0 time = 610
* CHECK dout1_47 vdout1_47ck60 = 0 time = 610
* CHECK dout1_48 vdout1_48ck60 = 0 time = 610
* CHECK dout1_49 vdout1_49ck60 = 0 time = 610
* CHECK dout1_50 vdout1_50ck60 = 1.8 time = 610
* CHECK dout1_51 vdout1_51ck60 = 1.8 time = 610
* CHECK dout1_52 vdout1_52ck60 = 1.8 time = 610
* CHECK dout1_53 vdout1_53ck60 = 1.8 time = 610
* CHECK dout1_54 vdout1_54ck60 = 1.8 time = 610
* CHECK dout1_55 vdout1_55ck60 = 1.8 time = 610
* CHECK dout1_56 vdout1_56ck60 = 1.8 time = 610
* CHECK dout1_57 vdout1_57ck60 = 0 time = 610
* CHECK dout1_58 vdout1_58ck60 = 0 time = 610
* CHECK dout1_59 vdout1_59ck60 = 1.8 time = 610
* CHECK dout1_60 vdout1_60ck60 = 0 time = 610
* CHECK dout1_61 vdout1_61ck60 = 0 time = 610
* CHECK dout1_62 vdout1_62ck60 = 1.8 time = 610
* CHECK dout1_63 vdout1_63ck60 = 0 time = 610
* CHECK dout0_0 vdout0_0ck61 = 1.8 time = 620
* CHECK dout0_1 vdout0_1ck61 = 1.8 time = 620
* CHECK dout0_2 vdout0_2ck61 = 1.8 time = 620
* CHECK dout0_3 vdout0_3ck61 = 1.8 time = 620
* CHECK dout0_4 vdout0_4ck61 = 0 time = 620
* CHECK dout0_5 vdout0_5ck61 = 1.8 time = 620
* CHECK dout0_6 vdout0_6ck61 = 0 time = 620
* CHECK dout0_7 vdout0_7ck61 = 1.8 time = 620
* CHECK dout0_8 vdout0_8ck61 = 1.8 time = 620
* CHECK dout0_9 vdout0_9ck61 = 0 time = 620
* CHECK dout0_10 vdout0_10ck61 = 1.8 time = 620
* CHECK dout0_11 vdout0_11ck61 = 1.8 time = 620
* CHECK dout0_12 vdout0_12ck61 = 0 time = 620
* CHECK dout0_13 vdout0_13ck61 = 1.8 time = 620
* CHECK dout0_14 vdout0_14ck61 = 1.8 time = 620
* CHECK dout0_15 vdout0_15ck61 = 0 time = 620
* CHECK dout0_16 vdout0_16ck61 = 1.8 time = 620
* CHECK dout0_17 vdout0_17ck61 = 1.8 time = 620
* CHECK dout0_18 vdout0_18ck61 = 1.8 time = 620
* CHECK dout0_19 vdout0_19ck61 = 1.8 time = 620
* CHECK dout0_20 vdout0_20ck61 = 1.8 time = 620
* CHECK dout0_21 vdout0_21ck61 = 1.8 time = 620
* CHECK dout0_22 vdout0_22ck61 = 0 time = 620
* CHECK dout0_23 vdout0_23ck61 = 1.8 time = 620
* CHECK dout0_24 vdout0_24ck61 = 1.8 time = 620
* CHECK dout0_25 vdout0_25ck61 = 0 time = 620
* CHECK dout0_26 vdout0_26ck61 = 0 time = 620
* CHECK dout0_27 vdout0_27ck61 = 1.8 time = 620
* CHECK dout0_28 vdout0_28ck61 = 0 time = 620
* CHECK dout0_29 vdout0_29ck61 = 0 time = 620
* CHECK dout0_30 vdout0_30ck61 = 1.8 time = 620
* CHECK dout0_31 vdout0_31ck61 = 1.8 time = 620
* CHECK dout0_32 vdout0_32ck61 = 0 time = 620
* CHECK dout0_33 vdout0_33ck61 = 0 time = 620
* CHECK dout0_34 vdout0_34ck61 = 1.8 time = 620
* CHECK dout0_35 vdout0_35ck61 = 0 time = 620
* CHECK dout0_36 vdout0_36ck61 = 0 time = 620
* CHECK dout0_37 vdout0_37ck61 = 1.8 time = 620
* CHECK dout0_38 vdout0_38ck61 = 0 time = 620
* CHECK dout0_39 vdout0_39ck61 = 0 time = 620
* CHECK dout0_40 vdout0_40ck61 = 0 time = 620
* CHECK dout0_41 vdout0_41ck61 = 1.8 time = 620
* CHECK dout0_42 vdout0_42ck61 = 0 time = 620
* CHECK dout0_43 vdout0_43ck61 = 0 time = 620
* CHECK dout0_44 vdout0_44ck61 = 0 time = 620
* CHECK dout0_45 vdout0_45ck61 = 1.8 time = 620
* CHECK dout0_46 vdout0_46ck61 = 1.8 time = 620
* CHECK dout0_47 vdout0_47ck61 = 0 time = 620
* CHECK dout0_48 vdout0_48ck61 = 0 time = 620
* CHECK dout0_49 vdout0_49ck61 = 1.8 time = 620
* CHECK dout0_50 vdout0_50ck61 = 1.8 time = 620
* CHECK dout0_51 vdout0_51ck61 = 0 time = 620
* CHECK dout0_52 vdout0_52ck61 = 1.8 time = 620
* CHECK dout0_53 vdout0_53ck61 = 0 time = 620
* CHECK dout0_54 vdout0_54ck61 = 0 time = 620
* CHECK dout0_55 vdout0_55ck61 = 0 time = 620
* CHECK dout0_56 vdout0_56ck61 = 1.8 time = 620
* CHECK dout0_57 vdout0_57ck61 = 1.8 time = 620
* CHECK dout0_58 vdout0_58ck61 = 0 time = 620
* CHECK dout0_59 vdout0_59ck61 = 0 time = 620
* CHECK dout0_60 vdout0_60ck61 = 1.8 time = 620
* CHECK dout0_61 vdout0_61ck61 = 0 time = 620
* CHECK dout0_62 vdout0_62ck61 = 0 time = 620
* CHECK dout0_63 vdout0_63ck61 = 1.8 time = 620
* CHECK dout0_0 vdout0_0ck64 = 0 time = 650
* CHECK dout0_1 vdout0_1ck64 = 1.8 time = 650
* CHECK dout0_2 vdout0_2ck64 = 0 time = 650
* CHECK dout0_3 vdout0_3ck64 = 0 time = 650
* CHECK dout0_4 vdout0_4ck64 = 0 time = 650
* CHECK dout0_5 vdout0_5ck64 = 1.8 time = 650
* CHECK dout0_6 vdout0_6ck64 = 1.8 time = 650
* CHECK dout0_7 vdout0_7ck64 = 0 time = 650
* CHECK dout0_8 vdout0_8ck64 = 1.8 time = 650
* CHECK dout0_9 vdout0_9ck64 = 1.8 time = 650
* CHECK dout0_10 vdout0_10ck64 = 0 time = 650
* CHECK dout0_11 vdout0_11ck64 = 0 time = 650
* CHECK dout0_12 vdout0_12ck64 = 0 time = 650
* CHECK dout0_13 vdout0_13ck64 = 1.8 time = 650
* CHECK dout0_14 vdout0_14ck64 = 1.8 time = 650
* CHECK dout0_15 vdout0_15ck64 = 0 time = 650
* CHECK dout0_16 vdout0_16ck64 = 0 time = 650
* CHECK dout0_17 vdout0_17ck64 = 1.8 time = 650
* CHECK dout0_18 vdout0_18ck64 = 0 time = 650
* CHECK dout0_19 vdout0_19ck64 = 0 time = 650
* CHECK dout0_20 vdout0_20ck64 = 0 time = 650
* CHECK dout0_21 vdout0_21ck64 = 1.8 time = 650
* CHECK dout0_22 vdout0_22ck64 = 0 time = 650
* CHECK dout0_23 vdout0_23ck64 = 0 time = 650
* CHECK dout0_24 vdout0_24ck64 = 1.8 time = 650
* CHECK dout0_25 vdout0_25ck64 = 1.8 time = 650
* CHECK dout0_26 vdout0_26ck64 = 0 time = 650
* CHECK dout0_27 vdout0_27ck64 = 1.8 time = 650
* CHECK dout0_28 vdout0_28ck64 = 1.8 time = 650
* CHECK dout0_29 vdout0_29ck64 = 1.8 time = 650
* CHECK dout0_30 vdout0_30ck64 = 0 time = 650
* CHECK dout0_31 vdout0_31ck64 = 1.8 time = 650
* CHECK dout0_32 vdout0_32ck64 = 1.8 time = 650
* CHECK dout0_33 vdout0_33ck64 = 0 time = 650
* CHECK dout0_34 vdout0_34ck64 = 0 time = 650
* CHECK dout0_35 vdout0_35ck64 = 0 time = 650
* CHECK dout0_36 vdout0_36ck64 = 1.8 time = 650
* CHECK dout0_37 vdout0_37ck64 = 1.8 time = 650
* CHECK dout0_38 vdout0_38ck64 = 0 time = 650
* CHECK dout0_39 vdout0_39ck64 = 0 time = 650
* CHECK dout0_40 vdout0_40ck64 = 0 time = 650
* CHECK dout0_41 vdout0_41ck64 = 0 time = 650
* CHECK dout0_42 vdout0_42ck64 = 1.8 time = 650
* CHECK dout0_43 vdout0_43ck64 = 0 time = 650
* CHECK dout0_44 vdout0_44ck64 = 1.8 time = 650
* CHECK dout0_45 vdout0_45ck64 = 1.8 time = 650
* CHECK dout0_46 vdout0_46ck64 = 1.8 time = 650
* CHECK dout0_47 vdout0_47ck64 = 0 time = 650
* CHECK dout0_48 vdout0_48ck64 = 0 time = 650
* CHECK dout0_49 vdout0_49ck64 = 0 time = 650
* CHECK dout0_50 vdout0_50ck64 = 0 time = 650
* CHECK dout0_51 vdout0_51ck64 = 0 time = 650
* CHECK dout0_52 vdout0_52ck64 = 1.8 time = 650
* CHECK dout0_53 vdout0_53ck64 = 0 time = 650
* CHECK dout0_54 vdout0_54ck64 = 0 time = 650
* CHECK dout0_55 vdout0_55ck64 = 0 time = 650
* CHECK dout0_56 vdout0_56ck64 = 1.8 time = 650
* CHECK dout0_57 vdout0_57ck64 = 0 time = 650
* CHECK dout0_58 vdout0_58ck64 = 0 time = 650
* CHECK dout0_59 vdout0_59ck64 = 1.8 time = 650
* CHECK dout0_60 vdout0_60ck64 = 0 time = 650
* CHECK dout0_61 vdout0_61ck64 = 0 time = 650
* CHECK dout0_62 vdout0_62ck64 = 0 time = 650
* CHECK dout0_63 vdout0_63ck64 = 1.8 time = 650
* CHECK dout0_0 vdout0_0ck65 = 1.8 time = 660
* CHECK dout0_1 vdout0_1ck65 = 0 time = 660
* CHECK dout0_2 vdout0_2ck65 = 0 time = 660
* CHECK dout0_3 vdout0_3ck65 = 1.8 time = 660
* CHECK dout0_4 vdout0_4ck65 = 1.8 time = 660
* CHECK dout0_5 vdout0_5ck65 = 1.8 time = 660
* CHECK dout0_6 vdout0_6ck65 = 1.8 time = 660
* CHECK dout0_7 vdout0_7ck65 = 1.8 time = 660
* CHECK dout0_8 vdout0_8ck65 = 1.8 time = 660
* CHECK dout0_9 vdout0_9ck65 = 0 time = 660
* CHECK dout0_10 vdout0_10ck65 = 0 time = 660
* CHECK dout0_11 vdout0_11ck65 = 0 time = 660
* CHECK dout0_12 vdout0_12ck65 = 1.8 time = 660
* CHECK dout0_13 vdout0_13ck65 = 1.8 time = 660
* CHECK dout0_14 vdout0_14ck65 = 0 time = 660
* CHECK dout0_15 vdout0_15ck65 = 0 time = 660
* CHECK dout0_16 vdout0_16ck65 = 0 time = 660
* CHECK dout0_17 vdout0_17ck65 = 1.8 time = 660
* CHECK dout0_18 vdout0_18ck65 = 1.8 time = 660
* CHECK dout0_19 vdout0_19ck65 = 1.8 time = 660
* CHECK dout0_20 vdout0_20ck65 = 1.8 time = 660
* CHECK dout0_21 vdout0_21ck65 = 1.8 time = 660
* CHECK dout0_22 vdout0_22ck65 = 0 time = 660
* CHECK dout0_23 vdout0_23ck65 = 1.8 time = 660
* CHECK dout0_24 vdout0_24ck65 = 1.8 time = 660
* CHECK dout0_25 vdout0_25ck65 = 0 time = 660
* CHECK dout0_26 vdout0_26ck65 = 0 time = 660
* CHECK dout0_27 vdout0_27ck65 = 1.8 time = 660
* CHECK dout0_28 vdout0_28ck65 = 0 time = 660
* CHECK dout0_29 vdout0_29ck65 = 0 time = 660
* CHECK dout0_30 vdout0_30ck65 = 1.8 time = 660
* CHECK dout0_31 vdout0_31ck65 = 0 time = 660
* CHECK dout0_32 vdout0_32ck65 = 0 time = 660
* CHECK dout0_33 vdout0_33ck65 = 0 time = 660
* CHECK dout0_34 vdout0_34ck65 = 0 time = 660
* CHECK dout0_35 vdout0_35ck65 = 0 time = 660
* CHECK dout0_36 vdout0_36ck65 = 1.8 time = 660
* CHECK dout0_37 vdout0_37ck65 = 1.8 time = 660
* CHECK dout0_38 vdout0_38ck65 = 0 time = 660
* CHECK dout0_39 vdout0_39ck65 = 0 time = 660
* CHECK dout0_40 vdout0_40ck65 = 1.8 time = 660
* CHECK dout0_41 vdout0_41ck65 = 1.8 time = 660
* CHECK dout0_42 vdout0_42ck65 = 0 time = 660
* CHECK dout0_43 vdout0_43ck65 = 1.8 time = 660
* CHECK dout0_44 vdout0_44ck65 = 1.8 time = 660
* CHECK dout0_45 vdout0_45ck65 = 0 time = 660
* CHECK dout0_46 vdout0_46ck65 = 1.8 time = 660
* CHECK dout0_47 vdout0_47ck65 = 1.8 time = 660
* CHECK dout0_48 vdout0_48ck65 = 1.8 time = 660
* CHECK dout0_49 vdout0_49ck65 = 0 time = 660
* CHECK dout0_50 vdout0_50ck65 = 1.8 time = 660
* CHECK dout0_51 vdout0_51ck65 = 1.8 time = 660
* CHECK dout0_52 vdout0_52ck65 = 0 time = 660
* CHECK dout0_53 vdout0_53ck65 = 0 time = 660
* CHECK dout0_54 vdout0_54ck65 = 1.8 time = 660
* CHECK dout0_55 vdout0_55ck65 = 1.8 time = 660
* CHECK dout0_56 vdout0_56ck65 = 1.8 time = 660
* CHECK dout0_57 vdout0_57ck65 = 0 time = 660
* CHECK dout0_58 vdout0_58ck65 = 0 time = 660
* CHECK dout0_59 vdout0_59ck65 = 1.8 time = 660
* CHECK dout0_60 vdout0_60ck65 = 1.8 time = 660
* CHECK dout0_61 vdout0_61ck65 = 0 time = 660
* CHECK dout0_62 vdout0_62ck65 = 0 time = 660
* CHECK dout0_63 vdout0_63ck65 = 0 time = 660
* CHECK dout1_0 vdout1_0ck66 = 1.8 time = 670
* CHECK dout1_1 vdout1_1ck66 = 1.8 time = 670
* CHECK dout1_2 vdout1_2ck66 = 0 time = 670
* CHECK dout1_3 vdout1_3ck66 = 1.8 time = 670
* CHECK dout1_4 vdout1_4ck66 = 1.8 time = 670
* CHECK dout1_5 vdout1_5ck66 = 0 time = 670
* CHECK dout1_6 vdout1_6ck66 = 0 time = 670
* CHECK dout1_7 vdout1_7ck66 = 0 time = 670
* CHECK dout1_8 vdout1_8ck66 = 1.8 time = 670
* CHECK dout1_9 vdout1_9ck66 = 0 time = 670
* CHECK dout1_10 vdout1_10ck66 = 0 time = 670
* CHECK dout1_11 vdout1_11ck66 = 0 time = 670
* CHECK dout1_12 vdout1_12ck66 = 1.8 time = 670
* CHECK dout1_13 vdout1_13ck66 = 1.8 time = 670
* CHECK dout1_14 vdout1_14ck66 = 0 time = 670
* CHECK dout1_15 vdout1_15ck66 = 0 time = 670
* CHECK dout1_16 vdout1_16ck66 = 0 time = 670
* CHECK dout1_17 vdout1_17ck66 = 1.8 time = 670
* CHECK dout1_18 vdout1_18ck66 = 0 time = 670
* CHECK dout1_19 vdout1_19ck66 = 0 time = 670
* CHECK dout1_20 vdout1_20ck66 = 0 time = 670
* CHECK dout1_21 vdout1_21ck66 = 1.8 time = 670
* CHECK dout1_22 vdout1_22ck66 = 1.8 time = 670
* CHECK dout1_23 vdout1_23ck66 = 0 time = 670
* CHECK dout1_24 vdout1_24ck66 = 0 time = 670
* CHECK dout1_25 vdout1_25ck66 = 0 time = 670
* CHECK dout1_26 vdout1_26ck66 = 1.8 time = 670
* CHECK dout1_27 vdout1_27ck66 = 0 time = 670
* CHECK dout1_28 vdout1_28ck66 = 0 time = 670
* CHECK dout1_29 vdout1_29ck66 = 1.8 time = 670
* CHECK dout1_30 vdout1_30ck66 = 0 time = 670
* CHECK dout1_31 vdout1_31ck66 = 1.8 time = 670
* CHECK dout1_32 vdout1_32ck66 = 1.8 time = 670
* CHECK dout1_33 vdout1_33ck66 = 1.8 time = 670
* CHECK dout1_34 vdout1_34ck66 = 1.8 time = 670
* CHECK dout1_35 vdout1_35ck66 = 0 time = 670
* CHECK dout1_36 vdout1_36ck66 = 0 time = 670
* CHECK dout1_37 vdout1_37ck66 = 0 time = 670
* CHECK dout1_38 vdout1_38ck66 = 1.8 time = 670
* CHECK dout1_39 vdout1_39ck66 = 1.8 time = 670
* CHECK dout1_40 vdout1_40ck66 = 1.8 time = 670
* CHECK dout1_41 vdout1_41ck66 = 1.8 time = 670
* CHECK dout1_42 vdout1_42ck66 = 1.8 time = 670
* CHECK dout1_43 vdout1_43ck66 = 1.8 time = 670
* CHECK dout1_44 vdout1_44ck66 = 1.8 time = 670
* CHECK dout1_45 vdout1_45ck66 = 1.8 time = 670
* CHECK dout1_46 vdout1_46ck66 = 0 time = 670
* CHECK dout1_47 vdout1_47ck66 = 1.8 time = 670
* CHECK dout1_48 vdout1_48ck66 = 0 time = 670
* CHECK dout1_49 vdout1_49ck66 = 1.8 time = 670
* CHECK dout1_50 vdout1_50ck66 = 1.8 time = 670
* CHECK dout1_51 vdout1_51ck66 = 0 time = 670
* CHECK dout1_52 vdout1_52ck66 = 1.8 time = 670
* CHECK dout1_53 vdout1_53ck66 = 0 time = 670
* CHECK dout1_54 vdout1_54ck66 = 1.8 time = 670
* CHECK dout1_55 vdout1_55ck66 = 0 time = 670
* CHECK dout1_56 vdout1_56ck66 = 1.8 time = 670
* CHECK dout1_57 vdout1_57ck66 = 0 time = 670
* CHECK dout1_58 vdout1_58ck66 = 0 time = 670
* CHECK dout1_59 vdout1_59ck66 = 1.8 time = 670
* CHECK dout1_60 vdout1_60ck66 = 0 time = 670
* CHECK dout1_61 vdout1_61ck66 = 1.8 time = 670
* CHECK dout1_62 vdout1_62ck66 = 1.8 time = 670
* CHECK dout1_63 vdout1_63ck66 = 1.8 time = 670
* CHECK dout0_0 vdout0_0ck68 = 1.8 time = 690
* CHECK dout0_1 vdout0_1ck68 = 1.8 time = 690
* CHECK dout0_2 vdout0_2ck68 = 0 time = 690
* CHECK dout0_3 vdout0_3ck68 = 1.8 time = 690
* CHECK dout0_4 vdout0_4ck68 = 1.8 time = 690
* CHECK dout0_5 vdout0_5ck68 = 0 time = 690
* CHECK dout0_6 vdout0_6ck68 = 0 time = 690
* CHECK dout0_7 vdout0_7ck68 = 0 time = 690
* CHECK dout0_8 vdout0_8ck68 = 1.8 time = 690
* CHECK dout0_9 vdout0_9ck68 = 0 time = 690
* CHECK dout0_10 vdout0_10ck68 = 0 time = 690
* CHECK dout0_11 vdout0_11ck68 = 0 time = 690
* CHECK dout0_12 vdout0_12ck68 = 1.8 time = 690
* CHECK dout0_13 vdout0_13ck68 = 1.8 time = 690
* CHECK dout0_14 vdout0_14ck68 = 0 time = 690
* CHECK dout0_15 vdout0_15ck68 = 0 time = 690
* CHECK dout0_16 vdout0_16ck68 = 0 time = 690
* CHECK dout0_17 vdout0_17ck68 = 1.8 time = 690
* CHECK dout0_18 vdout0_18ck68 = 0 time = 690
* CHECK dout0_19 vdout0_19ck68 = 0 time = 690
* CHECK dout0_20 vdout0_20ck68 = 0 time = 690
* CHECK dout0_21 vdout0_21ck68 = 1.8 time = 690
* CHECK dout0_22 vdout0_22ck68 = 1.8 time = 690
* CHECK dout0_23 vdout0_23ck68 = 0 time = 690
* CHECK dout0_24 vdout0_24ck68 = 0 time = 690
* CHECK dout0_25 vdout0_25ck68 = 0 time = 690
* CHECK dout0_26 vdout0_26ck68 = 1.8 time = 690
* CHECK dout0_27 vdout0_27ck68 = 0 time = 690
* CHECK dout0_28 vdout0_28ck68 = 0 time = 690
* CHECK dout0_29 vdout0_29ck68 = 1.8 time = 690
* CHECK dout0_30 vdout0_30ck68 = 0 time = 690
* CHECK dout0_31 vdout0_31ck68 = 1.8 time = 690
* CHECK dout0_32 vdout0_32ck68 = 1.8 time = 690
* CHECK dout0_33 vdout0_33ck68 = 1.8 time = 690
* CHECK dout0_34 vdout0_34ck68 = 1.8 time = 690
* CHECK dout0_35 vdout0_35ck68 = 0 time = 690
* CHECK dout0_36 vdout0_36ck68 = 0 time = 690
* CHECK dout0_37 vdout0_37ck68 = 0 time = 690
* CHECK dout0_38 vdout0_38ck68 = 1.8 time = 690
* CHECK dout0_39 vdout0_39ck68 = 1.8 time = 690
* CHECK dout0_40 vdout0_40ck68 = 1.8 time = 690
* CHECK dout0_41 vdout0_41ck68 = 1.8 time = 690
* CHECK dout0_42 vdout0_42ck68 = 1.8 time = 690
* CHECK dout0_43 vdout0_43ck68 = 1.8 time = 690
* CHECK dout0_44 vdout0_44ck68 = 1.8 time = 690
* CHECK dout0_45 vdout0_45ck68 = 1.8 time = 690
* CHECK dout0_46 vdout0_46ck68 = 0 time = 690
* CHECK dout0_47 vdout0_47ck68 = 1.8 time = 690
* CHECK dout0_48 vdout0_48ck68 = 0 time = 690
* CHECK dout0_49 vdout0_49ck68 = 1.8 time = 690
* CHECK dout0_50 vdout0_50ck68 = 1.8 time = 690
* CHECK dout0_51 vdout0_51ck68 = 0 time = 690
* CHECK dout0_52 vdout0_52ck68 = 1.8 time = 690
* CHECK dout0_53 vdout0_53ck68 = 0 time = 690
* CHECK dout0_54 vdout0_54ck68 = 1.8 time = 690
* CHECK dout0_55 vdout0_55ck68 = 0 time = 690
* CHECK dout0_56 vdout0_56ck68 = 1.8 time = 690
* CHECK dout0_57 vdout0_57ck68 = 0 time = 690
* CHECK dout0_58 vdout0_58ck68 = 0 time = 690
* CHECK dout0_59 vdout0_59ck68 = 1.8 time = 690
* CHECK dout0_60 vdout0_60ck68 = 0 time = 690
* CHECK dout0_61 vdout0_61ck68 = 1.8 time = 690
* CHECK dout0_62 vdout0_62ck68 = 1.8 time = 690
* CHECK dout0_63 vdout0_63ck68 = 1.8 time = 690
* CHECK dout1_0 vdout1_0ck68 = 1.8 time = 690
* CHECK dout1_1 vdout1_1ck68 = 0 time = 690
* CHECK dout1_2 vdout1_2ck68 = 1.8 time = 690
* CHECK dout1_3 vdout1_3ck68 = 0 time = 690
* CHECK dout1_4 vdout1_4ck68 = 1.8 time = 690
* CHECK dout1_5 vdout1_5ck68 = 1.8 time = 690
* CHECK dout1_6 vdout1_6ck68 = 0 time = 690
* CHECK dout1_7 vdout1_7ck68 = 1.8 time = 690
* CHECK dout1_8 vdout1_8ck68 = 1.8 time = 690
* CHECK dout1_9 vdout1_9ck68 = 0 time = 690
* CHECK dout1_10 vdout1_10ck68 = 0 time = 690
* CHECK dout1_11 vdout1_11ck68 = 1.8 time = 690
* CHECK dout1_12 vdout1_12ck68 = 0 time = 690
* CHECK dout1_13 vdout1_13ck68 = 1.8 time = 690
* CHECK dout1_14 vdout1_14ck68 = 0 time = 690
* CHECK dout1_15 vdout1_15ck68 = 1.8 time = 690
* CHECK dout1_16 vdout1_16ck68 = 1.8 time = 690
* CHECK dout1_17 vdout1_17ck68 = 1.8 time = 690
* CHECK dout1_18 vdout1_18ck68 = 0 time = 690
* CHECK dout1_19 vdout1_19ck68 = 0 time = 690
* CHECK dout1_20 vdout1_20ck68 = 0 time = 690
* CHECK dout1_21 vdout1_21ck68 = 1.8 time = 690
* CHECK dout1_22 vdout1_22ck68 = 1.8 time = 690
* CHECK dout1_23 vdout1_23ck68 = 1.8 time = 690
* CHECK dout1_24 vdout1_24ck68 = 0 time = 690
* CHECK dout1_25 vdout1_25ck68 = 0 time = 690
* CHECK dout1_26 vdout1_26ck68 = 1.8 time = 690
* CHECK dout1_27 vdout1_27ck68 = 1.8 time = 690
* CHECK dout1_28 vdout1_28ck68 = 0 time = 690
* CHECK dout1_29 vdout1_29ck68 = 1.8 time = 690
* CHECK dout1_30 vdout1_30ck68 = 1.8 time = 690
* CHECK dout1_31 vdout1_31ck68 = 1.8 time = 690
* CHECK dout1_32 vdout1_32ck68 = 0 time = 690
* CHECK dout1_33 vdout1_33ck68 = 0 time = 690
* CHECK dout1_34 vdout1_34ck68 = 0 time = 690
* CHECK dout1_35 vdout1_35ck68 = 0 time = 690
* CHECK dout1_36 vdout1_36ck68 = 1.8 time = 690
* CHECK dout1_37 vdout1_37ck68 = 1.8 time = 690
* CHECK dout1_38 vdout1_38ck68 = 0 time = 690
* CHECK dout1_39 vdout1_39ck68 = 1.8 time = 690
* CHECK dout1_40 vdout1_40ck68 = 0 time = 690
* CHECK dout1_41 vdout1_41ck68 = 0 time = 690
* CHECK dout1_42 vdout1_42ck68 = 1.8 time = 690
* CHECK dout1_43 vdout1_43ck68 = 0 time = 690
* CHECK dout1_44 vdout1_44ck68 = 0 time = 690
* CHECK dout1_45 vdout1_45ck68 = 1.8 time = 690
* CHECK dout1_46 vdout1_46ck68 = 1.8 time = 690
* CHECK dout1_47 vdout1_47ck68 = 1.8 time = 690
* CHECK dout1_48 vdout1_48ck68 = 1.8 time = 690
* CHECK dout1_49 vdout1_49ck68 = 1.8 time = 690
* CHECK dout1_50 vdout1_50ck68 = 0 time = 690
* CHECK dout1_51 vdout1_51ck68 = 0 time = 690
* CHECK dout1_52 vdout1_52ck68 = 1.8 time = 690
* CHECK dout1_53 vdout1_53ck68 = 0 time = 690
* CHECK dout1_54 vdout1_54ck68 = 0 time = 690
* CHECK dout1_55 vdout1_55ck68 = 0 time = 690
* CHECK dout1_56 vdout1_56ck68 = 0 time = 690
* CHECK dout1_57 vdout1_57ck68 = 1.8 time = 690
* CHECK dout1_58 vdout1_58ck68 = 1.8 time = 690
* CHECK dout1_59 vdout1_59ck68 = 0 time = 690
* CHECK dout1_60 vdout1_60ck68 = 0 time = 690
* CHECK dout1_61 vdout1_61ck68 = 0 time = 690
* CHECK dout1_62 vdout1_62ck68 = 0 time = 690
* CHECK dout1_63 vdout1_63ck68 = 1.8 time = 690
* CHECK dout1_0 vdout1_0ck69 = 1.8 time = 700
* CHECK dout1_1 vdout1_1ck69 = 0 time = 700
* CHECK dout1_2 vdout1_2ck69 = 1.8 time = 700
* CHECK dout1_3 vdout1_3ck69 = 1.8 time = 700
* CHECK dout1_4 vdout1_4ck69 = 0 time = 700
* CHECK dout1_5 vdout1_5ck69 = 1.8 time = 700
* CHECK dout1_6 vdout1_6ck69 = 0 time = 700
* CHECK dout1_7 vdout1_7ck69 = 1.8 time = 700
* CHECK dout1_8 vdout1_8ck69 = 0 time = 700
* CHECK dout1_9 vdout1_9ck69 = 1.8 time = 700
* CHECK dout1_10 vdout1_10ck69 = 0 time = 700
* CHECK dout1_11 vdout1_11ck69 = 1.8 time = 700
* CHECK dout1_12 vdout1_12ck69 = 1.8 time = 700
* CHECK dout1_13 vdout1_13ck69 = 0 time = 700
* CHECK dout1_14 vdout1_14ck69 = 1.8 time = 700
* CHECK dout1_15 vdout1_15ck69 = 1.8 time = 700
* CHECK dout1_16 vdout1_16ck69 = 0 time = 700
* CHECK dout1_17 vdout1_17ck69 = 0 time = 700
* CHECK dout1_18 vdout1_18ck69 = 1.8 time = 700
* CHECK dout1_19 vdout1_19ck69 = 1.8 time = 700
* CHECK dout1_20 vdout1_20ck69 = 0 time = 700
* CHECK dout1_21 vdout1_21ck69 = 1.8 time = 700
* CHECK dout1_22 vdout1_22ck69 = 0 time = 700
* CHECK dout1_23 vdout1_23ck69 = 0 time = 700
* CHECK dout1_24 vdout1_24ck69 = 1.8 time = 700
* CHECK dout1_25 vdout1_25ck69 = 0 time = 700
* CHECK dout1_26 vdout1_26ck69 = 1.8 time = 700
* CHECK dout1_27 vdout1_27ck69 = 0 time = 700
* CHECK dout1_28 vdout1_28ck69 = 1.8 time = 700
* CHECK dout1_29 vdout1_29ck69 = 1.8 time = 700
* CHECK dout1_30 vdout1_30ck69 = 1.8 time = 700
* CHECK dout1_31 vdout1_31ck69 = 1.8 time = 700
* CHECK dout1_32 vdout1_32ck69 = 0 time = 700
* CHECK dout1_33 vdout1_33ck69 = 0 time = 700
* CHECK dout1_34 vdout1_34ck69 = 0 time = 700
* CHECK dout1_35 vdout1_35ck69 = 1.8 time = 700
* CHECK dout1_36 vdout1_36ck69 = 1.8 time = 700
* CHECK dout1_37 vdout1_37ck69 = 0 time = 700
* CHECK dout1_38 vdout1_38ck69 = 0 time = 700
* CHECK dout1_39 vdout1_39ck69 = 1.8 time = 700
* CHECK dout1_40 vdout1_40ck69 = 1.8 time = 700
* CHECK dout1_41 vdout1_41ck69 = 1.8 time = 700
* CHECK dout1_42 vdout1_42ck69 = 0 time = 700
* CHECK dout1_43 vdout1_43ck69 = 0 time = 700
* CHECK dout1_44 vdout1_44ck69 = 1.8 time = 700
* CHECK dout1_45 vdout1_45ck69 = 1.8 time = 700
* CHECK dout1_46 vdout1_46ck69 = 0 time = 700
* CHECK dout1_47 vdout1_47ck69 = 0 time = 700
* CHECK dout1_48 vdout1_48ck69 = 0 time = 700
* CHECK dout1_49 vdout1_49ck69 = 1.8 time = 700
* CHECK dout1_50 vdout1_50ck69 = 1.8 time = 700
* CHECK dout1_51 vdout1_51ck69 = 1.8 time = 700
* CHECK dout1_52 vdout1_52ck69 = 0 time = 700
* CHECK dout1_53 vdout1_53ck69 = 0 time = 700
* CHECK dout1_54 vdout1_54ck69 = 0 time = 700
* CHECK dout1_55 vdout1_55ck69 = 0 time = 700
* CHECK dout1_56 vdout1_56ck69 = 1.8 time = 700
* CHECK dout1_57 vdout1_57ck69 = 0 time = 700
* CHECK dout1_58 vdout1_58ck69 = 1.8 time = 700
* CHECK dout1_59 vdout1_59ck69 = 0 time = 700
* CHECK dout1_60 vdout1_60ck69 = 0 time = 700
* CHECK dout1_61 vdout1_61ck69 = 1.8 time = 700
* CHECK dout1_62 vdout1_62ck69 = 1.8 time = 700
* CHECK dout1_63 vdout1_63ck69 = 1.8 time = 700
* CHECK dout0_0 vdout0_0ck70 = 1.8 time = 710
* CHECK dout0_1 vdout0_1ck70 = 0 time = 710
* CHECK dout0_2 vdout0_2ck70 = 0 time = 710
* CHECK dout0_3 vdout0_3ck70 = 1.8 time = 710
* CHECK dout0_4 vdout0_4ck70 = 1.8 time = 710
* CHECK dout0_5 vdout0_5ck70 = 1.8 time = 710
* CHECK dout0_6 vdout0_6ck70 = 1.8 time = 710
* CHECK dout0_7 vdout0_7ck70 = 1.8 time = 710
* CHECK dout0_8 vdout0_8ck70 = 1.8 time = 710
* CHECK dout0_9 vdout0_9ck70 = 0 time = 710
* CHECK dout0_10 vdout0_10ck70 = 0 time = 710
* CHECK dout0_11 vdout0_11ck70 = 0 time = 710
* CHECK dout0_12 vdout0_12ck70 = 1.8 time = 710
* CHECK dout0_13 vdout0_13ck70 = 1.8 time = 710
* CHECK dout0_14 vdout0_14ck70 = 0 time = 710
* CHECK dout0_15 vdout0_15ck70 = 0 time = 710
* CHECK dout0_16 vdout0_16ck70 = 0 time = 710
* CHECK dout0_17 vdout0_17ck70 = 1.8 time = 710
* CHECK dout0_18 vdout0_18ck70 = 1.8 time = 710
* CHECK dout0_19 vdout0_19ck70 = 1.8 time = 710
* CHECK dout0_20 vdout0_20ck70 = 1.8 time = 710
* CHECK dout0_21 vdout0_21ck70 = 1.8 time = 710
* CHECK dout0_22 vdout0_22ck70 = 0 time = 710
* CHECK dout0_23 vdout0_23ck70 = 1.8 time = 710
* CHECK dout0_24 vdout0_24ck70 = 1.8 time = 710
* CHECK dout0_25 vdout0_25ck70 = 0 time = 710
* CHECK dout0_26 vdout0_26ck70 = 0 time = 710
* CHECK dout0_27 vdout0_27ck70 = 1.8 time = 710
* CHECK dout0_28 vdout0_28ck70 = 0 time = 710
* CHECK dout0_29 vdout0_29ck70 = 0 time = 710
* CHECK dout0_30 vdout0_30ck70 = 1.8 time = 710
* CHECK dout0_31 vdout0_31ck70 = 0 time = 710
* CHECK dout0_32 vdout0_32ck70 = 0 time = 710
* CHECK dout0_33 vdout0_33ck70 = 0 time = 710
* CHECK dout0_34 vdout0_34ck70 = 0 time = 710
* CHECK dout0_35 vdout0_35ck70 = 0 time = 710
* CHECK dout0_36 vdout0_36ck70 = 1.8 time = 710
* CHECK dout0_37 vdout0_37ck70 = 1.8 time = 710
* CHECK dout0_38 vdout0_38ck70 = 0 time = 710
* CHECK dout0_39 vdout0_39ck70 = 0 time = 710
* CHECK dout0_40 vdout0_40ck70 = 1.8 time = 710
* CHECK dout0_41 vdout0_41ck70 = 1.8 time = 710
* CHECK dout0_42 vdout0_42ck70 = 0 time = 710
* CHECK dout0_43 vdout0_43ck70 = 1.8 time = 710
* CHECK dout0_44 vdout0_44ck70 = 1.8 time = 710
* CHECK dout0_45 vdout0_45ck70 = 0 time = 710
* CHECK dout0_46 vdout0_46ck70 = 1.8 time = 710
* CHECK dout0_47 vdout0_47ck70 = 1.8 time = 710
* CHECK dout0_48 vdout0_48ck70 = 1.8 time = 710
* CHECK dout0_49 vdout0_49ck70 = 0 time = 710
* CHECK dout0_50 vdout0_50ck70 = 1.8 time = 710
* CHECK dout0_51 vdout0_51ck70 = 1.8 time = 710
* CHECK dout0_52 vdout0_52ck70 = 0 time = 710
* CHECK dout0_53 vdout0_53ck70 = 0 time = 710
* CHECK dout0_54 vdout0_54ck70 = 1.8 time = 710
* CHECK dout0_55 vdout0_55ck70 = 1.8 time = 710
* CHECK dout0_56 vdout0_56ck70 = 1.8 time = 710
* CHECK dout0_57 vdout0_57ck70 = 0 time = 710
* CHECK dout0_58 vdout0_58ck70 = 0 time = 710
* CHECK dout0_59 vdout0_59ck70 = 1.8 time = 710
* CHECK dout0_60 vdout0_60ck70 = 1.8 time = 710
* CHECK dout0_61 vdout0_61ck70 = 0 time = 710
* CHECK dout0_62 vdout0_62ck70 = 0 time = 710
* CHECK dout0_63 vdout0_63ck70 = 0 time = 710
* CHECK dout1_0 vdout1_0ck70 = 1.8 time = 710
* CHECK dout1_1 vdout1_1ck70 = 0 time = 710
* CHECK dout1_2 vdout1_2ck70 = 0 time = 710
* CHECK dout1_3 vdout1_3ck70 = 1.8 time = 710
* CHECK dout1_4 vdout1_4ck70 = 1.8 time = 710
* CHECK dout1_5 vdout1_5ck70 = 1.8 time = 710
* CHECK dout1_6 vdout1_6ck70 = 1.8 time = 710
* CHECK dout1_7 vdout1_7ck70 = 1.8 time = 710
* CHECK dout1_8 vdout1_8ck70 = 1.8 time = 710
* CHECK dout1_9 vdout1_9ck70 = 0 time = 710
* CHECK dout1_10 vdout1_10ck70 = 0 time = 710
* CHECK dout1_11 vdout1_11ck70 = 0 time = 710
* CHECK dout1_12 vdout1_12ck70 = 1.8 time = 710
* CHECK dout1_13 vdout1_13ck70 = 1.8 time = 710
* CHECK dout1_14 vdout1_14ck70 = 0 time = 710
* CHECK dout1_15 vdout1_15ck70 = 0 time = 710
* CHECK dout1_16 vdout1_16ck70 = 0 time = 710
* CHECK dout1_17 vdout1_17ck70 = 1.8 time = 710
* CHECK dout1_18 vdout1_18ck70 = 1.8 time = 710
* CHECK dout1_19 vdout1_19ck70 = 1.8 time = 710
* CHECK dout1_20 vdout1_20ck70 = 1.8 time = 710
* CHECK dout1_21 vdout1_21ck70 = 1.8 time = 710
* CHECK dout1_22 vdout1_22ck70 = 0 time = 710
* CHECK dout1_23 vdout1_23ck70 = 1.8 time = 710
* CHECK dout1_24 vdout1_24ck70 = 1.8 time = 710
* CHECK dout1_25 vdout1_25ck70 = 0 time = 710
* CHECK dout1_26 vdout1_26ck70 = 0 time = 710
* CHECK dout1_27 vdout1_27ck70 = 1.8 time = 710
* CHECK dout1_28 vdout1_28ck70 = 0 time = 710
* CHECK dout1_29 vdout1_29ck70 = 0 time = 710
* CHECK dout1_30 vdout1_30ck70 = 1.8 time = 710
* CHECK dout1_31 vdout1_31ck70 = 0 time = 710
* CHECK dout1_32 vdout1_32ck70 = 0 time = 710
* CHECK dout1_33 vdout1_33ck70 = 0 time = 710
* CHECK dout1_34 vdout1_34ck70 = 0 time = 710
* CHECK dout1_35 vdout1_35ck70 = 0 time = 710
* CHECK dout1_36 vdout1_36ck70 = 1.8 time = 710
* CHECK dout1_37 vdout1_37ck70 = 1.8 time = 710
* CHECK dout1_38 vdout1_38ck70 = 0 time = 710
* CHECK dout1_39 vdout1_39ck70 = 0 time = 710
* CHECK dout1_40 vdout1_40ck70 = 1.8 time = 710
* CHECK dout1_41 vdout1_41ck70 = 1.8 time = 710
* CHECK dout1_42 vdout1_42ck70 = 0 time = 710
* CHECK dout1_43 vdout1_43ck70 = 1.8 time = 710
* CHECK dout1_44 vdout1_44ck70 = 1.8 time = 710
* CHECK dout1_45 vdout1_45ck70 = 0 time = 710
* CHECK dout1_46 vdout1_46ck70 = 1.8 time = 710
* CHECK dout1_47 vdout1_47ck70 = 1.8 time = 710
* CHECK dout1_48 vdout1_48ck70 = 1.8 time = 710
* CHECK dout1_49 vdout1_49ck70 = 0 time = 710
* CHECK dout1_50 vdout1_50ck70 = 1.8 time = 710
* CHECK dout1_51 vdout1_51ck70 = 1.8 time = 710
* CHECK dout1_52 vdout1_52ck70 = 0 time = 710
* CHECK dout1_53 vdout1_53ck70 = 0 time = 710
* CHECK dout1_54 vdout1_54ck70 = 1.8 time = 710
* CHECK dout1_55 vdout1_55ck70 = 1.8 time = 710
* CHECK dout1_56 vdout1_56ck70 = 1.8 time = 710
* CHECK dout1_57 vdout1_57ck70 = 0 time = 710
* CHECK dout1_58 vdout1_58ck70 = 0 time = 710
* CHECK dout1_59 vdout1_59ck70 = 1.8 time = 710
* CHECK dout1_60 vdout1_60ck70 = 1.8 time = 710
* CHECK dout1_61 vdout1_61ck70 = 0 time = 710
* CHECK dout1_62 vdout1_62ck70 = 0 time = 710
* CHECK dout1_63 vdout1_63ck70 = 0 time = 710
* CHECK dout1_0 vdout1_0ck71 = 1.8 time = 720
* CHECK dout1_1 vdout1_1ck71 = 0 time = 720
* CHECK dout1_2 vdout1_2ck71 = 1.8 time = 720
* CHECK dout1_3 vdout1_3ck71 = 1.8 time = 720
* CHECK dout1_4 vdout1_4ck71 = 0 time = 720
* CHECK dout1_5 vdout1_5ck71 = 1.8 time = 720
* CHECK dout1_6 vdout1_6ck71 = 0 time = 720
* CHECK dout1_7 vdout1_7ck71 = 1.8 time = 720
* CHECK dout1_8 vdout1_8ck71 = 0 time = 720
* CHECK dout1_9 vdout1_9ck71 = 1.8 time = 720
* CHECK dout1_10 vdout1_10ck71 = 0 time = 720
* CHECK dout1_11 vdout1_11ck71 = 1.8 time = 720
* CHECK dout1_12 vdout1_12ck71 = 1.8 time = 720
* CHECK dout1_13 vdout1_13ck71 = 0 time = 720
* CHECK dout1_14 vdout1_14ck71 = 1.8 time = 720
* CHECK dout1_15 vdout1_15ck71 = 1.8 time = 720
* CHECK dout1_16 vdout1_16ck71 = 0 time = 720
* CHECK dout1_17 vdout1_17ck71 = 0 time = 720
* CHECK dout1_18 vdout1_18ck71 = 1.8 time = 720
* CHECK dout1_19 vdout1_19ck71 = 1.8 time = 720
* CHECK dout1_20 vdout1_20ck71 = 0 time = 720
* CHECK dout1_21 vdout1_21ck71 = 1.8 time = 720
* CHECK dout1_22 vdout1_22ck71 = 0 time = 720
* CHECK dout1_23 vdout1_23ck71 = 0 time = 720
* CHECK dout1_24 vdout1_24ck71 = 1.8 time = 720
* CHECK dout1_25 vdout1_25ck71 = 0 time = 720
* CHECK dout1_26 vdout1_26ck71 = 1.8 time = 720
* CHECK dout1_27 vdout1_27ck71 = 0 time = 720
* CHECK dout1_28 vdout1_28ck71 = 1.8 time = 720
* CHECK dout1_29 vdout1_29ck71 = 1.8 time = 720
* CHECK dout1_30 vdout1_30ck71 = 1.8 time = 720
* CHECK dout1_31 vdout1_31ck71 = 1.8 time = 720
* CHECK dout1_32 vdout1_32ck71 = 0 time = 720
* CHECK dout1_33 vdout1_33ck71 = 0 time = 720
* CHECK dout1_34 vdout1_34ck71 = 0 time = 720
* CHECK dout1_35 vdout1_35ck71 = 1.8 time = 720
* CHECK dout1_36 vdout1_36ck71 = 1.8 time = 720
* CHECK dout1_37 vdout1_37ck71 = 0 time = 720
* CHECK dout1_38 vdout1_38ck71 = 0 time = 720
* CHECK dout1_39 vdout1_39ck71 = 1.8 time = 720
* CHECK dout1_40 vdout1_40ck71 = 1.8 time = 720
* CHECK dout1_41 vdout1_41ck71 = 1.8 time = 720
* CHECK dout1_42 vdout1_42ck71 = 0 time = 720
* CHECK dout1_43 vdout1_43ck71 = 0 time = 720
* CHECK dout1_44 vdout1_44ck71 = 1.8 time = 720
* CHECK dout1_45 vdout1_45ck71 = 1.8 time = 720
* CHECK dout1_46 vdout1_46ck71 = 0 time = 720
* CHECK dout1_47 vdout1_47ck71 = 0 time = 720
* CHECK dout1_48 vdout1_48ck71 = 0 time = 720
* CHECK dout1_49 vdout1_49ck71 = 1.8 time = 720
* CHECK dout1_50 vdout1_50ck71 = 1.8 time = 720
* CHECK dout1_51 vdout1_51ck71 = 1.8 time = 720
* CHECK dout1_52 vdout1_52ck71 = 0 time = 720
* CHECK dout1_53 vdout1_53ck71 = 0 time = 720
* CHECK dout1_54 vdout1_54ck71 = 0 time = 720
* CHECK dout1_55 vdout1_55ck71 = 0 time = 720
* CHECK dout1_56 vdout1_56ck71 = 1.8 time = 720
* CHECK dout1_57 vdout1_57ck71 = 0 time = 720
* CHECK dout1_58 vdout1_58ck71 = 1.8 time = 720
* CHECK dout1_59 vdout1_59ck71 = 0 time = 720
* CHECK dout1_60 vdout1_60ck71 = 0 time = 720
* CHECK dout1_61 vdout1_61ck71 = 1.8 time = 720
* CHECK dout1_62 vdout1_62ck71 = 1.8 time = 720
* CHECK dout1_63 vdout1_63ck71 = 1.8 time = 720
* CHECK dout0_0 vdout0_0ck72 = 1.8 time = 730
* CHECK dout0_1 vdout0_1ck72 = 0 time = 730
* CHECK dout0_2 vdout0_2ck72 = 0 time = 730
* CHECK dout0_3 vdout0_3ck72 = 1.8 time = 730
* CHECK dout0_4 vdout0_4ck72 = 1.8 time = 730
* CHECK dout0_5 vdout0_5ck72 = 1.8 time = 730
* CHECK dout0_6 vdout0_6ck72 = 1.8 time = 730
* CHECK dout0_7 vdout0_7ck72 = 1.8 time = 730
* CHECK dout0_8 vdout0_8ck72 = 1.8 time = 730
* CHECK dout0_9 vdout0_9ck72 = 0 time = 730
* CHECK dout0_10 vdout0_10ck72 = 0 time = 730
* CHECK dout0_11 vdout0_11ck72 = 0 time = 730
* CHECK dout0_12 vdout0_12ck72 = 1.8 time = 730
* CHECK dout0_13 vdout0_13ck72 = 1.8 time = 730
* CHECK dout0_14 vdout0_14ck72 = 0 time = 730
* CHECK dout0_15 vdout0_15ck72 = 0 time = 730
* CHECK dout0_16 vdout0_16ck72 = 0 time = 730
* CHECK dout0_17 vdout0_17ck72 = 1.8 time = 730
* CHECK dout0_18 vdout0_18ck72 = 1.8 time = 730
* CHECK dout0_19 vdout0_19ck72 = 1.8 time = 730
* CHECK dout0_20 vdout0_20ck72 = 1.8 time = 730
* CHECK dout0_21 vdout0_21ck72 = 1.8 time = 730
* CHECK dout0_22 vdout0_22ck72 = 0 time = 730
* CHECK dout0_23 vdout0_23ck72 = 1.8 time = 730
* CHECK dout0_24 vdout0_24ck72 = 1.8 time = 730
* CHECK dout0_25 vdout0_25ck72 = 0 time = 730
* CHECK dout0_26 vdout0_26ck72 = 0 time = 730
* CHECK dout0_27 vdout0_27ck72 = 1.8 time = 730
* CHECK dout0_28 vdout0_28ck72 = 0 time = 730
* CHECK dout0_29 vdout0_29ck72 = 0 time = 730
* CHECK dout0_30 vdout0_30ck72 = 1.8 time = 730
* CHECK dout0_31 vdout0_31ck72 = 0 time = 730
* CHECK dout0_32 vdout0_32ck72 = 0 time = 730
* CHECK dout0_33 vdout0_33ck72 = 0 time = 730
* CHECK dout0_34 vdout0_34ck72 = 0 time = 730
* CHECK dout0_35 vdout0_35ck72 = 0 time = 730
* CHECK dout0_36 vdout0_36ck72 = 1.8 time = 730
* CHECK dout0_37 vdout0_37ck72 = 1.8 time = 730
* CHECK dout0_38 vdout0_38ck72 = 0 time = 730
* CHECK dout0_39 vdout0_39ck72 = 0 time = 730
* CHECK dout0_40 vdout0_40ck72 = 1.8 time = 730
* CHECK dout0_41 vdout0_41ck72 = 1.8 time = 730
* CHECK dout0_42 vdout0_42ck72 = 0 time = 730
* CHECK dout0_43 vdout0_43ck72 = 1.8 time = 730
* CHECK dout0_44 vdout0_44ck72 = 1.8 time = 730
* CHECK dout0_45 vdout0_45ck72 = 0 time = 730
* CHECK dout0_46 vdout0_46ck72 = 1.8 time = 730
* CHECK dout0_47 vdout0_47ck72 = 1.8 time = 730
* CHECK dout0_48 vdout0_48ck72 = 1.8 time = 730
* CHECK dout0_49 vdout0_49ck72 = 0 time = 730
* CHECK dout0_50 vdout0_50ck72 = 1.8 time = 730
* CHECK dout0_51 vdout0_51ck72 = 1.8 time = 730
* CHECK dout0_52 vdout0_52ck72 = 0 time = 730
* CHECK dout0_53 vdout0_53ck72 = 0 time = 730
* CHECK dout0_54 vdout0_54ck72 = 1.8 time = 730
* CHECK dout0_55 vdout0_55ck72 = 1.8 time = 730
* CHECK dout0_56 vdout0_56ck72 = 1.8 time = 730
* CHECK dout0_57 vdout0_57ck72 = 0 time = 730
* CHECK dout0_58 vdout0_58ck72 = 0 time = 730
* CHECK dout0_59 vdout0_59ck72 = 1.8 time = 730
* CHECK dout0_60 vdout0_60ck72 = 1.8 time = 730
* CHECK dout0_61 vdout0_61ck72 = 0 time = 730
* CHECK dout0_62 vdout0_62ck72 = 0 time = 730
* CHECK dout0_63 vdout0_63ck72 = 0 time = 730
* CHECK dout0_0 vdout0_0ck73 = 1.8 time = 740
* CHECK dout0_1 vdout0_1ck73 = 0 time = 740
* CHECK dout0_2 vdout0_2ck73 = 0 time = 740
* CHECK dout0_3 vdout0_3ck73 = 1.8 time = 740
* CHECK dout0_4 vdout0_4ck73 = 1.8 time = 740
* CHECK dout0_5 vdout0_5ck73 = 1.8 time = 740
* CHECK dout0_6 vdout0_6ck73 = 1.8 time = 740
* CHECK dout0_7 vdout0_7ck73 = 1.8 time = 740
* CHECK dout0_8 vdout0_8ck73 = 1.8 time = 740
* CHECK dout0_9 vdout0_9ck73 = 0 time = 740
* CHECK dout0_10 vdout0_10ck73 = 0 time = 740
* CHECK dout0_11 vdout0_11ck73 = 0 time = 740
* CHECK dout0_12 vdout0_12ck73 = 1.8 time = 740
* CHECK dout0_13 vdout0_13ck73 = 1.8 time = 740
* CHECK dout0_14 vdout0_14ck73 = 0 time = 740
* CHECK dout0_15 vdout0_15ck73 = 0 time = 740
* CHECK dout0_16 vdout0_16ck73 = 0 time = 740
* CHECK dout0_17 vdout0_17ck73 = 1.8 time = 740
* CHECK dout0_18 vdout0_18ck73 = 1.8 time = 740
* CHECK dout0_19 vdout0_19ck73 = 1.8 time = 740
* CHECK dout0_20 vdout0_20ck73 = 1.8 time = 740
* CHECK dout0_21 vdout0_21ck73 = 1.8 time = 740
* CHECK dout0_22 vdout0_22ck73 = 0 time = 740
* CHECK dout0_23 vdout0_23ck73 = 1.8 time = 740
* CHECK dout0_24 vdout0_24ck73 = 1.8 time = 740
* CHECK dout0_25 vdout0_25ck73 = 0 time = 740
* CHECK dout0_26 vdout0_26ck73 = 0 time = 740
* CHECK dout0_27 vdout0_27ck73 = 1.8 time = 740
* CHECK dout0_28 vdout0_28ck73 = 0 time = 740
* CHECK dout0_29 vdout0_29ck73 = 0 time = 740
* CHECK dout0_30 vdout0_30ck73 = 1.8 time = 740
* CHECK dout0_31 vdout0_31ck73 = 0 time = 740
* CHECK dout0_32 vdout0_32ck73 = 0 time = 740
* CHECK dout0_33 vdout0_33ck73 = 0 time = 740
* CHECK dout0_34 vdout0_34ck73 = 0 time = 740
* CHECK dout0_35 vdout0_35ck73 = 0 time = 740
* CHECK dout0_36 vdout0_36ck73 = 1.8 time = 740
* CHECK dout0_37 vdout0_37ck73 = 1.8 time = 740
* CHECK dout0_38 vdout0_38ck73 = 0 time = 740
* CHECK dout0_39 vdout0_39ck73 = 0 time = 740
* CHECK dout0_40 vdout0_40ck73 = 1.8 time = 740
* CHECK dout0_41 vdout0_41ck73 = 1.8 time = 740
* CHECK dout0_42 vdout0_42ck73 = 0 time = 740
* CHECK dout0_43 vdout0_43ck73 = 1.8 time = 740
* CHECK dout0_44 vdout0_44ck73 = 1.8 time = 740
* CHECK dout0_45 vdout0_45ck73 = 0 time = 740
* CHECK dout0_46 vdout0_46ck73 = 1.8 time = 740
* CHECK dout0_47 vdout0_47ck73 = 1.8 time = 740
* CHECK dout0_48 vdout0_48ck73 = 1.8 time = 740
* CHECK dout0_49 vdout0_49ck73 = 0 time = 740
* CHECK dout0_50 vdout0_50ck73 = 1.8 time = 740
* CHECK dout0_51 vdout0_51ck73 = 1.8 time = 740
* CHECK dout0_52 vdout0_52ck73 = 0 time = 740
* CHECK dout0_53 vdout0_53ck73 = 0 time = 740
* CHECK dout0_54 vdout0_54ck73 = 1.8 time = 740
* CHECK dout0_55 vdout0_55ck73 = 1.8 time = 740
* CHECK dout0_56 vdout0_56ck73 = 1.8 time = 740
* CHECK dout0_57 vdout0_57ck73 = 0 time = 740
* CHECK dout0_58 vdout0_58ck73 = 0 time = 740
* CHECK dout0_59 vdout0_59ck73 = 1.8 time = 740
* CHECK dout0_60 vdout0_60ck73 = 1.8 time = 740
* CHECK dout0_61 vdout0_61ck73 = 0 time = 740
* CHECK dout0_62 vdout0_62ck73 = 0 time = 740
* CHECK dout0_63 vdout0_63ck73 = 0 time = 740
* CHECK dout1_0 vdout1_0ck73 = 0 time = 740
* CHECK dout1_1 vdout1_1ck73 = 1.8 time = 740
* CHECK dout1_2 vdout1_2ck73 = 1.8 time = 740
* CHECK dout1_3 vdout1_3ck73 = 0 time = 740
* CHECK dout1_4 vdout1_4ck73 = 1.8 time = 740
* CHECK dout1_5 vdout1_5ck73 = 0 time = 740
* CHECK dout1_6 vdout1_6ck73 = 0 time = 740
* CHECK dout1_7 vdout1_7ck73 = 1.8 time = 740
* CHECK dout1_8 vdout1_8ck73 = 1.8 time = 740
* CHECK dout1_9 vdout1_9ck73 = 0 time = 740
* CHECK dout1_10 vdout1_10ck73 = 1.8 time = 740
* CHECK dout1_11 vdout1_11ck73 = 0 time = 740
* CHECK dout1_12 vdout1_12ck73 = 0 time = 740
* CHECK dout1_13 vdout1_13ck73 = 0 time = 740
* CHECK dout1_14 vdout1_14ck73 = 1.8 time = 740
* CHECK dout1_15 vdout1_15ck73 = 1.8 time = 740
* CHECK dout1_16 vdout1_16ck73 = 1.8 time = 740
* CHECK dout1_17 vdout1_17ck73 = 0 time = 740
* CHECK dout1_18 vdout1_18ck73 = 0 time = 740
* CHECK dout1_19 vdout1_19ck73 = 1.8 time = 740
* CHECK dout1_20 vdout1_20ck73 = 0 time = 740
* CHECK dout1_21 vdout1_21ck73 = 0 time = 740
* CHECK dout1_22 vdout1_22ck73 = 0 time = 740
* CHECK dout1_23 vdout1_23ck73 = 0 time = 740
* CHECK dout1_24 vdout1_24ck73 = 1.8 time = 740
* CHECK dout1_25 vdout1_25ck73 = 0 time = 740
* CHECK dout1_26 vdout1_26ck73 = 0 time = 740
* CHECK dout1_27 vdout1_27ck73 = 1.8 time = 740
* CHECK dout1_28 vdout1_28ck73 = 0 time = 740
* CHECK dout1_29 vdout1_29ck73 = 0 time = 740
* CHECK dout1_30 vdout1_30ck73 = 1.8 time = 740
* CHECK dout1_31 vdout1_31ck73 = 1.8 time = 740
* CHECK dout1_32 vdout1_32ck73 = 0 time = 740
* CHECK dout1_33 vdout1_33ck73 = 1.8 time = 740
* CHECK dout1_34 vdout1_34ck73 = 1.8 time = 740
* CHECK dout1_35 vdout1_35ck73 = 0 time = 740
* CHECK dout1_36 vdout1_36ck73 = 1.8 time = 740
* CHECK dout1_37 vdout1_37ck73 = 0 time = 740
* CHECK dout1_38 vdout1_38ck73 = 0 time = 740
* CHECK dout1_39 vdout1_39ck73 = 1.8 time = 740
* CHECK dout1_40 vdout1_40ck73 = 0 time = 740
* CHECK dout1_41 vdout1_41ck73 = 1.8 time = 740
* CHECK dout1_42 vdout1_42ck73 = 1.8 time = 740
* CHECK dout1_43 vdout1_43ck73 = 0 time = 740
* CHECK dout1_44 vdout1_44ck73 = 1.8 time = 740
* CHECK dout1_45 vdout1_45ck73 = 1.8 time = 740
* CHECK dout1_46 vdout1_46ck73 = 1.8 time = 740
* CHECK dout1_47 vdout1_47ck73 = 1.8 time = 740
* CHECK dout1_48 vdout1_48ck73 = 1.8 time = 740
* CHECK dout1_49 vdout1_49ck73 = 1.8 time = 740
* CHECK dout1_50 vdout1_50ck73 = 0 time = 740
* CHECK dout1_51 vdout1_51ck73 = 0 time = 740
* CHECK dout1_52 vdout1_52ck73 = 1.8 time = 740
* CHECK dout1_53 vdout1_53ck73 = 1.8 time = 740
* CHECK dout1_54 vdout1_54ck73 = 0 time = 740
* CHECK dout1_55 vdout1_55ck73 = 0 time = 740
* CHECK dout1_56 vdout1_56ck73 = 1.8 time = 740
* CHECK dout1_57 vdout1_57ck73 = 0 time = 740
* CHECK dout1_58 vdout1_58ck73 = 0 time = 740
* CHECK dout1_59 vdout1_59ck73 = 1.8 time = 740
* CHECK dout1_60 vdout1_60ck73 = 0 time = 740
* CHECK dout1_61 vdout1_61ck73 = 0 time = 740
* CHECK dout1_62 vdout1_62ck73 = 0 time = 740
* CHECK dout1_63 vdout1_63ck73 = 1.8 time = 740
* CHECK dout0_0 vdout0_0ck74 = 1.8 time = 750
* CHECK dout0_1 vdout0_1ck74 = 0 time = 750
* CHECK dout0_2 vdout0_2ck74 = 0 time = 750
* CHECK dout0_3 vdout0_3ck74 = 1.8 time = 750
* CHECK dout0_4 vdout0_4ck74 = 1.8 time = 750
* CHECK dout0_5 vdout0_5ck74 = 1.8 time = 750
* CHECK dout0_6 vdout0_6ck74 = 1.8 time = 750
* CHECK dout0_7 vdout0_7ck74 = 1.8 time = 750
* CHECK dout0_8 vdout0_8ck74 = 1.8 time = 750
* CHECK dout0_9 vdout0_9ck74 = 0 time = 750
* CHECK dout0_10 vdout0_10ck74 = 0 time = 750
* CHECK dout0_11 vdout0_11ck74 = 0 time = 750
* CHECK dout0_12 vdout0_12ck74 = 1.8 time = 750
* CHECK dout0_13 vdout0_13ck74 = 1.8 time = 750
* CHECK dout0_14 vdout0_14ck74 = 0 time = 750
* CHECK dout0_15 vdout0_15ck74 = 0 time = 750
* CHECK dout0_16 vdout0_16ck74 = 0 time = 750
* CHECK dout0_17 vdout0_17ck74 = 1.8 time = 750
* CHECK dout0_18 vdout0_18ck74 = 1.8 time = 750
* CHECK dout0_19 vdout0_19ck74 = 1.8 time = 750
* CHECK dout0_20 vdout0_20ck74 = 1.8 time = 750
* CHECK dout0_21 vdout0_21ck74 = 1.8 time = 750
* CHECK dout0_22 vdout0_22ck74 = 0 time = 750
* CHECK dout0_23 vdout0_23ck74 = 1.8 time = 750
* CHECK dout0_24 vdout0_24ck74 = 1.8 time = 750
* CHECK dout0_25 vdout0_25ck74 = 0 time = 750
* CHECK dout0_26 vdout0_26ck74 = 0 time = 750
* CHECK dout0_27 vdout0_27ck74 = 1.8 time = 750
* CHECK dout0_28 vdout0_28ck74 = 0 time = 750
* CHECK dout0_29 vdout0_29ck74 = 0 time = 750
* CHECK dout0_30 vdout0_30ck74 = 1.8 time = 750
* CHECK dout0_31 vdout0_31ck74 = 0 time = 750
* CHECK dout0_32 vdout0_32ck74 = 0 time = 750
* CHECK dout0_33 vdout0_33ck74 = 0 time = 750
* CHECK dout0_34 vdout0_34ck74 = 0 time = 750
* CHECK dout0_35 vdout0_35ck74 = 0 time = 750
* CHECK dout0_36 vdout0_36ck74 = 1.8 time = 750
* CHECK dout0_37 vdout0_37ck74 = 1.8 time = 750
* CHECK dout0_38 vdout0_38ck74 = 0 time = 750
* CHECK dout0_39 vdout0_39ck74 = 0 time = 750
* CHECK dout0_40 vdout0_40ck74 = 1.8 time = 750
* CHECK dout0_41 vdout0_41ck74 = 1.8 time = 750
* CHECK dout0_42 vdout0_42ck74 = 0 time = 750
* CHECK dout0_43 vdout0_43ck74 = 1.8 time = 750
* CHECK dout0_44 vdout0_44ck74 = 1.8 time = 750
* CHECK dout0_45 vdout0_45ck74 = 0 time = 750
* CHECK dout0_46 vdout0_46ck74 = 1.8 time = 750
* CHECK dout0_47 vdout0_47ck74 = 1.8 time = 750
* CHECK dout0_48 vdout0_48ck74 = 1.8 time = 750
* CHECK dout0_49 vdout0_49ck74 = 0 time = 750
* CHECK dout0_50 vdout0_50ck74 = 1.8 time = 750
* CHECK dout0_51 vdout0_51ck74 = 1.8 time = 750
* CHECK dout0_52 vdout0_52ck74 = 0 time = 750
* CHECK dout0_53 vdout0_53ck74 = 0 time = 750
* CHECK dout0_54 vdout0_54ck74 = 1.8 time = 750
* CHECK dout0_55 vdout0_55ck74 = 1.8 time = 750
* CHECK dout0_56 vdout0_56ck74 = 1.8 time = 750
* CHECK dout0_57 vdout0_57ck74 = 0 time = 750
* CHECK dout0_58 vdout0_58ck74 = 0 time = 750
* CHECK dout0_59 vdout0_59ck74 = 1.8 time = 750
* CHECK dout0_60 vdout0_60ck74 = 1.8 time = 750
* CHECK dout0_61 vdout0_61ck74 = 0 time = 750
* CHECK dout0_62 vdout0_62ck74 = 0 time = 750
* CHECK dout0_63 vdout0_63ck74 = 0 time = 750
* CHECK dout1_0 vdout1_0ck74 = 1.8 time = 750
* CHECK dout1_1 vdout1_1ck74 = 0 time = 750
* CHECK dout1_2 vdout1_2ck74 = 0 time = 750
* CHECK dout1_3 vdout1_3ck74 = 1.8 time = 750
* CHECK dout1_4 vdout1_4ck74 = 1.8 time = 750
* CHECK dout1_5 vdout1_5ck74 = 1.8 time = 750
* CHECK dout1_6 vdout1_6ck74 = 1.8 time = 750
* CHECK dout1_7 vdout1_7ck74 = 1.8 time = 750
* CHECK dout1_8 vdout1_8ck74 = 1.8 time = 750
* CHECK dout1_9 vdout1_9ck74 = 0 time = 750
* CHECK dout1_10 vdout1_10ck74 = 0 time = 750
* CHECK dout1_11 vdout1_11ck74 = 0 time = 750
* CHECK dout1_12 vdout1_12ck74 = 1.8 time = 750
* CHECK dout1_13 vdout1_13ck74 = 1.8 time = 750
* CHECK dout1_14 vdout1_14ck74 = 0 time = 750
* CHECK dout1_15 vdout1_15ck74 = 0 time = 750
* CHECK dout1_16 vdout1_16ck74 = 0 time = 750
* CHECK dout1_17 vdout1_17ck74 = 1.8 time = 750
* CHECK dout1_18 vdout1_18ck74 = 1.8 time = 750
* CHECK dout1_19 vdout1_19ck74 = 1.8 time = 750
* CHECK dout1_20 vdout1_20ck74 = 1.8 time = 750
* CHECK dout1_21 vdout1_21ck74 = 1.8 time = 750
* CHECK dout1_22 vdout1_22ck74 = 0 time = 750
* CHECK dout1_23 vdout1_23ck74 = 1.8 time = 750
* CHECK dout1_24 vdout1_24ck74 = 1.8 time = 750
* CHECK dout1_25 vdout1_25ck74 = 0 time = 750
* CHECK dout1_26 vdout1_26ck74 = 0 time = 750
* CHECK dout1_27 vdout1_27ck74 = 1.8 time = 750
* CHECK dout1_28 vdout1_28ck74 = 0 time = 750
* CHECK dout1_29 vdout1_29ck74 = 0 time = 750
* CHECK dout1_30 vdout1_30ck74 = 1.8 time = 750
* CHECK dout1_31 vdout1_31ck74 = 0 time = 750
* CHECK dout1_32 vdout1_32ck74 = 0 time = 750
* CHECK dout1_33 vdout1_33ck74 = 0 time = 750
* CHECK dout1_34 vdout1_34ck74 = 0 time = 750
* CHECK dout1_35 vdout1_35ck74 = 0 time = 750
* CHECK dout1_36 vdout1_36ck74 = 1.8 time = 750
* CHECK dout1_37 vdout1_37ck74 = 1.8 time = 750
* CHECK dout1_38 vdout1_38ck74 = 0 time = 750
* CHECK dout1_39 vdout1_39ck74 = 0 time = 750
* CHECK dout1_40 vdout1_40ck74 = 1.8 time = 750
* CHECK dout1_41 vdout1_41ck74 = 1.8 time = 750
* CHECK dout1_42 vdout1_42ck74 = 0 time = 750
* CHECK dout1_43 vdout1_43ck74 = 1.8 time = 750
* CHECK dout1_44 vdout1_44ck74 = 1.8 time = 750
* CHECK dout1_45 vdout1_45ck74 = 0 time = 750
* CHECK dout1_46 vdout1_46ck74 = 1.8 time = 750
* CHECK dout1_47 vdout1_47ck74 = 1.8 time = 750
* CHECK dout1_48 vdout1_48ck74 = 1.8 time = 750
* CHECK dout1_49 vdout1_49ck74 = 0 time = 750
* CHECK dout1_50 vdout1_50ck74 = 1.8 time = 750
* CHECK dout1_51 vdout1_51ck74 = 1.8 time = 750
* CHECK dout1_52 vdout1_52ck74 = 0 time = 750
* CHECK dout1_53 vdout1_53ck74 = 0 time = 750
* CHECK dout1_54 vdout1_54ck74 = 1.8 time = 750
* CHECK dout1_55 vdout1_55ck74 = 1.8 time = 750
* CHECK dout1_56 vdout1_56ck74 = 1.8 time = 750
* CHECK dout1_57 vdout1_57ck74 = 0 time = 750
* CHECK dout1_58 vdout1_58ck74 = 0 time = 750
* CHECK dout1_59 vdout1_59ck74 = 1.8 time = 750
* CHECK dout1_60 vdout1_60ck74 = 1.8 time = 750
* CHECK dout1_61 vdout1_61ck74 = 0 time = 750
* CHECK dout1_62 vdout1_62ck74 = 0 time = 750
* CHECK dout1_63 vdout1_63ck74 = 0 time = 750
* CHECK dout0_0 vdout0_0ck75 = 1.8 time = 760
* CHECK dout0_1 vdout0_1ck75 = 0 time = 760
* CHECK dout0_2 vdout0_2ck75 = 0 time = 760
* CHECK dout0_3 vdout0_3ck75 = 1.8 time = 760
* CHECK dout0_4 vdout0_4ck75 = 1.8 time = 760
* CHECK dout0_5 vdout0_5ck75 = 1.8 time = 760
* CHECK dout0_6 vdout0_6ck75 = 1.8 time = 760
* CHECK dout0_7 vdout0_7ck75 = 1.8 time = 760
* CHECK dout0_8 vdout0_8ck75 = 1.8 time = 760
* CHECK dout0_9 vdout0_9ck75 = 0 time = 760
* CHECK dout0_10 vdout0_10ck75 = 0 time = 760
* CHECK dout0_11 vdout0_11ck75 = 0 time = 760
* CHECK dout0_12 vdout0_12ck75 = 1.8 time = 760
* CHECK dout0_13 vdout0_13ck75 = 1.8 time = 760
* CHECK dout0_14 vdout0_14ck75 = 0 time = 760
* CHECK dout0_15 vdout0_15ck75 = 0 time = 760
* CHECK dout0_16 vdout0_16ck75 = 0 time = 760
* CHECK dout0_17 vdout0_17ck75 = 1.8 time = 760
* CHECK dout0_18 vdout0_18ck75 = 1.8 time = 760
* CHECK dout0_19 vdout0_19ck75 = 1.8 time = 760
* CHECK dout0_20 vdout0_20ck75 = 1.8 time = 760
* CHECK dout0_21 vdout0_21ck75 = 1.8 time = 760
* CHECK dout0_22 vdout0_22ck75 = 0 time = 760
* CHECK dout0_23 vdout0_23ck75 = 1.8 time = 760
* CHECK dout0_24 vdout0_24ck75 = 1.8 time = 760
* CHECK dout0_25 vdout0_25ck75 = 0 time = 760
* CHECK dout0_26 vdout0_26ck75 = 0 time = 760
* CHECK dout0_27 vdout0_27ck75 = 1.8 time = 760
* CHECK dout0_28 vdout0_28ck75 = 0 time = 760
* CHECK dout0_29 vdout0_29ck75 = 0 time = 760
* CHECK dout0_30 vdout0_30ck75 = 1.8 time = 760
* CHECK dout0_31 vdout0_31ck75 = 0 time = 760
* CHECK dout0_32 vdout0_32ck75 = 0 time = 760
* CHECK dout0_33 vdout0_33ck75 = 0 time = 760
* CHECK dout0_34 vdout0_34ck75 = 0 time = 760
* CHECK dout0_35 vdout0_35ck75 = 0 time = 760
* CHECK dout0_36 vdout0_36ck75 = 1.8 time = 760
* CHECK dout0_37 vdout0_37ck75 = 1.8 time = 760
* CHECK dout0_38 vdout0_38ck75 = 0 time = 760
* CHECK dout0_39 vdout0_39ck75 = 0 time = 760
* CHECK dout0_40 vdout0_40ck75 = 1.8 time = 760
* CHECK dout0_41 vdout0_41ck75 = 1.8 time = 760
* CHECK dout0_42 vdout0_42ck75 = 0 time = 760
* CHECK dout0_43 vdout0_43ck75 = 1.8 time = 760
* CHECK dout0_44 vdout0_44ck75 = 1.8 time = 760
* CHECK dout0_45 vdout0_45ck75 = 0 time = 760
* CHECK dout0_46 vdout0_46ck75 = 1.8 time = 760
* CHECK dout0_47 vdout0_47ck75 = 1.8 time = 760
* CHECK dout0_48 vdout0_48ck75 = 1.8 time = 760
* CHECK dout0_49 vdout0_49ck75 = 0 time = 760
* CHECK dout0_50 vdout0_50ck75 = 1.8 time = 760
* CHECK dout0_51 vdout0_51ck75 = 1.8 time = 760
* CHECK dout0_52 vdout0_52ck75 = 0 time = 760
* CHECK dout0_53 vdout0_53ck75 = 0 time = 760
* CHECK dout0_54 vdout0_54ck75 = 1.8 time = 760
* CHECK dout0_55 vdout0_55ck75 = 1.8 time = 760
* CHECK dout0_56 vdout0_56ck75 = 1.8 time = 760
* CHECK dout0_57 vdout0_57ck75 = 0 time = 760
* CHECK dout0_58 vdout0_58ck75 = 0 time = 760
* CHECK dout0_59 vdout0_59ck75 = 1.8 time = 760
* CHECK dout0_60 vdout0_60ck75 = 1.8 time = 760
* CHECK dout0_61 vdout0_61ck75 = 0 time = 760
* CHECK dout0_62 vdout0_62ck75 = 0 time = 760
* CHECK dout0_63 vdout0_63ck75 = 0 time = 760
* CHECK dout1_0 vdout1_0ck75 = 0 time = 760
* CHECK dout1_1 vdout1_1ck75 = 1.8 time = 760
* CHECK dout1_2 vdout1_2ck75 = 1.8 time = 760
* CHECK dout1_3 vdout1_3ck75 = 0 time = 760
* CHECK dout1_4 vdout1_4ck75 = 1.8 time = 760
* CHECK dout1_5 vdout1_5ck75 = 0 time = 760
* CHECK dout1_6 vdout1_6ck75 = 0 time = 760
* CHECK dout1_7 vdout1_7ck75 = 1.8 time = 760
* CHECK dout1_8 vdout1_8ck75 = 1.8 time = 760
* CHECK dout1_9 vdout1_9ck75 = 0 time = 760
* CHECK dout1_10 vdout1_10ck75 = 1.8 time = 760
* CHECK dout1_11 vdout1_11ck75 = 0 time = 760
* CHECK dout1_12 vdout1_12ck75 = 0 time = 760
* CHECK dout1_13 vdout1_13ck75 = 0 time = 760
* CHECK dout1_14 vdout1_14ck75 = 1.8 time = 760
* CHECK dout1_15 vdout1_15ck75 = 1.8 time = 760
* CHECK dout1_16 vdout1_16ck75 = 1.8 time = 760
* CHECK dout1_17 vdout1_17ck75 = 0 time = 760
* CHECK dout1_18 vdout1_18ck75 = 0 time = 760
* CHECK dout1_19 vdout1_19ck75 = 1.8 time = 760
* CHECK dout1_20 vdout1_20ck75 = 0 time = 760
* CHECK dout1_21 vdout1_21ck75 = 0 time = 760
* CHECK dout1_22 vdout1_22ck75 = 0 time = 760
* CHECK dout1_23 vdout1_23ck75 = 0 time = 760
* CHECK dout1_24 vdout1_24ck75 = 1.8 time = 760
* CHECK dout1_25 vdout1_25ck75 = 0 time = 760
* CHECK dout1_26 vdout1_26ck75 = 0 time = 760
* CHECK dout1_27 vdout1_27ck75 = 1.8 time = 760
* CHECK dout1_28 vdout1_28ck75 = 0 time = 760
* CHECK dout1_29 vdout1_29ck75 = 0 time = 760
* CHECK dout1_30 vdout1_30ck75 = 1.8 time = 760
* CHECK dout1_31 vdout1_31ck75 = 1.8 time = 760
* CHECK dout1_32 vdout1_32ck75 = 0 time = 760
* CHECK dout1_33 vdout1_33ck75 = 1.8 time = 760
* CHECK dout1_34 vdout1_34ck75 = 1.8 time = 760
* CHECK dout1_35 vdout1_35ck75 = 0 time = 760
* CHECK dout1_36 vdout1_36ck75 = 1.8 time = 760
* CHECK dout1_37 vdout1_37ck75 = 0 time = 760
* CHECK dout1_38 vdout1_38ck75 = 0 time = 760
* CHECK dout1_39 vdout1_39ck75 = 1.8 time = 760
* CHECK dout1_40 vdout1_40ck75 = 0 time = 760
* CHECK dout1_41 vdout1_41ck75 = 1.8 time = 760
* CHECK dout1_42 vdout1_42ck75 = 1.8 time = 760
* CHECK dout1_43 vdout1_43ck75 = 0 time = 760
* CHECK dout1_44 vdout1_44ck75 = 1.8 time = 760
* CHECK dout1_45 vdout1_45ck75 = 1.8 time = 760
* CHECK dout1_46 vdout1_46ck75 = 1.8 time = 760
* CHECK dout1_47 vdout1_47ck75 = 1.8 time = 760
* CHECK dout1_48 vdout1_48ck75 = 1.8 time = 760
* CHECK dout1_49 vdout1_49ck75 = 1.8 time = 760
* CHECK dout1_50 vdout1_50ck75 = 0 time = 760
* CHECK dout1_51 vdout1_51ck75 = 0 time = 760
* CHECK dout1_52 vdout1_52ck75 = 1.8 time = 760
* CHECK dout1_53 vdout1_53ck75 = 1.8 time = 760
* CHECK dout1_54 vdout1_54ck75 = 0 time = 760
* CHECK dout1_55 vdout1_55ck75 = 0 time = 760
* CHECK dout1_56 vdout1_56ck75 = 1.8 time = 760
* CHECK dout1_57 vdout1_57ck75 = 0 time = 760
* CHECK dout1_58 vdout1_58ck75 = 0 time = 760
* CHECK dout1_59 vdout1_59ck75 = 1.8 time = 760
* CHECK dout1_60 vdout1_60ck75 = 0 time = 760
* CHECK dout1_61 vdout1_61ck75 = 0 time = 760
* CHECK dout1_62 vdout1_62ck75 = 0 time = 760
* CHECK dout1_63 vdout1_63ck75 = 1.8 time = 760
* CHECK dout1_0 vdout1_0ck76 = 1.8 time = 770
* CHECK dout1_1 vdout1_1ck76 = 0 time = 770
* CHECK dout1_2 vdout1_2ck76 = 1.8 time = 770
* CHECK dout1_3 vdout1_3ck76 = 0 time = 770
* CHECK dout1_4 vdout1_4ck76 = 1.8 time = 770
* CHECK dout1_5 vdout1_5ck76 = 1.8 time = 770
* CHECK dout1_6 vdout1_6ck76 = 0 time = 770
* CHECK dout1_7 vdout1_7ck76 = 1.8 time = 770
* CHECK dout1_8 vdout1_8ck76 = 1.8 time = 770
* CHECK dout1_9 vdout1_9ck76 = 0 time = 770
* CHECK dout1_10 vdout1_10ck76 = 0 time = 770
* CHECK dout1_11 vdout1_11ck76 = 1.8 time = 770
* CHECK dout1_12 vdout1_12ck76 = 0 time = 770
* CHECK dout1_13 vdout1_13ck76 = 1.8 time = 770
* CHECK dout1_14 vdout1_14ck76 = 0 time = 770
* CHECK dout1_15 vdout1_15ck76 = 1.8 time = 770
* CHECK dout1_16 vdout1_16ck76 = 1.8 time = 770
* CHECK dout1_17 vdout1_17ck76 = 1.8 time = 770
* CHECK dout1_18 vdout1_18ck76 = 0 time = 770
* CHECK dout1_19 vdout1_19ck76 = 0 time = 770
* CHECK dout1_20 vdout1_20ck76 = 0 time = 770
* CHECK dout1_21 vdout1_21ck76 = 1.8 time = 770
* CHECK dout1_22 vdout1_22ck76 = 1.8 time = 770
* CHECK dout1_23 vdout1_23ck76 = 1.8 time = 770
* CHECK dout1_24 vdout1_24ck76 = 0 time = 770
* CHECK dout1_25 vdout1_25ck76 = 0 time = 770
* CHECK dout1_26 vdout1_26ck76 = 1.8 time = 770
* CHECK dout1_27 vdout1_27ck76 = 1.8 time = 770
* CHECK dout1_28 vdout1_28ck76 = 0 time = 770
* CHECK dout1_29 vdout1_29ck76 = 1.8 time = 770
* CHECK dout1_30 vdout1_30ck76 = 1.8 time = 770
* CHECK dout1_31 vdout1_31ck76 = 1.8 time = 770
* CHECK dout1_32 vdout1_32ck76 = 0 time = 770
* CHECK dout1_33 vdout1_33ck76 = 0 time = 770
* CHECK dout1_34 vdout1_34ck76 = 0 time = 770
* CHECK dout1_35 vdout1_35ck76 = 0 time = 770
* CHECK dout1_36 vdout1_36ck76 = 1.8 time = 770
* CHECK dout1_37 vdout1_37ck76 = 1.8 time = 770
* CHECK dout1_38 vdout1_38ck76 = 0 time = 770
* CHECK dout1_39 vdout1_39ck76 = 1.8 time = 770
* CHECK dout1_40 vdout1_40ck76 = 0 time = 770
* CHECK dout1_41 vdout1_41ck76 = 0 time = 770
* CHECK dout1_42 vdout1_42ck76 = 1.8 time = 770
* CHECK dout1_43 vdout1_43ck76 = 0 time = 770
* CHECK dout1_44 vdout1_44ck76 = 0 time = 770
* CHECK dout1_45 vdout1_45ck76 = 1.8 time = 770
* CHECK dout1_46 vdout1_46ck76 = 1.8 time = 770
* CHECK dout1_47 vdout1_47ck76 = 1.8 time = 770
* CHECK dout1_48 vdout1_48ck76 = 1.8 time = 770
* CHECK dout1_49 vdout1_49ck76 = 1.8 time = 770
* CHECK dout1_50 vdout1_50ck76 = 0 time = 770
* CHECK dout1_51 vdout1_51ck76 = 0 time = 770
* CHECK dout1_52 vdout1_52ck76 = 1.8 time = 770
* CHECK dout1_53 vdout1_53ck76 = 0 time = 770
* CHECK dout1_54 vdout1_54ck76 = 0 time = 770
* CHECK dout1_55 vdout1_55ck76 = 0 time = 770
* CHECK dout1_56 vdout1_56ck76 = 0 time = 770
* CHECK dout1_57 vdout1_57ck76 = 1.8 time = 770
* CHECK dout1_58 vdout1_58ck76 = 1.8 time = 770
* CHECK dout1_59 vdout1_59ck76 = 0 time = 770
* CHECK dout1_60 vdout1_60ck76 = 0 time = 770
* CHECK dout1_61 vdout1_61ck76 = 0 time = 770
* CHECK dout1_62 vdout1_62ck76 = 0 time = 770
* CHECK dout1_63 vdout1_63ck76 = 1.8 time = 770
* CHECK dout1_0 vdout1_0ck77 = 1.8 time = 780
* CHECK dout1_1 vdout1_1ck77 = 0 time = 780
* CHECK dout1_2 vdout1_2ck77 = 1.8 time = 780
* CHECK dout1_3 vdout1_3ck77 = 1.8 time = 780
* CHECK dout1_4 vdout1_4ck77 = 0 time = 780
* CHECK dout1_5 vdout1_5ck77 = 1.8 time = 780
* CHECK dout1_6 vdout1_6ck77 = 0 time = 780
* CHECK dout1_7 vdout1_7ck77 = 1.8 time = 780
* CHECK dout1_8 vdout1_8ck77 = 0 time = 780
* CHECK dout1_9 vdout1_9ck77 = 1.8 time = 780
* CHECK dout1_10 vdout1_10ck77 = 0 time = 780
* CHECK dout1_11 vdout1_11ck77 = 1.8 time = 780
* CHECK dout1_12 vdout1_12ck77 = 1.8 time = 780
* CHECK dout1_13 vdout1_13ck77 = 0 time = 780
* CHECK dout1_14 vdout1_14ck77 = 1.8 time = 780
* CHECK dout1_15 vdout1_15ck77 = 1.8 time = 780
* CHECK dout1_16 vdout1_16ck77 = 0 time = 780
* CHECK dout1_17 vdout1_17ck77 = 0 time = 780
* CHECK dout1_18 vdout1_18ck77 = 1.8 time = 780
* CHECK dout1_19 vdout1_19ck77 = 1.8 time = 780
* CHECK dout1_20 vdout1_20ck77 = 0 time = 780
* CHECK dout1_21 vdout1_21ck77 = 1.8 time = 780
* CHECK dout1_22 vdout1_22ck77 = 0 time = 780
* CHECK dout1_23 vdout1_23ck77 = 0 time = 780
* CHECK dout1_24 vdout1_24ck77 = 1.8 time = 780
* CHECK dout1_25 vdout1_25ck77 = 0 time = 780
* CHECK dout1_26 vdout1_26ck77 = 1.8 time = 780
* CHECK dout1_27 vdout1_27ck77 = 0 time = 780
* CHECK dout1_28 vdout1_28ck77 = 1.8 time = 780
* CHECK dout1_29 vdout1_29ck77 = 1.8 time = 780
* CHECK dout1_30 vdout1_30ck77 = 1.8 time = 780
* CHECK dout1_31 vdout1_31ck77 = 1.8 time = 780
* CHECK dout1_32 vdout1_32ck77 = 0 time = 780
* CHECK dout1_33 vdout1_33ck77 = 0 time = 780
* CHECK dout1_34 vdout1_34ck77 = 0 time = 780
* CHECK dout1_35 vdout1_35ck77 = 1.8 time = 780
* CHECK dout1_36 vdout1_36ck77 = 1.8 time = 780
* CHECK dout1_37 vdout1_37ck77 = 0 time = 780
* CHECK dout1_38 vdout1_38ck77 = 0 time = 780
* CHECK dout1_39 vdout1_39ck77 = 1.8 time = 780
* CHECK dout1_40 vdout1_40ck77 = 1.8 time = 780
* CHECK dout1_41 vdout1_41ck77 = 1.8 time = 780
* CHECK dout1_42 vdout1_42ck77 = 0 time = 780
* CHECK dout1_43 vdout1_43ck77 = 0 time = 780
* CHECK dout1_44 vdout1_44ck77 = 1.8 time = 780
* CHECK dout1_45 vdout1_45ck77 = 1.8 time = 780
* CHECK dout1_46 vdout1_46ck77 = 0 time = 780
* CHECK dout1_47 vdout1_47ck77 = 0 time = 780
* CHECK dout1_48 vdout1_48ck77 = 0 time = 780
* CHECK dout1_49 vdout1_49ck77 = 1.8 time = 780
* CHECK dout1_50 vdout1_50ck77 = 1.8 time = 780
* CHECK dout1_51 vdout1_51ck77 = 1.8 time = 780
* CHECK dout1_52 vdout1_52ck77 = 0 time = 780
* CHECK dout1_53 vdout1_53ck77 = 0 time = 780
* CHECK dout1_54 vdout1_54ck77 = 0 time = 780
* CHECK dout1_55 vdout1_55ck77 = 0 time = 780
* CHECK dout1_56 vdout1_56ck77 = 1.8 time = 780
* CHECK dout1_57 vdout1_57ck77 = 0 time = 780
* CHECK dout1_58 vdout1_58ck77 = 1.8 time = 780
* CHECK dout1_59 vdout1_59ck77 = 0 time = 780
* CHECK dout1_60 vdout1_60ck77 = 0 time = 780
* CHECK dout1_61 vdout1_61ck77 = 1.8 time = 780
* CHECK dout1_62 vdout1_62ck77 = 1.8 time = 780
* CHECK dout1_63 vdout1_63ck77 = 1.8 time = 780
* CHECK dout1_0 vdout1_0ck78 = 1.8 time = 790
* CHECK dout1_1 vdout1_1ck78 = 0 time = 790
* CHECK dout1_2 vdout1_2ck78 = 1.8 time = 790
* CHECK dout1_3 vdout1_3ck78 = 1.8 time = 790
* CHECK dout1_4 vdout1_4ck78 = 0 time = 790
* CHECK dout1_5 vdout1_5ck78 = 1.8 time = 790
* CHECK dout1_6 vdout1_6ck78 = 0 time = 790
* CHECK dout1_7 vdout1_7ck78 = 1.8 time = 790
* CHECK dout1_8 vdout1_8ck78 = 0 time = 790
* CHECK dout1_9 vdout1_9ck78 = 1.8 time = 790
* CHECK dout1_10 vdout1_10ck78 = 0 time = 790
* CHECK dout1_11 vdout1_11ck78 = 1.8 time = 790
* CHECK dout1_12 vdout1_12ck78 = 1.8 time = 790
* CHECK dout1_13 vdout1_13ck78 = 0 time = 790
* CHECK dout1_14 vdout1_14ck78 = 1.8 time = 790
* CHECK dout1_15 vdout1_15ck78 = 1.8 time = 790
* CHECK dout1_16 vdout1_16ck78 = 0 time = 790
* CHECK dout1_17 vdout1_17ck78 = 0 time = 790
* CHECK dout1_18 vdout1_18ck78 = 1.8 time = 790
* CHECK dout1_19 vdout1_19ck78 = 1.8 time = 790
* CHECK dout1_20 vdout1_20ck78 = 0 time = 790
* CHECK dout1_21 vdout1_21ck78 = 1.8 time = 790
* CHECK dout1_22 vdout1_22ck78 = 0 time = 790
* CHECK dout1_23 vdout1_23ck78 = 0 time = 790
* CHECK dout1_24 vdout1_24ck78 = 1.8 time = 790
* CHECK dout1_25 vdout1_25ck78 = 0 time = 790
* CHECK dout1_26 vdout1_26ck78 = 1.8 time = 790
* CHECK dout1_27 vdout1_27ck78 = 0 time = 790
* CHECK dout1_28 vdout1_28ck78 = 1.8 time = 790
* CHECK dout1_29 vdout1_29ck78 = 1.8 time = 790
* CHECK dout1_30 vdout1_30ck78 = 1.8 time = 790
* CHECK dout1_31 vdout1_31ck78 = 1.8 time = 790
* CHECK dout1_32 vdout1_32ck78 = 0 time = 790
* CHECK dout1_33 vdout1_33ck78 = 0 time = 790
* CHECK dout1_34 vdout1_34ck78 = 0 time = 790
* CHECK dout1_35 vdout1_35ck78 = 1.8 time = 790
* CHECK dout1_36 vdout1_36ck78 = 1.8 time = 790
* CHECK dout1_37 vdout1_37ck78 = 0 time = 790
* CHECK dout1_38 vdout1_38ck78 = 0 time = 790
* CHECK dout1_39 vdout1_39ck78 = 1.8 time = 790
* CHECK dout1_40 vdout1_40ck78 = 1.8 time = 790
* CHECK dout1_41 vdout1_41ck78 = 1.8 time = 790
* CHECK dout1_42 vdout1_42ck78 = 0 time = 790
* CHECK dout1_43 vdout1_43ck78 = 0 time = 790
* CHECK dout1_44 vdout1_44ck78 = 1.8 time = 790
* CHECK dout1_45 vdout1_45ck78 = 1.8 time = 790
* CHECK dout1_46 vdout1_46ck78 = 0 time = 790
* CHECK dout1_47 vdout1_47ck78 = 0 time = 790
* CHECK dout1_48 vdout1_48ck78 = 0 time = 790
* CHECK dout1_49 vdout1_49ck78 = 1.8 time = 790
* CHECK dout1_50 vdout1_50ck78 = 1.8 time = 790
* CHECK dout1_51 vdout1_51ck78 = 1.8 time = 790
* CHECK dout1_52 vdout1_52ck78 = 0 time = 790
* CHECK dout1_53 vdout1_53ck78 = 0 time = 790
* CHECK dout1_54 vdout1_54ck78 = 0 time = 790
* CHECK dout1_55 vdout1_55ck78 = 0 time = 790
* CHECK dout1_56 vdout1_56ck78 = 1.8 time = 790
* CHECK dout1_57 vdout1_57ck78 = 0 time = 790
* CHECK dout1_58 vdout1_58ck78 = 1.8 time = 790
* CHECK dout1_59 vdout1_59ck78 = 0 time = 790
* CHECK dout1_60 vdout1_60ck78 = 0 time = 790
* CHECK dout1_61 vdout1_61ck78 = 1.8 time = 790
* CHECK dout1_62 vdout1_62ck78 = 1.8 time = 790
* CHECK dout1_63 vdout1_63ck78 = 1.8 time = 790
* CHECK dout0_0 vdout0_0ck79 = 1.8 time = 800
* CHECK dout0_1 vdout0_1ck79 = 0 time = 800
* CHECK dout0_2 vdout0_2ck79 = 1.8 time = 800
* CHECK dout0_3 vdout0_3ck79 = 0 time = 800
* CHECK dout0_4 vdout0_4ck79 = 1.8 time = 800
* CHECK dout0_5 vdout0_5ck79 = 1.8 time = 800
* CHECK dout0_6 vdout0_6ck79 = 0 time = 800
* CHECK dout0_7 vdout0_7ck79 = 1.8 time = 800
* CHECK dout0_8 vdout0_8ck79 = 1.8 time = 800
* CHECK dout0_9 vdout0_9ck79 = 0 time = 800
* CHECK dout0_10 vdout0_10ck79 = 0 time = 800
* CHECK dout0_11 vdout0_11ck79 = 1.8 time = 800
* CHECK dout0_12 vdout0_12ck79 = 0 time = 800
* CHECK dout0_13 vdout0_13ck79 = 1.8 time = 800
* CHECK dout0_14 vdout0_14ck79 = 0 time = 800
* CHECK dout0_15 vdout0_15ck79 = 1.8 time = 800
* CHECK dout0_16 vdout0_16ck79 = 1.8 time = 800
* CHECK dout0_17 vdout0_17ck79 = 1.8 time = 800
* CHECK dout0_18 vdout0_18ck79 = 0 time = 800
* CHECK dout0_19 vdout0_19ck79 = 0 time = 800
* CHECK dout0_20 vdout0_20ck79 = 0 time = 800
* CHECK dout0_21 vdout0_21ck79 = 1.8 time = 800
* CHECK dout0_22 vdout0_22ck79 = 1.8 time = 800
* CHECK dout0_23 vdout0_23ck79 = 1.8 time = 800
* CHECK dout0_24 vdout0_24ck79 = 0 time = 800
* CHECK dout0_25 vdout0_25ck79 = 0 time = 800
* CHECK dout0_26 vdout0_26ck79 = 1.8 time = 800
* CHECK dout0_27 vdout0_27ck79 = 1.8 time = 800
* CHECK dout0_28 vdout0_28ck79 = 0 time = 800
* CHECK dout0_29 vdout0_29ck79 = 1.8 time = 800
* CHECK dout0_30 vdout0_30ck79 = 1.8 time = 800
* CHECK dout0_31 vdout0_31ck79 = 1.8 time = 800
* CHECK dout0_32 vdout0_32ck79 = 0 time = 800
* CHECK dout0_33 vdout0_33ck79 = 0 time = 800
* CHECK dout0_34 vdout0_34ck79 = 0 time = 800
* CHECK dout0_35 vdout0_35ck79 = 0 time = 800
* CHECK dout0_36 vdout0_36ck79 = 1.8 time = 800
* CHECK dout0_37 vdout0_37ck79 = 1.8 time = 800
* CHECK dout0_38 vdout0_38ck79 = 0 time = 800
* CHECK dout0_39 vdout0_39ck79 = 1.8 time = 800
* CHECK dout0_40 vdout0_40ck79 = 0 time = 800
* CHECK dout0_41 vdout0_41ck79 = 0 time = 800
* CHECK dout0_42 vdout0_42ck79 = 1.8 time = 800
* CHECK dout0_43 vdout0_43ck79 = 0 time = 800
* CHECK dout0_44 vdout0_44ck79 = 0 time = 800
* CHECK dout0_45 vdout0_45ck79 = 1.8 time = 800
* CHECK dout0_46 vdout0_46ck79 = 1.8 time = 800
* CHECK dout0_47 vdout0_47ck79 = 1.8 time = 800
* CHECK dout0_48 vdout0_48ck79 = 1.8 time = 800
* CHECK dout0_49 vdout0_49ck79 = 1.8 time = 800
* CHECK dout0_50 vdout0_50ck79 = 0 time = 800
* CHECK dout0_51 vdout0_51ck79 = 0 time = 800
* CHECK dout0_52 vdout0_52ck79 = 1.8 time = 800
* CHECK dout0_53 vdout0_53ck79 = 0 time = 800
* CHECK dout0_54 vdout0_54ck79 = 0 time = 800
* CHECK dout0_55 vdout0_55ck79 = 0 time = 800
* CHECK dout0_56 vdout0_56ck79 = 0 time = 800
* CHECK dout0_57 vdout0_57ck79 = 1.8 time = 800
* CHECK dout0_58 vdout0_58ck79 = 1.8 time = 800
* CHECK dout0_59 vdout0_59ck79 = 0 time = 800
* CHECK dout0_60 vdout0_60ck79 = 0 time = 800
* CHECK dout0_61 vdout0_61ck79 = 0 time = 800
* CHECK dout0_62 vdout0_62ck79 = 0 time = 800
* CHECK dout0_63 vdout0_63ck79 = 1.8 time = 800
* CHECK dout0_0 vdout0_0ck80 = 1.8 time = 810
* CHECK dout0_1 vdout0_1ck80 = 0 time = 810
* CHECK dout0_2 vdout0_2ck80 = 1.8 time = 810
* CHECK dout0_3 vdout0_3ck80 = 0 time = 810
* CHECK dout0_4 vdout0_4ck80 = 1.8 time = 810
* CHECK dout0_5 vdout0_5ck80 = 1.8 time = 810
* CHECK dout0_6 vdout0_6ck80 = 0 time = 810
* CHECK dout0_7 vdout0_7ck80 = 1.8 time = 810
* CHECK dout0_8 vdout0_8ck80 = 1.8 time = 810
* CHECK dout0_9 vdout0_9ck80 = 0 time = 810
* CHECK dout0_10 vdout0_10ck80 = 0 time = 810
* CHECK dout0_11 vdout0_11ck80 = 1.8 time = 810
* CHECK dout0_12 vdout0_12ck80 = 0 time = 810
* CHECK dout0_13 vdout0_13ck80 = 1.8 time = 810
* CHECK dout0_14 vdout0_14ck80 = 0 time = 810
* CHECK dout0_15 vdout0_15ck80 = 1.8 time = 810
* CHECK dout0_16 vdout0_16ck80 = 1.8 time = 810
* CHECK dout0_17 vdout0_17ck80 = 1.8 time = 810
* CHECK dout0_18 vdout0_18ck80 = 0 time = 810
* CHECK dout0_19 vdout0_19ck80 = 0 time = 810
* CHECK dout0_20 vdout0_20ck80 = 0 time = 810
* CHECK dout0_21 vdout0_21ck80 = 1.8 time = 810
* CHECK dout0_22 vdout0_22ck80 = 1.8 time = 810
* CHECK dout0_23 vdout0_23ck80 = 1.8 time = 810
* CHECK dout0_24 vdout0_24ck80 = 0 time = 810
* CHECK dout0_25 vdout0_25ck80 = 0 time = 810
* CHECK dout0_26 vdout0_26ck80 = 1.8 time = 810
* CHECK dout0_27 vdout0_27ck80 = 1.8 time = 810
* CHECK dout0_28 vdout0_28ck80 = 0 time = 810
* CHECK dout0_29 vdout0_29ck80 = 1.8 time = 810
* CHECK dout0_30 vdout0_30ck80 = 1.8 time = 810
* CHECK dout0_31 vdout0_31ck80 = 1.8 time = 810
* CHECK dout0_32 vdout0_32ck80 = 0 time = 810
* CHECK dout0_33 vdout0_33ck80 = 0 time = 810
* CHECK dout0_34 vdout0_34ck80 = 0 time = 810
* CHECK dout0_35 vdout0_35ck80 = 0 time = 810
* CHECK dout0_36 vdout0_36ck80 = 1.8 time = 810
* CHECK dout0_37 vdout0_37ck80 = 1.8 time = 810
* CHECK dout0_38 vdout0_38ck80 = 0 time = 810
* CHECK dout0_39 vdout0_39ck80 = 1.8 time = 810
* CHECK dout0_40 vdout0_40ck80 = 0 time = 810
* CHECK dout0_41 vdout0_41ck80 = 0 time = 810
* CHECK dout0_42 vdout0_42ck80 = 1.8 time = 810
* CHECK dout0_43 vdout0_43ck80 = 0 time = 810
* CHECK dout0_44 vdout0_44ck80 = 0 time = 810
* CHECK dout0_45 vdout0_45ck80 = 1.8 time = 810
* CHECK dout0_46 vdout0_46ck80 = 1.8 time = 810
* CHECK dout0_47 vdout0_47ck80 = 1.8 time = 810
* CHECK dout0_48 vdout0_48ck80 = 1.8 time = 810
* CHECK dout0_49 vdout0_49ck80 = 1.8 time = 810
* CHECK dout0_50 vdout0_50ck80 = 0 time = 810
* CHECK dout0_51 vdout0_51ck80 = 0 time = 810
* CHECK dout0_52 vdout0_52ck80 = 1.8 time = 810
* CHECK dout0_53 vdout0_53ck80 = 0 time = 810
* CHECK dout0_54 vdout0_54ck80 = 0 time = 810
* CHECK dout0_55 vdout0_55ck80 = 0 time = 810
* CHECK dout0_56 vdout0_56ck80 = 0 time = 810
* CHECK dout0_57 vdout0_57ck80 = 1.8 time = 810
* CHECK dout0_58 vdout0_58ck80 = 1.8 time = 810
* CHECK dout0_59 vdout0_59ck80 = 0 time = 810
* CHECK dout0_60 vdout0_60ck80 = 0 time = 810
* CHECK dout0_61 vdout0_61ck80 = 0 time = 810
* CHECK dout0_62 vdout0_62ck80 = 0 time = 810
* CHECK dout0_63 vdout0_63ck80 = 1.8 time = 810
* CHECK dout0_0 vdout0_0ck81 = 0 time = 820
* CHECK dout0_1 vdout0_1ck81 = 1.8 time = 820
* CHECK dout0_2 vdout0_2ck81 = 1.8 time = 820
* CHECK dout0_3 vdout0_3ck81 = 0 time = 820
* CHECK dout0_4 vdout0_4ck81 = 1.8 time = 820
* CHECK dout0_5 vdout0_5ck81 = 0 time = 820
* CHECK dout0_6 vdout0_6ck81 = 0 time = 820
* CHECK dout0_7 vdout0_7ck81 = 1.8 time = 820
* CHECK dout0_8 vdout0_8ck81 = 1.8 time = 820
* CHECK dout0_9 vdout0_9ck81 = 0 time = 820
* CHECK dout0_10 vdout0_10ck81 = 1.8 time = 820
* CHECK dout0_11 vdout0_11ck81 = 0 time = 820
* CHECK dout0_12 vdout0_12ck81 = 0 time = 820
* CHECK dout0_13 vdout0_13ck81 = 0 time = 820
* CHECK dout0_14 vdout0_14ck81 = 1.8 time = 820
* CHECK dout0_15 vdout0_15ck81 = 1.8 time = 820
* CHECK dout0_16 vdout0_16ck81 = 1.8 time = 820
* CHECK dout0_17 vdout0_17ck81 = 0 time = 820
* CHECK dout0_18 vdout0_18ck81 = 0 time = 820
* CHECK dout0_19 vdout0_19ck81 = 1.8 time = 820
* CHECK dout0_20 vdout0_20ck81 = 0 time = 820
* CHECK dout0_21 vdout0_21ck81 = 0 time = 820
* CHECK dout0_22 vdout0_22ck81 = 0 time = 820
* CHECK dout0_23 vdout0_23ck81 = 0 time = 820
* CHECK dout0_24 vdout0_24ck81 = 1.8 time = 820
* CHECK dout0_25 vdout0_25ck81 = 0 time = 820
* CHECK dout0_26 vdout0_26ck81 = 0 time = 820
* CHECK dout0_27 vdout0_27ck81 = 1.8 time = 820
* CHECK dout0_28 vdout0_28ck81 = 0 time = 820
* CHECK dout0_29 vdout0_29ck81 = 0 time = 820
* CHECK dout0_30 vdout0_30ck81 = 1.8 time = 820
* CHECK dout0_31 vdout0_31ck81 = 1.8 time = 820
* CHECK dout0_32 vdout0_32ck81 = 0 time = 820
* CHECK dout0_33 vdout0_33ck81 = 1.8 time = 820
* CHECK dout0_34 vdout0_34ck81 = 1.8 time = 820
* CHECK dout0_35 vdout0_35ck81 = 0 time = 820
* CHECK dout0_36 vdout0_36ck81 = 1.8 time = 820
* CHECK dout0_37 vdout0_37ck81 = 0 time = 820
* CHECK dout0_38 vdout0_38ck81 = 0 time = 820
* CHECK dout0_39 vdout0_39ck81 = 1.8 time = 820
* CHECK dout0_40 vdout0_40ck81 = 0 time = 820
* CHECK dout0_41 vdout0_41ck81 = 1.8 time = 820
* CHECK dout0_42 vdout0_42ck81 = 1.8 time = 820
* CHECK dout0_43 vdout0_43ck81 = 0 time = 820
* CHECK dout0_44 vdout0_44ck81 = 1.8 time = 820
* CHECK dout0_45 vdout0_45ck81 = 1.8 time = 820
* CHECK dout0_46 vdout0_46ck81 = 1.8 time = 820
* CHECK dout0_47 vdout0_47ck81 = 1.8 time = 820
* CHECK dout0_48 vdout0_48ck81 = 1.8 time = 820
* CHECK dout0_49 vdout0_49ck81 = 1.8 time = 820
* CHECK dout0_50 vdout0_50ck81 = 0 time = 820
* CHECK dout0_51 vdout0_51ck81 = 0 time = 820
* CHECK dout0_52 vdout0_52ck81 = 1.8 time = 820
* CHECK dout0_53 vdout0_53ck81 = 1.8 time = 820
* CHECK dout0_54 vdout0_54ck81 = 0 time = 820
* CHECK dout0_55 vdout0_55ck81 = 0 time = 820
* CHECK dout0_56 vdout0_56ck81 = 1.8 time = 820
* CHECK dout0_57 vdout0_57ck81 = 0 time = 820
* CHECK dout0_58 vdout0_58ck81 = 0 time = 820
* CHECK dout0_59 vdout0_59ck81 = 1.8 time = 820
* CHECK dout0_60 vdout0_60ck81 = 0 time = 820
* CHECK dout0_61 vdout0_61ck81 = 0 time = 820
* CHECK dout0_62 vdout0_62ck81 = 0 time = 820
* CHECK dout0_63 vdout0_63ck81 = 1.8 time = 820
* CHECK dout1_0 vdout1_0ck81 = 1.8 time = 820
* CHECK dout1_1 vdout1_1ck81 = 0 time = 820
* CHECK dout1_2 vdout1_2ck81 = 1.8 time = 820
* CHECK dout1_3 vdout1_3ck81 = 1.8 time = 820
* CHECK dout1_4 vdout1_4ck81 = 0 time = 820
* CHECK dout1_5 vdout1_5ck81 = 1.8 time = 820
* CHECK dout1_6 vdout1_6ck81 = 0 time = 820
* CHECK dout1_7 vdout1_7ck81 = 1.8 time = 820
* CHECK dout1_8 vdout1_8ck81 = 0 time = 820
* CHECK dout1_9 vdout1_9ck81 = 1.8 time = 820
* CHECK dout1_10 vdout1_10ck81 = 0 time = 820
* CHECK dout1_11 vdout1_11ck81 = 1.8 time = 820
* CHECK dout1_12 vdout1_12ck81 = 1.8 time = 820
* CHECK dout1_13 vdout1_13ck81 = 0 time = 820
* CHECK dout1_14 vdout1_14ck81 = 1.8 time = 820
* CHECK dout1_15 vdout1_15ck81 = 1.8 time = 820
* CHECK dout1_16 vdout1_16ck81 = 0 time = 820
* CHECK dout1_17 vdout1_17ck81 = 0 time = 820
* CHECK dout1_18 vdout1_18ck81 = 1.8 time = 820
* CHECK dout1_19 vdout1_19ck81 = 1.8 time = 820
* CHECK dout1_20 vdout1_20ck81 = 0 time = 820
* CHECK dout1_21 vdout1_21ck81 = 1.8 time = 820
* CHECK dout1_22 vdout1_22ck81 = 0 time = 820
* CHECK dout1_23 vdout1_23ck81 = 0 time = 820
* CHECK dout1_24 vdout1_24ck81 = 1.8 time = 820
* CHECK dout1_25 vdout1_25ck81 = 0 time = 820
* CHECK dout1_26 vdout1_26ck81 = 1.8 time = 820
* CHECK dout1_27 vdout1_27ck81 = 0 time = 820
* CHECK dout1_28 vdout1_28ck81 = 1.8 time = 820
* CHECK dout1_29 vdout1_29ck81 = 1.8 time = 820
* CHECK dout1_30 vdout1_30ck81 = 1.8 time = 820
* CHECK dout1_31 vdout1_31ck81 = 1.8 time = 820
* CHECK dout1_32 vdout1_32ck81 = 0 time = 820
* CHECK dout1_33 vdout1_33ck81 = 0 time = 820
* CHECK dout1_34 vdout1_34ck81 = 0 time = 820
* CHECK dout1_35 vdout1_35ck81 = 1.8 time = 820
* CHECK dout1_36 vdout1_36ck81 = 1.8 time = 820
* CHECK dout1_37 vdout1_37ck81 = 0 time = 820
* CHECK dout1_38 vdout1_38ck81 = 0 time = 820
* CHECK dout1_39 vdout1_39ck81 = 1.8 time = 820
* CHECK dout1_40 vdout1_40ck81 = 1.8 time = 820
* CHECK dout1_41 vdout1_41ck81 = 1.8 time = 820
* CHECK dout1_42 vdout1_42ck81 = 0 time = 820
* CHECK dout1_43 vdout1_43ck81 = 0 time = 820
* CHECK dout1_44 vdout1_44ck81 = 1.8 time = 820
* CHECK dout1_45 vdout1_45ck81 = 1.8 time = 820
* CHECK dout1_46 vdout1_46ck81 = 0 time = 820
* CHECK dout1_47 vdout1_47ck81 = 0 time = 820
* CHECK dout1_48 vdout1_48ck81 = 0 time = 820
* CHECK dout1_49 vdout1_49ck81 = 1.8 time = 820
* CHECK dout1_50 vdout1_50ck81 = 1.8 time = 820
* CHECK dout1_51 vdout1_51ck81 = 1.8 time = 820
* CHECK dout1_52 vdout1_52ck81 = 0 time = 820
* CHECK dout1_53 vdout1_53ck81 = 0 time = 820
* CHECK dout1_54 vdout1_54ck81 = 0 time = 820
* CHECK dout1_55 vdout1_55ck81 = 0 time = 820
* CHECK dout1_56 vdout1_56ck81 = 1.8 time = 820
* CHECK dout1_57 vdout1_57ck81 = 0 time = 820
* CHECK dout1_58 vdout1_58ck81 = 1.8 time = 820
* CHECK dout1_59 vdout1_59ck81 = 0 time = 820
* CHECK dout1_60 vdout1_60ck81 = 0 time = 820
* CHECK dout1_61 vdout1_61ck81 = 1.8 time = 820
* CHECK dout1_62 vdout1_62ck81 = 1.8 time = 820
* CHECK dout1_63 vdout1_63ck81 = 1.8 time = 820
* CHECK dout1_0 vdout1_0ck82 = 0 time = 830
* CHECK dout1_1 vdout1_1ck82 = 1.8 time = 830
* CHECK dout1_2 vdout1_2ck82 = 1.8 time = 830
* CHECK dout1_3 vdout1_3ck82 = 0 time = 830
* CHECK dout1_4 vdout1_4ck82 = 1.8 time = 830
* CHECK dout1_5 vdout1_5ck82 = 0 time = 830
* CHECK dout1_6 vdout1_6ck82 = 0 time = 830
* CHECK dout1_7 vdout1_7ck82 = 1.8 time = 830
* CHECK dout1_8 vdout1_8ck82 = 1.8 time = 830
* CHECK dout1_9 vdout1_9ck82 = 0 time = 830
* CHECK dout1_10 vdout1_10ck82 = 1.8 time = 830
* CHECK dout1_11 vdout1_11ck82 = 0 time = 830
* CHECK dout1_12 vdout1_12ck82 = 0 time = 830
* CHECK dout1_13 vdout1_13ck82 = 0 time = 830
* CHECK dout1_14 vdout1_14ck82 = 1.8 time = 830
* CHECK dout1_15 vdout1_15ck82 = 1.8 time = 830
* CHECK dout1_16 vdout1_16ck82 = 1.8 time = 830
* CHECK dout1_17 vdout1_17ck82 = 0 time = 830
* CHECK dout1_18 vdout1_18ck82 = 0 time = 830
* CHECK dout1_19 vdout1_19ck82 = 1.8 time = 830
* CHECK dout1_20 vdout1_20ck82 = 0 time = 830
* CHECK dout1_21 vdout1_21ck82 = 0 time = 830
* CHECK dout1_22 vdout1_22ck82 = 0 time = 830
* CHECK dout1_23 vdout1_23ck82 = 0 time = 830
* CHECK dout1_24 vdout1_24ck82 = 1.8 time = 830
* CHECK dout1_25 vdout1_25ck82 = 0 time = 830
* CHECK dout1_26 vdout1_26ck82 = 0 time = 830
* CHECK dout1_27 vdout1_27ck82 = 1.8 time = 830
* CHECK dout1_28 vdout1_28ck82 = 0 time = 830
* CHECK dout1_29 vdout1_29ck82 = 0 time = 830
* CHECK dout1_30 vdout1_30ck82 = 1.8 time = 830
* CHECK dout1_31 vdout1_31ck82 = 1.8 time = 830
* CHECK dout1_32 vdout1_32ck82 = 0 time = 830
* CHECK dout1_33 vdout1_33ck82 = 1.8 time = 830
* CHECK dout1_34 vdout1_34ck82 = 1.8 time = 830
* CHECK dout1_35 vdout1_35ck82 = 0 time = 830
* CHECK dout1_36 vdout1_36ck82 = 1.8 time = 830
* CHECK dout1_37 vdout1_37ck82 = 0 time = 830
* CHECK dout1_38 vdout1_38ck82 = 0 time = 830
* CHECK dout1_39 vdout1_39ck82 = 1.8 time = 830
* CHECK dout1_40 vdout1_40ck82 = 0 time = 830
* CHECK dout1_41 vdout1_41ck82 = 1.8 time = 830
* CHECK dout1_42 vdout1_42ck82 = 1.8 time = 830
* CHECK dout1_43 vdout1_43ck82 = 0 time = 830
* CHECK dout1_44 vdout1_44ck82 = 1.8 time = 830
* CHECK dout1_45 vdout1_45ck82 = 1.8 time = 830
* CHECK dout1_46 vdout1_46ck82 = 1.8 time = 830
* CHECK dout1_47 vdout1_47ck82 = 1.8 time = 830
* CHECK dout1_48 vdout1_48ck82 = 1.8 time = 830
* CHECK dout1_49 vdout1_49ck82 = 1.8 time = 830
* CHECK dout1_50 vdout1_50ck82 = 0 time = 830
* CHECK dout1_51 vdout1_51ck82 = 0 time = 830
* CHECK dout1_52 vdout1_52ck82 = 1.8 time = 830
* CHECK dout1_53 vdout1_53ck82 = 1.8 time = 830
* CHECK dout1_54 vdout1_54ck82 = 0 time = 830
* CHECK dout1_55 vdout1_55ck82 = 0 time = 830
* CHECK dout1_56 vdout1_56ck82 = 1.8 time = 830
* CHECK dout1_57 vdout1_57ck82 = 0 time = 830
* CHECK dout1_58 vdout1_58ck82 = 0 time = 830
* CHECK dout1_59 vdout1_59ck82 = 1.8 time = 830
* CHECK dout1_60 vdout1_60ck82 = 0 time = 830
* CHECK dout1_61 vdout1_61ck82 = 0 time = 830
* CHECK dout1_62 vdout1_62ck82 = 0 time = 830
* CHECK dout1_63 vdout1_63ck82 = 1.8 time = 830
* CHECK dout0_0 vdout0_0ck83 = 0 time = 840
* CHECK dout0_1 vdout0_1ck83 = 1.8 time = 840
* CHECK dout0_2 vdout0_2ck83 = 1.8 time = 840
* CHECK dout0_3 vdout0_3ck83 = 0 time = 840
* CHECK dout0_4 vdout0_4ck83 = 1.8 time = 840
* CHECK dout0_5 vdout0_5ck83 = 0 time = 840
* CHECK dout0_6 vdout0_6ck83 = 0 time = 840
* CHECK dout0_7 vdout0_7ck83 = 1.8 time = 840
* CHECK dout0_8 vdout0_8ck83 = 1.8 time = 840
* CHECK dout0_9 vdout0_9ck83 = 0 time = 840
* CHECK dout0_10 vdout0_10ck83 = 1.8 time = 840
* CHECK dout0_11 vdout0_11ck83 = 0 time = 840
* CHECK dout0_12 vdout0_12ck83 = 0 time = 840
* CHECK dout0_13 vdout0_13ck83 = 0 time = 840
* CHECK dout0_14 vdout0_14ck83 = 1.8 time = 840
* CHECK dout0_15 vdout0_15ck83 = 1.8 time = 840
* CHECK dout0_16 vdout0_16ck83 = 1.8 time = 840
* CHECK dout0_17 vdout0_17ck83 = 0 time = 840
* CHECK dout0_18 vdout0_18ck83 = 0 time = 840
* CHECK dout0_19 vdout0_19ck83 = 1.8 time = 840
* CHECK dout0_20 vdout0_20ck83 = 0 time = 840
* CHECK dout0_21 vdout0_21ck83 = 0 time = 840
* CHECK dout0_22 vdout0_22ck83 = 0 time = 840
* CHECK dout0_23 vdout0_23ck83 = 0 time = 840
* CHECK dout0_24 vdout0_24ck83 = 1.8 time = 840
* CHECK dout0_25 vdout0_25ck83 = 0 time = 840
* CHECK dout0_26 vdout0_26ck83 = 0 time = 840
* CHECK dout0_27 vdout0_27ck83 = 1.8 time = 840
* CHECK dout0_28 vdout0_28ck83 = 0 time = 840
* CHECK dout0_29 vdout0_29ck83 = 0 time = 840
* CHECK dout0_30 vdout0_30ck83 = 1.8 time = 840
* CHECK dout0_31 vdout0_31ck83 = 1.8 time = 840
* CHECK dout0_32 vdout0_32ck83 = 0 time = 840
* CHECK dout0_33 vdout0_33ck83 = 1.8 time = 840
* CHECK dout0_34 vdout0_34ck83 = 1.8 time = 840
* CHECK dout0_35 vdout0_35ck83 = 0 time = 840
* CHECK dout0_36 vdout0_36ck83 = 1.8 time = 840
* CHECK dout0_37 vdout0_37ck83 = 0 time = 840
* CHECK dout0_38 vdout0_38ck83 = 0 time = 840
* CHECK dout0_39 vdout0_39ck83 = 1.8 time = 840
* CHECK dout0_40 vdout0_40ck83 = 0 time = 840
* CHECK dout0_41 vdout0_41ck83 = 1.8 time = 840
* CHECK dout0_42 vdout0_42ck83 = 1.8 time = 840
* CHECK dout0_43 vdout0_43ck83 = 0 time = 840
* CHECK dout0_44 vdout0_44ck83 = 1.8 time = 840
* CHECK dout0_45 vdout0_45ck83 = 1.8 time = 840
* CHECK dout0_46 vdout0_46ck83 = 1.8 time = 840
* CHECK dout0_47 vdout0_47ck83 = 1.8 time = 840
* CHECK dout0_48 vdout0_48ck83 = 1.8 time = 840
* CHECK dout0_49 vdout0_49ck83 = 1.8 time = 840
* CHECK dout0_50 vdout0_50ck83 = 0 time = 840
* CHECK dout0_51 vdout0_51ck83 = 0 time = 840
* CHECK dout0_52 vdout0_52ck83 = 1.8 time = 840
* CHECK dout0_53 vdout0_53ck83 = 1.8 time = 840
* CHECK dout0_54 vdout0_54ck83 = 0 time = 840
* CHECK dout0_55 vdout0_55ck83 = 0 time = 840
* CHECK dout0_56 vdout0_56ck83 = 1.8 time = 840
* CHECK dout0_57 vdout0_57ck83 = 0 time = 840
* CHECK dout0_58 vdout0_58ck83 = 0 time = 840
* CHECK dout0_59 vdout0_59ck83 = 1.8 time = 840
* CHECK dout0_60 vdout0_60ck83 = 0 time = 840
* CHECK dout0_61 vdout0_61ck83 = 0 time = 840
* CHECK dout0_62 vdout0_62ck83 = 0 time = 840
* CHECK dout0_63 vdout0_63ck83 = 1.8 time = 840
* CHECK dout1_0 vdout1_0ck83 = 0 time = 840
* CHECK dout1_1 vdout1_1ck83 = 1.8 time = 840
* CHECK dout1_2 vdout1_2ck83 = 0 time = 840
* CHECK dout1_3 vdout1_3ck83 = 1.8 time = 840
* CHECK dout1_4 vdout1_4ck83 = 0 time = 840
* CHECK dout1_5 vdout1_5ck83 = 0 time = 840
* CHECK dout1_6 vdout1_6ck83 = 0 time = 840
* CHECK dout1_7 vdout1_7ck83 = 0 time = 840
* CHECK dout1_8 vdout1_8ck83 = 1.8 time = 840
* CHECK dout1_9 vdout1_9ck83 = 1.8 time = 840
* CHECK dout1_10 vdout1_10ck83 = 0 time = 840
* CHECK dout1_11 vdout1_11ck83 = 0 time = 840
* CHECK dout1_12 vdout1_12ck83 = 1.8 time = 840
* CHECK dout1_13 vdout1_13ck83 = 0 time = 840
* CHECK dout1_14 vdout1_14ck83 = 0 time = 840
* CHECK dout1_15 vdout1_15ck83 = 0 time = 840
* CHECK dout1_16 vdout1_16ck83 = 1.8 time = 840
* CHECK dout1_17 vdout1_17ck83 = 0 time = 840
* CHECK dout1_18 vdout1_18ck83 = 1.8 time = 840
* CHECK dout1_19 vdout1_19ck83 = 1.8 time = 840
* CHECK dout1_20 vdout1_20ck83 = 0 time = 840
* CHECK dout1_21 vdout1_21ck83 = 0 time = 840
* CHECK dout1_22 vdout1_22ck83 = 0 time = 840
* CHECK dout1_23 vdout1_23ck83 = 1.8 time = 840
* CHECK dout1_24 vdout1_24ck83 = 0 time = 840
* CHECK dout1_25 vdout1_25ck83 = 0 time = 840
* CHECK dout1_26 vdout1_26ck83 = 0 time = 840
* CHECK dout1_27 vdout1_27ck83 = 0 time = 840
* CHECK dout1_28 vdout1_28ck83 = 0 time = 840
* CHECK dout1_29 vdout1_29ck83 = 0 time = 840
* CHECK dout1_30 vdout1_30ck83 = 1.8 time = 840
* CHECK dout1_31 vdout1_31ck83 = 0 time = 840
* CHECK dout1_32 vdout1_32ck83 = 1.8 time = 840
* CHECK dout1_33 vdout1_33ck83 = 1.8 time = 840
* CHECK dout1_34 vdout1_34ck83 = 1.8 time = 840
* CHECK dout1_35 vdout1_35ck83 = 0 time = 840
* CHECK dout1_36 vdout1_36ck83 = 0 time = 840
* CHECK dout1_37 vdout1_37ck83 = 1.8 time = 840
* CHECK dout1_38 vdout1_38ck83 = 1.8 time = 840
* CHECK dout1_39 vdout1_39ck83 = 0 time = 840
* CHECK dout1_40 vdout1_40ck83 = 0 time = 840
* CHECK dout1_41 vdout1_41ck83 = 0 time = 840
* CHECK dout1_42 vdout1_42ck83 = 1.8 time = 840
* CHECK dout1_43 vdout1_43ck83 = 1.8 time = 840
* CHECK dout1_44 vdout1_44ck83 = 1.8 time = 840
* CHECK dout1_45 vdout1_45ck83 = 1.8 time = 840
* CHECK dout1_46 vdout1_46ck83 = 0 time = 840
* CHECK dout1_47 vdout1_47ck83 = 0 time = 840
* CHECK dout1_48 vdout1_48ck83 = 1.8 time = 840
* CHECK dout1_49 vdout1_49ck83 = 1.8 time = 840
* CHECK dout1_50 vdout1_50ck83 = 0 time = 840
* CHECK dout1_51 vdout1_51ck83 = 0 time = 840
* CHECK dout1_52 vdout1_52ck83 = 0 time = 840
* CHECK dout1_53 vdout1_53ck83 = 0 time = 840
* CHECK dout1_54 vdout1_54ck83 = 0 time = 840
* CHECK dout1_55 vdout1_55ck83 = 0 time = 840
* CHECK dout1_56 vdout1_56ck83 = 1.8 time = 840
* CHECK dout1_57 vdout1_57ck83 = 0 time = 840
* CHECK dout1_58 vdout1_58ck83 = 0 time = 840
* CHECK dout1_59 vdout1_59ck83 = 0 time = 840
* CHECK dout1_60 vdout1_60ck83 = 0 time = 840
* CHECK dout1_61 vdout1_61ck83 = 1.8 time = 840
* CHECK dout1_62 vdout1_62ck83 = 1.8 time = 840
* CHECK dout1_63 vdout1_63ck83 = 1.8 time = 840
* CHECK dout1_0 vdout1_0ck84 = 1.8 time = 850
* CHECK dout1_1 vdout1_1ck84 = 0 time = 850
* CHECK dout1_2 vdout1_2ck84 = 1.8 time = 850
* CHECK dout1_3 vdout1_3ck84 = 1.8 time = 850
* CHECK dout1_4 vdout1_4ck84 = 0 time = 850
* CHECK dout1_5 vdout1_5ck84 = 1.8 time = 850
* CHECK dout1_6 vdout1_6ck84 = 0 time = 850
* CHECK dout1_7 vdout1_7ck84 = 1.8 time = 850
* CHECK dout1_8 vdout1_8ck84 = 0 time = 850
* CHECK dout1_9 vdout1_9ck84 = 1.8 time = 850
* CHECK dout1_10 vdout1_10ck84 = 0 time = 850
* CHECK dout1_11 vdout1_11ck84 = 1.8 time = 850
* CHECK dout1_12 vdout1_12ck84 = 1.8 time = 850
* CHECK dout1_13 vdout1_13ck84 = 0 time = 850
* CHECK dout1_14 vdout1_14ck84 = 1.8 time = 850
* CHECK dout1_15 vdout1_15ck84 = 1.8 time = 850
* CHECK dout1_16 vdout1_16ck84 = 0 time = 850
* CHECK dout1_17 vdout1_17ck84 = 0 time = 850
* CHECK dout1_18 vdout1_18ck84 = 1.8 time = 850
* CHECK dout1_19 vdout1_19ck84 = 1.8 time = 850
* CHECK dout1_20 vdout1_20ck84 = 0 time = 850
* CHECK dout1_21 vdout1_21ck84 = 1.8 time = 850
* CHECK dout1_22 vdout1_22ck84 = 0 time = 850
* CHECK dout1_23 vdout1_23ck84 = 0 time = 850
* CHECK dout1_24 vdout1_24ck84 = 1.8 time = 850
* CHECK dout1_25 vdout1_25ck84 = 0 time = 850
* CHECK dout1_26 vdout1_26ck84 = 1.8 time = 850
* CHECK dout1_27 vdout1_27ck84 = 0 time = 850
* CHECK dout1_28 vdout1_28ck84 = 1.8 time = 850
* CHECK dout1_29 vdout1_29ck84 = 1.8 time = 850
* CHECK dout1_30 vdout1_30ck84 = 1.8 time = 850
* CHECK dout1_31 vdout1_31ck84 = 1.8 time = 850
* CHECK dout1_32 vdout1_32ck84 = 0 time = 850
* CHECK dout1_33 vdout1_33ck84 = 0 time = 850
* CHECK dout1_34 vdout1_34ck84 = 0 time = 850
* CHECK dout1_35 vdout1_35ck84 = 1.8 time = 850
* CHECK dout1_36 vdout1_36ck84 = 1.8 time = 850
* CHECK dout1_37 vdout1_37ck84 = 0 time = 850
* CHECK dout1_38 vdout1_38ck84 = 0 time = 850
* CHECK dout1_39 vdout1_39ck84 = 1.8 time = 850
* CHECK dout1_40 vdout1_40ck84 = 1.8 time = 850
* CHECK dout1_41 vdout1_41ck84 = 1.8 time = 850
* CHECK dout1_42 vdout1_42ck84 = 0 time = 850
* CHECK dout1_43 vdout1_43ck84 = 0 time = 850
* CHECK dout1_44 vdout1_44ck84 = 1.8 time = 850
* CHECK dout1_45 vdout1_45ck84 = 1.8 time = 850
* CHECK dout1_46 vdout1_46ck84 = 0 time = 850
* CHECK dout1_47 vdout1_47ck84 = 0 time = 850
* CHECK dout1_48 vdout1_48ck84 = 0 time = 850
* CHECK dout1_49 vdout1_49ck84 = 1.8 time = 850
* CHECK dout1_50 vdout1_50ck84 = 1.8 time = 850
* CHECK dout1_51 vdout1_51ck84 = 1.8 time = 850
* CHECK dout1_52 vdout1_52ck84 = 0 time = 850
* CHECK dout1_53 vdout1_53ck84 = 0 time = 850
* CHECK dout1_54 vdout1_54ck84 = 0 time = 850
* CHECK dout1_55 vdout1_55ck84 = 0 time = 850
* CHECK dout1_56 vdout1_56ck84 = 1.8 time = 850
* CHECK dout1_57 vdout1_57ck84 = 0 time = 850
* CHECK dout1_58 vdout1_58ck84 = 1.8 time = 850
* CHECK dout1_59 vdout1_59ck84 = 0 time = 850
* CHECK dout1_60 vdout1_60ck84 = 0 time = 850
* CHECK dout1_61 vdout1_61ck84 = 1.8 time = 850
* CHECK dout1_62 vdout1_62ck84 = 1.8 time = 850
* CHECK dout1_63 vdout1_63ck84 = 1.8 time = 850
* CHECK dout0_0 vdout0_0ck85 = 1.8 time = 860
* CHECK dout0_1 vdout0_1ck85 = 0 time = 860
* CHECK dout0_2 vdout0_2ck85 = 1.8 time = 860
* CHECK dout0_3 vdout0_3ck85 = 1.8 time = 860
* CHECK dout0_4 vdout0_4ck85 = 0 time = 860
* CHECK dout0_5 vdout0_5ck85 = 1.8 time = 860
* CHECK dout0_6 vdout0_6ck85 = 0 time = 860
* CHECK dout0_7 vdout0_7ck85 = 1.8 time = 860
* CHECK dout0_8 vdout0_8ck85 = 0 time = 860
* CHECK dout0_9 vdout0_9ck85 = 1.8 time = 860
* CHECK dout0_10 vdout0_10ck85 = 0 time = 860
* CHECK dout0_11 vdout0_11ck85 = 1.8 time = 860
* CHECK dout0_12 vdout0_12ck85 = 1.8 time = 860
* CHECK dout0_13 vdout0_13ck85 = 0 time = 860
* CHECK dout0_14 vdout0_14ck85 = 1.8 time = 860
* CHECK dout0_15 vdout0_15ck85 = 1.8 time = 860
* CHECK dout0_16 vdout0_16ck85 = 0 time = 860
* CHECK dout0_17 vdout0_17ck85 = 0 time = 860
* CHECK dout0_18 vdout0_18ck85 = 1.8 time = 860
* CHECK dout0_19 vdout0_19ck85 = 1.8 time = 860
* CHECK dout0_20 vdout0_20ck85 = 0 time = 860
* CHECK dout0_21 vdout0_21ck85 = 1.8 time = 860
* CHECK dout0_22 vdout0_22ck85 = 0 time = 860
* CHECK dout0_23 vdout0_23ck85 = 0 time = 860
* CHECK dout0_24 vdout0_24ck85 = 1.8 time = 860
* CHECK dout0_25 vdout0_25ck85 = 0 time = 860
* CHECK dout0_26 vdout0_26ck85 = 1.8 time = 860
* CHECK dout0_27 vdout0_27ck85 = 0 time = 860
* CHECK dout0_28 vdout0_28ck85 = 1.8 time = 860
* CHECK dout0_29 vdout0_29ck85 = 1.8 time = 860
* CHECK dout0_30 vdout0_30ck85 = 1.8 time = 860
* CHECK dout0_31 vdout0_31ck85 = 1.8 time = 860
* CHECK dout0_32 vdout0_32ck85 = 0 time = 860
* CHECK dout0_33 vdout0_33ck85 = 0 time = 860
* CHECK dout0_34 vdout0_34ck85 = 0 time = 860
* CHECK dout0_35 vdout0_35ck85 = 1.8 time = 860
* CHECK dout0_36 vdout0_36ck85 = 1.8 time = 860
* CHECK dout0_37 vdout0_37ck85 = 0 time = 860
* CHECK dout0_38 vdout0_38ck85 = 0 time = 860
* CHECK dout0_39 vdout0_39ck85 = 1.8 time = 860
* CHECK dout0_40 vdout0_40ck85 = 1.8 time = 860
* CHECK dout0_41 vdout0_41ck85 = 1.8 time = 860
* CHECK dout0_42 vdout0_42ck85 = 0 time = 860
* CHECK dout0_43 vdout0_43ck85 = 0 time = 860
* CHECK dout0_44 vdout0_44ck85 = 1.8 time = 860
* CHECK dout0_45 vdout0_45ck85 = 1.8 time = 860
* CHECK dout0_46 vdout0_46ck85 = 0 time = 860
* CHECK dout0_47 vdout0_47ck85 = 0 time = 860
* CHECK dout0_48 vdout0_48ck85 = 0 time = 860
* CHECK dout0_49 vdout0_49ck85 = 1.8 time = 860
* CHECK dout0_50 vdout0_50ck85 = 1.8 time = 860
* CHECK dout0_51 vdout0_51ck85 = 1.8 time = 860
* CHECK dout0_52 vdout0_52ck85 = 0 time = 860
* CHECK dout0_53 vdout0_53ck85 = 0 time = 860
* CHECK dout0_54 vdout0_54ck85 = 0 time = 860
* CHECK dout0_55 vdout0_55ck85 = 0 time = 860
* CHECK dout0_56 vdout0_56ck85 = 1.8 time = 860
* CHECK dout0_57 vdout0_57ck85 = 0 time = 860
* CHECK dout0_58 vdout0_58ck85 = 1.8 time = 860
* CHECK dout0_59 vdout0_59ck85 = 0 time = 860
* CHECK dout0_60 vdout0_60ck85 = 0 time = 860
* CHECK dout0_61 vdout0_61ck85 = 1.8 time = 860
* CHECK dout0_62 vdout0_62ck85 = 1.8 time = 860
* CHECK dout0_63 vdout0_63ck85 = 1.8 time = 860
* CHECK dout0_0 vdout0_0ck86 = 1.8 time = 870
* CHECK dout0_1 vdout0_1ck86 = 0 time = 870
* CHECK dout0_2 vdout0_2ck86 = 1.8 time = 870
* CHECK dout0_3 vdout0_3ck86 = 0 time = 870
* CHECK dout0_4 vdout0_4ck86 = 0 time = 870
* CHECK dout0_5 vdout0_5ck86 = 1.8 time = 870
* CHECK dout0_6 vdout0_6ck86 = 1.8 time = 870
* CHECK dout0_7 vdout0_7ck86 = 0 time = 870
* CHECK dout0_8 vdout0_8ck86 = 0 time = 870
* CHECK dout0_9 vdout0_9ck86 = 1.8 time = 870
* CHECK dout0_10 vdout0_10ck86 = 0 time = 870
* CHECK dout0_11 vdout0_11ck86 = 1.8 time = 870
* CHECK dout0_12 vdout0_12ck86 = 0 time = 870
* CHECK dout0_13 vdout0_13ck86 = 1.8 time = 870
* CHECK dout0_14 vdout0_14ck86 = 1.8 time = 870
* CHECK dout0_15 vdout0_15ck86 = 1.8 time = 870
* CHECK dout0_16 vdout0_16ck86 = 0 time = 870
* CHECK dout0_17 vdout0_17ck86 = 1.8 time = 870
* CHECK dout0_18 vdout0_18ck86 = 1.8 time = 870
* CHECK dout0_19 vdout0_19ck86 = 0 time = 870
* CHECK dout0_20 vdout0_20ck86 = 1.8 time = 870
* CHECK dout0_21 vdout0_21ck86 = 1.8 time = 870
* CHECK dout0_22 vdout0_22ck86 = 0 time = 870
* CHECK dout0_23 vdout0_23ck86 = 1.8 time = 870
* CHECK dout0_24 vdout0_24ck86 = 1.8 time = 870
* CHECK dout0_25 vdout0_25ck86 = 1.8 time = 870
* CHECK dout0_26 vdout0_26ck86 = 1.8 time = 870
* CHECK dout0_27 vdout0_27ck86 = 1.8 time = 870
* CHECK dout0_28 vdout0_28ck86 = 1.8 time = 870
* CHECK dout0_29 vdout0_29ck86 = 0 time = 870
* CHECK dout0_30 vdout0_30ck86 = 0 time = 870
* CHECK dout0_31 vdout0_31ck86 = 1.8 time = 870
* CHECK dout0_32 vdout0_32ck86 = 0 time = 870
* CHECK dout0_33 vdout0_33ck86 = 1.8 time = 870
* CHECK dout0_34 vdout0_34ck86 = 1.8 time = 870
* CHECK dout0_35 vdout0_35ck86 = 0 time = 870
* CHECK dout0_36 vdout0_36ck86 = 0 time = 870
* CHECK dout0_37 vdout0_37ck86 = 1.8 time = 870
* CHECK dout0_38 vdout0_38ck86 = 0 time = 870
* CHECK dout0_39 vdout0_39ck86 = 0 time = 870
* CHECK dout0_40 vdout0_40ck86 = 0 time = 870
* CHECK dout0_41 vdout0_41ck86 = 1.8 time = 870
* CHECK dout0_42 vdout0_42ck86 = 0 time = 870
* CHECK dout0_43 vdout0_43ck86 = 0 time = 870
* CHECK dout0_44 vdout0_44ck86 = 0 time = 870
* CHECK dout0_45 vdout0_45ck86 = 0 time = 870
* CHECK dout0_46 vdout0_46ck86 = 1.8 time = 870
* CHECK dout0_47 vdout0_47ck86 = 0 time = 870
* CHECK dout0_48 vdout0_48ck86 = 1.8 time = 870
* CHECK dout0_49 vdout0_49ck86 = 0 time = 870
* CHECK dout0_50 vdout0_50ck86 = 0 time = 870
* CHECK dout0_51 vdout0_51ck86 = 0 time = 870
* CHECK dout0_52 vdout0_52ck86 = 0 time = 870
* CHECK dout0_53 vdout0_53ck86 = 1.8 time = 870
* CHECK dout0_54 vdout0_54ck86 = 1.8 time = 870
* CHECK dout0_55 vdout0_55ck86 = 0 time = 870
* CHECK dout0_56 vdout0_56ck86 = 0 time = 870
* CHECK dout0_57 vdout0_57ck86 = 1.8 time = 870
* CHECK dout0_58 vdout0_58ck86 = 1.8 time = 870
* CHECK dout0_59 vdout0_59ck86 = 0 time = 870
* CHECK dout0_60 vdout0_60ck86 = 0 time = 870
* CHECK dout0_61 vdout0_61ck86 = 0 time = 870
* CHECK dout0_62 vdout0_62ck86 = 1.8 time = 870
* CHECK dout0_63 vdout0_63ck86 = 1.8 time = 870
* CHECK dout1_0 vdout1_0ck86 = 1.8 time = 870
* CHECK dout1_1 vdout1_1ck86 = 0 time = 870
* CHECK dout1_2 vdout1_2ck86 = 1.8 time = 870
* CHECK dout1_3 vdout1_3ck86 = 1.8 time = 870
* CHECK dout1_4 vdout1_4ck86 = 0 time = 870
* CHECK dout1_5 vdout1_5ck86 = 1.8 time = 870
* CHECK dout1_6 vdout1_6ck86 = 0 time = 870
* CHECK dout1_7 vdout1_7ck86 = 1.8 time = 870
* CHECK dout1_8 vdout1_8ck86 = 0 time = 870
* CHECK dout1_9 vdout1_9ck86 = 1.8 time = 870
* CHECK dout1_10 vdout1_10ck86 = 0 time = 870
* CHECK dout1_11 vdout1_11ck86 = 1.8 time = 870
* CHECK dout1_12 vdout1_12ck86 = 1.8 time = 870
* CHECK dout1_13 vdout1_13ck86 = 0 time = 870
* CHECK dout1_14 vdout1_14ck86 = 1.8 time = 870
* CHECK dout1_15 vdout1_15ck86 = 1.8 time = 870
* CHECK dout1_16 vdout1_16ck86 = 0 time = 870
* CHECK dout1_17 vdout1_17ck86 = 0 time = 870
* CHECK dout1_18 vdout1_18ck86 = 1.8 time = 870
* CHECK dout1_19 vdout1_19ck86 = 1.8 time = 870
* CHECK dout1_20 vdout1_20ck86 = 0 time = 870
* CHECK dout1_21 vdout1_21ck86 = 1.8 time = 870
* CHECK dout1_22 vdout1_22ck86 = 0 time = 870
* CHECK dout1_23 vdout1_23ck86 = 0 time = 870
* CHECK dout1_24 vdout1_24ck86 = 1.8 time = 870
* CHECK dout1_25 vdout1_25ck86 = 0 time = 870
* CHECK dout1_26 vdout1_26ck86 = 1.8 time = 870
* CHECK dout1_27 vdout1_27ck86 = 0 time = 870
* CHECK dout1_28 vdout1_28ck86 = 1.8 time = 870
* CHECK dout1_29 vdout1_29ck86 = 1.8 time = 870
* CHECK dout1_30 vdout1_30ck86 = 1.8 time = 870
* CHECK dout1_31 vdout1_31ck86 = 1.8 time = 870
* CHECK dout1_32 vdout1_32ck86 = 0 time = 870
* CHECK dout1_33 vdout1_33ck86 = 0 time = 870
* CHECK dout1_34 vdout1_34ck86 = 0 time = 870
* CHECK dout1_35 vdout1_35ck86 = 1.8 time = 870
* CHECK dout1_36 vdout1_36ck86 = 1.8 time = 870
* CHECK dout1_37 vdout1_37ck86 = 0 time = 870
* CHECK dout1_38 vdout1_38ck86 = 0 time = 870
* CHECK dout1_39 vdout1_39ck86 = 1.8 time = 870
* CHECK dout1_40 vdout1_40ck86 = 1.8 time = 870
* CHECK dout1_41 vdout1_41ck86 = 1.8 time = 870
* CHECK dout1_42 vdout1_42ck86 = 0 time = 870
* CHECK dout1_43 vdout1_43ck86 = 0 time = 870
* CHECK dout1_44 vdout1_44ck86 = 1.8 time = 870
* CHECK dout1_45 vdout1_45ck86 = 1.8 time = 870
* CHECK dout1_46 vdout1_46ck86 = 0 time = 870
* CHECK dout1_47 vdout1_47ck86 = 0 time = 870
* CHECK dout1_48 vdout1_48ck86 = 0 time = 870
* CHECK dout1_49 vdout1_49ck86 = 1.8 time = 870
* CHECK dout1_50 vdout1_50ck86 = 1.8 time = 870
* CHECK dout1_51 vdout1_51ck86 = 1.8 time = 870
* CHECK dout1_52 vdout1_52ck86 = 0 time = 870
* CHECK dout1_53 vdout1_53ck86 = 0 time = 870
* CHECK dout1_54 vdout1_54ck86 = 0 time = 870
* CHECK dout1_55 vdout1_55ck86 = 0 time = 870
* CHECK dout1_56 vdout1_56ck86 = 1.8 time = 870
* CHECK dout1_57 vdout1_57ck86 = 0 time = 870
* CHECK dout1_58 vdout1_58ck86 = 1.8 time = 870
* CHECK dout1_59 vdout1_59ck86 = 0 time = 870
* CHECK dout1_60 vdout1_60ck86 = 0 time = 870
* CHECK dout1_61 vdout1_61ck86 = 1.8 time = 870
* CHECK dout1_62 vdout1_62ck86 = 1.8 time = 870
* CHECK dout1_63 vdout1_63ck86 = 1.8 time = 870
* CHECK dout0_0 vdout0_0ck88 = 0 time = 890
* CHECK dout0_1 vdout0_1ck88 = 1.8 time = 890
* CHECK dout0_2 vdout0_2ck88 = 1.8 time = 890
* CHECK dout0_3 vdout0_3ck88 = 0 time = 890
* CHECK dout0_4 vdout0_4ck88 = 0 time = 890
* CHECK dout0_5 vdout0_5ck88 = 1.8 time = 890
* CHECK dout0_6 vdout0_6ck88 = 0 time = 890
* CHECK dout0_7 vdout0_7ck88 = 0 time = 890
* CHECK dout0_8 vdout0_8ck88 = 0 time = 890
* CHECK dout0_9 vdout0_9ck88 = 1.8 time = 890
* CHECK dout0_10 vdout0_10ck88 = 0 time = 890
* CHECK dout0_11 vdout0_11ck88 = 0 time = 890
* CHECK dout0_12 vdout0_12ck88 = 1.8 time = 890
* CHECK dout0_13 vdout0_13ck88 = 0 time = 890
* CHECK dout0_14 vdout0_14ck88 = 1.8 time = 890
* CHECK dout0_15 vdout0_15ck88 = 0 time = 890
* CHECK dout0_16 vdout0_16ck88 = 0 time = 890
* CHECK dout0_17 vdout0_17ck88 = 0 time = 890
* CHECK dout0_18 vdout0_18ck88 = 1.8 time = 890
* CHECK dout0_19 vdout0_19ck88 = 0 time = 890
* CHECK dout0_20 vdout0_20ck88 = 0 time = 890
* CHECK dout0_21 vdout0_21ck88 = 1.8 time = 890
* CHECK dout0_22 vdout0_22ck88 = 1.8 time = 890
* CHECK dout0_23 vdout0_23ck88 = 1.8 time = 890
* CHECK dout0_24 vdout0_24ck88 = 0 time = 890
* CHECK dout0_25 vdout0_25ck88 = 0 time = 890
* CHECK dout0_26 vdout0_26ck88 = 0 time = 890
* CHECK dout0_27 vdout0_27ck88 = 1.8 time = 890
* CHECK dout0_28 vdout0_28ck88 = 0 time = 890
* CHECK dout0_29 vdout0_29ck88 = 1.8 time = 890
* CHECK dout0_30 vdout0_30ck88 = 0 time = 890
* CHECK dout0_31 vdout0_31ck88 = 0 time = 890
* CHECK dout0_32 vdout0_32ck88 = 0 time = 890
* CHECK dout0_33 vdout0_33ck88 = 0 time = 890
* CHECK dout0_34 vdout0_34ck88 = 0 time = 890
* CHECK dout0_35 vdout0_35ck88 = 1.8 time = 890
* CHECK dout0_36 vdout0_36ck88 = 0 time = 890
* CHECK dout0_37 vdout0_37ck88 = 1.8 time = 890
* CHECK dout0_38 vdout0_38ck88 = 1.8 time = 890
* CHECK dout0_39 vdout0_39ck88 = 1.8 time = 890
* CHECK dout0_40 vdout0_40ck88 = 0 time = 890
* CHECK dout0_41 vdout0_41ck88 = 1.8 time = 890
* CHECK dout0_42 vdout0_42ck88 = 0 time = 890
* CHECK dout0_43 vdout0_43ck88 = 1.8 time = 890
* CHECK dout0_44 vdout0_44ck88 = 0 time = 890
* CHECK dout0_45 vdout0_45ck88 = 0 time = 890
* CHECK dout0_46 vdout0_46ck88 = 1.8 time = 890
* CHECK dout0_47 vdout0_47ck88 = 1.8 time = 890
* CHECK dout0_48 vdout0_48ck88 = 0 time = 890
* CHECK dout0_49 vdout0_49ck88 = 0 time = 890
* CHECK dout0_50 vdout0_50ck88 = 1.8 time = 890
* CHECK dout0_51 vdout0_51ck88 = 0 time = 890
* CHECK dout0_52 vdout0_52ck88 = 1.8 time = 890
* CHECK dout0_53 vdout0_53ck88 = 1.8 time = 890
* CHECK dout0_54 vdout0_54ck88 = 1.8 time = 890
* CHECK dout0_55 vdout0_55ck88 = 0 time = 890
* CHECK dout0_56 vdout0_56ck88 = 0 time = 890
* CHECK dout0_57 vdout0_57ck88 = 0 time = 890
* CHECK dout0_58 vdout0_58ck88 = 1.8 time = 890
* CHECK dout0_59 vdout0_59ck88 = 0 time = 890
* CHECK dout0_60 vdout0_60ck88 = 0 time = 890
* CHECK dout0_61 vdout0_61ck88 = 0 time = 890
* CHECK dout0_62 vdout0_62ck88 = 0 time = 890
* CHECK dout0_63 vdout0_63ck88 = 1.8 time = 890
* CHECK dout1_0 vdout1_0ck89 = 0 time = 900
* CHECK dout1_1 vdout1_1ck89 = 1.8 time = 900
* CHECK dout1_2 vdout1_2ck89 = 1.8 time = 900
* CHECK dout1_3 vdout1_3ck89 = 0 time = 900
* CHECK dout1_4 vdout1_4ck89 = 1.8 time = 900
* CHECK dout1_5 vdout1_5ck89 = 0 time = 900
* CHECK dout1_6 vdout1_6ck89 = 0 time = 900
* CHECK dout1_7 vdout1_7ck89 = 1.8 time = 900
* CHECK dout1_8 vdout1_8ck89 = 1.8 time = 900
* CHECK dout1_9 vdout1_9ck89 = 0 time = 900
* CHECK dout1_10 vdout1_10ck89 = 1.8 time = 900
* CHECK dout1_11 vdout1_11ck89 = 0 time = 900
* CHECK dout1_12 vdout1_12ck89 = 0 time = 900
* CHECK dout1_13 vdout1_13ck89 = 0 time = 900
* CHECK dout1_14 vdout1_14ck89 = 1.8 time = 900
* CHECK dout1_15 vdout1_15ck89 = 1.8 time = 900
* CHECK dout1_16 vdout1_16ck89 = 1.8 time = 900
* CHECK dout1_17 vdout1_17ck89 = 0 time = 900
* CHECK dout1_18 vdout1_18ck89 = 0 time = 900
* CHECK dout1_19 vdout1_19ck89 = 1.8 time = 900
* CHECK dout1_20 vdout1_20ck89 = 0 time = 900
* CHECK dout1_21 vdout1_21ck89 = 0 time = 900
* CHECK dout1_22 vdout1_22ck89 = 0 time = 900
* CHECK dout1_23 vdout1_23ck89 = 0 time = 900
* CHECK dout1_24 vdout1_24ck89 = 1.8 time = 900
* CHECK dout1_25 vdout1_25ck89 = 0 time = 900
* CHECK dout1_26 vdout1_26ck89 = 0 time = 900
* CHECK dout1_27 vdout1_27ck89 = 1.8 time = 900
* CHECK dout1_28 vdout1_28ck89 = 0 time = 900
* CHECK dout1_29 vdout1_29ck89 = 0 time = 900
* CHECK dout1_30 vdout1_30ck89 = 1.8 time = 900
* CHECK dout1_31 vdout1_31ck89 = 1.8 time = 900
* CHECK dout1_32 vdout1_32ck89 = 0 time = 900
* CHECK dout1_33 vdout1_33ck89 = 1.8 time = 900
* CHECK dout1_34 vdout1_34ck89 = 1.8 time = 900
* CHECK dout1_35 vdout1_35ck89 = 0 time = 900
* CHECK dout1_36 vdout1_36ck89 = 1.8 time = 900
* CHECK dout1_37 vdout1_37ck89 = 0 time = 900
* CHECK dout1_38 vdout1_38ck89 = 0 time = 900
* CHECK dout1_39 vdout1_39ck89 = 1.8 time = 900
* CHECK dout1_40 vdout1_40ck89 = 0 time = 900
* CHECK dout1_41 vdout1_41ck89 = 1.8 time = 900
* CHECK dout1_42 vdout1_42ck89 = 1.8 time = 900
* CHECK dout1_43 vdout1_43ck89 = 0 time = 900
* CHECK dout1_44 vdout1_44ck89 = 1.8 time = 900
* CHECK dout1_45 vdout1_45ck89 = 1.8 time = 900
* CHECK dout1_46 vdout1_46ck89 = 1.8 time = 900
* CHECK dout1_47 vdout1_47ck89 = 1.8 time = 900
* CHECK dout1_48 vdout1_48ck89 = 1.8 time = 900
* CHECK dout1_49 vdout1_49ck89 = 1.8 time = 900
* CHECK dout1_50 vdout1_50ck89 = 0 time = 900
* CHECK dout1_51 vdout1_51ck89 = 0 time = 900
* CHECK dout1_52 vdout1_52ck89 = 1.8 time = 900
* CHECK dout1_53 vdout1_53ck89 = 1.8 time = 900
* CHECK dout1_54 vdout1_54ck89 = 0 time = 900
* CHECK dout1_55 vdout1_55ck89 = 0 time = 900
* CHECK dout1_56 vdout1_56ck89 = 1.8 time = 900
* CHECK dout1_57 vdout1_57ck89 = 0 time = 900
* CHECK dout1_58 vdout1_58ck89 = 0 time = 900
* CHECK dout1_59 vdout1_59ck89 = 1.8 time = 900
* CHECK dout1_60 vdout1_60ck89 = 0 time = 900
* CHECK dout1_61 vdout1_61ck89 = 0 time = 900
* CHECK dout1_62 vdout1_62ck89 = 0 time = 900
* CHECK dout1_63 vdout1_63ck89 = 1.8 time = 900
* CHECK dout0_0 vdout0_0ck90 = 0 time = 910
* CHECK dout0_1 vdout0_1ck90 = 1.8 time = 910
* CHECK dout0_2 vdout0_2ck90 = 1.8 time = 910
* CHECK dout0_3 vdout0_3ck90 = 0 time = 910
* CHECK dout0_4 vdout0_4ck90 = 1.8 time = 910
* CHECK dout0_5 vdout0_5ck90 = 0 time = 910
* CHECK dout0_6 vdout0_6ck90 = 0 time = 910
* CHECK dout0_7 vdout0_7ck90 = 1.8 time = 910
* CHECK dout0_8 vdout0_8ck90 = 1.8 time = 910
* CHECK dout0_9 vdout0_9ck90 = 0 time = 910
* CHECK dout0_10 vdout0_10ck90 = 1.8 time = 910
* CHECK dout0_11 vdout0_11ck90 = 0 time = 910
* CHECK dout0_12 vdout0_12ck90 = 0 time = 910
* CHECK dout0_13 vdout0_13ck90 = 0 time = 910
* CHECK dout0_14 vdout0_14ck90 = 1.8 time = 910
* CHECK dout0_15 vdout0_15ck90 = 1.8 time = 910
* CHECK dout0_16 vdout0_16ck90 = 1.8 time = 910
* CHECK dout0_17 vdout0_17ck90 = 0 time = 910
* CHECK dout0_18 vdout0_18ck90 = 0 time = 910
* CHECK dout0_19 vdout0_19ck90 = 1.8 time = 910
* CHECK dout0_20 vdout0_20ck90 = 0 time = 910
* CHECK dout0_21 vdout0_21ck90 = 0 time = 910
* CHECK dout0_22 vdout0_22ck90 = 0 time = 910
* CHECK dout0_23 vdout0_23ck90 = 0 time = 910
* CHECK dout0_24 vdout0_24ck90 = 1.8 time = 910
* CHECK dout0_25 vdout0_25ck90 = 0 time = 910
* CHECK dout0_26 vdout0_26ck90 = 0 time = 910
* CHECK dout0_27 vdout0_27ck90 = 1.8 time = 910
* CHECK dout0_28 vdout0_28ck90 = 0 time = 910
* CHECK dout0_29 vdout0_29ck90 = 0 time = 910
* CHECK dout0_30 vdout0_30ck90 = 1.8 time = 910
* CHECK dout0_31 vdout0_31ck90 = 1.8 time = 910
* CHECK dout0_32 vdout0_32ck90 = 0 time = 910
* CHECK dout0_33 vdout0_33ck90 = 1.8 time = 910
* CHECK dout0_34 vdout0_34ck90 = 1.8 time = 910
* CHECK dout0_35 vdout0_35ck90 = 0 time = 910
* CHECK dout0_36 vdout0_36ck90 = 1.8 time = 910
* CHECK dout0_37 vdout0_37ck90 = 0 time = 910
* CHECK dout0_38 vdout0_38ck90 = 0 time = 910
* CHECK dout0_39 vdout0_39ck90 = 1.8 time = 910
* CHECK dout0_40 vdout0_40ck90 = 0 time = 910
* CHECK dout0_41 vdout0_41ck90 = 1.8 time = 910
* CHECK dout0_42 vdout0_42ck90 = 1.8 time = 910
* CHECK dout0_43 vdout0_43ck90 = 0 time = 910
* CHECK dout0_44 vdout0_44ck90 = 1.8 time = 910
* CHECK dout0_45 vdout0_45ck90 = 1.8 time = 910
* CHECK dout0_46 vdout0_46ck90 = 1.8 time = 910
* CHECK dout0_47 vdout0_47ck90 = 1.8 time = 910
* CHECK dout0_48 vdout0_48ck90 = 1.8 time = 910
* CHECK dout0_49 vdout0_49ck90 = 1.8 time = 910
* CHECK dout0_50 vdout0_50ck90 = 0 time = 910
* CHECK dout0_51 vdout0_51ck90 = 0 time = 910
* CHECK dout0_52 vdout0_52ck90 = 1.8 time = 910
* CHECK dout0_53 vdout0_53ck90 = 1.8 time = 910
* CHECK dout0_54 vdout0_54ck90 = 0 time = 910
* CHECK dout0_55 vdout0_55ck90 = 0 time = 910
* CHECK dout0_56 vdout0_56ck90 = 1.8 time = 910
* CHECK dout0_57 vdout0_57ck90 = 0 time = 910
* CHECK dout0_58 vdout0_58ck90 = 0 time = 910
* CHECK dout0_59 vdout0_59ck90 = 1.8 time = 910
* CHECK dout0_60 vdout0_60ck90 = 0 time = 910
* CHECK dout0_61 vdout0_61ck90 = 0 time = 910
* CHECK dout0_62 vdout0_62ck90 = 0 time = 910
* CHECK dout0_63 vdout0_63ck90 = 1.8 time = 910
* CHECK dout0_0 vdout0_0ck91 = 0 time = 920
* CHECK dout0_1 vdout0_1ck91 = 1.8 time = 920
* CHECK dout0_2 vdout0_2ck91 = 1.8 time = 920
* CHECK dout0_3 vdout0_3ck91 = 0 time = 920
* CHECK dout0_4 vdout0_4ck91 = 1.8 time = 920
* CHECK dout0_5 vdout0_5ck91 = 0 time = 920
* CHECK dout0_6 vdout0_6ck91 = 0 time = 920
* CHECK dout0_7 vdout0_7ck91 = 1.8 time = 920
* CHECK dout0_8 vdout0_8ck91 = 1.8 time = 920
* CHECK dout0_9 vdout0_9ck91 = 0 time = 920
* CHECK dout0_10 vdout0_10ck91 = 1.8 time = 920
* CHECK dout0_11 vdout0_11ck91 = 0 time = 920
* CHECK dout0_12 vdout0_12ck91 = 0 time = 920
* CHECK dout0_13 vdout0_13ck91 = 0 time = 920
* CHECK dout0_14 vdout0_14ck91 = 1.8 time = 920
* CHECK dout0_15 vdout0_15ck91 = 1.8 time = 920
* CHECK dout0_16 vdout0_16ck91 = 1.8 time = 920
* CHECK dout0_17 vdout0_17ck91 = 0 time = 920
* CHECK dout0_18 vdout0_18ck91 = 0 time = 920
* CHECK dout0_19 vdout0_19ck91 = 1.8 time = 920
* CHECK dout0_20 vdout0_20ck91 = 0 time = 920
* CHECK dout0_21 vdout0_21ck91 = 0 time = 920
* CHECK dout0_22 vdout0_22ck91 = 0 time = 920
* CHECK dout0_23 vdout0_23ck91 = 0 time = 920
* CHECK dout0_24 vdout0_24ck91 = 1.8 time = 920
* CHECK dout0_25 vdout0_25ck91 = 0 time = 920
* CHECK dout0_26 vdout0_26ck91 = 0 time = 920
* CHECK dout0_27 vdout0_27ck91 = 1.8 time = 920
* CHECK dout0_28 vdout0_28ck91 = 0 time = 920
* CHECK dout0_29 vdout0_29ck91 = 0 time = 920
* CHECK dout0_30 vdout0_30ck91 = 1.8 time = 920
* CHECK dout0_31 vdout0_31ck91 = 1.8 time = 920
* CHECK dout0_32 vdout0_32ck91 = 0 time = 920
* CHECK dout0_33 vdout0_33ck91 = 1.8 time = 920
* CHECK dout0_34 vdout0_34ck91 = 1.8 time = 920
* CHECK dout0_35 vdout0_35ck91 = 0 time = 920
* CHECK dout0_36 vdout0_36ck91 = 1.8 time = 920
* CHECK dout0_37 vdout0_37ck91 = 0 time = 920
* CHECK dout0_38 vdout0_38ck91 = 0 time = 920
* CHECK dout0_39 vdout0_39ck91 = 1.8 time = 920
* CHECK dout0_40 vdout0_40ck91 = 0 time = 920
* CHECK dout0_41 vdout0_41ck91 = 1.8 time = 920
* CHECK dout0_42 vdout0_42ck91 = 1.8 time = 920
* CHECK dout0_43 vdout0_43ck91 = 0 time = 920
* CHECK dout0_44 vdout0_44ck91 = 1.8 time = 920
* CHECK dout0_45 vdout0_45ck91 = 1.8 time = 920
* CHECK dout0_46 vdout0_46ck91 = 1.8 time = 920
* CHECK dout0_47 vdout0_47ck91 = 1.8 time = 920
* CHECK dout0_48 vdout0_48ck91 = 1.8 time = 920
* CHECK dout0_49 vdout0_49ck91 = 1.8 time = 920
* CHECK dout0_50 vdout0_50ck91 = 0 time = 920
* CHECK dout0_51 vdout0_51ck91 = 0 time = 920
* CHECK dout0_52 vdout0_52ck91 = 1.8 time = 920
* CHECK dout0_53 vdout0_53ck91 = 1.8 time = 920
* CHECK dout0_54 vdout0_54ck91 = 0 time = 920
* CHECK dout0_55 vdout0_55ck91 = 0 time = 920
* CHECK dout0_56 vdout0_56ck91 = 1.8 time = 920
* CHECK dout0_57 vdout0_57ck91 = 0 time = 920
* CHECK dout0_58 vdout0_58ck91 = 0 time = 920
* CHECK dout0_59 vdout0_59ck91 = 1.8 time = 920
* CHECK dout0_60 vdout0_60ck91 = 0 time = 920
* CHECK dout0_61 vdout0_61ck91 = 0 time = 920
* CHECK dout0_62 vdout0_62ck91 = 0 time = 920
* CHECK dout0_63 vdout0_63ck91 = 1.8 time = 920
* CHECK dout1_0 vdout1_0ck91 = 0 time = 920
* CHECK dout1_1 vdout1_1ck91 = 1.8 time = 920
* CHECK dout1_2 vdout1_2ck91 = 1.8 time = 920
* CHECK dout1_3 vdout1_3ck91 = 0 time = 920
* CHECK dout1_4 vdout1_4ck91 = 1.8 time = 920
* CHECK dout1_5 vdout1_5ck91 = 0 time = 920
* CHECK dout1_6 vdout1_6ck91 = 0 time = 920
* CHECK dout1_7 vdout1_7ck91 = 1.8 time = 920
* CHECK dout1_8 vdout1_8ck91 = 1.8 time = 920
* CHECK dout1_9 vdout1_9ck91 = 0 time = 920
* CHECK dout1_10 vdout1_10ck91 = 1.8 time = 920
* CHECK dout1_11 vdout1_11ck91 = 0 time = 920
* CHECK dout1_12 vdout1_12ck91 = 0 time = 920
* CHECK dout1_13 vdout1_13ck91 = 0 time = 920
* CHECK dout1_14 vdout1_14ck91 = 1.8 time = 920
* CHECK dout1_15 vdout1_15ck91 = 1.8 time = 920
* CHECK dout1_16 vdout1_16ck91 = 1.8 time = 920
* CHECK dout1_17 vdout1_17ck91 = 0 time = 920
* CHECK dout1_18 vdout1_18ck91 = 0 time = 920
* CHECK dout1_19 vdout1_19ck91 = 1.8 time = 920
* CHECK dout1_20 vdout1_20ck91 = 0 time = 920
* CHECK dout1_21 vdout1_21ck91 = 0 time = 920
* CHECK dout1_22 vdout1_22ck91 = 0 time = 920
* CHECK dout1_23 vdout1_23ck91 = 0 time = 920
* CHECK dout1_24 vdout1_24ck91 = 1.8 time = 920
* CHECK dout1_25 vdout1_25ck91 = 0 time = 920
* CHECK dout1_26 vdout1_26ck91 = 0 time = 920
* CHECK dout1_27 vdout1_27ck91 = 1.8 time = 920
* CHECK dout1_28 vdout1_28ck91 = 0 time = 920
* CHECK dout1_29 vdout1_29ck91 = 0 time = 920
* CHECK dout1_30 vdout1_30ck91 = 1.8 time = 920
* CHECK dout1_31 vdout1_31ck91 = 1.8 time = 920
* CHECK dout1_32 vdout1_32ck91 = 0 time = 920
* CHECK dout1_33 vdout1_33ck91 = 1.8 time = 920
* CHECK dout1_34 vdout1_34ck91 = 1.8 time = 920
* CHECK dout1_35 vdout1_35ck91 = 0 time = 920
* CHECK dout1_36 vdout1_36ck91 = 1.8 time = 920
* CHECK dout1_37 vdout1_37ck91 = 0 time = 920
* CHECK dout1_38 vdout1_38ck91 = 0 time = 920
* CHECK dout1_39 vdout1_39ck91 = 1.8 time = 920
* CHECK dout1_40 vdout1_40ck91 = 0 time = 920
* CHECK dout1_41 vdout1_41ck91 = 1.8 time = 920
* CHECK dout1_42 vdout1_42ck91 = 1.8 time = 920
* CHECK dout1_43 vdout1_43ck91 = 0 time = 920
* CHECK dout1_44 vdout1_44ck91 = 1.8 time = 920
* CHECK dout1_45 vdout1_45ck91 = 1.8 time = 920
* CHECK dout1_46 vdout1_46ck91 = 1.8 time = 920
* CHECK dout1_47 vdout1_47ck91 = 1.8 time = 920
* CHECK dout1_48 vdout1_48ck91 = 1.8 time = 920
* CHECK dout1_49 vdout1_49ck91 = 1.8 time = 920
* CHECK dout1_50 vdout1_50ck91 = 0 time = 920
* CHECK dout1_51 vdout1_51ck91 = 0 time = 920
* CHECK dout1_52 vdout1_52ck91 = 1.8 time = 920
* CHECK dout1_53 vdout1_53ck91 = 1.8 time = 920
* CHECK dout1_54 vdout1_54ck91 = 0 time = 920
* CHECK dout1_55 vdout1_55ck91 = 0 time = 920
* CHECK dout1_56 vdout1_56ck91 = 1.8 time = 920
* CHECK dout1_57 vdout1_57ck91 = 0 time = 920
* CHECK dout1_58 vdout1_58ck91 = 0 time = 920
* CHECK dout1_59 vdout1_59ck91 = 1.8 time = 920
* CHECK dout1_60 vdout1_60ck91 = 0 time = 920
* CHECK dout1_61 vdout1_61ck91 = 0 time = 920
* CHECK dout1_62 vdout1_62ck91 = 0 time = 920
* CHECK dout1_63 vdout1_63ck91 = 1.8 time = 920
* CHECK dout0_0 vdout0_0ck92 = 1.8 time = 930
* CHECK dout0_1 vdout0_1ck92 = 0 time = 930
* CHECK dout0_2 vdout0_2ck92 = 1.8 time = 930
* CHECK dout0_3 vdout0_3ck92 = 1.8 time = 930
* CHECK dout0_4 vdout0_4ck92 = 0 time = 930
* CHECK dout0_5 vdout0_5ck92 = 1.8 time = 930
* CHECK dout0_6 vdout0_6ck92 = 0 time = 930
* CHECK dout0_7 vdout0_7ck92 = 1.8 time = 930
* CHECK dout0_8 vdout0_8ck92 = 0 time = 930
* CHECK dout0_9 vdout0_9ck92 = 1.8 time = 930
* CHECK dout0_10 vdout0_10ck92 = 0 time = 930
* CHECK dout0_11 vdout0_11ck92 = 1.8 time = 930
* CHECK dout0_12 vdout0_12ck92 = 1.8 time = 930
* CHECK dout0_13 vdout0_13ck92 = 0 time = 930
* CHECK dout0_14 vdout0_14ck92 = 1.8 time = 930
* CHECK dout0_15 vdout0_15ck92 = 1.8 time = 930
* CHECK dout0_16 vdout0_16ck92 = 0 time = 930
* CHECK dout0_17 vdout0_17ck92 = 0 time = 930
* CHECK dout0_18 vdout0_18ck92 = 1.8 time = 930
* CHECK dout0_19 vdout0_19ck92 = 1.8 time = 930
* CHECK dout0_20 vdout0_20ck92 = 0 time = 930
* CHECK dout0_21 vdout0_21ck92 = 1.8 time = 930
* CHECK dout0_22 vdout0_22ck92 = 0 time = 930
* CHECK dout0_23 vdout0_23ck92 = 0 time = 930
* CHECK dout0_24 vdout0_24ck92 = 1.8 time = 930
* CHECK dout0_25 vdout0_25ck92 = 0 time = 930
* CHECK dout0_26 vdout0_26ck92 = 1.8 time = 930
* CHECK dout0_27 vdout0_27ck92 = 0 time = 930
* CHECK dout0_28 vdout0_28ck92 = 1.8 time = 930
* CHECK dout0_29 vdout0_29ck92 = 1.8 time = 930
* CHECK dout0_30 vdout0_30ck92 = 1.8 time = 930
* CHECK dout0_31 vdout0_31ck92 = 1.8 time = 930
* CHECK dout0_32 vdout0_32ck92 = 0 time = 930
* CHECK dout0_33 vdout0_33ck92 = 0 time = 930
* CHECK dout0_34 vdout0_34ck92 = 0 time = 930
* CHECK dout0_35 vdout0_35ck92 = 1.8 time = 930
* CHECK dout0_36 vdout0_36ck92 = 1.8 time = 930
* CHECK dout0_37 vdout0_37ck92 = 0 time = 930
* CHECK dout0_38 vdout0_38ck92 = 0 time = 930
* CHECK dout0_39 vdout0_39ck92 = 1.8 time = 930
* CHECK dout0_40 vdout0_40ck92 = 1.8 time = 930
* CHECK dout0_41 vdout0_41ck92 = 1.8 time = 930
* CHECK dout0_42 vdout0_42ck92 = 0 time = 930
* CHECK dout0_43 vdout0_43ck92 = 0 time = 930
* CHECK dout0_44 vdout0_44ck92 = 1.8 time = 930
* CHECK dout0_45 vdout0_45ck92 = 1.8 time = 930
* CHECK dout0_46 vdout0_46ck92 = 0 time = 930
* CHECK dout0_47 vdout0_47ck92 = 0 time = 930
* CHECK dout0_48 vdout0_48ck92 = 0 time = 930
* CHECK dout0_49 vdout0_49ck92 = 1.8 time = 930
* CHECK dout0_50 vdout0_50ck92 = 1.8 time = 930
* CHECK dout0_51 vdout0_51ck92 = 1.8 time = 930
* CHECK dout0_52 vdout0_52ck92 = 0 time = 930
* CHECK dout0_53 vdout0_53ck92 = 0 time = 930
* CHECK dout0_54 vdout0_54ck92 = 0 time = 930
* CHECK dout0_55 vdout0_55ck92 = 0 time = 930
* CHECK dout0_56 vdout0_56ck92 = 1.8 time = 930
* CHECK dout0_57 vdout0_57ck92 = 0 time = 930
* CHECK dout0_58 vdout0_58ck92 = 1.8 time = 930
* CHECK dout0_59 vdout0_59ck92 = 0 time = 930
* CHECK dout0_60 vdout0_60ck92 = 0 time = 930
* CHECK dout0_61 vdout0_61ck92 = 1.8 time = 930
* CHECK dout0_62 vdout0_62ck92 = 1.8 time = 930
* CHECK dout0_63 vdout0_63ck92 = 1.8 time = 930
* CHECK dout0_0 vdout0_0ck94 = 0 time = 950
* CHECK dout0_1 vdout0_1ck94 = 1.8 time = 950
* CHECK dout0_2 vdout0_2ck94 = 0 time = 950
* CHECK dout0_3 vdout0_3ck94 = 0 time = 950
* CHECK dout0_4 vdout0_4ck94 = 1.8 time = 950
* CHECK dout0_5 vdout0_5ck94 = 1.8 time = 950
* CHECK dout0_6 vdout0_6ck94 = 1.8 time = 950
* CHECK dout0_7 vdout0_7ck94 = 0 time = 950
* CHECK dout0_8 vdout0_8ck94 = 0 time = 950
* CHECK dout0_9 vdout0_9ck94 = 0 time = 950
* CHECK dout0_10 vdout0_10ck94 = 0 time = 950
* CHECK dout0_11 vdout0_11ck94 = 0 time = 950
* CHECK dout0_12 vdout0_12ck94 = 0 time = 950
* CHECK dout0_13 vdout0_13ck94 = 0 time = 950
* CHECK dout0_14 vdout0_14ck94 = 1.8 time = 950
* CHECK dout0_15 vdout0_15ck94 = 1.8 time = 950
* CHECK dout0_16 vdout0_16ck94 = 0 time = 950
* CHECK dout0_17 vdout0_17ck94 = 1.8 time = 950
* CHECK dout0_18 vdout0_18ck94 = 1.8 time = 950
* CHECK dout0_19 vdout0_19ck94 = 1.8 time = 950
* CHECK dout0_20 vdout0_20ck94 = 1.8 time = 950
* CHECK dout0_21 vdout0_21ck94 = 0 time = 950
* CHECK dout0_22 vdout0_22ck94 = 1.8 time = 950
* CHECK dout0_23 vdout0_23ck94 = 0 time = 950
* CHECK dout0_24 vdout0_24ck94 = 0 time = 950
* CHECK dout0_25 vdout0_25ck94 = 0 time = 950
* CHECK dout0_26 vdout0_26ck94 = 1.8 time = 950
* CHECK dout0_27 vdout0_27ck94 = 1.8 time = 950
* CHECK dout0_28 vdout0_28ck94 = 0 time = 950
* CHECK dout0_29 vdout0_29ck94 = 0 time = 950
* CHECK dout0_30 vdout0_30ck94 = 0 time = 950
* CHECK dout0_31 vdout0_31ck94 = 0 time = 950
* CHECK dout0_32 vdout0_32ck94 = 1.8 time = 950
* CHECK dout0_33 vdout0_33ck94 = 1.8 time = 950
* CHECK dout0_34 vdout0_34ck94 = 1.8 time = 950
* CHECK dout0_35 vdout0_35ck94 = 1.8 time = 950
* CHECK dout0_36 vdout0_36ck94 = 1.8 time = 950
* CHECK dout0_37 vdout0_37ck94 = 0 time = 950
* CHECK dout0_38 vdout0_38ck94 = 0 time = 950
* CHECK dout0_39 vdout0_39ck94 = 0 time = 950
* CHECK dout0_40 vdout0_40ck94 = 1.8 time = 950
* CHECK dout0_41 vdout0_41ck94 = 1.8 time = 950
* CHECK dout0_42 vdout0_42ck94 = 0 time = 950
* CHECK dout0_43 vdout0_43ck94 = 1.8 time = 950
* CHECK dout0_44 vdout0_44ck94 = 0 time = 950
* CHECK dout0_45 vdout0_45ck94 = 1.8 time = 950
* CHECK dout0_46 vdout0_46ck94 = 1.8 time = 950
* CHECK dout0_47 vdout0_47ck94 = 0 time = 950
* CHECK dout0_48 vdout0_48ck94 = 0 time = 950
* CHECK dout0_49 vdout0_49ck94 = 1.8 time = 950
* CHECK dout0_50 vdout0_50ck94 = 1.8 time = 950
* CHECK dout0_51 vdout0_51ck94 = 0 time = 950
* CHECK dout0_52 vdout0_52ck94 = 0 time = 950
* CHECK dout0_53 vdout0_53ck94 = 1.8 time = 950
* CHECK dout0_54 vdout0_54ck94 = 0 time = 950
* CHECK dout0_55 vdout0_55ck94 = 1.8 time = 950
* CHECK dout0_56 vdout0_56ck94 = 1.8 time = 950
* CHECK dout0_57 vdout0_57ck94 = 0 time = 950
* CHECK dout0_58 vdout0_58ck94 = 1.8 time = 950
* CHECK dout0_59 vdout0_59ck94 = 1.8 time = 950
* CHECK dout0_60 vdout0_60ck94 = 0 time = 950
* CHECK dout0_61 vdout0_61ck94 = 1.8 time = 950
* CHECK dout0_62 vdout0_62ck94 = 1.8 time = 950
* CHECK dout0_63 vdout0_63ck94 = 0 time = 950
* CHECK dout0_0 vdout0_0ck95 = 0 time = 960
* CHECK dout0_1 vdout0_1ck95 = 1.8 time = 960
* CHECK dout0_2 vdout0_2ck95 = 1.8 time = 960
* CHECK dout0_3 vdout0_3ck95 = 0 time = 960
* CHECK dout0_4 vdout0_4ck95 = 0 time = 960
* CHECK dout0_5 vdout0_5ck95 = 1.8 time = 960
* CHECK dout0_6 vdout0_6ck95 = 0 time = 960
* CHECK dout0_7 vdout0_7ck95 = 0 time = 960
* CHECK dout0_8 vdout0_8ck95 = 0 time = 960
* CHECK dout0_9 vdout0_9ck95 = 1.8 time = 960
* CHECK dout0_10 vdout0_10ck95 = 0 time = 960
* CHECK dout0_11 vdout0_11ck95 = 0 time = 960
* CHECK dout0_12 vdout0_12ck95 = 1.8 time = 960
* CHECK dout0_13 vdout0_13ck95 = 0 time = 960
* CHECK dout0_14 vdout0_14ck95 = 1.8 time = 960
* CHECK dout0_15 vdout0_15ck95 = 0 time = 960
* CHECK dout0_16 vdout0_16ck95 = 0 time = 960
* CHECK dout0_17 vdout0_17ck95 = 0 time = 960
* CHECK dout0_18 vdout0_18ck95 = 1.8 time = 960
* CHECK dout0_19 vdout0_19ck95 = 0 time = 960
* CHECK dout0_20 vdout0_20ck95 = 0 time = 960
* CHECK dout0_21 vdout0_21ck95 = 1.8 time = 960
* CHECK dout0_22 vdout0_22ck95 = 1.8 time = 960
* CHECK dout0_23 vdout0_23ck95 = 1.8 time = 960
* CHECK dout0_24 vdout0_24ck95 = 0 time = 960
* CHECK dout0_25 vdout0_25ck95 = 0 time = 960
* CHECK dout0_26 vdout0_26ck95 = 0 time = 960
* CHECK dout0_27 vdout0_27ck95 = 1.8 time = 960
* CHECK dout0_28 vdout0_28ck95 = 0 time = 960
* CHECK dout0_29 vdout0_29ck95 = 1.8 time = 960
* CHECK dout0_30 vdout0_30ck95 = 0 time = 960
* CHECK dout0_31 vdout0_31ck95 = 0 time = 960
* CHECK dout0_32 vdout0_32ck95 = 0 time = 960
* CHECK dout0_33 vdout0_33ck95 = 0 time = 960
* CHECK dout0_34 vdout0_34ck95 = 0 time = 960
* CHECK dout0_35 vdout0_35ck95 = 1.8 time = 960
* CHECK dout0_36 vdout0_36ck95 = 0 time = 960
* CHECK dout0_37 vdout0_37ck95 = 1.8 time = 960
* CHECK dout0_38 vdout0_38ck95 = 1.8 time = 960
* CHECK dout0_39 vdout0_39ck95 = 1.8 time = 960
* CHECK dout0_40 vdout0_40ck95 = 0 time = 960
* CHECK dout0_41 vdout0_41ck95 = 1.8 time = 960
* CHECK dout0_42 vdout0_42ck95 = 0 time = 960
* CHECK dout0_43 vdout0_43ck95 = 1.8 time = 960
* CHECK dout0_44 vdout0_44ck95 = 0 time = 960
* CHECK dout0_45 vdout0_45ck95 = 0 time = 960
* CHECK dout0_46 vdout0_46ck95 = 1.8 time = 960
* CHECK dout0_47 vdout0_47ck95 = 1.8 time = 960
* CHECK dout0_48 vdout0_48ck95 = 0 time = 960
* CHECK dout0_49 vdout0_49ck95 = 0 time = 960
* CHECK dout0_50 vdout0_50ck95 = 1.8 time = 960
* CHECK dout0_51 vdout0_51ck95 = 0 time = 960
* CHECK dout0_52 vdout0_52ck95 = 1.8 time = 960
* CHECK dout0_53 vdout0_53ck95 = 1.8 time = 960
* CHECK dout0_54 vdout0_54ck95 = 1.8 time = 960
* CHECK dout0_55 vdout0_55ck95 = 0 time = 960
* CHECK dout0_56 vdout0_56ck95 = 0 time = 960
* CHECK dout0_57 vdout0_57ck95 = 0 time = 960
* CHECK dout0_58 vdout0_58ck95 = 1.8 time = 960
* CHECK dout0_59 vdout0_59ck95 = 0 time = 960
* CHECK dout0_60 vdout0_60ck95 = 0 time = 960
* CHECK dout0_61 vdout0_61ck95 = 0 time = 960
* CHECK dout0_62 vdout0_62ck95 = 0 time = 960
* CHECK dout0_63 vdout0_63ck95 = 1.8 time = 960
* CHECK dout1_0 vdout1_0ck95 = 0 time = 960
* CHECK dout1_1 vdout1_1ck95 = 1.8 time = 960
* CHECK dout1_2 vdout1_2ck95 = 1.8 time = 960
* CHECK dout1_3 vdout1_3ck95 = 0 time = 960
* CHECK dout1_4 vdout1_4ck95 = 0 time = 960
* CHECK dout1_5 vdout1_5ck95 = 1.8 time = 960
* CHECK dout1_6 vdout1_6ck95 = 0 time = 960
* CHECK dout1_7 vdout1_7ck95 = 0 time = 960
* CHECK dout1_8 vdout1_8ck95 = 0 time = 960
* CHECK dout1_9 vdout1_9ck95 = 1.8 time = 960
* CHECK dout1_10 vdout1_10ck95 = 0 time = 960
* CHECK dout1_11 vdout1_11ck95 = 0 time = 960
* CHECK dout1_12 vdout1_12ck95 = 1.8 time = 960
* CHECK dout1_13 vdout1_13ck95 = 0 time = 960
* CHECK dout1_14 vdout1_14ck95 = 1.8 time = 960
* CHECK dout1_15 vdout1_15ck95 = 0 time = 960
* CHECK dout1_16 vdout1_16ck95 = 0 time = 960
* CHECK dout1_17 vdout1_17ck95 = 0 time = 960
* CHECK dout1_18 vdout1_18ck95 = 1.8 time = 960
* CHECK dout1_19 vdout1_19ck95 = 0 time = 960
* CHECK dout1_20 vdout1_20ck95 = 0 time = 960
* CHECK dout1_21 vdout1_21ck95 = 1.8 time = 960
* CHECK dout1_22 vdout1_22ck95 = 1.8 time = 960
* CHECK dout1_23 vdout1_23ck95 = 1.8 time = 960
* CHECK dout1_24 vdout1_24ck95 = 0 time = 960
* CHECK dout1_25 vdout1_25ck95 = 0 time = 960
* CHECK dout1_26 vdout1_26ck95 = 0 time = 960
* CHECK dout1_27 vdout1_27ck95 = 1.8 time = 960
* CHECK dout1_28 vdout1_28ck95 = 0 time = 960
* CHECK dout1_29 vdout1_29ck95 = 1.8 time = 960
* CHECK dout1_30 vdout1_30ck95 = 0 time = 960
* CHECK dout1_31 vdout1_31ck95 = 0 time = 960
* CHECK dout1_32 vdout1_32ck95 = 0 time = 960
* CHECK dout1_33 vdout1_33ck95 = 0 time = 960
* CHECK dout1_34 vdout1_34ck95 = 0 time = 960
* CHECK dout1_35 vdout1_35ck95 = 1.8 time = 960
* CHECK dout1_36 vdout1_36ck95 = 0 time = 960
* CHECK dout1_37 vdout1_37ck95 = 1.8 time = 960
* CHECK dout1_38 vdout1_38ck95 = 1.8 time = 960
* CHECK dout1_39 vdout1_39ck95 = 1.8 time = 960
* CHECK dout1_40 vdout1_40ck95 = 0 time = 960
* CHECK dout1_41 vdout1_41ck95 = 1.8 time = 960
* CHECK dout1_42 vdout1_42ck95 = 0 time = 960
* CHECK dout1_43 vdout1_43ck95 = 1.8 time = 960
* CHECK dout1_44 vdout1_44ck95 = 0 time = 960
* CHECK dout1_45 vdout1_45ck95 = 0 time = 960
* CHECK dout1_46 vdout1_46ck95 = 1.8 time = 960
* CHECK dout1_47 vdout1_47ck95 = 1.8 time = 960
* CHECK dout1_48 vdout1_48ck95 = 0 time = 960
* CHECK dout1_49 vdout1_49ck95 = 0 time = 960
* CHECK dout1_50 vdout1_50ck95 = 1.8 time = 960
* CHECK dout1_51 vdout1_51ck95 = 0 time = 960
* CHECK dout1_52 vdout1_52ck95 = 1.8 time = 960
* CHECK dout1_53 vdout1_53ck95 = 1.8 time = 960
* CHECK dout1_54 vdout1_54ck95 = 1.8 time = 960
* CHECK dout1_55 vdout1_55ck95 = 0 time = 960
* CHECK dout1_56 vdout1_56ck95 = 0 time = 960
* CHECK dout1_57 vdout1_57ck95 = 0 time = 960
* CHECK dout1_58 vdout1_58ck95 = 1.8 time = 960
* CHECK dout1_59 vdout1_59ck95 = 0 time = 960
* CHECK dout1_60 vdout1_60ck95 = 0 time = 960
* CHECK dout1_61 vdout1_61ck95 = 0 time = 960
* CHECK dout1_62 vdout1_62ck95 = 0 time = 960
* CHECK dout1_63 vdout1_63ck95 = 1.8 time = 960
* CHECK dout0_0 vdout0_0ck98 = 0 time = 990
* CHECK dout0_1 vdout0_1ck98 = 1.8 time = 990
* CHECK dout0_2 vdout0_2ck98 = 0 time = 990
* CHECK dout0_3 vdout0_3ck98 = 0 time = 990
* CHECK dout0_4 vdout0_4ck98 = 1.8 time = 990
* CHECK dout0_5 vdout0_5ck98 = 1.8 time = 990
* CHECK dout0_6 vdout0_6ck98 = 1.8 time = 990
* CHECK dout0_7 vdout0_7ck98 = 0 time = 990
* CHECK dout0_8 vdout0_8ck98 = 0 time = 990
* CHECK dout0_9 vdout0_9ck98 = 0 time = 990
* CHECK dout0_10 vdout0_10ck98 = 0 time = 990
* CHECK dout0_11 vdout0_11ck98 = 0 time = 990
* CHECK dout0_12 vdout0_12ck98 = 0 time = 990
* CHECK dout0_13 vdout0_13ck98 = 0 time = 990
* CHECK dout0_14 vdout0_14ck98 = 1.8 time = 990
* CHECK dout0_15 vdout0_15ck98 = 1.8 time = 990
* CHECK dout0_16 vdout0_16ck98 = 0 time = 990
* CHECK dout0_17 vdout0_17ck98 = 1.8 time = 990
* CHECK dout0_18 vdout0_18ck98 = 1.8 time = 990
* CHECK dout0_19 vdout0_19ck98 = 1.8 time = 990
* CHECK dout0_20 vdout0_20ck98 = 1.8 time = 990
* CHECK dout0_21 vdout0_21ck98 = 0 time = 990
* CHECK dout0_22 vdout0_22ck98 = 1.8 time = 990
* CHECK dout0_23 vdout0_23ck98 = 0 time = 990
* CHECK dout0_24 vdout0_24ck98 = 0 time = 990
* CHECK dout0_25 vdout0_25ck98 = 0 time = 990
* CHECK dout0_26 vdout0_26ck98 = 1.8 time = 990
* CHECK dout0_27 vdout0_27ck98 = 1.8 time = 990
* CHECK dout0_28 vdout0_28ck98 = 0 time = 990
* CHECK dout0_29 vdout0_29ck98 = 0 time = 990
* CHECK dout0_30 vdout0_30ck98 = 0 time = 990
* CHECK dout0_31 vdout0_31ck98 = 0 time = 990
* CHECK dout0_32 vdout0_32ck98 = 1.8 time = 990
* CHECK dout0_33 vdout0_33ck98 = 1.8 time = 990
* CHECK dout0_34 vdout0_34ck98 = 1.8 time = 990
* CHECK dout0_35 vdout0_35ck98 = 1.8 time = 990
* CHECK dout0_36 vdout0_36ck98 = 1.8 time = 990
* CHECK dout0_37 vdout0_37ck98 = 0 time = 990
* CHECK dout0_38 vdout0_38ck98 = 0 time = 990
* CHECK dout0_39 vdout0_39ck98 = 0 time = 990
* CHECK dout0_40 vdout0_40ck98 = 1.8 time = 990
* CHECK dout0_41 vdout0_41ck98 = 1.8 time = 990
* CHECK dout0_42 vdout0_42ck98 = 0 time = 990
* CHECK dout0_43 vdout0_43ck98 = 1.8 time = 990
* CHECK dout0_44 vdout0_44ck98 = 0 time = 990
* CHECK dout0_45 vdout0_45ck98 = 1.8 time = 990
* CHECK dout0_46 vdout0_46ck98 = 1.8 time = 990
* CHECK dout0_47 vdout0_47ck98 = 0 time = 990
* CHECK dout0_48 vdout0_48ck98 = 0 time = 990
* CHECK dout0_49 vdout0_49ck98 = 1.8 time = 990
* CHECK dout0_50 vdout0_50ck98 = 1.8 time = 990
* CHECK dout0_51 vdout0_51ck98 = 0 time = 990
* CHECK dout0_52 vdout0_52ck98 = 0 time = 990
* CHECK dout0_53 vdout0_53ck98 = 1.8 time = 990
* CHECK dout0_54 vdout0_54ck98 = 0 time = 990
* CHECK dout0_55 vdout0_55ck98 = 1.8 time = 990
* CHECK dout0_56 vdout0_56ck98 = 1.8 time = 990
* CHECK dout0_57 vdout0_57ck98 = 0 time = 990
* CHECK dout0_58 vdout0_58ck98 = 1.8 time = 990
* CHECK dout0_59 vdout0_59ck98 = 1.8 time = 990
* CHECK dout0_60 vdout0_60ck98 = 0 time = 990
* CHECK dout0_61 vdout0_61ck98 = 1.8 time = 990
* CHECK dout0_62 vdout0_62ck98 = 1.8 time = 990
* CHECK dout0_63 vdout0_63ck98 = 0 time = 990
* CHECK dout0_0 vdout0_0ck99 = 0 time = 1000
* CHECK dout0_1 vdout0_1ck99 = 0 time = 1000
* CHECK dout0_2 vdout0_2ck99 = 0 time = 1000
* CHECK dout0_3 vdout0_3ck99 = 0 time = 1000
* CHECK dout0_4 vdout0_4ck99 = 0 time = 1000
* CHECK dout0_5 vdout0_5ck99 = 0 time = 1000
* CHECK dout0_6 vdout0_6ck99 = 0 time = 1000
* CHECK dout0_7 vdout0_7ck99 = 1.8 time = 1000
* CHECK dout0_8 vdout0_8ck99 = 1.8 time = 1000
* CHECK dout0_9 vdout0_9ck99 = 0 time = 1000
* CHECK dout0_10 vdout0_10ck99 = 1.8 time = 1000
* CHECK dout0_11 vdout0_11ck99 = 1.8 time = 1000
* CHECK dout0_12 vdout0_12ck99 = 1.8 time = 1000
* CHECK dout0_13 vdout0_13ck99 = 1.8 time = 1000
* CHECK dout0_14 vdout0_14ck99 = 1.8 time = 1000
* CHECK dout0_15 vdout0_15ck99 = 0 time = 1000
* CHECK dout0_16 vdout0_16ck99 = 1.8 time = 1000
* CHECK dout0_17 vdout0_17ck99 = 0 time = 1000
* CHECK dout0_18 vdout0_18ck99 = 0 time = 1000
* CHECK dout0_19 vdout0_19ck99 = 0 time = 1000
* CHECK dout0_20 vdout0_20ck99 = 1.8 time = 1000
* CHECK dout0_21 vdout0_21ck99 = 0 time = 1000
* CHECK dout0_22 vdout0_22ck99 = 0 time = 1000
* CHECK dout0_23 vdout0_23ck99 = 1.8 time = 1000
* CHECK dout0_24 vdout0_24ck99 = 0 time = 1000
* CHECK dout0_25 vdout0_25ck99 = 0 time = 1000
* CHECK dout0_26 vdout0_26ck99 = 1.8 time = 1000
* CHECK dout0_27 vdout0_27ck99 = 1.8 time = 1000
* CHECK dout0_28 vdout0_28ck99 = 1.8 time = 1000
* CHECK dout0_29 vdout0_29ck99 = 0 time = 1000
* CHECK dout0_30 vdout0_30ck99 = 1.8 time = 1000
* CHECK dout0_31 vdout0_31ck99 = 0 time = 1000
* CHECK dout0_32 vdout0_32ck99 = 0 time = 1000
* CHECK dout0_33 vdout0_33ck99 = 1.8 time = 1000
* CHECK dout0_34 vdout0_34ck99 = 0 time = 1000
* CHECK dout0_35 vdout0_35ck99 = 0 time = 1000
* CHECK dout0_36 vdout0_36ck99 = 1.8 time = 1000
* CHECK dout0_37 vdout0_37ck99 = 1.8 time = 1000
* CHECK dout0_38 vdout0_38ck99 = 1.8 time = 1000
* CHECK dout0_39 vdout0_39ck99 = 0 time = 1000
* CHECK dout0_40 vdout0_40ck99 = 0 time = 1000
* CHECK dout0_41 vdout0_41ck99 = 1.8 time = 1000
* CHECK dout0_42 vdout0_42ck99 = 1.8 time = 1000
* CHECK dout0_43 vdout0_43ck99 = 0 time = 1000
* CHECK dout0_44 vdout0_44ck99 = 0 time = 1000
* CHECK dout0_45 vdout0_45ck99 = 1.8 time = 1000
* CHECK dout0_46 vdout0_46ck99 = 0 time = 1000
* CHECK dout0_47 vdout0_47ck99 = 1.8 time = 1000
* CHECK dout0_48 vdout0_48ck99 = 1.8 time = 1000
* CHECK dout0_49 vdout0_49ck99 = 1.8 time = 1000
* CHECK dout0_50 vdout0_50ck99 = 0 time = 1000
* CHECK dout0_51 vdout0_51ck99 = 0 time = 1000
* CHECK dout0_52 vdout0_52ck99 = 1.8 time = 1000
* CHECK dout0_53 vdout0_53ck99 = 0 time = 1000
* CHECK dout0_54 vdout0_54ck99 = 1.8 time = 1000
* CHECK dout0_55 vdout0_55ck99 = 1.8 time = 1000
* CHECK dout0_56 vdout0_56ck99 = 0 time = 1000
* CHECK dout0_57 vdout0_57ck99 = 0 time = 1000
* CHECK dout0_58 vdout0_58ck99 = 0 time = 1000
* CHECK dout0_59 vdout0_59ck99 = 0 time = 1000
* CHECK dout0_60 vdout0_60ck99 = 0 time = 1000
* CHECK dout0_61 vdout0_61ck99 = 0 time = 1000
* CHECK dout0_62 vdout0_62ck99 = 1.8 time = 1000
* CHECK dout0_63 vdout0_63ck99 = 1.8 time = 1000
* CHECK dout1_0 vdout1_0ck101 = 0 time = 1020
* CHECK dout1_1 vdout1_1ck101 = 1.8 time = 1020
* CHECK dout1_2 vdout1_2ck101 = 0 time = 1020
* CHECK dout1_3 vdout1_3ck101 = 0 time = 1020
* CHECK dout1_4 vdout1_4ck101 = 1.8 time = 1020
* CHECK dout1_5 vdout1_5ck101 = 1.8 time = 1020
* CHECK dout1_6 vdout1_6ck101 = 1.8 time = 1020
* CHECK dout1_7 vdout1_7ck101 = 0 time = 1020
* CHECK dout1_8 vdout1_8ck101 = 0 time = 1020
* CHECK dout1_9 vdout1_9ck101 = 0 time = 1020
* CHECK dout1_10 vdout1_10ck101 = 0 time = 1020
* CHECK dout1_11 vdout1_11ck101 = 0 time = 1020
* CHECK dout1_12 vdout1_12ck101 = 0 time = 1020
* CHECK dout1_13 vdout1_13ck101 = 0 time = 1020
* CHECK dout1_14 vdout1_14ck101 = 1.8 time = 1020
* CHECK dout1_15 vdout1_15ck101 = 1.8 time = 1020
* CHECK dout1_16 vdout1_16ck101 = 0 time = 1020
* CHECK dout1_17 vdout1_17ck101 = 1.8 time = 1020
* CHECK dout1_18 vdout1_18ck101 = 1.8 time = 1020
* CHECK dout1_19 vdout1_19ck101 = 1.8 time = 1020
* CHECK dout1_20 vdout1_20ck101 = 1.8 time = 1020
* CHECK dout1_21 vdout1_21ck101 = 0 time = 1020
* CHECK dout1_22 vdout1_22ck101 = 1.8 time = 1020
* CHECK dout1_23 vdout1_23ck101 = 0 time = 1020
* CHECK dout1_24 vdout1_24ck101 = 0 time = 1020
* CHECK dout1_25 vdout1_25ck101 = 0 time = 1020
* CHECK dout1_26 vdout1_26ck101 = 1.8 time = 1020
* CHECK dout1_27 vdout1_27ck101 = 1.8 time = 1020
* CHECK dout1_28 vdout1_28ck101 = 0 time = 1020
* CHECK dout1_29 vdout1_29ck101 = 0 time = 1020
* CHECK dout1_30 vdout1_30ck101 = 0 time = 1020
* CHECK dout1_31 vdout1_31ck101 = 0 time = 1020
* CHECK dout1_32 vdout1_32ck101 = 1.8 time = 1020
* CHECK dout1_33 vdout1_33ck101 = 1.8 time = 1020
* CHECK dout1_34 vdout1_34ck101 = 1.8 time = 1020
* CHECK dout1_35 vdout1_35ck101 = 1.8 time = 1020
* CHECK dout1_36 vdout1_36ck101 = 1.8 time = 1020
* CHECK dout1_37 vdout1_37ck101 = 0 time = 1020
* CHECK dout1_38 vdout1_38ck101 = 0 time = 1020
* CHECK dout1_39 vdout1_39ck101 = 0 time = 1020
* CHECK dout1_40 vdout1_40ck101 = 1.8 time = 1020
* CHECK dout1_41 vdout1_41ck101 = 1.8 time = 1020
* CHECK dout1_42 vdout1_42ck101 = 0 time = 1020
* CHECK dout1_43 vdout1_43ck101 = 1.8 time = 1020
* CHECK dout1_44 vdout1_44ck101 = 0 time = 1020
* CHECK dout1_45 vdout1_45ck101 = 1.8 time = 1020
* CHECK dout1_46 vdout1_46ck101 = 1.8 time = 1020
* CHECK dout1_47 vdout1_47ck101 = 0 time = 1020
* CHECK dout1_48 vdout1_48ck101 = 0 time = 1020
* CHECK dout1_49 vdout1_49ck101 = 1.8 time = 1020
* CHECK dout1_50 vdout1_50ck101 = 1.8 time = 1020
* CHECK dout1_51 vdout1_51ck101 = 0 time = 1020
* CHECK dout1_52 vdout1_52ck101 = 0 time = 1020
* CHECK dout1_53 vdout1_53ck101 = 1.8 time = 1020
* CHECK dout1_54 vdout1_54ck101 = 0 time = 1020
* CHECK dout1_55 vdout1_55ck101 = 1.8 time = 1020
* CHECK dout1_56 vdout1_56ck101 = 1.8 time = 1020
* CHECK dout1_57 vdout1_57ck101 = 0 time = 1020
* CHECK dout1_58 vdout1_58ck101 = 1.8 time = 1020
* CHECK dout1_59 vdout1_59ck101 = 1.8 time = 1020
* CHECK dout1_60 vdout1_60ck101 = 0 time = 1020
* CHECK dout1_61 vdout1_61ck101 = 1.8 time = 1020
* CHECK dout1_62 vdout1_62ck101 = 1.8 time = 1020
* CHECK dout1_63 vdout1_63ck101 = 0 time = 1020
* CHECK dout0_0 vdout0_0ck102 = 0 time = 1030
* CHECK dout0_1 vdout0_1ck102 = 0 time = 1030
* CHECK dout0_2 vdout0_2ck102 = 0 time = 1030
* CHECK dout0_3 vdout0_3ck102 = 0 time = 1030
* CHECK dout0_4 vdout0_4ck102 = 0 time = 1030
* CHECK dout0_5 vdout0_5ck102 = 0 time = 1030
* CHECK dout0_6 vdout0_6ck102 = 0 time = 1030
* CHECK dout0_7 vdout0_7ck102 = 1.8 time = 1030
* CHECK dout0_8 vdout0_8ck102 = 1.8 time = 1030
* CHECK dout0_9 vdout0_9ck102 = 0 time = 1030
* CHECK dout0_10 vdout0_10ck102 = 1.8 time = 1030
* CHECK dout0_11 vdout0_11ck102 = 1.8 time = 1030
* CHECK dout0_12 vdout0_12ck102 = 1.8 time = 1030
* CHECK dout0_13 vdout0_13ck102 = 1.8 time = 1030
* CHECK dout0_14 vdout0_14ck102 = 1.8 time = 1030
* CHECK dout0_15 vdout0_15ck102 = 0 time = 1030
* CHECK dout0_16 vdout0_16ck102 = 1.8 time = 1030
* CHECK dout0_17 vdout0_17ck102 = 0 time = 1030
* CHECK dout0_18 vdout0_18ck102 = 0 time = 1030
* CHECK dout0_19 vdout0_19ck102 = 0 time = 1030
* CHECK dout0_20 vdout0_20ck102 = 1.8 time = 1030
* CHECK dout0_21 vdout0_21ck102 = 0 time = 1030
* CHECK dout0_22 vdout0_22ck102 = 0 time = 1030
* CHECK dout0_23 vdout0_23ck102 = 1.8 time = 1030
* CHECK dout0_24 vdout0_24ck102 = 0 time = 1030
* CHECK dout0_25 vdout0_25ck102 = 0 time = 1030
* CHECK dout0_26 vdout0_26ck102 = 1.8 time = 1030
* CHECK dout0_27 vdout0_27ck102 = 1.8 time = 1030
* CHECK dout0_28 vdout0_28ck102 = 1.8 time = 1030
* CHECK dout0_29 vdout0_29ck102 = 0 time = 1030
* CHECK dout0_30 vdout0_30ck102 = 1.8 time = 1030
* CHECK dout0_31 vdout0_31ck102 = 0 time = 1030
* CHECK dout0_32 vdout0_32ck102 = 0 time = 1030
* CHECK dout0_33 vdout0_33ck102 = 1.8 time = 1030
* CHECK dout0_34 vdout0_34ck102 = 0 time = 1030
* CHECK dout0_35 vdout0_35ck102 = 0 time = 1030
* CHECK dout0_36 vdout0_36ck102 = 1.8 time = 1030
* CHECK dout0_37 vdout0_37ck102 = 1.8 time = 1030
* CHECK dout0_38 vdout0_38ck102 = 1.8 time = 1030
* CHECK dout0_39 vdout0_39ck102 = 0 time = 1030
* CHECK dout0_40 vdout0_40ck102 = 0 time = 1030
* CHECK dout0_41 vdout0_41ck102 = 1.8 time = 1030
* CHECK dout0_42 vdout0_42ck102 = 1.8 time = 1030
* CHECK dout0_43 vdout0_43ck102 = 0 time = 1030
* CHECK dout0_44 vdout0_44ck102 = 0 time = 1030
* CHECK dout0_45 vdout0_45ck102 = 1.8 time = 1030
* CHECK dout0_46 vdout0_46ck102 = 0 time = 1030
* CHECK dout0_47 vdout0_47ck102 = 1.8 time = 1030
* CHECK dout0_48 vdout0_48ck102 = 1.8 time = 1030
* CHECK dout0_49 vdout0_49ck102 = 1.8 time = 1030
* CHECK dout0_50 vdout0_50ck102 = 0 time = 1030
* CHECK dout0_51 vdout0_51ck102 = 0 time = 1030
* CHECK dout0_52 vdout0_52ck102 = 1.8 time = 1030
* CHECK dout0_53 vdout0_53ck102 = 0 time = 1030
* CHECK dout0_54 vdout0_54ck102 = 1.8 time = 1030
* CHECK dout0_55 vdout0_55ck102 = 1.8 time = 1030
* CHECK dout0_56 vdout0_56ck102 = 0 time = 1030
* CHECK dout0_57 vdout0_57ck102 = 0 time = 1030
* CHECK dout0_58 vdout0_58ck102 = 0 time = 1030
* CHECK dout0_59 vdout0_59ck102 = 0 time = 1030
* CHECK dout0_60 vdout0_60ck102 = 0 time = 1030
* CHECK dout0_61 vdout0_61ck102 = 0 time = 1030
* CHECK dout0_62 vdout0_62ck102 = 1.8 time = 1030
* CHECK dout0_63 vdout0_63ck102 = 1.8 time = 1030
* CHECK dout1_0 vdout1_0ck103 = 1.8 time = 1040
* CHECK dout1_1 vdout1_1ck103 = 0 time = 1040
* CHECK dout1_2 vdout1_2ck103 = 1.8 time = 1040
* CHECK dout1_3 vdout1_3ck103 = 1.8 time = 1040
* CHECK dout1_4 vdout1_4ck103 = 0 time = 1040
* CHECK dout1_5 vdout1_5ck103 = 1.8 time = 1040
* CHECK dout1_6 vdout1_6ck103 = 0 time = 1040
* CHECK dout1_7 vdout1_7ck103 = 1.8 time = 1040
* CHECK dout1_8 vdout1_8ck103 = 0 time = 1040
* CHECK dout1_9 vdout1_9ck103 = 1.8 time = 1040
* CHECK dout1_10 vdout1_10ck103 = 0 time = 1040
* CHECK dout1_11 vdout1_11ck103 = 1.8 time = 1040
* CHECK dout1_12 vdout1_12ck103 = 1.8 time = 1040
* CHECK dout1_13 vdout1_13ck103 = 0 time = 1040
* CHECK dout1_14 vdout1_14ck103 = 1.8 time = 1040
* CHECK dout1_15 vdout1_15ck103 = 1.8 time = 1040
* CHECK dout1_16 vdout1_16ck103 = 0 time = 1040
* CHECK dout1_17 vdout1_17ck103 = 0 time = 1040
* CHECK dout1_18 vdout1_18ck103 = 1.8 time = 1040
* CHECK dout1_19 vdout1_19ck103 = 1.8 time = 1040
* CHECK dout1_20 vdout1_20ck103 = 0 time = 1040
* CHECK dout1_21 vdout1_21ck103 = 1.8 time = 1040
* CHECK dout1_22 vdout1_22ck103 = 0 time = 1040
* CHECK dout1_23 vdout1_23ck103 = 0 time = 1040
* CHECK dout1_24 vdout1_24ck103 = 1.8 time = 1040
* CHECK dout1_25 vdout1_25ck103 = 0 time = 1040
* CHECK dout1_26 vdout1_26ck103 = 1.8 time = 1040
* CHECK dout1_27 vdout1_27ck103 = 0 time = 1040
* CHECK dout1_28 vdout1_28ck103 = 1.8 time = 1040
* CHECK dout1_29 vdout1_29ck103 = 1.8 time = 1040
* CHECK dout1_30 vdout1_30ck103 = 1.8 time = 1040
* CHECK dout1_31 vdout1_31ck103 = 1.8 time = 1040
* CHECK dout1_32 vdout1_32ck103 = 0 time = 1040
* CHECK dout1_33 vdout1_33ck103 = 0 time = 1040
* CHECK dout1_34 vdout1_34ck103 = 0 time = 1040
* CHECK dout1_35 vdout1_35ck103 = 1.8 time = 1040
* CHECK dout1_36 vdout1_36ck103 = 1.8 time = 1040
* CHECK dout1_37 vdout1_37ck103 = 0 time = 1040
* CHECK dout1_38 vdout1_38ck103 = 0 time = 1040
* CHECK dout1_39 vdout1_39ck103 = 1.8 time = 1040
* CHECK dout1_40 vdout1_40ck103 = 1.8 time = 1040
* CHECK dout1_41 vdout1_41ck103 = 1.8 time = 1040
* CHECK dout1_42 vdout1_42ck103 = 0 time = 1040
* CHECK dout1_43 vdout1_43ck103 = 0 time = 1040
* CHECK dout1_44 vdout1_44ck103 = 1.8 time = 1040
* CHECK dout1_45 vdout1_45ck103 = 1.8 time = 1040
* CHECK dout1_46 vdout1_46ck103 = 0 time = 1040
* CHECK dout1_47 vdout1_47ck103 = 0 time = 1040
* CHECK dout1_48 vdout1_48ck103 = 0 time = 1040
* CHECK dout1_49 vdout1_49ck103 = 1.8 time = 1040
* CHECK dout1_50 vdout1_50ck103 = 1.8 time = 1040
* CHECK dout1_51 vdout1_51ck103 = 1.8 time = 1040
* CHECK dout1_52 vdout1_52ck103 = 0 time = 1040
* CHECK dout1_53 vdout1_53ck103 = 0 time = 1040
* CHECK dout1_54 vdout1_54ck103 = 0 time = 1040
* CHECK dout1_55 vdout1_55ck103 = 0 time = 1040
* CHECK dout1_56 vdout1_56ck103 = 1.8 time = 1040
* CHECK dout1_57 vdout1_57ck103 = 0 time = 1040
* CHECK dout1_58 vdout1_58ck103 = 1.8 time = 1040
* CHECK dout1_59 vdout1_59ck103 = 0 time = 1040
* CHECK dout1_60 vdout1_60ck103 = 0 time = 1040
* CHECK dout1_61 vdout1_61ck103 = 1.8 time = 1040
* CHECK dout1_62 vdout1_62ck103 = 1.8 time = 1040
* CHECK dout1_63 vdout1_63ck103 = 1.8 time = 1040
* CHECK dout0_0 vdout0_0ck105 = 0 time = 1060
* CHECK dout0_1 vdout0_1ck105 = 0 time = 1060
* CHECK dout0_2 vdout0_2ck105 = 0 time = 1060
* CHECK dout0_3 vdout0_3ck105 = 0 time = 1060
* CHECK dout0_4 vdout0_4ck105 = 0 time = 1060
* CHECK dout0_5 vdout0_5ck105 = 0 time = 1060
* CHECK dout0_6 vdout0_6ck105 = 0 time = 1060
* CHECK dout0_7 vdout0_7ck105 = 1.8 time = 1060
* CHECK dout0_8 vdout0_8ck105 = 1.8 time = 1060
* CHECK dout0_9 vdout0_9ck105 = 0 time = 1060
* CHECK dout0_10 vdout0_10ck105 = 1.8 time = 1060
* CHECK dout0_11 vdout0_11ck105 = 1.8 time = 1060
* CHECK dout0_12 vdout0_12ck105 = 1.8 time = 1060
* CHECK dout0_13 vdout0_13ck105 = 1.8 time = 1060
* CHECK dout0_14 vdout0_14ck105 = 1.8 time = 1060
* CHECK dout0_15 vdout0_15ck105 = 0 time = 1060
* CHECK dout0_16 vdout0_16ck105 = 1.8 time = 1060
* CHECK dout0_17 vdout0_17ck105 = 0 time = 1060
* CHECK dout0_18 vdout0_18ck105 = 0 time = 1060
* CHECK dout0_19 vdout0_19ck105 = 0 time = 1060
* CHECK dout0_20 vdout0_20ck105 = 1.8 time = 1060
* CHECK dout0_21 vdout0_21ck105 = 0 time = 1060
* CHECK dout0_22 vdout0_22ck105 = 0 time = 1060
* CHECK dout0_23 vdout0_23ck105 = 1.8 time = 1060
* CHECK dout0_24 vdout0_24ck105 = 0 time = 1060
* CHECK dout0_25 vdout0_25ck105 = 0 time = 1060
* CHECK dout0_26 vdout0_26ck105 = 1.8 time = 1060
* CHECK dout0_27 vdout0_27ck105 = 1.8 time = 1060
* CHECK dout0_28 vdout0_28ck105 = 1.8 time = 1060
* CHECK dout0_29 vdout0_29ck105 = 0 time = 1060
* CHECK dout0_30 vdout0_30ck105 = 1.8 time = 1060
* CHECK dout0_31 vdout0_31ck105 = 0 time = 1060
* CHECK dout0_32 vdout0_32ck105 = 0 time = 1060
* CHECK dout0_33 vdout0_33ck105 = 1.8 time = 1060
* CHECK dout0_34 vdout0_34ck105 = 0 time = 1060
* CHECK dout0_35 vdout0_35ck105 = 0 time = 1060
* CHECK dout0_36 vdout0_36ck105 = 1.8 time = 1060
* CHECK dout0_37 vdout0_37ck105 = 1.8 time = 1060
* CHECK dout0_38 vdout0_38ck105 = 1.8 time = 1060
* CHECK dout0_39 vdout0_39ck105 = 0 time = 1060
* CHECK dout0_40 vdout0_40ck105 = 0 time = 1060
* CHECK dout0_41 vdout0_41ck105 = 1.8 time = 1060
* CHECK dout0_42 vdout0_42ck105 = 1.8 time = 1060
* CHECK dout0_43 vdout0_43ck105 = 0 time = 1060
* CHECK dout0_44 vdout0_44ck105 = 0 time = 1060
* CHECK dout0_45 vdout0_45ck105 = 1.8 time = 1060
* CHECK dout0_46 vdout0_46ck105 = 0 time = 1060
* CHECK dout0_47 vdout0_47ck105 = 1.8 time = 1060
* CHECK dout0_48 vdout0_48ck105 = 1.8 time = 1060
* CHECK dout0_49 vdout0_49ck105 = 1.8 time = 1060
* CHECK dout0_50 vdout0_50ck105 = 0 time = 1060
* CHECK dout0_51 vdout0_51ck105 = 0 time = 1060
* CHECK dout0_52 vdout0_52ck105 = 1.8 time = 1060
* CHECK dout0_53 vdout0_53ck105 = 0 time = 1060
* CHECK dout0_54 vdout0_54ck105 = 1.8 time = 1060
* CHECK dout0_55 vdout0_55ck105 = 1.8 time = 1060
* CHECK dout0_56 vdout0_56ck105 = 0 time = 1060
* CHECK dout0_57 vdout0_57ck105 = 0 time = 1060
* CHECK dout0_58 vdout0_58ck105 = 0 time = 1060
* CHECK dout0_59 vdout0_59ck105 = 0 time = 1060
* CHECK dout0_60 vdout0_60ck105 = 0 time = 1060
* CHECK dout0_61 vdout0_61ck105 = 0 time = 1060
* CHECK dout0_62 vdout0_62ck105 = 1.8 time = 1060
* CHECK dout0_63 vdout0_63ck105 = 1.8 time = 1060
* CHECK dout0_0 vdout0_0ck107 = 1.8 time = 1080
* CHECK dout0_1 vdout0_1ck107 = 0 time = 1080
* CHECK dout0_2 vdout0_2ck107 = 1.8 time = 1080
* CHECK dout0_3 vdout0_3ck107 = 1.8 time = 1080
* CHECK dout0_4 vdout0_4ck107 = 0 time = 1080
* CHECK dout0_5 vdout0_5ck107 = 1.8 time = 1080
* CHECK dout0_6 vdout0_6ck107 = 0 time = 1080
* CHECK dout0_7 vdout0_7ck107 = 1.8 time = 1080
* CHECK dout0_8 vdout0_8ck107 = 0 time = 1080
* CHECK dout0_9 vdout0_9ck107 = 1.8 time = 1080
* CHECK dout0_10 vdout0_10ck107 = 0 time = 1080
* CHECK dout0_11 vdout0_11ck107 = 1.8 time = 1080
* CHECK dout0_12 vdout0_12ck107 = 1.8 time = 1080
* CHECK dout0_13 vdout0_13ck107 = 0 time = 1080
* CHECK dout0_14 vdout0_14ck107 = 1.8 time = 1080
* CHECK dout0_15 vdout0_15ck107 = 1.8 time = 1080
* CHECK dout0_16 vdout0_16ck107 = 0 time = 1080
* CHECK dout0_17 vdout0_17ck107 = 0 time = 1080
* CHECK dout0_18 vdout0_18ck107 = 1.8 time = 1080
* CHECK dout0_19 vdout0_19ck107 = 1.8 time = 1080
* CHECK dout0_20 vdout0_20ck107 = 0 time = 1080
* CHECK dout0_21 vdout0_21ck107 = 1.8 time = 1080
* CHECK dout0_22 vdout0_22ck107 = 0 time = 1080
* CHECK dout0_23 vdout0_23ck107 = 0 time = 1080
* CHECK dout0_24 vdout0_24ck107 = 1.8 time = 1080
* CHECK dout0_25 vdout0_25ck107 = 0 time = 1080
* CHECK dout0_26 vdout0_26ck107 = 1.8 time = 1080
* CHECK dout0_27 vdout0_27ck107 = 0 time = 1080
* CHECK dout0_28 vdout0_28ck107 = 1.8 time = 1080
* CHECK dout0_29 vdout0_29ck107 = 1.8 time = 1080
* CHECK dout0_30 vdout0_30ck107 = 1.8 time = 1080
* CHECK dout0_31 vdout0_31ck107 = 1.8 time = 1080
* CHECK dout0_32 vdout0_32ck107 = 0 time = 1080
* CHECK dout0_33 vdout0_33ck107 = 0 time = 1080
* CHECK dout0_34 vdout0_34ck107 = 0 time = 1080
* CHECK dout0_35 vdout0_35ck107 = 1.8 time = 1080
* CHECK dout0_36 vdout0_36ck107 = 1.8 time = 1080
* CHECK dout0_37 vdout0_37ck107 = 0 time = 1080
* CHECK dout0_38 vdout0_38ck107 = 0 time = 1080
* CHECK dout0_39 vdout0_39ck107 = 1.8 time = 1080
* CHECK dout0_40 vdout0_40ck107 = 1.8 time = 1080
* CHECK dout0_41 vdout0_41ck107 = 1.8 time = 1080
* CHECK dout0_42 vdout0_42ck107 = 0 time = 1080
* CHECK dout0_43 vdout0_43ck107 = 0 time = 1080
* CHECK dout0_44 vdout0_44ck107 = 1.8 time = 1080
* CHECK dout0_45 vdout0_45ck107 = 1.8 time = 1080
* CHECK dout0_46 vdout0_46ck107 = 0 time = 1080
* CHECK dout0_47 vdout0_47ck107 = 0 time = 1080
* CHECK dout0_48 vdout0_48ck107 = 0 time = 1080
* CHECK dout0_49 vdout0_49ck107 = 1.8 time = 1080
* CHECK dout0_50 vdout0_50ck107 = 1.8 time = 1080
* CHECK dout0_51 vdout0_51ck107 = 1.8 time = 1080
* CHECK dout0_52 vdout0_52ck107 = 0 time = 1080
* CHECK dout0_53 vdout0_53ck107 = 0 time = 1080
* CHECK dout0_54 vdout0_54ck107 = 0 time = 1080
* CHECK dout0_55 vdout0_55ck107 = 0 time = 1080
* CHECK dout0_56 vdout0_56ck107 = 1.8 time = 1080
* CHECK dout0_57 vdout0_57ck107 = 0 time = 1080
* CHECK dout0_58 vdout0_58ck107 = 1.8 time = 1080
* CHECK dout0_59 vdout0_59ck107 = 0 time = 1080
* CHECK dout0_60 vdout0_60ck107 = 0 time = 1080
* CHECK dout0_61 vdout0_61ck107 = 1.8 time = 1080
* CHECK dout0_62 vdout0_62ck107 = 1.8 time = 1080
* CHECK dout0_63 vdout0_63ck107 = 1.8 time = 1080
* CHECK dout1_0 vdout1_0ck107 = 0 time = 1080
* CHECK dout1_1 vdout1_1ck107 = 1.8 time = 1080
* CHECK dout1_2 vdout1_2ck107 = 0 time = 1080
* CHECK dout1_3 vdout1_3ck107 = 0 time = 1080
* CHECK dout1_4 vdout1_4ck107 = 1.8 time = 1080
* CHECK dout1_5 vdout1_5ck107 = 1.8 time = 1080
* CHECK dout1_6 vdout1_6ck107 = 1.8 time = 1080
* CHECK dout1_7 vdout1_7ck107 = 0 time = 1080
* CHECK dout1_8 vdout1_8ck107 = 0 time = 1080
* CHECK dout1_9 vdout1_9ck107 = 0 time = 1080
* CHECK dout1_10 vdout1_10ck107 = 0 time = 1080
* CHECK dout1_11 vdout1_11ck107 = 0 time = 1080
* CHECK dout1_12 vdout1_12ck107 = 0 time = 1080
* CHECK dout1_13 vdout1_13ck107 = 0 time = 1080
* CHECK dout1_14 vdout1_14ck107 = 1.8 time = 1080
* CHECK dout1_15 vdout1_15ck107 = 1.8 time = 1080
* CHECK dout1_16 vdout1_16ck107 = 0 time = 1080
* CHECK dout1_17 vdout1_17ck107 = 1.8 time = 1080
* CHECK dout1_18 vdout1_18ck107 = 1.8 time = 1080
* CHECK dout1_19 vdout1_19ck107 = 1.8 time = 1080
* CHECK dout1_20 vdout1_20ck107 = 1.8 time = 1080
* CHECK dout1_21 vdout1_21ck107 = 0 time = 1080
* CHECK dout1_22 vdout1_22ck107 = 1.8 time = 1080
* CHECK dout1_23 vdout1_23ck107 = 0 time = 1080
* CHECK dout1_24 vdout1_24ck107 = 0 time = 1080
* CHECK dout1_25 vdout1_25ck107 = 0 time = 1080
* CHECK dout1_26 vdout1_26ck107 = 1.8 time = 1080
* CHECK dout1_27 vdout1_27ck107 = 1.8 time = 1080
* CHECK dout1_28 vdout1_28ck107 = 0 time = 1080
* CHECK dout1_29 vdout1_29ck107 = 0 time = 1080
* CHECK dout1_30 vdout1_30ck107 = 0 time = 1080
* CHECK dout1_31 vdout1_31ck107 = 0 time = 1080
* CHECK dout1_32 vdout1_32ck107 = 1.8 time = 1080
* CHECK dout1_33 vdout1_33ck107 = 1.8 time = 1080
* CHECK dout1_34 vdout1_34ck107 = 1.8 time = 1080
* CHECK dout1_35 vdout1_35ck107 = 1.8 time = 1080
* CHECK dout1_36 vdout1_36ck107 = 1.8 time = 1080
* CHECK dout1_37 vdout1_37ck107 = 0 time = 1080
* CHECK dout1_38 vdout1_38ck107 = 0 time = 1080
* CHECK dout1_39 vdout1_39ck107 = 0 time = 1080
* CHECK dout1_40 vdout1_40ck107 = 1.8 time = 1080
* CHECK dout1_41 vdout1_41ck107 = 1.8 time = 1080
* CHECK dout1_42 vdout1_42ck107 = 0 time = 1080
* CHECK dout1_43 vdout1_43ck107 = 1.8 time = 1080
* CHECK dout1_44 vdout1_44ck107 = 0 time = 1080
* CHECK dout1_45 vdout1_45ck107 = 1.8 time = 1080
* CHECK dout1_46 vdout1_46ck107 = 1.8 time = 1080
* CHECK dout1_47 vdout1_47ck107 = 0 time = 1080
* CHECK dout1_48 vdout1_48ck107 = 0 time = 1080
* CHECK dout1_49 vdout1_49ck107 = 1.8 time = 1080
* CHECK dout1_50 vdout1_50ck107 = 1.8 time = 1080
* CHECK dout1_51 vdout1_51ck107 = 0 time = 1080
* CHECK dout1_52 vdout1_52ck107 = 0 time = 1080
* CHECK dout1_53 vdout1_53ck107 = 1.8 time = 1080
* CHECK dout1_54 vdout1_54ck107 = 0 time = 1080
* CHECK dout1_55 vdout1_55ck107 = 1.8 time = 1080
* CHECK dout1_56 vdout1_56ck107 = 1.8 time = 1080
* CHECK dout1_57 vdout1_57ck107 = 0 time = 1080
* CHECK dout1_58 vdout1_58ck107 = 1.8 time = 1080
* CHECK dout1_59 vdout1_59ck107 = 1.8 time = 1080
* CHECK dout1_60 vdout1_60ck107 = 0 time = 1080
* CHECK dout1_61 vdout1_61ck107 = 1.8 time = 1080
* CHECK dout1_62 vdout1_62ck107 = 1.8 time = 1080
* CHECK dout1_63 vdout1_63ck107 = 0 time = 1080
* CHECK dout0_0 vdout0_0ck109 = 1.8 time = 1100
* CHECK dout0_1 vdout0_1ck109 = 1.8 time = 1100
* CHECK dout0_2 vdout0_2ck109 = 1.8 time = 1100
* CHECK dout0_3 vdout0_3ck109 = 1.8 time = 1100
* CHECK dout0_4 vdout0_4ck109 = 0 time = 1100
* CHECK dout0_5 vdout0_5ck109 = 1.8 time = 1100
* CHECK dout0_6 vdout0_6ck109 = 1.8 time = 1100
* CHECK dout0_7 vdout0_7ck109 = 0 time = 1100
* CHECK dout0_8 vdout0_8ck109 = 0 time = 1100
* CHECK dout0_9 vdout0_9ck109 = 0 time = 1100
* CHECK dout0_10 vdout0_10ck109 = 0 time = 1100
* CHECK dout0_11 vdout0_11ck109 = 0 time = 1100
* CHECK dout0_12 vdout0_12ck109 = 1.8 time = 1100
* CHECK dout0_13 vdout0_13ck109 = 0 time = 1100
* CHECK dout0_14 vdout0_14ck109 = 0 time = 1100
* CHECK dout0_15 vdout0_15ck109 = 1.8 time = 1100
* CHECK dout0_16 vdout0_16ck109 = 0 time = 1100
* CHECK dout0_17 vdout0_17ck109 = 1.8 time = 1100
* CHECK dout0_18 vdout0_18ck109 = 0 time = 1100
* CHECK dout0_19 vdout0_19ck109 = 0 time = 1100
* CHECK dout0_20 vdout0_20ck109 = 1.8 time = 1100
* CHECK dout0_21 vdout0_21ck109 = 1.8 time = 1100
* CHECK dout0_22 vdout0_22ck109 = 1.8 time = 1100
* CHECK dout0_23 vdout0_23ck109 = 0 time = 1100
* CHECK dout0_24 vdout0_24ck109 = 0 time = 1100
* CHECK dout0_25 vdout0_25ck109 = 0 time = 1100
* CHECK dout0_26 vdout0_26ck109 = 0 time = 1100
* CHECK dout0_27 vdout0_27ck109 = 0 time = 1100
* CHECK dout0_28 vdout0_28ck109 = 0 time = 1100
* CHECK dout0_29 vdout0_29ck109 = 1.8 time = 1100
* CHECK dout0_30 vdout0_30ck109 = 0 time = 1100
* CHECK dout0_31 vdout0_31ck109 = 0 time = 1100
* CHECK dout0_32 vdout0_32ck109 = 0 time = 1100
* CHECK dout0_33 vdout0_33ck109 = 1.8 time = 1100
* CHECK dout0_34 vdout0_34ck109 = 1.8 time = 1100
* CHECK dout0_35 vdout0_35ck109 = 0 time = 1100
* CHECK dout0_36 vdout0_36ck109 = 0 time = 1100
* CHECK dout0_37 vdout0_37ck109 = 0 time = 1100
* CHECK dout0_38 vdout0_38ck109 = 0 time = 1100
* CHECK dout0_39 vdout0_39ck109 = 0 time = 1100
* CHECK dout0_40 vdout0_40ck109 = 1.8 time = 1100
* CHECK dout0_41 vdout0_41ck109 = 0 time = 1100
* CHECK dout0_42 vdout0_42ck109 = 0 time = 1100
* CHECK dout0_43 vdout0_43ck109 = 1.8 time = 1100
* CHECK dout0_44 vdout0_44ck109 = 0 time = 1100
* CHECK dout0_45 vdout0_45ck109 = 1.8 time = 1100
* CHECK dout0_46 vdout0_46ck109 = 0 time = 1100
* CHECK dout0_47 vdout0_47ck109 = 1.8 time = 1100
* CHECK dout0_48 vdout0_48ck109 = 1.8 time = 1100
* CHECK dout0_49 vdout0_49ck109 = 1.8 time = 1100
* CHECK dout0_50 vdout0_50ck109 = 0 time = 1100
* CHECK dout0_51 vdout0_51ck109 = 0 time = 1100
* CHECK dout0_52 vdout0_52ck109 = 0 time = 1100
* CHECK dout0_53 vdout0_53ck109 = 1.8 time = 1100
* CHECK dout0_54 vdout0_54ck109 = 1.8 time = 1100
* CHECK dout0_55 vdout0_55ck109 = 1.8 time = 1100
* CHECK dout0_56 vdout0_56ck109 = 1.8 time = 1100
* CHECK dout0_57 vdout0_57ck109 = 1.8 time = 1100
* CHECK dout0_58 vdout0_58ck109 = 0 time = 1100
* CHECK dout0_59 vdout0_59ck109 = 0 time = 1100
* CHECK dout0_60 vdout0_60ck109 = 1.8 time = 1100
* CHECK dout0_61 vdout0_61ck109 = 0 time = 1100
* CHECK dout0_62 vdout0_62ck109 = 1.8 time = 1100
* CHECK dout0_63 vdout0_63ck109 = 0 time = 1100
* CHECK dout0_0 vdout0_0ck110 = 0 time = 1110
* CHECK dout0_1 vdout0_1ck110 = 1.8 time = 1110
* CHECK dout0_2 vdout0_2ck110 = 0 time = 1110
* CHECK dout0_3 vdout0_3ck110 = 0 time = 1110
* CHECK dout0_4 vdout0_4ck110 = 1.8 time = 1110
* CHECK dout0_5 vdout0_5ck110 = 1.8 time = 1110
* CHECK dout0_6 vdout0_6ck110 = 1.8 time = 1110
* CHECK dout0_7 vdout0_7ck110 = 0 time = 1110
* CHECK dout0_8 vdout0_8ck110 = 0 time = 1110
* CHECK dout0_9 vdout0_9ck110 = 0 time = 1110
* CHECK dout0_10 vdout0_10ck110 = 0 time = 1110
* CHECK dout0_11 vdout0_11ck110 = 0 time = 1110
* CHECK dout0_12 vdout0_12ck110 = 0 time = 1110
* CHECK dout0_13 vdout0_13ck110 = 0 time = 1110
* CHECK dout0_14 vdout0_14ck110 = 1.8 time = 1110
* CHECK dout0_15 vdout0_15ck110 = 1.8 time = 1110
* CHECK dout0_16 vdout0_16ck110 = 0 time = 1110
* CHECK dout0_17 vdout0_17ck110 = 1.8 time = 1110
* CHECK dout0_18 vdout0_18ck110 = 1.8 time = 1110
* CHECK dout0_19 vdout0_19ck110 = 1.8 time = 1110
* CHECK dout0_20 vdout0_20ck110 = 1.8 time = 1110
* CHECK dout0_21 vdout0_21ck110 = 0 time = 1110
* CHECK dout0_22 vdout0_22ck110 = 1.8 time = 1110
* CHECK dout0_23 vdout0_23ck110 = 0 time = 1110
* CHECK dout0_24 vdout0_24ck110 = 0 time = 1110
* CHECK dout0_25 vdout0_25ck110 = 0 time = 1110
* CHECK dout0_26 vdout0_26ck110 = 1.8 time = 1110
* CHECK dout0_27 vdout0_27ck110 = 1.8 time = 1110
* CHECK dout0_28 vdout0_28ck110 = 0 time = 1110
* CHECK dout0_29 vdout0_29ck110 = 0 time = 1110
* CHECK dout0_30 vdout0_30ck110 = 0 time = 1110
* CHECK dout0_31 vdout0_31ck110 = 0 time = 1110
* CHECK dout0_32 vdout0_32ck110 = 1.8 time = 1110
* CHECK dout0_33 vdout0_33ck110 = 1.8 time = 1110
* CHECK dout0_34 vdout0_34ck110 = 1.8 time = 1110
* CHECK dout0_35 vdout0_35ck110 = 1.8 time = 1110
* CHECK dout0_36 vdout0_36ck110 = 1.8 time = 1110
* CHECK dout0_37 vdout0_37ck110 = 0 time = 1110
* CHECK dout0_38 vdout0_38ck110 = 0 time = 1110
* CHECK dout0_39 vdout0_39ck110 = 0 time = 1110
* CHECK dout0_40 vdout0_40ck110 = 1.8 time = 1110
* CHECK dout0_41 vdout0_41ck110 = 1.8 time = 1110
* CHECK dout0_42 vdout0_42ck110 = 0 time = 1110
* CHECK dout0_43 vdout0_43ck110 = 1.8 time = 1110
* CHECK dout0_44 vdout0_44ck110 = 0 time = 1110
* CHECK dout0_45 vdout0_45ck110 = 1.8 time = 1110
* CHECK dout0_46 vdout0_46ck110 = 1.8 time = 1110
* CHECK dout0_47 vdout0_47ck110 = 0 time = 1110
* CHECK dout0_48 vdout0_48ck110 = 0 time = 1110
* CHECK dout0_49 vdout0_49ck110 = 1.8 time = 1110
* CHECK dout0_50 vdout0_50ck110 = 1.8 time = 1110
* CHECK dout0_51 vdout0_51ck110 = 0 time = 1110
* CHECK dout0_52 vdout0_52ck110 = 0 time = 1110
* CHECK dout0_53 vdout0_53ck110 = 1.8 time = 1110
* CHECK dout0_54 vdout0_54ck110 = 0 time = 1110
* CHECK dout0_55 vdout0_55ck110 = 1.8 time = 1110
* CHECK dout0_56 vdout0_56ck110 = 1.8 time = 1110
* CHECK dout0_57 vdout0_57ck110 = 0 time = 1110
* CHECK dout0_58 vdout0_58ck110 = 1.8 time = 1110
* CHECK dout0_59 vdout0_59ck110 = 1.8 time = 1110
* CHECK dout0_60 vdout0_60ck110 = 0 time = 1110
* CHECK dout0_61 vdout0_61ck110 = 1.8 time = 1110
* CHECK dout0_62 vdout0_62ck110 = 1.8 time = 1110
* CHECK dout0_63 vdout0_63ck110 = 0 time = 1110
* CHECK dout0_0 vdout0_0ck111 = 1.8 time = 1120
* CHECK dout0_1 vdout0_1ck111 = 1.8 time = 1120
* CHECK dout0_2 vdout0_2ck111 = 1.8 time = 1120
* CHECK dout0_3 vdout0_3ck111 = 1.8 time = 1120
* CHECK dout0_4 vdout0_4ck111 = 0 time = 1120
* CHECK dout0_5 vdout0_5ck111 = 1.8 time = 1120
* CHECK dout0_6 vdout0_6ck111 = 1.8 time = 1120
* CHECK dout0_7 vdout0_7ck111 = 0 time = 1120
* CHECK dout0_8 vdout0_8ck111 = 0 time = 1120
* CHECK dout0_9 vdout0_9ck111 = 0 time = 1120
* CHECK dout0_10 vdout0_10ck111 = 0 time = 1120
* CHECK dout0_11 vdout0_11ck111 = 0 time = 1120
* CHECK dout0_12 vdout0_12ck111 = 1.8 time = 1120
* CHECK dout0_13 vdout0_13ck111 = 0 time = 1120
* CHECK dout0_14 vdout0_14ck111 = 0 time = 1120
* CHECK dout0_15 vdout0_15ck111 = 1.8 time = 1120
* CHECK dout0_16 vdout0_16ck111 = 0 time = 1120
* CHECK dout0_17 vdout0_17ck111 = 1.8 time = 1120
* CHECK dout0_18 vdout0_18ck111 = 0 time = 1120
* CHECK dout0_19 vdout0_19ck111 = 0 time = 1120
* CHECK dout0_20 vdout0_20ck111 = 1.8 time = 1120
* CHECK dout0_21 vdout0_21ck111 = 1.8 time = 1120
* CHECK dout0_22 vdout0_22ck111 = 1.8 time = 1120
* CHECK dout0_23 vdout0_23ck111 = 0 time = 1120
* CHECK dout0_24 vdout0_24ck111 = 0 time = 1120
* CHECK dout0_25 vdout0_25ck111 = 0 time = 1120
* CHECK dout0_26 vdout0_26ck111 = 0 time = 1120
* CHECK dout0_27 vdout0_27ck111 = 0 time = 1120
* CHECK dout0_28 vdout0_28ck111 = 0 time = 1120
* CHECK dout0_29 vdout0_29ck111 = 1.8 time = 1120
* CHECK dout0_30 vdout0_30ck111 = 0 time = 1120
* CHECK dout0_31 vdout0_31ck111 = 0 time = 1120
* CHECK dout0_32 vdout0_32ck111 = 0 time = 1120
* CHECK dout0_33 vdout0_33ck111 = 1.8 time = 1120
* CHECK dout0_34 vdout0_34ck111 = 1.8 time = 1120
* CHECK dout0_35 vdout0_35ck111 = 0 time = 1120
* CHECK dout0_36 vdout0_36ck111 = 0 time = 1120
* CHECK dout0_37 vdout0_37ck111 = 0 time = 1120
* CHECK dout0_38 vdout0_38ck111 = 0 time = 1120
* CHECK dout0_39 vdout0_39ck111 = 0 time = 1120
* CHECK dout0_40 vdout0_40ck111 = 1.8 time = 1120
* CHECK dout0_41 vdout0_41ck111 = 0 time = 1120
* CHECK dout0_42 vdout0_42ck111 = 0 time = 1120
* CHECK dout0_43 vdout0_43ck111 = 1.8 time = 1120
* CHECK dout0_44 vdout0_44ck111 = 0 time = 1120
* CHECK dout0_45 vdout0_45ck111 = 1.8 time = 1120
* CHECK dout0_46 vdout0_46ck111 = 0 time = 1120
* CHECK dout0_47 vdout0_47ck111 = 1.8 time = 1120
* CHECK dout0_48 vdout0_48ck111 = 1.8 time = 1120
* CHECK dout0_49 vdout0_49ck111 = 1.8 time = 1120
* CHECK dout0_50 vdout0_50ck111 = 0 time = 1120
* CHECK dout0_51 vdout0_51ck111 = 0 time = 1120
* CHECK dout0_52 vdout0_52ck111 = 0 time = 1120
* CHECK dout0_53 vdout0_53ck111 = 1.8 time = 1120
* CHECK dout0_54 vdout0_54ck111 = 1.8 time = 1120
* CHECK dout0_55 vdout0_55ck111 = 1.8 time = 1120
* CHECK dout0_56 vdout0_56ck111 = 1.8 time = 1120
* CHECK dout0_57 vdout0_57ck111 = 1.8 time = 1120
* CHECK dout0_58 vdout0_58ck111 = 0 time = 1120
* CHECK dout0_59 vdout0_59ck111 = 0 time = 1120
* CHECK dout0_60 vdout0_60ck111 = 1.8 time = 1120
* CHECK dout0_61 vdout0_61ck111 = 0 time = 1120
* CHECK dout0_62 vdout0_62ck111 = 1.8 time = 1120
* CHECK dout0_63 vdout0_63ck111 = 0 time = 1120
* CHECK dout1_0 vdout1_0ck111 = 0 time = 1120
* CHECK dout1_1 vdout1_1ck111 = 0 time = 1120
* CHECK dout1_2 vdout1_2ck111 = 0 time = 1120
* CHECK dout1_3 vdout1_3ck111 = 0 time = 1120
* CHECK dout1_4 vdout1_4ck111 = 0 time = 1120
* CHECK dout1_5 vdout1_5ck111 = 0 time = 1120
* CHECK dout1_6 vdout1_6ck111 = 0 time = 1120
* CHECK dout1_7 vdout1_7ck111 = 1.8 time = 1120
* CHECK dout1_8 vdout1_8ck111 = 1.8 time = 1120
* CHECK dout1_9 vdout1_9ck111 = 0 time = 1120
* CHECK dout1_10 vdout1_10ck111 = 1.8 time = 1120
* CHECK dout1_11 vdout1_11ck111 = 1.8 time = 1120
* CHECK dout1_12 vdout1_12ck111 = 1.8 time = 1120
* CHECK dout1_13 vdout1_13ck111 = 1.8 time = 1120
* CHECK dout1_14 vdout1_14ck111 = 1.8 time = 1120
* CHECK dout1_15 vdout1_15ck111 = 0 time = 1120
* CHECK dout1_16 vdout1_16ck111 = 1.8 time = 1120
* CHECK dout1_17 vdout1_17ck111 = 0 time = 1120
* CHECK dout1_18 vdout1_18ck111 = 0 time = 1120
* CHECK dout1_19 vdout1_19ck111 = 0 time = 1120
* CHECK dout1_20 vdout1_20ck111 = 1.8 time = 1120
* CHECK dout1_21 vdout1_21ck111 = 0 time = 1120
* CHECK dout1_22 vdout1_22ck111 = 0 time = 1120
* CHECK dout1_23 vdout1_23ck111 = 1.8 time = 1120
* CHECK dout1_24 vdout1_24ck111 = 0 time = 1120
* CHECK dout1_25 vdout1_25ck111 = 0 time = 1120
* CHECK dout1_26 vdout1_26ck111 = 1.8 time = 1120
* CHECK dout1_27 vdout1_27ck111 = 1.8 time = 1120
* CHECK dout1_28 vdout1_28ck111 = 1.8 time = 1120
* CHECK dout1_29 vdout1_29ck111 = 0 time = 1120
* CHECK dout1_30 vdout1_30ck111 = 1.8 time = 1120
* CHECK dout1_31 vdout1_31ck111 = 0 time = 1120
* CHECK dout1_32 vdout1_32ck111 = 0 time = 1120
* CHECK dout1_33 vdout1_33ck111 = 1.8 time = 1120
* CHECK dout1_34 vdout1_34ck111 = 0 time = 1120
* CHECK dout1_35 vdout1_35ck111 = 0 time = 1120
* CHECK dout1_36 vdout1_36ck111 = 1.8 time = 1120
* CHECK dout1_37 vdout1_37ck111 = 1.8 time = 1120
* CHECK dout1_38 vdout1_38ck111 = 1.8 time = 1120
* CHECK dout1_39 vdout1_39ck111 = 0 time = 1120
* CHECK dout1_40 vdout1_40ck111 = 0 time = 1120
* CHECK dout1_41 vdout1_41ck111 = 1.8 time = 1120
* CHECK dout1_42 vdout1_42ck111 = 1.8 time = 1120
* CHECK dout1_43 vdout1_43ck111 = 0 time = 1120
* CHECK dout1_44 vdout1_44ck111 = 0 time = 1120
* CHECK dout1_45 vdout1_45ck111 = 1.8 time = 1120
* CHECK dout1_46 vdout1_46ck111 = 0 time = 1120
* CHECK dout1_47 vdout1_47ck111 = 1.8 time = 1120
* CHECK dout1_48 vdout1_48ck111 = 1.8 time = 1120
* CHECK dout1_49 vdout1_49ck111 = 1.8 time = 1120
* CHECK dout1_50 vdout1_50ck111 = 0 time = 1120
* CHECK dout1_51 vdout1_51ck111 = 0 time = 1120
* CHECK dout1_52 vdout1_52ck111 = 1.8 time = 1120
* CHECK dout1_53 vdout1_53ck111 = 0 time = 1120
* CHECK dout1_54 vdout1_54ck111 = 1.8 time = 1120
* CHECK dout1_55 vdout1_55ck111 = 1.8 time = 1120
* CHECK dout1_56 vdout1_56ck111 = 0 time = 1120
* CHECK dout1_57 vdout1_57ck111 = 0 time = 1120
* CHECK dout1_58 vdout1_58ck111 = 0 time = 1120
* CHECK dout1_59 vdout1_59ck111 = 0 time = 1120
* CHECK dout1_60 vdout1_60ck111 = 0 time = 1120
* CHECK dout1_61 vdout1_61ck111 = 0 time = 1120
* CHECK dout1_62 vdout1_62ck111 = 1.8 time = 1120
* CHECK dout1_63 vdout1_63ck111 = 1.8 time = 1120
* CHECK dout0_0 vdout0_0ck115 = 1.8 time = 1160
* CHECK dout0_1 vdout0_1ck115 = 0 time = 1160
* CHECK dout0_2 vdout0_2ck115 = 1.8 time = 1160
* CHECK dout0_3 vdout0_3ck115 = 1.8 time = 1160
* CHECK dout0_4 vdout0_4ck115 = 0 time = 1160
* CHECK dout0_5 vdout0_5ck115 = 1.8 time = 1160
* CHECK dout0_6 vdout0_6ck115 = 0 time = 1160
* CHECK dout0_7 vdout0_7ck115 = 1.8 time = 1160
* CHECK dout0_8 vdout0_8ck115 = 0 time = 1160
* CHECK dout0_9 vdout0_9ck115 = 1.8 time = 1160
* CHECK dout0_10 vdout0_10ck115 = 0 time = 1160
* CHECK dout0_11 vdout0_11ck115 = 1.8 time = 1160
* CHECK dout0_12 vdout0_12ck115 = 1.8 time = 1160
* CHECK dout0_13 vdout0_13ck115 = 0 time = 1160
* CHECK dout0_14 vdout0_14ck115 = 1.8 time = 1160
* CHECK dout0_15 vdout0_15ck115 = 1.8 time = 1160
* CHECK dout0_16 vdout0_16ck115 = 0 time = 1160
* CHECK dout0_17 vdout0_17ck115 = 0 time = 1160
* CHECK dout0_18 vdout0_18ck115 = 1.8 time = 1160
* CHECK dout0_19 vdout0_19ck115 = 1.8 time = 1160
* CHECK dout0_20 vdout0_20ck115 = 0 time = 1160
* CHECK dout0_21 vdout0_21ck115 = 1.8 time = 1160
* CHECK dout0_22 vdout0_22ck115 = 0 time = 1160
* CHECK dout0_23 vdout0_23ck115 = 0 time = 1160
* CHECK dout0_24 vdout0_24ck115 = 1.8 time = 1160
* CHECK dout0_25 vdout0_25ck115 = 0 time = 1160
* CHECK dout0_26 vdout0_26ck115 = 1.8 time = 1160
* CHECK dout0_27 vdout0_27ck115 = 0 time = 1160
* CHECK dout0_28 vdout0_28ck115 = 1.8 time = 1160
* CHECK dout0_29 vdout0_29ck115 = 1.8 time = 1160
* CHECK dout0_30 vdout0_30ck115 = 1.8 time = 1160
* CHECK dout0_31 vdout0_31ck115 = 1.8 time = 1160
* CHECK dout0_32 vdout0_32ck115 = 0 time = 1160
* CHECK dout0_33 vdout0_33ck115 = 0 time = 1160
* CHECK dout0_34 vdout0_34ck115 = 0 time = 1160
* CHECK dout0_35 vdout0_35ck115 = 1.8 time = 1160
* CHECK dout0_36 vdout0_36ck115 = 1.8 time = 1160
* CHECK dout0_37 vdout0_37ck115 = 0 time = 1160
* CHECK dout0_38 vdout0_38ck115 = 0 time = 1160
* CHECK dout0_39 vdout0_39ck115 = 1.8 time = 1160
* CHECK dout0_40 vdout0_40ck115 = 1.8 time = 1160
* CHECK dout0_41 vdout0_41ck115 = 1.8 time = 1160
* CHECK dout0_42 vdout0_42ck115 = 0 time = 1160
* CHECK dout0_43 vdout0_43ck115 = 0 time = 1160
* CHECK dout0_44 vdout0_44ck115 = 1.8 time = 1160
* CHECK dout0_45 vdout0_45ck115 = 1.8 time = 1160
* CHECK dout0_46 vdout0_46ck115 = 0 time = 1160
* CHECK dout0_47 vdout0_47ck115 = 0 time = 1160
* CHECK dout0_48 vdout0_48ck115 = 0 time = 1160
* CHECK dout0_49 vdout0_49ck115 = 1.8 time = 1160
* CHECK dout0_50 vdout0_50ck115 = 1.8 time = 1160
* CHECK dout0_51 vdout0_51ck115 = 1.8 time = 1160
* CHECK dout0_52 vdout0_52ck115 = 0 time = 1160
* CHECK dout0_53 vdout0_53ck115 = 0 time = 1160
* CHECK dout0_54 vdout0_54ck115 = 0 time = 1160
* CHECK dout0_55 vdout0_55ck115 = 0 time = 1160
* CHECK dout0_56 vdout0_56ck115 = 1.8 time = 1160
* CHECK dout0_57 vdout0_57ck115 = 0 time = 1160
* CHECK dout0_58 vdout0_58ck115 = 1.8 time = 1160
* CHECK dout0_59 vdout0_59ck115 = 0 time = 1160
* CHECK dout0_60 vdout0_60ck115 = 0 time = 1160
* CHECK dout0_61 vdout0_61ck115 = 1.8 time = 1160
* CHECK dout0_62 vdout0_62ck115 = 1.8 time = 1160
* CHECK dout0_63 vdout0_63ck115 = 1.8 time = 1160
* CHECK dout0_0 vdout0_0ck117 = 1.8 time = 1180
* CHECK dout0_1 vdout0_1ck117 = 1.8 time = 1180
* CHECK dout0_2 vdout0_2ck117 = 1.8 time = 1180
* CHECK dout0_3 vdout0_3ck117 = 1.8 time = 1180
* CHECK dout0_4 vdout0_4ck117 = 0 time = 1180
* CHECK dout0_5 vdout0_5ck117 = 1.8 time = 1180
* CHECK dout0_6 vdout0_6ck117 = 1.8 time = 1180
* CHECK dout0_7 vdout0_7ck117 = 0 time = 1180
* CHECK dout0_8 vdout0_8ck117 = 0 time = 1180
* CHECK dout0_9 vdout0_9ck117 = 0 time = 1180
* CHECK dout0_10 vdout0_10ck117 = 0 time = 1180
* CHECK dout0_11 vdout0_11ck117 = 0 time = 1180
* CHECK dout0_12 vdout0_12ck117 = 1.8 time = 1180
* CHECK dout0_13 vdout0_13ck117 = 0 time = 1180
* CHECK dout0_14 vdout0_14ck117 = 0 time = 1180
* CHECK dout0_15 vdout0_15ck117 = 1.8 time = 1180
* CHECK dout0_16 vdout0_16ck117 = 0 time = 1180
* CHECK dout0_17 vdout0_17ck117 = 1.8 time = 1180
* CHECK dout0_18 vdout0_18ck117 = 0 time = 1180
* CHECK dout0_19 vdout0_19ck117 = 0 time = 1180
* CHECK dout0_20 vdout0_20ck117 = 1.8 time = 1180
* CHECK dout0_21 vdout0_21ck117 = 1.8 time = 1180
* CHECK dout0_22 vdout0_22ck117 = 1.8 time = 1180
* CHECK dout0_23 vdout0_23ck117 = 0 time = 1180
* CHECK dout0_24 vdout0_24ck117 = 0 time = 1180
* CHECK dout0_25 vdout0_25ck117 = 0 time = 1180
* CHECK dout0_26 vdout0_26ck117 = 0 time = 1180
* CHECK dout0_27 vdout0_27ck117 = 0 time = 1180
* CHECK dout0_28 vdout0_28ck117 = 0 time = 1180
* CHECK dout0_29 vdout0_29ck117 = 1.8 time = 1180
* CHECK dout0_30 vdout0_30ck117 = 0 time = 1180
* CHECK dout0_31 vdout0_31ck117 = 0 time = 1180
* CHECK dout0_32 vdout0_32ck117 = 0 time = 1180
* CHECK dout0_33 vdout0_33ck117 = 1.8 time = 1180
* CHECK dout0_34 vdout0_34ck117 = 1.8 time = 1180
* CHECK dout0_35 vdout0_35ck117 = 0 time = 1180
* CHECK dout0_36 vdout0_36ck117 = 0 time = 1180
* CHECK dout0_37 vdout0_37ck117 = 0 time = 1180
* CHECK dout0_38 vdout0_38ck117 = 0 time = 1180
* CHECK dout0_39 vdout0_39ck117 = 0 time = 1180
* CHECK dout0_40 vdout0_40ck117 = 1.8 time = 1180
* CHECK dout0_41 vdout0_41ck117 = 0 time = 1180
* CHECK dout0_42 vdout0_42ck117 = 0 time = 1180
* CHECK dout0_43 vdout0_43ck117 = 1.8 time = 1180
* CHECK dout0_44 vdout0_44ck117 = 0 time = 1180
* CHECK dout0_45 vdout0_45ck117 = 1.8 time = 1180
* CHECK dout0_46 vdout0_46ck117 = 0 time = 1180
* CHECK dout0_47 vdout0_47ck117 = 1.8 time = 1180
* CHECK dout0_48 vdout0_48ck117 = 1.8 time = 1180
* CHECK dout0_49 vdout0_49ck117 = 1.8 time = 1180
* CHECK dout0_50 vdout0_50ck117 = 0 time = 1180
* CHECK dout0_51 vdout0_51ck117 = 0 time = 1180
* CHECK dout0_52 vdout0_52ck117 = 0 time = 1180
* CHECK dout0_53 vdout0_53ck117 = 1.8 time = 1180
* CHECK dout0_54 vdout0_54ck117 = 1.8 time = 1180
* CHECK dout0_55 vdout0_55ck117 = 1.8 time = 1180
* CHECK dout0_56 vdout0_56ck117 = 1.8 time = 1180
* CHECK dout0_57 vdout0_57ck117 = 1.8 time = 1180
* CHECK dout0_58 vdout0_58ck117 = 0 time = 1180
* CHECK dout0_59 vdout0_59ck117 = 0 time = 1180
* CHECK dout0_60 vdout0_60ck117 = 1.8 time = 1180
* CHECK dout0_61 vdout0_61ck117 = 0 time = 1180
* CHECK dout0_62 vdout0_62ck117 = 1.8 time = 1180
* CHECK dout0_63 vdout0_63ck117 = 0 time = 1180
* CHECK dout0_0 vdout0_0ck118 = 1.8 time = 1190
* CHECK dout0_1 vdout0_1ck118 = 0 time = 1190
* CHECK dout0_2 vdout0_2ck118 = 1.8 time = 1190
* CHECK dout0_3 vdout0_3ck118 = 1.8 time = 1190
* CHECK dout0_4 vdout0_4ck118 = 0 time = 1190
* CHECK dout0_5 vdout0_5ck118 = 1.8 time = 1190
* CHECK dout0_6 vdout0_6ck118 = 0 time = 1190
* CHECK dout0_7 vdout0_7ck118 = 1.8 time = 1190
* CHECK dout0_8 vdout0_8ck118 = 0 time = 1190
* CHECK dout0_9 vdout0_9ck118 = 1.8 time = 1190
* CHECK dout0_10 vdout0_10ck118 = 0 time = 1190
* CHECK dout0_11 vdout0_11ck118 = 1.8 time = 1190
* CHECK dout0_12 vdout0_12ck118 = 1.8 time = 1190
* CHECK dout0_13 vdout0_13ck118 = 0 time = 1190
* CHECK dout0_14 vdout0_14ck118 = 1.8 time = 1190
* CHECK dout0_15 vdout0_15ck118 = 1.8 time = 1190
* CHECK dout0_16 vdout0_16ck118 = 0 time = 1190
* CHECK dout0_17 vdout0_17ck118 = 0 time = 1190
* CHECK dout0_18 vdout0_18ck118 = 1.8 time = 1190
* CHECK dout0_19 vdout0_19ck118 = 1.8 time = 1190
* CHECK dout0_20 vdout0_20ck118 = 0 time = 1190
* CHECK dout0_21 vdout0_21ck118 = 1.8 time = 1190
* CHECK dout0_22 vdout0_22ck118 = 0 time = 1190
* CHECK dout0_23 vdout0_23ck118 = 0 time = 1190
* CHECK dout0_24 vdout0_24ck118 = 1.8 time = 1190
* CHECK dout0_25 vdout0_25ck118 = 0 time = 1190
* CHECK dout0_26 vdout0_26ck118 = 1.8 time = 1190
* CHECK dout0_27 vdout0_27ck118 = 0 time = 1190
* CHECK dout0_28 vdout0_28ck118 = 1.8 time = 1190
* CHECK dout0_29 vdout0_29ck118 = 1.8 time = 1190
* CHECK dout0_30 vdout0_30ck118 = 1.8 time = 1190
* CHECK dout0_31 vdout0_31ck118 = 1.8 time = 1190
* CHECK dout0_32 vdout0_32ck118 = 0 time = 1190
* CHECK dout0_33 vdout0_33ck118 = 0 time = 1190
* CHECK dout0_34 vdout0_34ck118 = 0 time = 1190
* CHECK dout0_35 vdout0_35ck118 = 1.8 time = 1190
* CHECK dout0_36 vdout0_36ck118 = 1.8 time = 1190
* CHECK dout0_37 vdout0_37ck118 = 0 time = 1190
* CHECK dout0_38 vdout0_38ck118 = 0 time = 1190
* CHECK dout0_39 vdout0_39ck118 = 1.8 time = 1190
* CHECK dout0_40 vdout0_40ck118 = 1.8 time = 1190
* CHECK dout0_41 vdout0_41ck118 = 1.8 time = 1190
* CHECK dout0_42 vdout0_42ck118 = 0 time = 1190
* CHECK dout0_43 vdout0_43ck118 = 0 time = 1190
* CHECK dout0_44 vdout0_44ck118 = 1.8 time = 1190
* CHECK dout0_45 vdout0_45ck118 = 1.8 time = 1190
* CHECK dout0_46 vdout0_46ck118 = 0 time = 1190
* CHECK dout0_47 vdout0_47ck118 = 0 time = 1190
* CHECK dout0_48 vdout0_48ck118 = 0 time = 1190
* CHECK dout0_49 vdout0_49ck118 = 1.8 time = 1190
* CHECK dout0_50 vdout0_50ck118 = 1.8 time = 1190
* CHECK dout0_51 vdout0_51ck118 = 1.8 time = 1190
* CHECK dout0_52 vdout0_52ck118 = 0 time = 1190
* CHECK dout0_53 vdout0_53ck118 = 0 time = 1190
* CHECK dout0_54 vdout0_54ck118 = 0 time = 1190
* CHECK dout0_55 vdout0_55ck118 = 0 time = 1190
* CHECK dout0_56 vdout0_56ck118 = 1.8 time = 1190
* CHECK dout0_57 vdout0_57ck118 = 0 time = 1190
* CHECK dout0_58 vdout0_58ck118 = 1.8 time = 1190
* CHECK dout0_59 vdout0_59ck118 = 0 time = 1190
* CHECK dout0_60 vdout0_60ck118 = 0 time = 1190
* CHECK dout0_61 vdout0_61ck118 = 1.8 time = 1190
* CHECK dout0_62 vdout0_62ck118 = 1.8 time = 1190
* CHECK dout0_63 vdout0_63ck118 = 1.8 time = 1190
* CHECK dout0_0 vdout0_0ck119 = 0 time = 1200
* CHECK dout0_1 vdout0_1ck119 = 1.8 time = 1200
* CHECK dout0_2 vdout0_2ck119 = 0 time = 1200
* CHECK dout0_3 vdout0_3ck119 = 0 time = 1200
* CHECK dout0_4 vdout0_4ck119 = 1.8 time = 1200
* CHECK dout0_5 vdout0_5ck119 = 0 time = 1200
* CHECK dout0_6 vdout0_6ck119 = 0 time = 1200
* CHECK dout0_7 vdout0_7ck119 = 0 time = 1200
* CHECK dout0_8 vdout0_8ck119 = 1.8 time = 1200
* CHECK dout0_9 vdout0_9ck119 = 0 time = 1200
* CHECK dout0_10 vdout0_10ck119 = 0 time = 1200
* CHECK dout0_11 vdout0_11ck119 = 1.8 time = 1200
* CHECK dout0_12 vdout0_12ck119 = 1.8 time = 1200
* CHECK dout0_13 vdout0_13ck119 = 1.8 time = 1200
* CHECK dout0_14 vdout0_14ck119 = 1.8 time = 1200
* CHECK dout0_15 vdout0_15ck119 = 1.8 time = 1200
* CHECK dout0_16 vdout0_16ck119 = 1.8 time = 1200
* CHECK dout0_17 vdout0_17ck119 = 0 time = 1200
* CHECK dout0_18 vdout0_18ck119 = 0 time = 1200
* CHECK dout0_19 vdout0_19ck119 = 0 time = 1200
* CHECK dout0_20 vdout0_20ck119 = 1.8 time = 1200
* CHECK dout0_21 vdout0_21ck119 = 0 time = 1200
* CHECK dout0_22 vdout0_22ck119 = 1.8 time = 1200
* CHECK dout0_23 vdout0_23ck119 = 0 time = 1200
* CHECK dout0_24 vdout0_24ck119 = 0 time = 1200
* CHECK dout0_25 vdout0_25ck119 = 1.8 time = 1200
* CHECK dout0_26 vdout0_26ck119 = 1.8 time = 1200
* CHECK dout0_27 vdout0_27ck119 = 0 time = 1200
* CHECK dout0_28 vdout0_28ck119 = 0 time = 1200
* CHECK dout0_29 vdout0_29ck119 = 0 time = 1200
* CHECK dout0_30 vdout0_30ck119 = 1.8 time = 1200
* CHECK dout0_31 vdout0_31ck119 = 0 time = 1200
* CHECK dout0_32 vdout0_32ck119 = 0 time = 1200
* CHECK dout0_33 vdout0_33ck119 = 0 time = 1200
* CHECK dout0_34 vdout0_34ck119 = 1.8 time = 1200
* CHECK dout0_35 vdout0_35ck119 = 0 time = 1200
* CHECK dout0_36 vdout0_36ck119 = 0 time = 1200
* CHECK dout0_37 vdout0_37ck119 = 0 time = 1200
* CHECK dout0_38 vdout0_38ck119 = 0 time = 1200
* CHECK dout0_39 vdout0_39ck119 = 1.8 time = 1200
* CHECK dout0_40 vdout0_40ck119 = 1.8 time = 1200
* CHECK dout0_41 vdout0_41ck119 = 0 time = 1200
* CHECK dout0_42 vdout0_42ck119 = 0 time = 1200
* CHECK dout0_43 vdout0_43ck119 = 0 time = 1200
* CHECK dout0_44 vdout0_44ck119 = 0 time = 1200
* CHECK dout0_45 vdout0_45ck119 = 0 time = 1200
* CHECK dout0_46 vdout0_46ck119 = 1.8 time = 1200
* CHECK dout0_47 vdout0_47ck119 = 1.8 time = 1200
* CHECK dout0_48 vdout0_48ck119 = 1.8 time = 1200
* CHECK dout0_49 vdout0_49ck119 = 1.8 time = 1200
* CHECK dout0_50 vdout0_50ck119 = 0 time = 1200
* CHECK dout0_51 vdout0_51ck119 = 1.8 time = 1200
* CHECK dout0_52 vdout0_52ck119 = 1.8 time = 1200
* CHECK dout0_53 vdout0_53ck119 = 1.8 time = 1200
* CHECK dout0_54 vdout0_54ck119 = 1.8 time = 1200
* CHECK dout0_55 vdout0_55ck119 = 1.8 time = 1200
* CHECK dout0_56 vdout0_56ck119 = 1.8 time = 1200
* CHECK dout0_57 vdout0_57ck119 = 1.8 time = 1200
* CHECK dout0_58 vdout0_58ck119 = 0 time = 1200
* CHECK dout0_59 vdout0_59ck119 = 1.8 time = 1200
* CHECK dout0_60 vdout0_60ck119 = 1.8 time = 1200
* CHECK dout0_61 vdout0_61ck119 = 1.8 time = 1200
* CHECK dout0_62 vdout0_62ck119 = 0 time = 1200
* CHECK dout0_63 vdout0_63ck119 = 0 time = 1200
* CHECK dout0_0 vdout0_0ck120 = 0 time = 1210
* CHECK dout0_1 vdout0_1ck120 = 1.8 time = 1210
* CHECK dout0_2 vdout0_2ck120 = 0 time = 1210
* CHECK dout0_3 vdout0_3ck120 = 0 time = 1210
* CHECK dout0_4 vdout0_4ck120 = 1.8 time = 1210
* CHECK dout0_5 vdout0_5ck120 = 1.8 time = 1210
* CHECK dout0_6 vdout0_6ck120 = 1.8 time = 1210
* CHECK dout0_7 vdout0_7ck120 = 0 time = 1210
* CHECK dout0_8 vdout0_8ck120 = 0 time = 1210
* CHECK dout0_9 vdout0_9ck120 = 0 time = 1210
* CHECK dout0_10 vdout0_10ck120 = 0 time = 1210
* CHECK dout0_11 vdout0_11ck120 = 0 time = 1210
* CHECK dout0_12 vdout0_12ck120 = 0 time = 1210
* CHECK dout0_13 vdout0_13ck120 = 0 time = 1210
* CHECK dout0_14 vdout0_14ck120 = 1.8 time = 1210
* CHECK dout0_15 vdout0_15ck120 = 1.8 time = 1210
* CHECK dout0_16 vdout0_16ck120 = 0 time = 1210
* CHECK dout0_17 vdout0_17ck120 = 1.8 time = 1210
* CHECK dout0_18 vdout0_18ck120 = 1.8 time = 1210
* CHECK dout0_19 vdout0_19ck120 = 1.8 time = 1210
* CHECK dout0_20 vdout0_20ck120 = 1.8 time = 1210
* CHECK dout0_21 vdout0_21ck120 = 0 time = 1210
* CHECK dout0_22 vdout0_22ck120 = 1.8 time = 1210
* CHECK dout0_23 vdout0_23ck120 = 0 time = 1210
* CHECK dout0_24 vdout0_24ck120 = 0 time = 1210
* CHECK dout0_25 vdout0_25ck120 = 0 time = 1210
* CHECK dout0_26 vdout0_26ck120 = 1.8 time = 1210
* CHECK dout0_27 vdout0_27ck120 = 1.8 time = 1210
* CHECK dout0_28 vdout0_28ck120 = 0 time = 1210
* CHECK dout0_29 vdout0_29ck120 = 0 time = 1210
* CHECK dout0_30 vdout0_30ck120 = 0 time = 1210
* CHECK dout0_31 vdout0_31ck120 = 0 time = 1210
* CHECK dout0_32 vdout0_32ck120 = 1.8 time = 1210
* CHECK dout0_33 vdout0_33ck120 = 1.8 time = 1210
* CHECK dout0_34 vdout0_34ck120 = 1.8 time = 1210
* CHECK dout0_35 vdout0_35ck120 = 1.8 time = 1210
* CHECK dout0_36 vdout0_36ck120 = 1.8 time = 1210
* CHECK dout0_37 vdout0_37ck120 = 0 time = 1210
* CHECK dout0_38 vdout0_38ck120 = 0 time = 1210
* CHECK dout0_39 vdout0_39ck120 = 0 time = 1210
* CHECK dout0_40 vdout0_40ck120 = 1.8 time = 1210
* CHECK dout0_41 vdout0_41ck120 = 1.8 time = 1210
* CHECK dout0_42 vdout0_42ck120 = 0 time = 1210
* CHECK dout0_43 vdout0_43ck120 = 1.8 time = 1210
* CHECK dout0_44 vdout0_44ck120 = 0 time = 1210
* CHECK dout0_45 vdout0_45ck120 = 1.8 time = 1210
* CHECK dout0_46 vdout0_46ck120 = 1.8 time = 1210
* CHECK dout0_47 vdout0_47ck120 = 0 time = 1210
* CHECK dout0_48 vdout0_48ck120 = 0 time = 1210
* CHECK dout0_49 vdout0_49ck120 = 1.8 time = 1210
* CHECK dout0_50 vdout0_50ck120 = 1.8 time = 1210
* CHECK dout0_51 vdout0_51ck120 = 0 time = 1210
* CHECK dout0_52 vdout0_52ck120 = 0 time = 1210
* CHECK dout0_53 vdout0_53ck120 = 1.8 time = 1210
* CHECK dout0_54 vdout0_54ck120 = 0 time = 1210
* CHECK dout0_55 vdout0_55ck120 = 1.8 time = 1210
* CHECK dout0_56 vdout0_56ck120 = 1.8 time = 1210
* CHECK dout0_57 vdout0_57ck120 = 0 time = 1210
* CHECK dout0_58 vdout0_58ck120 = 1.8 time = 1210
* CHECK dout0_59 vdout0_59ck120 = 1.8 time = 1210
* CHECK dout0_60 vdout0_60ck120 = 0 time = 1210
* CHECK dout0_61 vdout0_61ck120 = 1.8 time = 1210
* CHECK dout0_62 vdout0_62ck120 = 1.8 time = 1210
* CHECK dout0_63 vdout0_63ck120 = 0 time = 1210
* CHECK dout1_0 vdout1_0ck120 = 1.8 time = 1210
* CHECK dout1_1 vdout1_1ck120 = 0 time = 1210
* CHECK dout1_2 vdout1_2ck120 = 1.8 time = 1210
* CHECK dout1_3 vdout1_3ck120 = 1.8 time = 1210
* CHECK dout1_4 vdout1_4ck120 = 0 time = 1210
* CHECK dout1_5 vdout1_5ck120 = 1.8 time = 1210
* CHECK dout1_6 vdout1_6ck120 = 0 time = 1210
* CHECK dout1_7 vdout1_7ck120 = 1.8 time = 1210
* CHECK dout1_8 vdout1_8ck120 = 0 time = 1210
* CHECK dout1_9 vdout1_9ck120 = 1.8 time = 1210
* CHECK dout1_10 vdout1_10ck120 = 0 time = 1210
* CHECK dout1_11 vdout1_11ck120 = 1.8 time = 1210
* CHECK dout1_12 vdout1_12ck120 = 1.8 time = 1210
* CHECK dout1_13 vdout1_13ck120 = 0 time = 1210
* CHECK dout1_14 vdout1_14ck120 = 1.8 time = 1210
* CHECK dout1_15 vdout1_15ck120 = 1.8 time = 1210
* CHECK dout1_16 vdout1_16ck120 = 0 time = 1210
* CHECK dout1_17 vdout1_17ck120 = 0 time = 1210
* CHECK dout1_18 vdout1_18ck120 = 1.8 time = 1210
* CHECK dout1_19 vdout1_19ck120 = 1.8 time = 1210
* CHECK dout1_20 vdout1_20ck120 = 0 time = 1210
* CHECK dout1_21 vdout1_21ck120 = 1.8 time = 1210
* CHECK dout1_22 vdout1_22ck120 = 0 time = 1210
* CHECK dout1_23 vdout1_23ck120 = 0 time = 1210
* CHECK dout1_24 vdout1_24ck120 = 1.8 time = 1210
* CHECK dout1_25 vdout1_25ck120 = 0 time = 1210
* CHECK dout1_26 vdout1_26ck120 = 1.8 time = 1210
* CHECK dout1_27 vdout1_27ck120 = 0 time = 1210
* CHECK dout1_28 vdout1_28ck120 = 1.8 time = 1210
* CHECK dout1_29 vdout1_29ck120 = 1.8 time = 1210
* CHECK dout1_30 vdout1_30ck120 = 1.8 time = 1210
* CHECK dout1_31 vdout1_31ck120 = 1.8 time = 1210
* CHECK dout1_32 vdout1_32ck120 = 0 time = 1210
* CHECK dout1_33 vdout1_33ck120 = 0 time = 1210
* CHECK dout1_34 vdout1_34ck120 = 0 time = 1210
* CHECK dout1_35 vdout1_35ck120 = 1.8 time = 1210
* CHECK dout1_36 vdout1_36ck120 = 1.8 time = 1210
* CHECK dout1_37 vdout1_37ck120 = 0 time = 1210
* CHECK dout1_38 vdout1_38ck120 = 0 time = 1210
* CHECK dout1_39 vdout1_39ck120 = 1.8 time = 1210
* CHECK dout1_40 vdout1_40ck120 = 1.8 time = 1210
* CHECK dout1_41 vdout1_41ck120 = 1.8 time = 1210
* CHECK dout1_42 vdout1_42ck120 = 0 time = 1210
* CHECK dout1_43 vdout1_43ck120 = 0 time = 1210
* CHECK dout1_44 vdout1_44ck120 = 1.8 time = 1210
* CHECK dout1_45 vdout1_45ck120 = 1.8 time = 1210
* CHECK dout1_46 vdout1_46ck120 = 0 time = 1210
* CHECK dout1_47 vdout1_47ck120 = 0 time = 1210
* CHECK dout1_48 vdout1_48ck120 = 0 time = 1210
* CHECK dout1_49 vdout1_49ck120 = 1.8 time = 1210
* CHECK dout1_50 vdout1_50ck120 = 1.8 time = 1210
* CHECK dout1_51 vdout1_51ck120 = 1.8 time = 1210
* CHECK dout1_52 vdout1_52ck120 = 0 time = 1210
* CHECK dout1_53 vdout1_53ck120 = 0 time = 1210
* CHECK dout1_54 vdout1_54ck120 = 0 time = 1210
* CHECK dout1_55 vdout1_55ck120 = 0 time = 1210
* CHECK dout1_56 vdout1_56ck120 = 1.8 time = 1210
* CHECK dout1_57 vdout1_57ck120 = 0 time = 1210
* CHECK dout1_58 vdout1_58ck120 = 1.8 time = 1210
* CHECK dout1_59 vdout1_59ck120 = 0 time = 1210
* CHECK dout1_60 vdout1_60ck120 = 0 time = 1210
* CHECK dout1_61 vdout1_61ck120 = 1.8 time = 1210
* CHECK dout1_62 vdout1_62ck120 = 1.8 time = 1210
* CHECK dout1_63 vdout1_63ck120 = 1.8 time = 1210
* CHECK dout0_0 vdout0_0ck121 = 1.8 time = 1220
* CHECK dout0_1 vdout0_1ck121 = 0 time = 1220
* CHECK dout0_2 vdout0_2ck121 = 1.8 time = 1220
* CHECK dout0_3 vdout0_3ck121 = 1.8 time = 1220
* CHECK dout0_4 vdout0_4ck121 = 0 time = 1220
* CHECK dout0_5 vdout0_5ck121 = 1.8 time = 1220
* CHECK dout0_6 vdout0_6ck121 = 0 time = 1220
* CHECK dout0_7 vdout0_7ck121 = 1.8 time = 1220
* CHECK dout0_8 vdout0_8ck121 = 0 time = 1220
* CHECK dout0_9 vdout0_9ck121 = 1.8 time = 1220
* CHECK dout0_10 vdout0_10ck121 = 0 time = 1220
* CHECK dout0_11 vdout0_11ck121 = 1.8 time = 1220
* CHECK dout0_12 vdout0_12ck121 = 1.8 time = 1220
* CHECK dout0_13 vdout0_13ck121 = 0 time = 1220
* CHECK dout0_14 vdout0_14ck121 = 1.8 time = 1220
* CHECK dout0_15 vdout0_15ck121 = 1.8 time = 1220
* CHECK dout0_16 vdout0_16ck121 = 0 time = 1220
* CHECK dout0_17 vdout0_17ck121 = 0 time = 1220
* CHECK dout0_18 vdout0_18ck121 = 1.8 time = 1220
* CHECK dout0_19 vdout0_19ck121 = 1.8 time = 1220
* CHECK dout0_20 vdout0_20ck121 = 0 time = 1220
* CHECK dout0_21 vdout0_21ck121 = 1.8 time = 1220
* CHECK dout0_22 vdout0_22ck121 = 0 time = 1220
* CHECK dout0_23 vdout0_23ck121 = 0 time = 1220
* CHECK dout0_24 vdout0_24ck121 = 1.8 time = 1220
* CHECK dout0_25 vdout0_25ck121 = 0 time = 1220
* CHECK dout0_26 vdout0_26ck121 = 1.8 time = 1220
* CHECK dout0_27 vdout0_27ck121 = 0 time = 1220
* CHECK dout0_28 vdout0_28ck121 = 1.8 time = 1220
* CHECK dout0_29 vdout0_29ck121 = 1.8 time = 1220
* CHECK dout0_30 vdout0_30ck121 = 1.8 time = 1220
* CHECK dout0_31 vdout0_31ck121 = 1.8 time = 1220
* CHECK dout0_32 vdout0_32ck121 = 0 time = 1220
* CHECK dout0_33 vdout0_33ck121 = 0 time = 1220
* CHECK dout0_34 vdout0_34ck121 = 0 time = 1220
* CHECK dout0_35 vdout0_35ck121 = 1.8 time = 1220
* CHECK dout0_36 vdout0_36ck121 = 1.8 time = 1220
* CHECK dout0_37 vdout0_37ck121 = 0 time = 1220
* CHECK dout0_38 vdout0_38ck121 = 0 time = 1220
* CHECK dout0_39 vdout0_39ck121 = 1.8 time = 1220
* CHECK dout0_40 vdout0_40ck121 = 1.8 time = 1220
* CHECK dout0_41 vdout0_41ck121 = 1.8 time = 1220
* CHECK dout0_42 vdout0_42ck121 = 0 time = 1220
* CHECK dout0_43 vdout0_43ck121 = 0 time = 1220
* CHECK dout0_44 vdout0_44ck121 = 1.8 time = 1220
* CHECK dout0_45 vdout0_45ck121 = 1.8 time = 1220
* CHECK dout0_46 vdout0_46ck121 = 0 time = 1220
* CHECK dout0_47 vdout0_47ck121 = 0 time = 1220
* CHECK dout0_48 vdout0_48ck121 = 0 time = 1220
* CHECK dout0_49 vdout0_49ck121 = 1.8 time = 1220
* CHECK dout0_50 vdout0_50ck121 = 1.8 time = 1220
* CHECK dout0_51 vdout0_51ck121 = 1.8 time = 1220
* CHECK dout0_52 vdout0_52ck121 = 0 time = 1220
* CHECK dout0_53 vdout0_53ck121 = 0 time = 1220
* CHECK dout0_54 vdout0_54ck121 = 0 time = 1220
* CHECK dout0_55 vdout0_55ck121 = 0 time = 1220
* CHECK dout0_56 vdout0_56ck121 = 1.8 time = 1220
* CHECK dout0_57 vdout0_57ck121 = 0 time = 1220
* CHECK dout0_58 vdout0_58ck121 = 1.8 time = 1220
* CHECK dout0_59 vdout0_59ck121 = 0 time = 1220
* CHECK dout0_60 vdout0_60ck121 = 0 time = 1220
* CHECK dout0_61 vdout0_61ck121 = 1.8 time = 1220
* CHECK dout0_62 vdout0_62ck121 = 1.8 time = 1220
* CHECK dout0_63 vdout0_63ck121 = 1.8 time = 1220
* CHECK dout1_0 vdout1_0ck121 = 0 time = 1220
* CHECK dout1_1 vdout1_1ck121 = 1.8 time = 1220
* CHECK dout1_2 vdout1_2ck121 = 0 time = 1220
* CHECK dout1_3 vdout1_3ck121 = 0 time = 1220
* CHECK dout1_4 vdout1_4ck121 = 1.8 time = 1220
* CHECK dout1_5 vdout1_5ck121 = 1.8 time = 1220
* CHECK dout1_6 vdout1_6ck121 = 1.8 time = 1220
* CHECK dout1_7 vdout1_7ck121 = 0 time = 1220
* CHECK dout1_8 vdout1_8ck121 = 0 time = 1220
* CHECK dout1_9 vdout1_9ck121 = 0 time = 1220
* CHECK dout1_10 vdout1_10ck121 = 0 time = 1220
* CHECK dout1_11 vdout1_11ck121 = 0 time = 1220
* CHECK dout1_12 vdout1_12ck121 = 0 time = 1220
* CHECK dout1_13 vdout1_13ck121 = 0 time = 1220
* CHECK dout1_14 vdout1_14ck121 = 1.8 time = 1220
* CHECK dout1_15 vdout1_15ck121 = 1.8 time = 1220
* CHECK dout1_16 vdout1_16ck121 = 0 time = 1220
* CHECK dout1_17 vdout1_17ck121 = 1.8 time = 1220
* CHECK dout1_18 vdout1_18ck121 = 1.8 time = 1220
* CHECK dout1_19 vdout1_19ck121 = 1.8 time = 1220
* CHECK dout1_20 vdout1_20ck121 = 1.8 time = 1220
* CHECK dout1_21 vdout1_21ck121 = 0 time = 1220
* CHECK dout1_22 vdout1_22ck121 = 1.8 time = 1220
* CHECK dout1_23 vdout1_23ck121 = 0 time = 1220
* CHECK dout1_24 vdout1_24ck121 = 0 time = 1220
* CHECK dout1_25 vdout1_25ck121 = 0 time = 1220
* CHECK dout1_26 vdout1_26ck121 = 1.8 time = 1220
* CHECK dout1_27 vdout1_27ck121 = 1.8 time = 1220
* CHECK dout1_28 vdout1_28ck121 = 0 time = 1220
* CHECK dout1_29 vdout1_29ck121 = 0 time = 1220
* CHECK dout1_30 vdout1_30ck121 = 0 time = 1220
* CHECK dout1_31 vdout1_31ck121 = 0 time = 1220
* CHECK dout1_32 vdout1_32ck121 = 1.8 time = 1220
* CHECK dout1_33 vdout1_33ck121 = 1.8 time = 1220
* CHECK dout1_34 vdout1_34ck121 = 1.8 time = 1220
* CHECK dout1_35 vdout1_35ck121 = 1.8 time = 1220
* CHECK dout1_36 vdout1_36ck121 = 1.8 time = 1220
* CHECK dout1_37 vdout1_37ck121 = 0 time = 1220
* CHECK dout1_38 vdout1_38ck121 = 0 time = 1220
* CHECK dout1_39 vdout1_39ck121 = 0 time = 1220
* CHECK dout1_40 vdout1_40ck121 = 1.8 time = 1220
* CHECK dout1_41 vdout1_41ck121 = 1.8 time = 1220
* CHECK dout1_42 vdout1_42ck121 = 0 time = 1220
* CHECK dout1_43 vdout1_43ck121 = 1.8 time = 1220
* CHECK dout1_44 vdout1_44ck121 = 0 time = 1220
* CHECK dout1_45 vdout1_45ck121 = 1.8 time = 1220
* CHECK dout1_46 vdout1_46ck121 = 1.8 time = 1220
* CHECK dout1_47 vdout1_47ck121 = 0 time = 1220
* CHECK dout1_48 vdout1_48ck121 = 0 time = 1220
* CHECK dout1_49 vdout1_49ck121 = 1.8 time = 1220
* CHECK dout1_50 vdout1_50ck121 = 1.8 time = 1220
* CHECK dout1_51 vdout1_51ck121 = 0 time = 1220
* CHECK dout1_52 vdout1_52ck121 = 0 time = 1220
* CHECK dout1_53 vdout1_53ck121 = 1.8 time = 1220
* CHECK dout1_54 vdout1_54ck121 = 0 time = 1220
* CHECK dout1_55 vdout1_55ck121 = 1.8 time = 1220
* CHECK dout1_56 vdout1_56ck121 = 1.8 time = 1220
* CHECK dout1_57 vdout1_57ck121 = 0 time = 1220
* CHECK dout1_58 vdout1_58ck121 = 1.8 time = 1220
* CHECK dout1_59 vdout1_59ck121 = 1.8 time = 1220
* CHECK dout1_60 vdout1_60ck121 = 0 time = 1220
* CHECK dout1_61 vdout1_61ck121 = 1.8 time = 1220
* CHECK dout1_62 vdout1_62ck121 = 1.8 time = 1220
* CHECK dout1_63 vdout1_63ck121 = 0 time = 1220
* CHECK dout0_0 vdout0_0ck122 = 0 time = 1230
* CHECK dout0_1 vdout0_1ck122 = 1.8 time = 1230
* CHECK dout0_2 vdout0_2ck122 = 0 time = 1230
* CHECK dout0_3 vdout0_3ck122 = 0 time = 1230
* CHECK dout0_4 vdout0_4ck122 = 1.8 time = 1230
* CHECK dout0_5 vdout0_5ck122 = 1.8 time = 1230
* CHECK dout0_6 vdout0_6ck122 = 1.8 time = 1230
* CHECK dout0_7 vdout0_7ck122 = 0 time = 1230
* CHECK dout0_8 vdout0_8ck122 = 0 time = 1230
* CHECK dout0_9 vdout0_9ck122 = 0 time = 1230
* CHECK dout0_10 vdout0_10ck122 = 0 time = 1230
* CHECK dout0_11 vdout0_11ck122 = 0 time = 1230
* CHECK dout0_12 vdout0_12ck122 = 0 time = 1230
* CHECK dout0_13 vdout0_13ck122 = 0 time = 1230
* CHECK dout0_14 vdout0_14ck122 = 1.8 time = 1230
* CHECK dout0_15 vdout0_15ck122 = 1.8 time = 1230
* CHECK dout0_16 vdout0_16ck122 = 0 time = 1230
* CHECK dout0_17 vdout0_17ck122 = 1.8 time = 1230
* CHECK dout0_18 vdout0_18ck122 = 1.8 time = 1230
* CHECK dout0_19 vdout0_19ck122 = 1.8 time = 1230
* CHECK dout0_20 vdout0_20ck122 = 1.8 time = 1230
* CHECK dout0_21 vdout0_21ck122 = 0 time = 1230
* CHECK dout0_22 vdout0_22ck122 = 1.8 time = 1230
* CHECK dout0_23 vdout0_23ck122 = 0 time = 1230
* CHECK dout0_24 vdout0_24ck122 = 0 time = 1230
* CHECK dout0_25 vdout0_25ck122 = 0 time = 1230
* CHECK dout0_26 vdout0_26ck122 = 1.8 time = 1230
* CHECK dout0_27 vdout0_27ck122 = 1.8 time = 1230
* CHECK dout0_28 vdout0_28ck122 = 0 time = 1230
* CHECK dout0_29 vdout0_29ck122 = 0 time = 1230
* CHECK dout0_30 vdout0_30ck122 = 0 time = 1230
* CHECK dout0_31 vdout0_31ck122 = 0 time = 1230
* CHECK dout0_32 vdout0_32ck122 = 1.8 time = 1230
* CHECK dout0_33 vdout0_33ck122 = 1.8 time = 1230
* CHECK dout0_34 vdout0_34ck122 = 1.8 time = 1230
* CHECK dout0_35 vdout0_35ck122 = 1.8 time = 1230
* CHECK dout0_36 vdout0_36ck122 = 1.8 time = 1230
* CHECK dout0_37 vdout0_37ck122 = 0 time = 1230
* CHECK dout0_38 vdout0_38ck122 = 0 time = 1230
* CHECK dout0_39 vdout0_39ck122 = 0 time = 1230
* CHECK dout0_40 vdout0_40ck122 = 1.8 time = 1230
* CHECK dout0_41 vdout0_41ck122 = 1.8 time = 1230
* CHECK dout0_42 vdout0_42ck122 = 0 time = 1230
* CHECK dout0_43 vdout0_43ck122 = 1.8 time = 1230
* CHECK dout0_44 vdout0_44ck122 = 0 time = 1230
* CHECK dout0_45 vdout0_45ck122 = 1.8 time = 1230
* CHECK dout0_46 vdout0_46ck122 = 1.8 time = 1230
* CHECK dout0_47 vdout0_47ck122 = 0 time = 1230
* CHECK dout0_48 vdout0_48ck122 = 0 time = 1230
* CHECK dout0_49 vdout0_49ck122 = 1.8 time = 1230
* CHECK dout0_50 vdout0_50ck122 = 1.8 time = 1230
* CHECK dout0_51 vdout0_51ck122 = 0 time = 1230
* CHECK dout0_52 vdout0_52ck122 = 0 time = 1230
* CHECK dout0_53 vdout0_53ck122 = 1.8 time = 1230
* CHECK dout0_54 vdout0_54ck122 = 0 time = 1230
* CHECK dout0_55 vdout0_55ck122 = 1.8 time = 1230
* CHECK dout0_56 vdout0_56ck122 = 1.8 time = 1230
* CHECK dout0_57 vdout0_57ck122 = 0 time = 1230
* CHECK dout0_58 vdout0_58ck122 = 1.8 time = 1230
* CHECK dout0_59 vdout0_59ck122 = 1.8 time = 1230
* CHECK dout0_60 vdout0_60ck122 = 0 time = 1230
* CHECK dout0_61 vdout0_61ck122 = 1.8 time = 1230
* CHECK dout0_62 vdout0_62ck122 = 1.8 time = 1230
* CHECK dout0_63 vdout0_63ck122 = 0 time = 1230
* CHECK dout1_0 vdout1_0ck122 = 0 time = 1230
* CHECK dout1_1 vdout1_1ck122 = 1.8 time = 1230
* CHECK dout1_2 vdout1_2ck122 = 0 time = 1230
* CHECK dout1_3 vdout1_3ck122 = 0 time = 1230
* CHECK dout1_4 vdout1_4ck122 = 1.8 time = 1230
* CHECK dout1_5 vdout1_5ck122 = 0 time = 1230
* CHECK dout1_6 vdout1_6ck122 = 0 time = 1230
* CHECK dout1_7 vdout1_7ck122 = 0 time = 1230
* CHECK dout1_8 vdout1_8ck122 = 1.8 time = 1230
* CHECK dout1_9 vdout1_9ck122 = 0 time = 1230
* CHECK dout1_10 vdout1_10ck122 = 0 time = 1230
* CHECK dout1_11 vdout1_11ck122 = 1.8 time = 1230
* CHECK dout1_12 vdout1_12ck122 = 1.8 time = 1230
* CHECK dout1_13 vdout1_13ck122 = 1.8 time = 1230
* CHECK dout1_14 vdout1_14ck122 = 1.8 time = 1230
* CHECK dout1_15 vdout1_15ck122 = 1.8 time = 1230
* CHECK dout1_16 vdout1_16ck122 = 1.8 time = 1230
* CHECK dout1_17 vdout1_17ck122 = 0 time = 1230
* CHECK dout1_18 vdout1_18ck122 = 0 time = 1230
* CHECK dout1_19 vdout1_19ck122 = 0 time = 1230
* CHECK dout1_20 vdout1_20ck122 = 1.8 time = 1230
* CHECK dout1_21 vdout1_21ck122 = 0 time = 1230
* CHECK dout1_22 vdout1_22ck122 = 1.8 time = 1230
* CHECK dout1_23 vdout1_23ck122 = 0 time = 1230
* CHECK dout1_24 vdout1_24ck122 = 0 time = 1230
* CHECK dout1_25 vdout1_25ck122 = 1.8 time = 1230
* CHECK dout1_26 vdout1_26ck122 = 1.8 time = 1230
* CHECK dout1_27 vdout1_27ck122 = 0 time = 1230
* CHECK dout1_28 vdout1_28ck122 = 0 time = 1230
* CHECK dout1_29 vdout1_29ck122 = 0 time = 1230
* CHECK dout1_30 vdout1_30ck122 = 1.8 time = 1230
* CHECK dout1_31 vdout1_31ck122 = 0 time = 1230
* CHECK dout1_32 vdout1_32ck122 = 0 time = 1230
* CHECK dout1_33 vdout1_33ck122 = 0 time = 1230
* CHECK dout1_34 vdout1_34ck122 = 1.8 time = 1230
* CHECK dout1_35 vdout1_35ck122 = 0 time = 1230
* CHECK dout1_36 vdout1_36ck122 = 0 time = 1230
* CHECK dout1_37 vdout1_37ck122 = 0 time = 1230
* CHECK dout1_38 vdout1_38ck122 = 0 time = 1230
* CHECK dout1_39 vdout1_39ck122 = 1.8 time = 1230
* CHECK dout1_40 vdout1_40ck122 = 1.8 time = 1230
* CHECK dout1_41 vdout1_41ck122 = 0 time = 1230
* CHECK dout1_42 vdout1_42ck122 = 0 time = 1230
* CHECK dout1_43 vdout1_43ck122 = 0 time = 1230
* CHECK dout1_44 vdout1_44ck122 = 0 time = 1230
* CHECK dout1_45 vdout1_45ck122 = 0 time = 1230
* CHECK dout1_46 vdout1_46ck122 = 1.8 time = 1230
* CHECK dout1_47 vdout1_47ck122 = 1.8 time = 1230
* CHECK dout1_48 vdout1_48ck122 = 1.8 time = 1230
* CHECK dout1_49 vdout1_49ck122 = 1.8 time = 1230
* CHECK dout1_50 vdout1_50ck122 = 0 time = 1230
* CHECK dout1_51 vdout1_51ck122 = 1.8 time = 1230
* CHECK dout1_52 vdout1_52ck122 = 1.8 time = 1230
* CHECK dout1_53 vdout1_53ck122 = 1.8 time = 1230
* CHECK dout1_54 vdout1_54ck122 = 1.8 time = 1230
* CHECK dout1_55 vdout1_55ck122 = 1.8 time = 1230
* CHECK dout1_56 vdout1_56ck122 = 1.8 time = 1230
* CHECK dout1_57 vdout1_57ck122 = 1.8 time = 1230
* CHECK dout1_58 vdout1_58ck122 = 0 time = 1230
* CHECK dout1_59 vdout1_59ck122 = 1.8 time = 1230
* CHECK dout1_60 vdout1_60ck122 = 1.8 time = 1230
* CHECK dout1_61 vdout1_61ck122 = 1.8 time = 1230
* CHECK dout1_62 vdout1_62ck122 = 0 time = 1230
* CHECK dout1_63 vdout1_63ck122 = 0 time = 1230
* CHECK dout1_0 vdout1_0ck123 = 0 time = 1240
* CHECK dout1_1 vdout1_1ck123 = 1.8 time = 1240
* CHECK dout1_2 vdout1_2ck123 = 0 time = 1240
* CHECK dout1_3 vdout1_3ck123 = 0 time = 1240
* CHECK dout1_4 vdout1_4ck123 = 1.8 time = 1240
* CHECK dout1_5 vdout1_5ck123 = 0 time = 1240
* CHECK dout1_6 vdout1_6ck123 = 0 time = 1240
* CHECK dout1_7 vdout1_7ck123 = 0 time = 1240
* CHECK dout1_8 vdout1_8ck123 = 1.8 time = 1240
* CHECK dout1_9 vdout1_9ck123 = 0 time = 1240
* CHECK dout1_10 vdout1_10ck123 = 0 time = 1240
* CHECK dout1_11 vdout1_11ck123 = 1.8 time = 1240
* CHECK dout1_12 vdout1_12ck123 = 1.8 time = 1240
* CHECK dout1_13 vdout1_13ck123 = 1.8 time = 1240
* CHECK dout1_14 vdout1_14ck123 = 1.8 time = 1240
* CHECK dout1_15 vdout1_15ck123 = 1.8 time = 1240
* CHECK dout1_16 vdout1_16ck123 = 1.8 time = 1240
* CHECK dout1_17 vdout1_17ck123 = 0 time = 1240
* CHECK dout1_18 vdout1_18ck123 = 0 time = 1240
* CHECK dout1_19 vdout1_19ck123 = 0 time = 1240
* CHECK dout1_20 vdout1_20ck123 = 1.8 time = 1240
* CHECK dout1_21 vdout1_21ck123 = 0 time = 1240
* CHECK dout1_22 vdout1_22ck123 = 1.8 time = 1240
* CHECK dout1_23 vdout1_23ck123 = 0 time = 1240
* CHECK dout1_24 vdout1_24ck123 = 0 time = 1240
* CHECK dout1_25 vdout1_25ck123 = 1.8 time = 1240
* CHECK dout1_26 vdout1_26ck123 = 1.8 time = 1240
* CHECK dout1_27 vdout1_27ck123 = 0 time = 1240
* CHECK dout1_28 vdout1_28ck123 = 0 time = 1240
* CHECK dout1_29 vdout1_29ck123 = 0 time = 1240
* CHECK dout1_30 vdout1_30ck123 = 1.8 time = 1240
* CHECK dout1_31 vdout1_31ck123 = 0 time = 1240
* CHECK dout1_32 vdout1_32ck123 = 0 time = 1240
* CHECK dout1_33 vdout1_33ck123 = 0 time = 1240
* CHECK dout1_34 vdout1_34ck123 = 1.8 time = 1240
* CHECK dout1_35 vdout1_35ck123 = 0 time = 1240
* CHECK dout1_36 vdout1_36ck123 = 0 time = 1240
* CHECK dout1_37 vdout1_37ck123 = 0 time = 1240
* CHECK dout1_38 vdout1_38ck123 = 0 time = 1240
* CHECK dout1_39 vdout1_39ck123 = 1.8 time = 1240
* CHECK dout1_40 vdout1_40ck123 = 1.8 time = 1240
* CHECK dout1_41 vdout1_41ck123 = 0 time = 1240
* CHECK dout1_42 vdout1_42ck123 = 0 time = 1240
* CHECK dout1_43 vdout1_43ck123 = 0 time = 1240
* CHECK dout1_44 vdout1_44ck123 = 0 time = 1240
* CHECK dout1_45 vdout1_45ck123 = 0 time = 1240
* CHECK dout1_46 vdout1_46ck123 = 1.8 time = 1240
* CHECK dout1_47 vdout1_47ck123 = 1.8 time = 1240
* CHECK dout1_48 vdout1_48ck123 = 1.8 time = 1240
* CHECK dout1_49 vdout1_49ck123 = 1.8 time = 1240
* CHECK dout1_50 vdout1_50ck123 = 0 time = 1240
* CHECK dout1_51 vdout1_51ck123 = 1.8 time = 1240
* CHECK dout1_52 vdout1_52ck123 = 1.8 time = 1240
* CHECK dout1_53 vdout1_53ck123 = 1.8 time = 1240
* CHECK dout1_54 vdout1_54ck123 = 1.8 time = 1240
* CHECK dout1_55 vdout1_55ck123 = 1.8 time = 1240
* CHECK dout1_56 vdout1_56ck123 = 1.8 time = 1240
* CHECK dout1_57 vdout1_57ck123 = 1.8 time = 1240
* CHECK dout1_58 vdout1_58ck123 = 0 time = 1240
* CHECK dout1_59 vdout1_59ck123 = 1.8 time = 1240
* CHECK dout1_60 vdout1_60ck123 = 1.8 time = 1240
* CHECK dout1_61 vdout1_61ck123 = 1.8 time = 1240
* CHECK dout1_62 vdout1_62ck123 = 0 time = 1240
* CHECK dout1_63 vdout1_63ck123 = 0 time = 1240
* CHECK dout0_0 vdout0_0ck124 = 0 time = 1250
* CHECK dout0_1 vdout0_1ck124 = 1.8 time = 1250
* CHECK dout0_2 vdout0_2ck124 = 0 time = 1250
* CHECK dout0_3 vdout0_3ck124 = 0 time = 1250
* CHECK dout0_4 vdout0_4ck124 = 1.8 time = 1250
* CHECK dout0_5 vdout0_5ck124 = 1.8 time = 1250
* CHECK dout0_6 vdout0_6ck124 = 1.8 time = 1250
* CHECK dout0_7 vdout0_7ck124 = 0 time = 1250
* CHECK dout0_8 vdout0_8ck124 = 0 time = 1250
* CHECK dout0_9 vdout0_9ck124 = 0 time = 1250
* CHECK dout0_10 vdout0_10ck124 = 0 time = 1250
* CHECK dout0_11 vdout0_11ck124 = 0 time = 1250
* CHECK dout0_12 vdout0_12ck124 = 0 time = 1250
* CHECK dout0_13 vdout0_13ck124 = 0 time = 1250
* CHECK dout0_14 vdout0_14ck124 = 1.8 time = 1250
* CHECK dout0_15 vdout0_15ck124 = 1.8 time = 1250
* CHECK dout0_16 vdout0_16ck124 = 0 time = 1250
* CHECK dout0_17 vdout0_17ck124 = 1.8 time = 1250
* CHECK dout0_18 vdout0_18ck124 = 1.8 time = 1250
* CHECK dout0_19 vdout0_19ck124 = 1.8 time = 1250
* CHECK dout0_20 vdout0_20ck124 = 1.8 time = 1250
* CHECK dout0_21 vdout0_21ck124 = 0 time = 1250
* CHECK dout0_22 vdout0_22ck124 = 1.8 time = 1250
* CHECK dout0_23 vdout0_23ck124 = 0 time = 1250
* CHECK dout0_24 vdout0_24ck124 = 0 time = 1250
* CHECK dout0_25 vdout0_25ck124 = 0 time = 1250
* CHECK dout0_26 vdout0_26ck124 = 1.8 time = 1250
* CHECK dout0_27 vdout0_27ck124 = 1.8 time = 1250
* CHECK dout0_28 vdout0_28ck124 = 0 time = 1250
* CHECK dout0_29 vdout0_29ck124 = 0 time = 1250
* CHECK dout0_30 vdout0_30ck124 = 0 time = 1250
* CHECK dout0_31 vdout0_31ck124 = 0 time = 1250
* CHECK dout0_32 vdout0_32ck124 = 1.8 time = 1250
* CHECK dout0_33 vdout0_33ck124 = 1.8 time = 1250
* CHECK dout0_34 vdout0_34ck124 = 1.8 time = 1250
* CHECK dout0_35 vdout0_35ck124 = 1.8 time = 1250
* CHECK dout0_36 vdout0_36ck124 = 1.8 time = 1250
* CHECK dout0_37 vdout0_37ck124 = 0 time = 1250
* CHECK dout0_38 vdout0_38ck124 = 0 time = 1250
* CHECK dout0_39 vdout0_39ck124 = 0 time = 1250
* CHECK dout0_40 vdout0_40ck124 = 1.8 time = 1250
* CHECK dout0_41 vdout0_41ck124 = 1.8 time = 1250
* CHECK dout0_42 vdout0_42ck124 = 0 time = 1250
* CHECK dout0_43 vdout0_43ck124 = 1.8 time = 1250
* CHECK dout0_44 vdout0_44ck124 = 0 time = 1250
* CHECK dout0_45 vdout0_45ck124 = 1.8 time = 1250
* CHECK dout0_46 vdout0_46ck124 = 1.8 time = 1250
* CHECK dout0_47 vdout0_47ck124 = 0 time = 1250
* CHECK dout0_48 vdout0_48ck124 = 0 time = 1250
* CHECK dout0_49 vdout0_49ck124 = 1.8 time = 1250
* CHECK dout0_50 vdout0_50ck124 = 1.8 time = 1250
* CHECK dout0_51 vdout0_51ck124 = 0 time = 1250
* CHECK dout0_52 vdout0_52ck124 = 0 time = 1250
* CHECK dout0_53 vdout0_53ck124 = 1.8 time = 1250
* CHECK dout0_54 vdout0_54ck124 = 0 time = 1250
* CHECK dout0_55 vdout0_55ck124 = 1.8 time = 1250
* CHECK dout0_56 vdout0_56ck124 = 1.8 time = 1250
* CHECK dout0_57 vdout0_57ck124 = 0 time = 1250
* CHECK dout0_58 vdout0_58ck124 = 1.8 time = 1250
* CHECK dout0_59 vdout0_59ck124 = 1.8 time = 1250
* CHECK dout0_60 vdout0_60ck124 = 0 time = 1250
* CHECK dout0_61 vdout0_61ck124 = 1.8 time = 1250
* CHECK dout0_62 vdout0_62ck124 = 1.8 time = 1250
* CHECK dout0_63 vdout0_63ck124 = 0 time = 1250
* CHECK dout1_0 vdout1_0ck124 = 1.8 time = 1250
* CHECK dout1_1 vdout1_1ck124 = 0 time = 1250
* CHECK dout1_2 vdout1_2ck124 = 1.8 time = 1250
* CHECK dout1_3 vdout1_3ck124 = 1.8 time = 1250
* CHECK dout1_4 vdout1_4ck124 = 0 time = 1250
* CHECK dout1_5 vdout1_5ck124 = 1.8 time = 1250
* CHECK dout1_6 vdout1_6ck124 = 0 time = 1250
* CHECK dout1_7 vdout1_7ck124 = 1.8 time = 1250
* CHECK dout1_8 vdout1_8ck124 = 0 time = 1250
* CHECK dout1_9 vdout1_9ck124 = 1.8 time = 1250
* CHECK dout1_10 vdout1_10ck124 = 0 time = 1250
* CHECK dout1_11 vdout1_11ck124 = 1.8 time = 1250
* CHECK dout1_12 vdout1_12ck124 = 1.8 time = 1250
* CHECK dout1_13 vdout1_13ck124 = 0 time = 1250
* CHECK dout1_14 vdout1_14ck124 = 1.8 time = 1250
* CHECK dout1_15 vdout1_15ck124 = 1.8 time = 1250
* CHECK dout1_16 vdout1_16ck124 = 0 time = 1250
* CHECK dout1_17 vdout1_17ck124 = 0 time = 1250
* CHECK dout1_18 vdout1_18ck124 = 1.8 time = 1250
* CHECK dout1_19 vdout1_19ck124 = 1.8 time = 1250
* CHECK dout1_20 vdout1_20ck124 = 0 time = 1250
* CHECK dout1_21 vdout1_21ck124 = 1.8 time = 1250
* CHECK dout1_22 vdout1_22ck124 = 0 time = 1250
* CHECK dout1_23 vdout1_23ck124 = 0 time = 1250
* CHECK dout1_24 vdout1_24ck124 = 1.8 time = 1250
* CHECK dout1_25 vdout1_25ck124 = 0 time = 1250
* CHECK dout1_26 vdout1_26ck124 = 1.8 time = 1250
* CHECK dout1_27 vdout1_27ck124 = 0 time = 1250
* CHECK dout1_28 vdout1_28ck124 = 1.8 time = 1250
* CHECK dout1_29 vdout1_29ck124 = 1.8 time = 1250
* CHECK dout1_30 vdout1_30ck124 = 1.8 time = 1250
* CHECK dout1_31 vdout1_31ck124 = 1.8 time = 1250
* CHECK dout1_32 vdout1_32ck124 = 0 time = 1250
* CHECK dout1_33 vdout1_33ck124 = 0 time = 1250
* CHECK dout1_34 vdout1_34ck124 = 0 time = 1250
* CHECK dout1_35 vdout1_35ck124 = 1.8 time = 1250
* CHECK dout1_36 vdout1_36ck124 = 1.8 time = 1250
* CHECK dout1_37 vdout1_37ck124 = 0 time = 1250
* CHECK dout1_38 vdout1_38ck124 = 0 time = 1250
* CHECK dout1_39 vdout1_39ck124 = 1.8 time = 1250
* CHECK dout1_40 vdout1_40ck124 = 1.8 time = 1250
* CHECK dout1_41 vdout1_41ck124 = 1.8 time = 1250
* CHECK dout1_42 vdout1_42ck124 = 0 time = 1250
* CHECK dout1_43 vdout1_43ck124 = 0 time = 1250
* CHECK dout1_44 vdout1_44ck124 = 1.8 time = 1250
* CHECK dout1_45 vdout1_45ck124 = 1.8 time = 1250
* CHECK dout1_46 vdout1_46ck124 = 0 time = 1250
* CHECK dout1_47 vdout1_47ck124 = 0 time = 1250
* CHECK dout1_48 vdout1_48ck124 = 0 time = 1250
* CHECK dout1_49 vdout1_49ck124 = 1.8 time = 1250
* CHECK dout1_50 vdout1_50ck124 = 1.8 time = 1250
* CHECK dout1_51 vdout1_51ck124 = 1.8 time = 1250
* CHECK dout1_52 vdout1_52ck124 = 0 time = 1250
* CHECK dout1_53 vdout1_53ck124 = 0 time = 1250
* CHECK dout1_54 vdout1_54ck124 = 0 time = 1250
* CHECK dout1_55 vdout1_55ck124 = 0 time = 1250
* CHECK dout1_56 vdout1_56ck124 = 1.8 time = 1250
* CHECK dout1_57 vdout1_57ck124 = 0 time = 1250
* CHECK dout1_58 vdout1_58ck124 = 1.8 time = 1250
* CHECK dout1_59 vdout1_59ck124 = 0 time = 1250
* CHECK dout1_60 vdout1_60ck124 = 0 time = 1250
* CHECK dout1_61 vdout1_61ck124 = 1.8 time = 1250
* CHECK dout1_62 vdout1_62ck124 = 1.8 time = 1250
* CHECK dout1_63 vdout1_63ck124 = 1.8 time = 1250
* CHECK dout0_0 vdout0_0ck125 = 0 time = 1260
* CHECK dout0_1 vdout0_1ck125 = 1.8 time = 1260
* CHECK dout0_2 vdout0_2ck125 = 0 time = 1260
* CHECK dout0_3 vdout0_3ck125 = 0 time = 1260
* CHECK dout0_4 vdout0_4ck125 = 1.8 time = 1260
* CHECK dout0_5 vdout0_5ck125 = 1.8 time = 1260
* CHECK dout0_6 vdout0_6ck125 = 1.8 time = 1260
* CHECK dout0_7 vdout0_7ck125 = 0 time = 1260
* CHECK dout0_8 vdout0_8ck125 = 0 time = 1260
* CHECK dout0_9 vdout0_9ck125 = 0 time = 1260
* CHECK dout0_10 vdout0_10ck125 = 0 time = 1260
* CHECK dout0_11 vdout0_11ck125 = 0 time = 1260
* CHECK dout0_12 vdout0_12ck125 = 0 time = 1260
* CHECK dout0_13 vdout0_13ck125 = 0 time = 1260
* CHECK dout0_14 vdout0_14ck125 = 1.8 time = 1260
* CHECK dout0_15 vdout0_15ck125 = 1.8 time = 1260
* CHECK dout0_16 vdout0_16ck125 = 0 time = 1260
* CHECK dout0_17 vdout0_17ck125 = 1.8 time = 1260
* CHECK dout0_18 vdout0_18ck125 = 1.8 time = 1260
* CHECK dout0_19 vdout0_19ck125 = 1.8 time = 1260
* CHECK dout0_20 vdout0_20ck125 = 1.8 time = 1260
* CHECK dout0_21 vdout0_21ck125 = 0 time = 1260
* CHECK dout0_22 vdout0_22ck125 = 1.8 time = 1260
* CHECK dout0_23 vdout0_23ck125 = 0 time = 1260
* CHECK dout0_24 vdout0_24ck125 = 0 time = 1260
* CHECK dout0_25 vdout0_25ck125 = 0 time = 1260
* CHECK dout0_26 vdout0_26ck125 = 1.8 time = 1260
* CHECK dout0_27 vdout0_27ck125 = 1.8 time = 1260
* CHECK dout0_28 vdout0_28ck125 = 0 time = 1260
* CHECK dout0_29 vdout0_29ck125 = 0 time = 1260
* CHECK dout0_30 vdout0_30ck125 = 0 time = 1260
* CHECK dout0_31 vdout0_31ck125 = 0 time = 1260
* CHECK dout0_32 vdout0_32ck125 = 1.8 time = 1260
* CHECK dout0_33 vdout0_33ck125 = 1.8 time = 1260
* CHECK dout0_34 vdout0_34ck125 = 1.8 time = 1260
* CHECK dout0_35 vdout0_35ck125 = 1.8 time = 1260
* CHECK dout0_36 vdout0_36ck125 = 1.8 time = 1260
* CHECK dout0_37 vdout0_37ck125 = 0 time = 1260
* CHECK dout0_38 vdout0_38ck125 = 0 time = 1260
* CHECK dout0_39 vdout0_39ck125 = 0 time = 1260
* CHECK dout0_40 vdout0_40ck125 = 1.8 time = 1260
* CHECK dout0_41 vdout0_41ck125 = 1.8 time = 1260
* CHECK dout0_42 vdout0_42ck125 = 0 time = 1260
* CHECK dout0_43 vdout0_43ck125 = 1.8 time = 1260
* CHECK dout0_44 vdout0_44ck125 = 0 time = 1260
* CHECK dout0_45 vdout0_45ck125 = 1.8 time = 1260
* CHECK dout0_46 vdout0_46ck125 = 1.8 time = 1260
* CHECK dout0_47 vdout0_47ck125 = 0 time = 1260
* CHECK dout0_48 vdout0_48ck125 = 0 time = 1260
* CHECK dout0_49 vdout0_49ck125 = 1.8 time = 1260
* CHECK dout0_50 vdout0_50ck125 = 1.8 time = 1260
* CHECK dout0_51 vdout0_51ck125 = 0 time = 1260
* CHECK dout0_52 vdout0_52ck125 = 0 time = 1260
* CHECK dout0_53 vdout0_53ck125 = 1.8 time = 1260
* CHECK dout0_54 vdout0_54ck125 = 0 time = 1260
* CHECK dout0_55 vdout0_55ck125 = 1.8 time = 1260
* CHECK dout0_56 vdout0_56ck125 = 1.8 time = 1260
* CHECK dout0_57 vdout0_57ck125 = 0 time = 1260
* CHECK dout0_58 vdout0_58ck125 = 1.8 time = 1260
* CHECK dout0_59 vdout0_59ck125 = 1.8 time = 1260
* CHECK dout0_60 vdout0_60ck125 = 0 time = 1260
* CHECK dout0_61 vdout0_61ck125 = 1.8 time = 1260
* CHECK dout0_62 vdout0_62ck125 = 1.8 time = 1260
* CHECK dout0_63 vdout0_63ck125 = 0 time = 1260
* CHECK dout0_0 vdout0_0ck127 = 0 time = 1280
* CHECK dout0_1 vdout0_1ck127 = 1.8 time = 1280
* CHECK dout0_2 vdout0_2ck127 = 0 time = 1280
* CHECK dout0_3 vdout0_3ck127 = 0 time = 1280
* CHECK dout0_4 vdout0_4ck127 = 0 time = 1280
* CHECK dout0_5 vdout0_5ck127 = 0 time = 1280
* CHECK dout0_6 vdout0_6ck127 = 1.8 time = 1280
* CHECK dout0_7 vdout0_7ck127 = 0 time = 1280
* CHECK dout0_8 vdout0_8ck127 = 0 time = 1280
* CHECK dout0_9 vdout0_9ck127 = 1.8 time = 1280
* CHECK dout0_10 vdout0_10ck127 = 1.8 time = 1280
* CHECK dout0_11 vdout0_11ck127 = 1.8 time = 1280
* CHECK dout0_12 vdout0_12ck127 = 1.8 time = 1280
* CHECK dout0_13 vdout0_13ck127 = 1.8 time = 1280
* CHECK dout0_14 vdout0_14ck127 = 0 time = 1280
* CHECK dout0_15 vdout0_15ck127 = 1.8 time = 1280
* CHECK dout0_16 vdout0_16ck127 = 1.8 time = 1280
* CHECK dout0_17 vdout0_17ck127 = 0 time = 1280
* CHECK dout0_18 vdout0_18ck127 = 1.8 time = 1280
* CHECK dout0_19 vdout0_19ck127 = 0 time = 1280
* CHECK dout0_20 vdout0_20ck127 = 0 time = 1280
* CHECK dout0_21 vdout0_21ck127 = 1.8 time = 1280
* CHECK dout0_22 vdout0_22ck127 = 1.8 time = 1280
* CHECK dout0_23 vdout0_23ck127 = 0 time = 1280
* CHECK dout0_24 vdout0_24ck127 = 1.8 time = 1280
* CHECK dout0_25 vdout0_25ck127 = 1.8 time = 1280
* CHECK dout0_26 vdout0_26ck127 = 1.8 time = 1280
* CHECK dout0_27 vdout0_27ck127 = 1.8 time = 1280
* CHECK dout0_28 vdout0_28ck127 = 0 time = 1280
* CHECK dout0_29 vdout0_29ck127 = 0 time = 1280
* CHECK dout0_30 vdout0_30ck127 = 1.8 time = 1280
* CHECK dout0_31 vdout0_31ck127 = 1.8 time = 1280
* CHECK dout0_32 vdout0_32ck127 = 1.8 time = 1280
* CHECK dout0_33 vdout0_33ck127 = 1.8 time = 1280
* CHECK dout0_34 vdout0_34ck127 = 0 time = 1280
* CHECK dout0_35 vdout0_35ck127 = 1.8 time = 1280
* CHECK dout0_36 vdout0_36ck127 = 1.8 time = 1280
* CHECK dout0_37 vdout0_37ck127 = 1.8 time = 1280
* CHECK dout0_38 vdout0_38ck127 = 1.8 time = 1280
* CHECK dout0_39 vdout0_39ck127 = 0 time = 1280
* CHECK dout0_40 vdout0_40ck127 = 0 time = 1280
* CHECK dout0_41 vdout0_41ck127 = 0 time = 1280
* CHECK dout0_42 vdout0_42ck127 = 0 time = 1280
* CHECK dout0_43 vdout0_43ck127 = 0 time = 1280
* CHECK dout0_44 vdout0_44ck127 = 1.8 time = 1280
* CHECK dout0_45 vdout0_45ck127 = 1.8 time = 1280
* CHECK dout0_46 vdout0_46ck127 = 1.8 time = 1280
* CHECK dout0_47 vdout0_47ck127 = 1.8 time = 1280
* CHECK dout0_48 vdout0_48ck127 = 1.8 time = 1280
* CHECK dout0_49 vdout0_49ck127 = 0 time = 1280
* CHECK dout0_50 vdout0_50ck127 = 0 time = 1280
* CHECK dout0_51 vdout0_51ck127 = 0 time = 1280
* CHECK dout0_52 vdout0_52ck127 = 1.8 time = 1280
* CHECK dout0_53 vdout0_53ck127 = 0 time = 1280
* CHECK dout0_54 vdout0_54ck127 = 0 time = 1280
* CHECK dout0_55 vdout0_55ck127 = 1.8 time = 1280
* CHECK dout0_56 vdout0_56ck127 = 0 time = 1280
* CHECK dout0_57 vdout0_57ck127 = 1.8 time = 1280
* CHECK dout0_58 vdout0_58ck127 = 1.8 time = 1280
* CHECK dout0_59 vdout0_59ck127 = 0 time = 1280
* CHECK dout0_60 vdout0_60ck127 = 0 time = 1280
* CHECK dout0_61 vdout0_61ck127 = 1.8 time = 1280
* CHECK dout0_62 vdout0_62ck127 = 1.8 time = 1280
* CHECK dout0_63 vdout0_63ck127 = 0 time = 1280
* CHECK dout0_0 vdout0_0ck129 = 0 time = 1300
* CHECK dout0_1 vdout0_1ck129 = 0 time = 1300
* CHECK dout0_2 vdout0_2ck129 = 1.8 time = 1300
* CHECK dout0_3 vdout0_3ck129 = 1.8 time = 1300
* CHECK dout0_4 vdout0_4ck129 = 1.8 time = 1300
* CHECK dout0_5 vdout0_5ck129 = 1.8 time = 1300
* CHECK dout0_6 vdout0_6ck129 = 1.8 time = 1300
* CHECK dout0_7 vdout0_7ck129 = 0 time = 1300
* CHECK dout0_8 vdout0_8ck129 = 1.8 time = 1300
* CHECK dout0_9 vdout0_9ck129 = 0 time = 1300
* CHECK dout0_10 vdout0_10ck129 = 1.8 time = 1300
* CHECK dout0_11 vdout0_11ck129 = 0 time = 1300
* CHECK dout0_12 vdout0_12ck129 = 0 time = 1300
* CHECK dout0_13 vdout0_13ck129 = 1.8 time = 1300
* CHECK dout0_14 vdout0_14ck129 = 1.8 time = 1300
* CHECK dout0_15 vdout0_15ck129 = 0 time = 1300
* CHECK dout0_16 vdout0_16ck129 = 1.8 time = 1300
* CHECK dout0_17 vdout0_17ck129 = 0 time = 1300
* CHECK dout0_18 vdout0_18ck129 = 1.8 time = 1300
* CHECK dout0_19 vdout0_19ck129 = 1.8 time = 1300
* CHECK dout0_20 vdout0_20ck129 = 0 time = 1300
* CHECK dout0_21 vdout0_21ck129 = 0 time = 1300
* CHECK dout0_22 vdout0_22ck129 = 1.8 time = 1300
* CHECK dout0_23 vdout0_23ck129 = 0 time = 1300
* CHECK dout0_24 vdout0_24ck129 = 0 time = 1300
* CHECK dout0_25 vdout0_25ck129 = 1.8 time = 1300
* CHECK dout0_26 vdout0_26ck129 = 0 time = 1300
* CHECK dout0_27 vdout0_27ck129 = 1.8 time = 1300
* CHECK dout0_28 vdout0_28ck129 = 0 time = 1300
* CHECK dout0_29 vdout0_29ck129 = 0 time = 1300
* CHECK dout0_30 vdout0_30ck129 = 1.8 time = 1300
* CHECK dout0_31 vdout0_31ck129 = 1.8 time = 1300
* CHECK dout0_32 vdout0_32ck129 = 1.8 time = 1300
* CHECK dout0_33 vdout0_33ck129 = 1.8 time = 1300
* CHECK dout0_34 vdout0_34ck129 = 0 time = 1300
* CHECK dout0_35 vdout0_35ck129 = 1.8 time = 1300
* CHECK dout0_36 vdout0_36ck129 = 1.8 time = 1300
* CHECK dout0_37 vdout0_37ck129 = 0 time = 1300
* CHECK dout0_38 vdout0_38ck129 = 0 time = 1300
* CHECK dout0_39 vdout0_39ck129 = 1.8 time = 1300
* CHECK dout0_40 vdout0_40ck129 = 0 time = 1300
* CHECK dout0_41 vdout0_41ck129 = 0 time = 1300
* CHECK dout0_42 vdout0_42ck129 = 0 time = 1300
* CHECK dout0_43 vdout0_43ck129 = 0 time = 1300
* CHECK dout0_44 vdout0_44ck129 = 0 time = 1300
* CHECK dout0_45 vdout0_45ck129 = 0 time = 1300
* CHECK dout0_46 vdout0_46ck129 = 1.8 time = 1300
* CHECK dout0_47 vdout0_47ck129 = 1.8 time = 1300
* CHECK dout0_48 vdout0_48ck129 = 1.8 time = 1300
* CHECK dout0_49 vdout0_49ck129 = 1.8 time = 1300
* CHECK dout0_50 vdout0_50ck129 = 0 time = 1300
* CHECK dout0_51 vdout0_51ck129 = 1.8 time = 1300
* CHECK dout0_52 vdout0_52ck129 = 0 time = 1300
* CHECK dout0_53 vdout0_53ck129 = 1.8 time = 1300
* CHECK dout0_54 vdout0_54ck129 = 1.8 time = 1300
* CHECK dout0_55 vdout0_55ck129 = 1.8 time = 1300
* CHECK dout0_56 vdout0_56ck129 = 1.8 time = 1300
* CHECK dout0_57 vdout0_57ck129 = 1.8 time = 1300
* CHECK dout0_58 vdout0_58ck129 = 1.8 time = 1300
* CHECK dout0_59 vdout0_59ck129 = 0 time = 1300
* CHECK dout0_60 vdout0_60ck129 = 1.8 time = 1300
* CHECK dout0_61 vdout0_61ck129 = 0 time = 1300
* CHECK dout0_62 vdout0_62ck129 = 0 time = 1300
* CHECK dout0_63 vdout0_63ck129 = 0 time = 1300
* CHECK dout1_0 vdout1_0ck130 = 0 time = 1310
* CHECK dout1_1 vdout1_1ck130 = 1.8 time = 1310
* CHECK dout1_2 vdout1_2ck130 = 0 time = 1310
* CHECK dout1_3 vdout1_3ck130 = 0 time = 1310
* CHECK dout1_4 vdout1_4ck130 = 1.8 time = 1310
* CHECK dout1_5 vdout1_5ck130 = 0 time = 1310
* CHECK dout1_6 vdout1_6ck130 = 0 time = 1310
* CHECK dout1_7 vdout1_7ck130 = 0 time = 1310
* CHECK dout1_8 vdout1_8ck130 = 1.8 time = 1310
* CHECK dout1_9 vdout1_9ck130 = 0 time = 1310
* CHECK dout1_10 vdout1_10ck130 = 0 time = 1310
* CHECK dout1_11 vdout1_11ck130 = 1.8 time = 1310
* CHECK dout1_12 vdout1_12ck130 = 1.8 time = 1310
* CHECK dout1_13 vdout1_13ck130 = 1.8 time = 1310
* CHECK dout1_14 vdout1_14ck130 = 1.8 time = 1310
* CHECK dout1_15 vdout1_15ck130 = 1.8 time = 1310
* CHECK dout1_16 vdout1_16ck130 = 1.8 time = 1310
* CHECK dout1_17 vdout1_17ck130 = 0 time = 1310
* CHECK dout1_18 vdout1_18ck130 = 0 time = 1310
* CHECK dout1_19 vdout1_19ck130 = 0 time = 1310
* CHECK dout1_20 vdout1_20ck130 = 1.8 time = 1310
* CHECK dout1_21 vdout1_21ck130 = 0 time = 1310
* CHECK dout1_22 vdout1_22ck130 = 1.8 time = 1310
* CHECK dout1_23 vdout1_23ck130 = 0 time = 1310
* CHECK dout1_24 vdout1_24ck130 = 0 time = 1310
* CHECK dout1_25 vdout1_25ck130 = 1.8 time = 1310
* CHECK dout1_26 vdout1_26ck130 = 1.8 time = 1310
* CHECK dout1_27 vdout1_27ck130 = 0 time = 1310
* CHECK dout1_28 vdout1_28ck130 = 0 time = 1310
* CHECK dout1_29 vdout1_29ck130 = 0 time = 1310
* CHECK dout1_30 vdout1_30ck130 = 1.8 time = 1310
* CHECK dout1_31 vdout1_31ck130 = 0 time = 1310
* CHECK dout1_32 vdout1_32ck130 = 0 time = 1310
* CHECK dout1_33 vdout1_33ck130 = 0 time = 1310
* CHECK dout1_34 vdout1_34ck130 = 1.8 time = 1310
* CHECK dout1_35 vdout1_35ck130 = 0 time = 1310
* CHECK dout1_36 vdout1_36ck130 = 0 time = 1310
* CHECK dout1_37 vdout1_37ck130 = 0 time = 1310
* CHECK dout1_38 vdout1_38ck130 = 0 time = 1310
* CHECK dout1_39 vdout1_39ck130 = 1.8 time = 1310
* CHECK dout1_40 vdout1_40ck130 = 1.8 time = 1310
* CHECK dout1_41 vdout1_41ck130 = 0 time = 1310
* CHECK dout1_42 vdout1_42ck130 = 0 time = 1310
* CHECK dout1_43 vdout1_43ck130 = 0 time = 1310
* CHECK dout1_44 vdout1_44ck130 = 0 time = 1310
* CHECK dout1_45 vdout1_45ck130 = 0 time = 1310
* CHECK dout1_46 vdout1_46ck130 = 1.8 time = 1310
* CHECK dout1_47 vdout1_47ck130 = 1.8 time = 1310
* CHECK dout1_48 vdout1_48ck130 = 1.8 time = 1310
* CHECK dout1_49 vdout1_49ck130 = 1.8 time = 1310
* CHECK dout1_50 vdout1_50ck130 = 0 time = 1310
* CHECK dout1_51 vdout1_51ck130 = 1.8 time = 1310
* CHECK dout1_52 vdout1_52ck130 = 1.8 time = 1310
* CHECK dout1_53 vdout1_53ck130 = 1.8 time = 1310
* CHECK dout1_54 vdout1_54ck130 = 1.8 time = 1310
* CHECK dout1_55 vdout1_55ck130 = 1.8 time = 1310
* CHECK dout1_56 vdout1_56ck130 = 1.8 time = 1310
* CHECK dout1_57 vdout1_57ck130 = 1.8 time = 1310
* CHECK dout1_58 vdout1_58ck130 = 0 time = 1310
* CHECK dout1_59 vdout1_59ck130 = 1.8 time = 1310
* CHECK dout1_60 vdout1_60ck130 = 1.8 time = 1310
* CHECK dout1_61 vdout1_61ck130 = 1.8 time = 1310
* CHECK dout1_62 vdout1_62ck130 = 0 time = 1310
* CHECK dout1_63 vdout1_63ck130 = 0 time = 1310
* CHECK dout1_0 vdout1_0ck131 = 0 time = 1320
* CHECK dout1_1 vdout1_1ck131 = 0 time = 1320
* CHECK dout1_2 vdout1_2ck131 = 1.8 time = 1320
* CHECK dout1_3 vdout1_3ck131 = 1.8 time = 1320
* CHECK dout1_4 vdout1_4ck131 = 1.8 time = 1320
* CHECK dout1_5 vdout1_5ck131 = 1.8 time = 1320
* CHECK dout1_6 vdout1_6ck131 = 1.8 time = 1320
* CHECK dout1_7 vdout1_7ck131 = 0 time = 1320
* CHECK dout1_8 vdout1_8ck131 = 1.8 time = 1320
* CHECK dout1_9 vdout1_9ck131 = 0 time = 1320
* CHECK dout1_10 vdout1_10ck131 = 1.8 time = 1320
* CHECK dout1_11 vdout1_11ck131 = 0 time = 1320
* CHECK dout1_12 vdout1_12ck131 = 0 time = 1320
* CHECK dout1_13 vdout1_13ck131 = 1.8 time = 1320
* CHECK dout1_14 vdout1_14ck131 = 1.8 time = 1320
* CHECK dout1_15 vdout1_15ck131 = 0 time = 1320
* CHECK dout1_16 vdout1_16ck131 = 1.8 time = 1320
* CHECK dout1_17 vdout1_17ck131 = 0 time = 1320
* CHECK dout1_18 vdout1_18ck131 = 1.8 time = 1320
* CHECK dout1_19 vdout1_19ck131 = 1.8 time = 1320
* CHECK dout1_20 vdout1_20ck131 = 0 time = 1320
* CHECK dout1_21 vdout1_21ck131 = 0 time = 1320
* CHECK dout1_22 vdout1_22ck131 = 1.8 time = 1320
* CHECK dout1_23 vdout1_23ck131 = 0 time = 1320
* CHECK dout1_24 vdout1_24ck131 = 0 time = 1320
* CHECK dout1_25 vdout1_25ck131 = 1.8 time = 1320
* CHECK dout1_26 vdout1_26ck131 = 0 time = 1320
* CHECK dout1_27 vdout1_27ck131 = 1.8 time = 1320
* CHECK dout1_28 vdout1_28ck131 = 0 time = 1320
* CHECK dout1_29 vdout1_29ck131 = 0 time = 1320
* CHECK dout1_30 vdout1_30ck131 = 1.8 time = 1320
* CHECK dout1_31 vdout1_31ck131 = 1.8 time = 1320
* CHECK dout1_32 vdout1_32ck131 = 1.8 time = 1320
* CHECK dout1_33 vdout1_33ck131 = 1.8 time = 1320
* CHECK dout1_34 vdout1_34ck131 = 0 time = 1320
* CHECK dout1_35 vdout1_35ck131 = 1.8 time = 1320
* CHECK dout1_36 vdout1_36ck131 = 1.8 time = 1320
* CHECK dout1_37 vdout1_37ck131 = 0 time = 1320
* CHECK dout1_38 vdout1_38ck131 = 0 time = 1320
* CHECK dout1_39 vdout1_39ck131 = 1.8 time = 1320
* CHECK dout1_40 vdout1_40ck131 = 0 time = 1320
* CHECK dout1_41 vdout1_41ck131 = 0 time = 1320
* CHECK dout1_42 vdout1_42ck131 = 0 time = 1320
* CHECK dout1_43 vdout1_43ck131 = 0 time = 1320
* CHECK dout1_44 vdout1_44ck131 = 0 time = 1320
* CHECK dout1_45 vdout1_45ck131 = 0 time = 1320
* CHECK dout1_46 vdout1_46ck131 = 1.8 time = 1320
* CHECK dout1_47 vdout1_47ck131 = 1.8 time = 1320
* CHECK dout1_48 vdout1_48ck131 = 1.8 time = 1320
* CHECK dout1_49 vdout1_49ck131 = 1.8 time = 1320
* CHECK dout1_50 vdout1_50ck131 = 0 time = 1320
* CHECK dout1_51 vdout1_51ck131 = 1.8 time = 1320
* CHECK dout1_52 vdout1_52ck131 = 0 time = 1320
* CHECK dout1_53 vdout1_53ck131 = 1.8 time = 1320
* CHECK dout1_54 vdout1_54ck131 = 1.8 time = 1320
* CHECK dout1_55 vdout1_55ck131 = 1.8 time = 1320
* CHECK dout1_56 vdout1_56ck131 = 1.8 time = 1320
* CHECK dout1_57 vdout1_57ck131 = 1.8 time = 1320
* CHECK dout1_58 vdout1_58ck131 = 1.8 time = 1320
* CHECK dout1_59 vdout1_59ck131 = 0 time = 1320
* CHECK dout1_60 vdout1_60ck131 = 1.8 time = 1320
* CHECK dout1_61 vdout1_61ck131 = 0 time = 1320
* CHECK dout1_62 vdout1_62ck131 = 0 time = 1320
* CHECK dout1_63 vdout1_63ck131 = 0 time = 1320
* CHECK dout0_0 vdout0_0ck132 = 0 time = 1330
* CHECK dout0_1 vdout0_1ck132 = 0 time = 1330
* CHECK dout0_2 vdout0_2ck132 = 1.8 time = 1330
* CHECK dout0_3 vdout0_3ck132 = 1.8 time = 1330
* CHECK dout0_4 vdout0_4ck132 = 1.8 time = 1330
* CHECK dout0_5 vdout0_5ck132 = 1.8 time = 1330
* CHECK dout0_6 vdout0_6ck132 = 1.8 time = 1330
* CHECK dout0_7 vdout0_7ck132 = 0 time = 1330
* CHECK dout0_8 vdout0_8ck132 = 1.8 time = 1330
* CHECK dout0_9 vdout0_9ck132 = 0 time = 1330
* CHECK dout0_10 vdout0_10ck132 = 1.8 time = 1330
* CHECK dout0_11 vdout0_11ck132 = 0 time = 1330
* CHECK dout0_12 vdout0_12ck132 = 0 time = 1330
* CHECK dout0_13 vdout0_13ck132 = 1.8 time = 1330
* CHECK dout0_14 vdout0_14ck132 = 1.8 time = 1330
* CHECK dout0_15 vdout0_15ck132 = 0 time = 1330
* CHECK dout0_16 vdout0_16ck132 = 1.8 time = 1330
* CHECK dout0_17 vdout0_17ck132 = 0 time = 1330
* CHECK dout0_18 vdout0_18ck132 = 1.8 time = 1330
* CHECK dout0_19 vdout0_19ck132 = 1.8 time = 1330
* CHECK dout0_20 vdout0_20ck132 = 0 time = 1330
* CHECK dout0_21 vdout0_21ck132 = 0 time = 1330
* CHECK dout0_22 vdout0_22ck132 = 1.8 time = 1330
* CHECK dout0_23 vdout0_23ck132 = 0 time = 1330
* CHECK dout0_24 vdout0_24ck132 = 0 time = 1330
* CHECK dout0_25 vdout0_25ck132 = 1.8 time = 1330
* CHECK dout0_26 vdout0_26ck132 = 0 time = 1330
* CHECK dout0_27 vdout0_27ck132 = 1.8 time = 1330
* CHECK dout0_28 vdout0_28ck132 = 0 time = 1330
* CHECK dout0_29 vdout0_29ck132 = 0 time = 1330
* CHECK dout0_30 vdout0_30ck132 = 1.8 time = 1330
* CHECK dout0_31 vdout0_31ck132 = 1.8 time = 1330
* CHECK dout0_32 vdout0_32ck132 = 1.8 time = 1330
* CHECK dout0_33 vdout0_33ck132 = 1.8 time = 1330
* CHECK dout0_34 vdout0_34ck132 = 0 time = 1330
* CHECK dout0_35 vdout0_35ck132 = 1.8 time = 1330
* CHECK dout0_36 vdout0_36ck132 = 1.8 time = 1330
* CHECK dout0_37 vdout0_37ck132 = 0 time = 1330
* CHECK dout0_38 vdout0_38ck132 = 0 time = 1330
* CHECK dout0_39 vdout0_39ck132 = 1.8 time = 1330
* CHECK dout0_40 vdout0_40ck132 = 0 time = 1330
* CHECK dout0_41 vdout0_41ck132 = 0 time = 1330
* CHECK dout0_42 vdout0_42ck132 = 0 time = 1330
* CHECK dout0_43 vdout0_43ck132 = 0 time = 1330
* CHECK dout0_44 vdout0_44ck132 = 0 time = 1330
* CHECK dout0_45 vdout0_45ck132 = 0 time = 1330
* CHECK dout0_46 vdout0_46ck132 = 1.8 time = 1330
* CHECK dout0_47 vdout0_47ck132 = 1.8 time = 1330
* CHECK dout0_48 vdout0_48ck132 = 1.8 time = 1330
* CHECK dout0_49 vdout0_49ck132 = 1.8 time = 1330
* CHECK dout0_50 vdout0_50ck132 = 0 time = 1330
* CHECK dout0_51 vdout0_51ck132 = 1.8 time = 1330
* CHECK dout0_52 vdout0_52ck132 = 0 time = 1330
* CHECK dout0_53 vdout0_53ck132 = 1.8 time = 1330
* CHECK dout0_54 vdout0_54ck132 = 1.8 time = 1330
* CHECK dout0_55 vdout0_55ck132 = 1.8 time = 1330
* CHECK dout0_56 vdout0_56ck132 = 1.8 time = 1330
* CHECK dout0_57 vdout0_57ck132 = 1.8 time = 1330
* CHECK dout0_58 vdout0_58ck132 = 1.8 time = 1330
* CHECK dout0_59 vdout0_59ck132 = 0 time = 1330
* CHECK dout0_60 vdout0_60ck132 = 1.8 time = 1330
* CHECK dout0_61 vdout0_61ck132 = 0 time = 1330
* CHECK dout0_62 vdout0_62ck132 = 0 time = 1330
* CHECK dout0_63 vdout0_63ck132 = 0 time = 1330
* CHECK dout0_0 vdout0_0ck133 = 0 time = 1340
* CHECK dout0_1 vdout0_1ck133 = 1.8 time = 1340
* CHECK dout0_2 vdout0_2ck133 = 0 time = 1340
* CHECK dout0_3 vdout0_3ck133 = 0 time = 1340
* CHECK dout0_4 vdout0_4ck133 = 1.8 time = 1340
* CHECK dout0_5 vdout0_5ck133 = 0 time = 1340
* CHECK dout0_6 vdout0_6ck133 = 0 time = 1340
* CHECK dout0_7 vdout0_7ck133 = 0 time = 1340
* CHECK dout0_8 vdout0_8ck133 = 1.8 time = 1340
* CHECK dout0_9 vdout0_9ck133 = 0 time = 1340
* CHECK dout0_10 vdout0_10ck133 = 0 time = 1340
* CHECK dout0_11 vdout0_11ck133 = 1.8 time = 1340
* CHECK dout0_12 vdout0_12ck133 = 1.8 time = 1340
* CHECK dout0_13 vdout0_13ck133 = 1.8 time = 1340
* CHECK dout0_14 vdout0_14ck133 = 1.8 time = 1340
* CHECK dout0_15 vdout0_15ck133 = 1.8 time = 1340
* CHECK dout0_16 vdout0_16ck133 = 1.8 time = 1340
* CHECK dout0_17 vdout0_17ck133 = 0 time = 1340
* CHECK dout0_18 vdout0_18ck133 = 0 time = 1340
* CHECK dout0_19 vdout0_19ck133 = 0 time = 1340
* CHECK dout0_20 vdout0_20ck133 = 1.8 time = 1340
* CHECK dout0_21 vdout0_21ck133 = 0 time = 1340
* CHECK dout0_22 vdout0_22ck133 = 1.8 time = 1340
* CHECK dout0_23 vdout0_23ck133 = 0 time = 1340
* CHECK dout0_24 vdout0_24ck133 = 0 time = 1340
* CHECK dout0_25 vdout0_25ck133 = 1.8 time = 1340
* CHECK dout0_26 vdout0_26ck133 = 1.8 time = 1340
* CHECK dout0_27 vdout0_27ck133 = 0 time = 1340
* CHECK dout0_28 vdout0_28ck133 = 0 time = 1340
* CHECK dout0_29 vdout0_29ck133 = 0 time = 1340
* CHECK dout0_30 vdout0_30ck133 = 1.8 time = 1340
* CHECK dout0_31 vdout0_31ck133 = 0 time = 1340
* CHECK dout0_32 vdout0_32ck133 = 0 time = 1340
* CHECK dout0_33 vdout0_33ck133 = 0 time = 1340
* CHECK dout0_34 vdout0_34ck133 = 1.8 time = 1340
* CHECK dout0_35 vdout0_35ck133 = 0 time = 1340
* CHECK dout0_36 vdout0_36ck133 = 0 time = 1340
* CHECK dout0_37 vdout0_37ck133 = 0 time = 1340
* CHECK dout0_38 vdout0_38ck133 = 0 time = 1340
* CHECK dout0_39 vdout0_39ck133 = 1.8 time = 1340
* CHECK dout0_40 vdout0_40ck133 = 1.8 time = 1340
* CHECK dout0_41 vdout0_41ck133 = 0 time = 1340
* CHECK dout0_42 vdout0_42ck133 = 0 time = 1340
* CHECK dout0_43 vdout0_43ck133 = 0 time = 1340
* CHECK dout0_44 vdout0_44ck133 = 0 time = 1340
* CHECK dout0_45 vdout0_45ck133 = 0 time = 1340
* CHECK dout0_46 vdout0_46ck133 = 1.8 time = 1340
* CHECK dout0_47 vdout0_47ck133 = 1.8 time = 1340
* CHECK dout0_48 vdout0_48ck133 = 1.8 time = 1340
* CHECK dout0_49 vdout0_49ck133 = 1.8 time = 1340
* CHECK dout0_50 vdout0_50ck133 = 0 time = 1340
* CHECK dout0_51 vdout0_51ck133 = 1.8 time = 1340
* CHECK dout0_52 vdout0_52ck133 = 1.8 time = 1340
* CHECK dout0_53 vdout0_53ck133 = 1.8 time = 1340
* CHECK dout0_54 vdout0_54ck133 = 1.8 time = 1340
* CHECK dout0_55 vdout0_55ck133 = 1.8 time = 1340
* CHECK dout0_56 vdout0_56ck133 = 1.8 time = 1340
* CHECK dout0_57 vdout0_57ck133 = 1.8 time = 1340
* CHECK dout0_58 vdout0_58ck133 = 0 time = 1340
* CHECK dout0_59 vdout0_59ck133 = 1.8 time = 1340
* CHECK dout0_60 vdout0_60ck133 = 1.8 time = 1340
* CHECK dout0_61 vdout0_61ck133 = 1.8 time = 1340
* CHECK dout0_62 vdout0_62ck133 = 0 time = 1340
* CHECK dout0_63 vdout0_63ck133 = 0 time = 1340
* CHECK dout1_0 vdout1_0ck133 = 0 time = 1340
* CHECK dout1_1 vdout1_1ck133 = 1.8 time = 1340
* CHECK dout1_2 vdout1_2ck133 = 0 time = 1340
* CHECK dout1_3 vdout1_3ck133 = 0 time = 1340
* CHECK dout1_4 vdout1_4ck133 = 1.8 time = 1340
* CHECK dout1_5 vdout1_5ck133 = 0 time = 1340
* CHECK dout1_6 vdout1_6ck133 = 0 time = 1340
* CHECK dout1_7 vdout1_7ck133 = 0 time = 1340
* CHECK dout1_8 vdout1_8ck133 = 1.8 time = 1340
* CHECK dout1_9 vdout1_9ck133 = 0 time = 1340
* CHECK dout1_10 vdout1_10ck133 = 0 time = 1340
* CHECK dout1_11 vdout1_11ck133 = 1.8 time = 1340
* CHECK dout1_12 vdout1_12ck133 = 1.8 time = 1340
* CHECK dout1_13 vdout1_13ck133 = 1.8 time = 1340
* CHECK dout1_14 vdout1_14ck133 = 1.8 time = 1340
* CHECK dout1_15 vdout1_15ck133 = 1.8 time = 1340
* CHECK dout1_16 vdout1_16ck133 = 1.8 time = 1340
* CHECK dout1_17 vdout1_17ck133 = 0 time = 1340
* CHECK dout1_18 vdout1_18ck133 = 0 time = 1340
* CHECK dout1_19 vdout1_19ck133 = 0 time = 1340
* CHECK dout1_20 vdout1_20ck133 = 1.8 time = 1340
* CHECK dout1_21 vdout1_21ck133 = 0 time = 1340
* CHECK dout1_22 vdout1_22ck133 = 1.8 time = 1340
* CHECK dout1_23 vdout1_23ck133 = 0 time = 1340
* CHECK dout1_24 vdout1_24ck133 = 0 time = 1340
* CHECK dout1_25 vdout1_25ck133 = 1.8 time = 1340
* CHECK dout1_26 vdout1_26ck133 = 1.8 time = 1340
* CHECK dout1_27 vdout1_27ck133 = 0 time = 1340
* CHECK dout1_28 vdout1_28ck133 = 0 time = 1340
* CHECK dout1_29 vdout1_29ck133 = 0 time = 1340
* CHECK dout1_30 vdout1_30ck133 = 1.8 time = 1340
* CHECK dout1_31 vdout1_31ck133 = 0 time = 1340
* CHECK dout1_32 vdout1_32ck133 = 0 time = 1340
* CHECK dout1_33 vdout1_33ck133 = 0 time = 1340
* CHECK dout1_34 vdout1_34ck133 = 1.8 time = 1340
* CHECK dout1_35 vdout1_35ck133 = 0 time = 1340
* CHECK dout1_36 vdout1_36ck133 = 0 time = 1340
* CHECK dout1_37 vdout1_37ck133 = 0 time = 1340
* CHECK dout1_38 vdout1_38ck133 = 0 time = 1340
* CHECK dout1_39 vdout1_39ck133 = 1.8 time = 1340
* CHECK dout1_40 vdout1_40ck133 = 1.8 time = 1340
* CHECK dout1_41 vdout1_41ck133 = 0 time = 1340
* CHECK dout1_42 vdout1_42ck133 = 0 time = 1340
* CHECK dout1_43 vdout1_43ck133 = 0 time = 1340
* CHECK dout1_44 vdout1_44ck133 = 0 time = 1340
* CHECK dout1_45 vdout1_45ck133 = 0 time = 1340
* CHECK dout1_46 vdout1_46ck133 = 1.8 time = 1340
* CHECK dout1_47 vdout1_47ck133 = 1.8 time = 1340
* CHECK dout1_48 vdout1_48ck133 = 1.8 time = 1340
* CHECK dout1_49 vdout1_49ck133 = 1.8 time = 1340
* CHECK dout1_50 vdout1_50ck133 = 0 time = 1340
* CHECK dout1_51 vdout1_51ck133 = 1.8 time = 1340
* CHECK dout1_52 vdout1_52ck133 = 1.8 time = 1340
* CHECK dout1_53 vdout1_53ck133 = 1.8 time = 1340
* CHECK dout1_54 vdout1_54ck133 = 1.8 time = 1340
* CHECK dout1_55 vdout1_55ck133 = 1.8 time = 1340
* CHECK dout1_56 vdout1_56ck133 = 1.8 time = 1340
* CHECK dout1_57 vdout1_57ck133 = 1.8 time = 1340
* CHECK dout1_58 vdout1_58ck133 = 0 time = 1340
* CHECK dout1_59 vdout1_59ck133 = 1.8 time = 1340
* CHECK dout1_60 vdout1_60ck133 = 1.8 time = 1340
* CHECK dout1_61 vdout1_61ck133 = 1.8 time = 1340
* CHECK dout1_62 vdout1_62ck133 = 0 time = 1340
* CHECK dout1_63 vdout1_63ck133 = 0 time = 1340
* CHECK dout0_0 vdout0_0ck135 = 0 time = 1360
* CHECK dout0_1 vdout0_1ck135 = 0 time = 1360
* CHECK dout0_2 vdout0_2ck135 = 1.8 time = 1360
* CHECK dout0_3 vdout0_3ck135 = 1.8 time = 1360
* CHECK dout0_4 vdout0_4ck135 = 1.8 time = 1360
* CHECK dout0_5 vdout0_5ck135 = 1.8 time = 1360
* CHECK dout0_6 vdout0_6ck135 = 1.8 time = 1360
* CHECK dout0_7 vdout0_7ck135 = 0 time = 1360
* CHECK dout0_8 vdout0_8ck135 = 1.8 time = 1360
* CHECK dout0_9 vdout0_9ck135 = 0 time = 1360
* CHECK dout0_10 vdout0_10ck135 = 1.8 time = 1360
* CHECK dout0_11 vdout0_11ck135 = 0 time = 1360
* CHECK dout0_12 vdout0_12ck135 = 0 time = 1360
* CHECK dout0_13 vdout0_13ck135 = 1.8 time = 1360
* CHECK dout0_14 vdout0_14ck135 = 1.8 time = 1360
* CHECK dout0_15 vdout0_15ck135 = 0 time = 1360
* CHECK dout0_16 vdout0_16ck135 = 1.8 time = 1360
* CHECK dout0_17 vdout0_17ck135 = 0 time = 1360
* CHECK dout0_18 vdout0_18ck135 = 1.8 time = 1360
* CHECK dout0_19 vdout0_19ck135 = 1.8 time = 1360
* CHECK dout0_20 vdout0_20ck135 = 0 time = 1360
* CHECK dout0_21 vdout0_21ck135 = 0 time = 1360
* CHECK dout0_22 vdout0_22ck135 = 1.8 time = 1360
* CHECK dout0_23 vdout0_23ck135 = 0 time = 1360
* CHECK dout0_24 vdout0_24ck135 = 0 time = 1360
* CHECK dout0_25 vdout0_25ck135 = 1.8 time = 1360
* CHECK dout0_26 vdout0_26ck135 = 0 time = 1360
* CHECK dout0_27 vdout0_27ck135 = 1.8 time = 1360
* CHECK dout0_28 vdout0_28ck135 = 0 time = 1360
* CHECK dout0_29 vdout0_29ck135 = 0 time = 1360
* CHECK dout0_30 vdout0_30ck135 = 1.8 time = 1360
* CHECK dout0_31 vdout0_31ck135 = 1.8 time = 1360
* CHECK dout0_32 vdout0_32ck135 = 1.8 time = 1360
* CHECK dout0_33 vdout0_33ck135 = 1.8 time = 1360
* CHECK dout0_34 vdout0_34ck135 = 0 time = 1360
* CHECK dout0_35 vdout0_35ck135 = 1.8 time = 1360
* CHECK dout0_36 vdout0_36ck135 = 1.8 time = 1360
* CHECK dout0_37 vdout0_37ck135 = 0 time = 1360
* CHECK dout0_38 vdout0_38ck135 = 0 time = 1360
* CHECK dout0_39 vdout0_39ck135 = 1.8 time = 1360
* CHECK dout0_40 vdout0_40ck135 = 0 time = 1360
* CHECK dout0_41 vdout0_41ck135 = 0 time = 1360
* CHECK dout0_42 vdout0_42ck135 = 0 time = 1360
* CHECK dout0_43 vdout0_43ck135 = 0 time = 1360
* CHECK dout0_44 vdout0_44ck135 = 0 time = 1360
* CHECK dout0_45 vdout0_45ck135 = 0 time = 1360
* CHECK dout0_46 vdout0_46ck135 = 1.8 time = 1360
* CHECK dout0_47 vdout0_47ck135 = 1.8 time = 1360
* CHECK dout0_48 vdout0_48ck135 = 1.8 time = 1360
* CHECK dout0_49 vdout0_49ck135 = 1.8 time = 1360
* CHECK dout0_50 vdout0_50ck135 = 0 time = 1360
* CHECK dout0_51 vdout0_51ck135 = 1.8 time = 1360
* CHECK dout0_52 vdout0_52ck135 = 0 time = 1360
* CHECK dout0_53 vdout0_53ck135 = 1.8 time = 1360
* CHECK dout0_54 vdout0_54ck135 = 1.8 time = 1360
* CHECK dout0_55 vdout0_55ck135 = 1.8 time = 1360
* CHECK dout0_56 vdout0_56ck135 = 1.8 time = 1360
* CHECK dout0_57 vdout0_57ck135 = 1.8 time = 1360
* CHECK dout0_58 vdout0_58ck135 = 1.8 time = 1360
* CHECK dout0_59 vdout0_59ck135 = 0 time = 1360
* CHECK dout0_60 vdout0_60ck135 = 1.8 time = 1360
* CHECK dout0_61 vdout0_61ck135 = 0 time = 1360
* CHECK dout0_62 vdout0_62ck135 = 0 time = 1360
* CHECK dout0_63 vdout0_63ck135 = 0 time = 1360
* CHECK dout1_0 vdout1_0ck135 = 1.8 time = 1360
* CHECK dout1_1 vdout1_1ck135 = 0 time = 1360
* CHECK dout1_2 vdout1_2ck135 = 1.8 time = 1360
* CHECK dout1_3 vdout1_3ck135 = 1.8 time = 1360
* CHECK dout1_4 vdout1_4ck135 = 0 time = 1360
* CHECK dout1_5 vdout1_5ck135 = 1.8 time = 1360
* CHECK dout1_6 vdout1_6ck135 = 0 time = 1360
* CHECK dout1_7 vdout1_7ck135 = 1.8 time = 1360
* CHECK dout1_8 vdout1_8ck135 = 0 time = 1360
* CHECK dout1_9 vdout1_9ck135 = 1.8 time = 1360
* CHECK dout1_10 vdout1_10ck135 = 0 time = 1360
* CHECK dout1_11 vdout1_11ck135 = 1.8 time = 1360
* CHECK dout1_12 vdout1_12ck135 = 1.8 time = 1360
* CHECK dout1_13 vdout1_13ck135 = 0 time = 1360
* CHECK dout1_14 vdout1_14ck135 = 1.8 time = 1360
* CHECK dout1_15 vdout1_15ck135 = 1.8 time = 1360
* CHECK dout1_16 vdout1_16ck135 = 0 time = 1360
* CHECK dout1_17 vdout1_17ck135 = 0 time = 1360
* CHECK dout1_18 vdout1_18ck135 = 1.8 time = 1360
* CHECK dout1_19 vdout1_19ck135 = 1.8 time = 1360
* CHECK dout1_20 vdout1_20ck135 = 0 time = 1360
* CHECK dout1_21 vdout1_21ck135 = 1.8 time = 1360
* CHECK dout1_22 vdout1_22ck135 = 0 time = 1360
* CHECK dout1_23 vdout1_23ck135 = 0 time = 1360
* CHECK dout1_24 vdout1_24ck135 = 1.8 time = 1360
* CHECK dout1_25 vdout1_25ck135 = 0 time = 1360
* CHECK dout1_26 vdout1_26ck135 = 1.8 time = 1360
* CHECK dout1_27 vdout1_27ck135 = 0 time = 1360
* CHECK dout1_28 vdout1_28ck135 = 1.8 time = 1360
* CHECK dout1_29 vdout1_29ck135 = 1.8 time = 1360
* CHECK dout1_30 vdout1_30ck135 = 1.8 time = 1360
* CHECK dout1_31 vdout1_31ck135 = 1.8 time = 1360
* CHECK dout1_32 vdout1_32ck135 = 0 time = 1360
* CHECK dout1_33 vdout1_33ck135 = 0 time = 1360
* CHECK dout1_34 vdout1_34ck135 = 0 time = 1360
* CHECK dout1_35 vdout1_35ck135 = 1.8 time = 1360
* CHECK dout1_36 vdout1_36ck135 = 1.8 time = 1360
* CHECK dout1_37 vdout1_37ck135 = 0 time = 1360
* CHECK dout1_38 vdout1_38ck135 = 0 time = 1360
* CHECK dout1_39 vdout1_39ck135 = 1.8 time = 1360
* CHECK dout1_40 vdout1_40ck135 = 1.8 time = 1360
* CHECK dout1_41 vdout1_41ck135 = 1.8 time = 1360
* CHECK dout1_42 vdout1_42ck135 = 0 time = 1360
* CHECK dout1_43 vdout1_43ck135 = 0 time = 1360
* CHECK dout1_44 vdout1_44ck135 = 1.8 time = 1360
* CHECK dout1_45 vdout1_45ck135 = 1.8 time = 1360
* CHECK dout1_46 vdout1_46ck135 = 0 time = 1360
* CHECK dout1_47 vdout1_47ck135 = 0 time = 1360
* CHECK dout1_48 vdout1_48ck135 = 0 time = 1360
* CHECK dout1_49 vdout1_49ck135 = 1.8 time = 1360
* CHECK dout1_50 vdout1_50ck135 = 1.8 time = 1360
* CHECK dout1_51 vdout1_51ck135 = 1.8 time = 1360
* CHECK dout1_52 vdout1_52ck135 = 0 time = 1360
* CHECK dout1_53 vdout1_53ck135 = 0 time = 1360
* CHECK dout1_54 vdout1_54ck135 = 0 time = 1360
* CHECK dout1_55 vdout1_55ck135 = 0 time = 1360
* CHECK dout1_56 vdout1_56ck135 = 1.8 time = 1360
* CHECK dout1_57 vdout1_57ck135 = 0 time = 1360
* CHECK dout1_58 vdout1_58ck135 = 1.8 time = 1360
* CHECK dout1_59 vdout1_59ck135 = 0 time = 1360
* CHECK dout1_60 vdout1_60ck135 = 0 time = 1360
* CHECK dout1_61 vdout1_61ck135 = 1.8 time = 1360
* CHECK dout1_62 vdout1_62ck135 = 1.8 time = 1360
* CHECK dout1_63 vdout1_63ck135 = 1.8 time = 1360
* CHECK dout0_0 vdout0_0ck136 = 0 time = 1370
* CHECK dout0_1 vdout0_1ck136 = 1.8 time = 1370
* CHECK dout0_2 vdout0_2ck136 = 0 time = 1370
* CHECK dout0_3 vdout0_3ck136 = 0 time = 1370
* CHECK dout0_4 vdout0_4ck136 = 1.8 time = 1370
* CHECK dout0_5 vdout0_5ck136 = 0 time = 1370
* CHECK dout0_6 vdout0_6ck136 = 0 time = 1370
* CHECK dout0_7 vdout0_7ck136 = 0 time = 1370
* CHECK dout0_8 vdout0_8ck136 = 1.8 time = 1370
* CHECK dout0_9 vdout0_9ck136 = 0 time = 1370
* CHECK dout0_10 vdout0_10ck136 = 0 time = 1370
* CHECK dout0_11 vdout0_11ck136 = 1.8 time = 1370
* CHECK dout0_12 vdout0_12ck136 = 1.8 time = 1370
* CHECK dout0_13 vdout0_13ck136 = 1.8 time = 1370
* CHECK dout0_14 vdout0_14ck136 = 1.8 time = 1370
* CHECK dout0_15 vdout0_15ck136 = 1.8 time = 1370
* CHECK dout0_16 vdout0_16ck136 = 1.8 time = 1370
* CHECK dout0_17 vdout0_17ck136 = 0 time = 1370
* CHECK dout0_18 vdout0_18ck136 = 0 time = 1370
* CHECK dout0_19 vdout0_19ck136 = 0 time = 1370
* CHECK dout0_20 vdout0_20ck136 = 1.8 time = 1370
* CHECK dout0_21 vdout0_21ck136 = 0 time = 1370
* CHECK dout0_22 vdout0_22ck136 = 1.8 time = 1370
* CHECK dout0_23 vdout0_23ck136 = 0 time = 1370
* CHECK dout0_24 vdout0_24ck136 = 0 time = 1370
* CHECK dout0_25 vdout0_25ck136 = 1.8 time = 1370
* CHECK dout0_26 vdout0_26ck136 = 1.8 time = 1370
* CHECK dout0_27 vdout0_27ck136 = 0 time = 1370
* CHECK dout0_28 vdout0_28ck136 = 0 time = 1370
* CHECK dout0_29 vdout0_29ck136 = 0 time = 1370
* CHECK dout0_30 vdout0_30ck136 = 1.8 time = 1370
* CHECK dout0_31 vdout0_31ck136 = 0 time = 1370
* CHECK dout0_32 vdout0_32ck136 = 0 time = 1370
* CHECK dout0_33 vdout0_33ck136 = 0 time = 1370
* CHECK dout0_34 vdout0_34ck136 = 1.8 time = 1370
* CHECK dout0_35 vdout0_35ck136 = 0 time = 1370
* CHECK dout0_36 vdout0_36ck136 = 0 time = 1370
* CHECK dout0_37 vdout0_37ck136 = 0 time = 1370
* CHECK dout0_38 vdout0_38ck136 = 0 time = 1370
* CHECK dout0_39 vdout0_39ck136 = 1.8 time = 1370
* CHECK dout0_40 vdout0_40ck136 = 1.8 time = 1370
* CHECK dout0_41 vdout0_41ck136 = 0 time = 1370
* CHECK dout0_42 vdout0_42ck136 = 0 time = 1370
* CHECK dout0_43 vdout0_43ck136 = 0 time = 1370
* CHECK dout0_44 vdout0_44ck136 = 0 time = 1370
* CHECK dout0_45 vdout0_45ck136 = 0 time = 1370
* CHECK dout0_46 vdout0_46ck136 = 1.8 time = 1370
* CHECK dout0_47 vdout0_47ck136 = 1.8 time = 1370
* CHECK dout0_48 vdout0_48ck136 = 1.8 time = 1370
* CHECK dout0_49 vdout0_49ck136 = 1.8 time = 1370
* CHECK dout0_50 vdout0_50ck136 = 0 time = 1370
* CHECK dout0_51 vdout0_51ck136 = 1.8 time = 1370
* CHECK dout0_52 vdout0_52ck136 = 1.8 time = 1370
* CHECK dout0_53 vdout0_53ck136 = 1.8 time = 1370
* CHECK dout0_54 vdout0_54ck136 = 1.8 time = 1370
* CHECK dout0_55 vdout0_55ck136 = 1.8 time = 1370
* CHECK dout0_56 vdout0_56ck136 = 1.8 time = 1370
* CHECK dout0_57 vdout0_57ck136 = 1.8 time = 1370
* CHECK dout0_58 vdout0_58ck136 = 0 time = 1370
* CHECK dout0_59 vdout0_59ck136 = 1.8 time = 1370
* CHECK dout0_60 vdout0_60ck136 = 1.8 time = 1370
* CHECK dout0_61 vdout0_61ck136 = 1.8 time = 1370
* CHECK dout0_62 vdout0_62ck136 = 0 time = 1370
* CHECK dout0_63 vdout0_63ck136 = 0 time = 1370
* CHECK dout1_0 vdout1_0ck136 = 0 time = 1370
* CHECK dout1_1 vdout1_1ck136 = 0 time = 1370
* CHECK dout1_2 vdout1_2ck136 = 1.8 time = 1370
* CHECK dout1_3 vdout1_3ck136 = 1.8 time = 1370
* CHECK dout1_4 vdout1_4ck136 = 1.8 time = 1370
* CHECK dout1_5 vdout1_5ck136 = 1.8 time = 1370
* CHECK dout1_6 vdout1_6ck136 = 1.8 time = 1370
* CHECK dout1_7 vdout1_7ck136 = 0 time = 1370
* CHECK dout1_8 vdout1_8ck136 = 1.8 time = 1370
* CHECK dout1_9 vdout1_9ck136 = 0 time = 1370
* CHECK dout1_10 vdout1_10ck136 = 1.8 time = 1370
* CHECK dout1_11 vdout1_11ck136 = 0 time = 1370
* CHECK dout1_12 vdout1_12ck136 = 0 time = 1370
* CHECK dout1_13 vdout1_13ck136 = 1.8 time = 1370
* CHECK dout1_14 vdout1_14ck136 = 1.8 time = 1370
* CHECK dout1_15 vdout1_15ck136 = 0 time = 1370
* CHECK dout1_16 vdout1_16ck136 = 1.8 time = 1370
* CHECK dout1_17 vdout1_17ck136 = 0 time = 1370
* CHECK dout1_18 vdout1_18ck136 = 1.8 time = 1370
* CHECK dout1_19 vdout1_19ck136 = 1.8 time = 1370
* CHECK dout1_20 vdout1_20ck136 = 0 time = 1370
* CHECK dout1_21 vdout1_21ck136 = 0 time = 1370
* CHECK dout1_22 vdout1_22ck136 = 1.8 time = 1370
* CHECK dout1_23 vdout1_23ck136 = 0 time = 1370
* CHECK dout1_24 vdout1_24ck136 = 0 time = 1370
* CHECK dout1_25 vdout1_25ck136 = 1.8 time = 1370
* CHECK dout1_26 vdout1_26ck136 = 0 time = 1370
* CHECK dout1_27 vdout1_27ck136 = 1.8 time = 1370
* CHECK dout1_28 vdout1_28ck136 = 0 time = 1370
* CHECK dout1_29 vdout1_29ck136 = 0 time = 1370
* CHECK dout1_30 vdout1_30ck136 = 1.8 time = 1370
* CHECK dout1_31 vdout1_31ck136 = 1.8 time = 1370
* CHECK dout1_32 vdout1_32ck136 = 1.8 time = 1370
* CHECK dout1_33 vdout1_33ck136 = 1.8 time = 1370
* CHECK dout1_34 vdout1_34ck136 = 0 time = 1370
* CHECK dout1_35 vdout1_35ck136 = 1.8 time = 1370
* CHECK dout1_36 vdout1_36ck136 = 1.8 time = 1370
* CHECK dout1_37 vdout1_37ck136 = 0 time = 1370
* CHECK dout1_38 vdout1_38ck136 = 0 time = 1370
* CHECK dout1_39 vdout1_39ck136 = 1.8 time = 1370
* CHECK dout1_40 vdout1_40ck136 = 0 time = 1370
* CHECK dout1_41 vdout1_41ck136 = 0 time = 1370
* CHECK dout1_42 vdout1_42ck136 = 0 time = 1370
* CHECK dout1_43 vdout1_43ck136 = 0 time = 1370
* CHECK dout1_44 vdout1_44ck136 = 0 time = 1370
* CHECK dout1_45 vdout1_45ck136 = 0 time = 1370
* CHECK dout1_46 vdout1_46ck136 = 1.8 time = 1370
* CHECK dout1_47 vdout1_47ck136 = 1.8 time = 1370
* CHECK dout1_48 vdout1_48ck136 = 1.8 time = 1370
* CHECK dout1_49 vdout1_49ck136 = 1.8 time = 1370
* CHECK dout1_50 vdout1_50ck136 = 0 time = 1370
* CHECK dout1_51 vdout1_51ck136 = 1.8 time = 1370
* CHECK dout1_52 vdout1_52ck136 = 0 time = 1370
* CHECK dout1_53 vdout1_53ck136 = 1.8 time = 1370
* CHECK dout1_54 vdout1_54ck136 = 1.8 time = 1370
* CHECK dout1_55 vdout1_55ck136 = 1.8 time = 1370
* CHECK dout1_56 vdout1_56ck136 = 1.8 time = 1370
* CHECK dout1_57 vdout1_57ck136 = 1.8 time = 1370
* CHECK dout1_58 vdout1_58ck136 = 1.8 time = 1370
* CHECK dout1_59 vdout1_59ck136 = 0 time = 1370
* CHECK dout1_60 vdout1_60ck136 = 1.8 time = 1370
* CHECK dout1_61 vdout1_61ck136 = 0 time = 1370
* CHECK dout1_62 vdout1_62ck136 = 0 time = 1370
* CHECK dout1_63 vdout1_63ck136 = 0 time = 1370
* CHECK dout0_0 vdout0_0ck138 = 0 time = 1390
* CHECK dout0_1 vdout0_1ck138 = 0 time = 1390
* CHECK dout0_2 vdout0_2ck138 = 1.8 time = 1390
* CHECK dout0_3 vdout0_3ck138 = 1.8 time = 1390
* CHECK dout0_4 vdout0_4ck138 = 1.8 time = 1390
* CHECK dout0_5 vdout0_5ck138 = 1.8 time = 1390
* CHECK dout0_6 vdout0_6ck138 = 1.8 time = 1390
* CHECK dout0_7 vdout0_7ck138 = 0 time = 1390
* CHECK dout0_8 vdout0_8ck138 = 1.8 time = 1390
* CHECK dout0_9 vdout0_9ck138 = 0 time = 1390
* CHECK dout0_10 vdout0_10ck138 = 1.8 time = 1390
* CHECK dout0_11 vdout0_11ck138 = 0 time = 1390
* CHECK dout0_12 vdout0_12ck138 = 0 time = 1390
* CHECK dout0_13 vdout0_13ck138 = 1.8 time = 1390
* CHECK dout0_14 vdout0_14ck138 = 1.8 time = 1390
* CHECK dout0_15 vdout0_15ck138 = 0 time = 1390
* CHECK dout0_16 vdout0_16ck138 = 1.8 time = 1390
* CHECK dout0_17 vdout0_17ck138 = 0 time = 1390
* CHECK dout0_18 vdout0_18ck138 = 1.8 time = 1390
* CHECK dout0_19 vdout0_19ck138 = 1.8 time = 1390
* CHECK dout0_20 vdout0_20ck138 = 0 time = 1390
* CHECK dout0_21 vdout0_21ck138 = 0 time = 1390
* CHECK dout0_22 vdout0_22ck138 = 1.8 time = 1390
* CHECK dout0_23 vdout0_23ck138 = 0 time = 1390
* CHECK dout0_24 vdout0_24ck138 = 0 time = 1390
* CHECK dout0_25 vdout0_25ck138 = 1.8 time = 1390
* CHECK dout0_26 vdout0_26ck138 = 0 time = 1390
* CHECK dout0_27 vdout0_27ck138 = 1.8 time = 1390
* CHECK dout0_28 vdout0_28ck138 = 0 time = 1390
* CHECK dout0_29 vdout0_29ck138 = 0 time = 1390
* CHECK dout0_30 vdout0_30ck138 = 1.8 time = 1390
* CHECK dout0_31 vdout0_31ck138 = 1.8 time = 1390
* CHECK dout0_32 vdout0_32ck138 = 1.8 time = 1390
* CHECK dout0_33 vdout0_33ck138 = 1.8 time = 1390
* CHECK dout0_34 vdout0_34ck138 = 0 time = 1390
* CHECK dout0_35 vdout0_35ck138 = 1.8 time = 1390
* CHECK dout0_36 vdout0_36ck138 = 1.8 time = 1390
* CHECK dout0_37 vdout0_37ck138 = 0 time = 1390
* CHECK dout0_38 vdout0_38ck138 = 0 time = 1390
* CHECK dout0_39 vdout0_39ck138 = 1.8 time = 1390
* CHECK dout0_40 vdout0_40ck138 = 0 time = 1390
* CHECK dout0_41 vdout0_41ck138 = 0 time = 1390
* CHECK dout0_42 vdout0_42ck138 = 0 time = 1390
* CHECK dout0_43 vdout0_43ck138 = 0 time = 1390
* CHECK dout0_44 vdout0_44ck138 = 0 time = 1390
* CHECK dout0_45 vdout0_45ck138 = 0 time = 1390
* CHECK dout0_46 vdout0_46ck138 = 1.8 time = 1390
* CHECK dout0_47 vdout0_47ck138 = 1.8 time = 1390
* CHECK dout0_48 vdout0_48ck138 = 1.8 time = 1390
* CHECK dout0_49 vdout0_49ck138 = 1.8 time = 1390
* CHECK dout0_50 vdout0_50ck138 = 0 time = 1390
* CHECK dout0_51 vdout0_51ck138 = 1.8 time = 1390
* CHECK dout0_52 vdout0_52ck138 = 0 time = 1390
* CHECK dout0_53 vdout0_53ck138 = 1.8 time = 1390
* CHECK dout0_54 vdout0_54ck138 = 1.8 time = 1390
* CHECK dout0_55 vdout0_55ck138 = 1.8 time = 1390
* CHECK dout0_56 vdout0_56ck138 = 1.8 time = 1390
* CHECK dout0_57 vdout0_57ck138 = 1.8 time = 1390
* CHECK dout0_58 vdout0_58ck138 = 1.8 time = 1390
* CHECK dout0_59 vdout0_59ck138 = 0 time = 1390
* CHECK dout0_60 vdout0_60ck138 = 1.8 time = 1390
* CHECK dout0_61 vdout0_61ck138 = 0 time = 1390
* CHECK dout0_62 vdout0_62ck138 = 0 time = 1390
* CHECK dout0_63 vdout0_63ck138 = 0 time = 1390
* CHECK dout1_0 vdout1_0ck138 = 0 time = 1390
* CHECK dout1_1 vdout1_1ck138 = 0 time = 1390
* CHECK dout1_2 vdout1_2ck138 = 0 time = 1390
* CHECK dout1_3 vdout1_3ck138 = 0 time = 1390
* CHECK dout1_4 vdout1_4ck138 = 0 time = 1390
* CHECK dout1_5 vdout1_5ck138 = 1.8 time = 1390
* CHECK dout1_6 vdout1_6ck138 = 1.8 time = 1390
* CHECK dout1_7 vdout1_7ck138 = 0 time = 1390
* CHECK dout1_8 vdout1_8ck138 = 0 time = 1390
* CHECK dout1_9 vdout1_9ck138 = 1.8 time = 1390
* CHECK dout1_10 vdout1_10ck138 = 0 time = 1390
* CHECK dout1_11 vdout1_11ck138 = 0 time = 1390
* CHECK dout1_12 vdout1_12ck138 = 1.8 time = 1390
* CHECK dout1_13 vdout1_13ck138 = 0 time = 1390
* CHECK dout1_14 vdout1_14ck138 = 1.8 time = 1390
* CHECK dout1_15 vdout1_15ck138 = 0 time = 1390
* CHECK dout1_16 vdout1_16ck138 = 1.8 time = 1390
* CHECK dout1_17 vdout1_17ck138 = 1.8 time = 1390
* CHECK dout1_18 vdout1_18ck138 = 1.8 time = 1390
* CHECK dout1_19 vdout1_19ck138 = 1.8 time = 1390
* CHECK dout1_20 vdout1_20ck138 = 0 time = 1390
* CHECK dout1_21 vdout1_21ck138 = 0 time = 1390
* CHECK dout1_22 vdout1_22ck138 = 0 time = 1390
* CHECK dout1_23 vdout1_23ck138 = 0 time = 1390
* CHECK dout1_24 vdout1_24ck138 = 0 time = 1390
* CHECK dout1_25 vdout1_25ck138 = 1.8 time = 1390
* CHECK dout1_26 vdout1_26ck138 = 1.8 time = 1390
* CHECK dout1_27 vdout1_27ck138 = 0 time = 1390
* CHECK dout1_28 vdout1_28ck138 = 0 time = 1390
* CHECK dout1_29 vdout1_29ck138 = 1.8 time = 1390
* CHECK dout1_30 vdout1_30ck138 = 1.8 time = 1390
* CHECK dout1_31 vdout1_31ck138 = 1.8 time = 1390
* CHECK dout1_32 vdout1_32ck138 = 0 time = 1390
* CHECK dout1_33 vdout1_33ck138 = 0 time = 1390
* CHECK dout1_34 vdout1_34ck138 = 1.8 time = 1390
* CHECK dout1_35 vdout1_35ck138 = 1.8 time = 1390
* CHECK dout1_36 vdout1_36ck138 = 1.8 time = 1390
* CHECK dout1_37 vdout1_37ck138 = 1.8 time = 1390
* CHECK dout1_38 vdout1_38ck138 = 1.8 time = 1390
* CHECK dout1_39 vdout1_39ck138 = 0 time = 1390
* CHECK dout1_40 vdout1_40ck138 = 1.8 time = 1390
* CHECK dout1_41 vdout1_41ck138 = 1.8 time = 1390
* CHECK dout1_42 vdout1_42ck138 = 1.8 time = 1390
* CHECK dout1_43 vdout1_43ck138 = 1.8 time = 1390
* CHECK dout1_44 vdout1_44ck138 = 1.8 time = 1390
* CHECK dout1_45 vdout1_45ck138 = 1.8 time = 1390
* CHECK dout1_46 vdout1_46ck138 = 0 time = 1390
* CHECK dout1_47 vdout1_47ck138 = 1.8 time = 1390
* CHECK dout1_48 vdout1_48ck138 = 0 time = 1390
* CHECK dout1_49 vdout1_49ck138 = 1.8 time = 1390
* CHECK dout1_50 vdout1_50ck138 = 0 time = 1390
* CHECK dout1_51 vdout1_51ck138 = 0 time = 1390
* CHECK dout1_52 vdout1_52ck138 = 1.8 time = 1390
* CHECK dout1_53 vdout1_53ck138 = 1.8 time = 1390
* CHECK dout1_54 vdout1_54ck138 = 0 time = 1390
* CHECK dout1_55 vdout1_55ck138 = 0 time = 1390
* CHECK dout1_56 vdout1_56ck138 = 1.8 time = 1390
* CHECK dout1_57 vdout1_57ck138 = 0 time = 1390
* CHECK dout1_58 vdout1_58ck138 = 0 time = 1390
* CHECK dout1_59 vdout1_59ck138 = 0 time = 1390
* CHECK dout1_60 vdout1_60ck138 = 0 time = 1390
* CHECK dout1_61 vdout1_61ck138 = 0 time = 1390
* CHECK dout1_62 vdout1_62ck138 = 0 time = 1390
* CHECK dout1_63 vdout1_63ck138 = 1.8 time = 1390
* CHECK dout0_0 vdout0_0ck139 = 0 time = 1400
* CHECK dout0_1 vdout0_1ck139 = 0 time = 1400
* CHECK dout0_2 vdout0_2ck139 = 1.8 time = 1400
* CHECK dout0_3 vdout0_3ck139 = 1.8 time = 1400
* CHECK dout0_4 vdout0_4ck139 = 1.8 time = 1400
* CHECK dout0_5 vdout0_5ck139 = 1.8 time = 1400
* CHECK dout0_6 vdout0_6ck139 = 1.8 time = 1400
* CHECK dout0_7 vdout0_7ck139 = 0 time = 1400
* CHECK dout0_8 vdout0_8ck139 = 1.8 time = 1400
* CHECK dout0_9 vdout0_9ck139 = 0 time = 1400
* CHECK dout0_10 vdout0_10ck139 = 1.8 time = 1400
* CHECK dout0_11 vdout0_11ck139 = 0 time = 1400
* CHECK dout0_12 vdout0_12ck139 = 0 time = 1400
* CHECK dout0_13 vdout0_13ck139 = 1.8 time = 1400
* CHECK dout0_14 vdout0_14ck139 = 1.8 time = 1400
* CHECK dout0_15 vdout0_15ck139 = 0 time = 1400
* CHECK dout0_16 vdout0_16ck139 = 1.8 time = 1400
* CHECK dout0_17 vdout0_17ck139 = 0 time = 1400
* CHECK dout0_18 vdout0_18ck139 = 1.8 time = 1400
* CHECK dout0_19 vdout0_19ck139 = 1.8 time = 1400
* CHECK dout0_20 vdout0_20ck139 = 0 time = 1400
* CHECK dout0_21 vdout0_21ck139 = 0 time = 1400
* CHECK dout0_22 vdout0_22ck139 = 1.8 time = 1400
* CHECK dout0_23 vdout0_23ck139 = 0 time = 1400
* CHECK dout0_24 vdout0_24ck139 = 0 time = 1400
* CHECK dout0_25 vdout0_25ck139 = 1.8 time = 1400
* CHECK dout0_26 vdout0_26ck139 = 0 time = 1400
* CHECK dout0_27 vdout0_27ck139 = 1.8 time = 1400
* CHECK dout0_28 vdout0_28ck139 = 0 time = 1400
* CHECK dout0_29 vdout0_29ck139 = 0 time = 1400
* CHECK dout0_30 vdout0_30ck139 = 1.8 time = 1400
* CHECK dout0_31 vdout0_31ck139 = 1.8 time = 1400
* CHECK dout0_32 vdout0_32ck139 = 1.8 time = 1400
* CHECK dout0_33 vdout0_33ck139 = 1.8 time = 1400
* CHECK dout0_34 vdout0_34ck139 = 0 time = 1400
* CHECK dout0_35 vdout0_35ck139 = 1.8 time = 1400
* CHECK dout0_36 vdout0_36ck139 = 1.8 time = 1400
* CHECK dout0_37 vdout0_37ck139 = 0 time = 1400
* CHECK dout0_38 vdout0_38ck139 = 0 time = 1400
* CHECK dout0_39 vdout0_39ck139 = 1.8 time = 1400
* CHECK dout0_40 vdout0_40ck139 = 0 time = 1400
* CHECK dout0_41 vdout0_41ck139 = 0 time = 1400
* CHECK dout0_42 vdout0_42ck139 = 0 time = 1400
* CHECK dout0_43 vdout0_43ck139 = 0 time = 1400
* CHECK dout0_44 vdout0_44ck139 = 0 time = 1400
* CHECK dout0_45 vdout0_45ck139 = 0 time = 1400
* CHECK dout0_46 vdout0_46ck139 = 1.8 time = 1400
* CHECK dout0_47 vdout0_47ck139 = 1.8 time = 1400
* CHECK dout0_48 vdout0_48ck139 = 1.8 time = 1400
* CHECK dout0_49 vdout0_49ck139 = 1.8 time = 1400
* CHECK dout0_50 vdout0_50ck139 = 0 time = 1400
* CHECK dout0_51 vdout0_51ck139 = 1.8 time = 1400
* CHECK dout0_52 vdout0_52ck139 = 0 time = 1400
* CHECK dout0_53 vdout0_53ck139 = 1.8 time = 1400
* CHECK dout0_54 vdout0_54ck139 = 1.8 time = 1400
* CHECK dout0_55 vdout0_55ck139 = 1.8 time = 1400
* CHECK dout0_56 vdout0_56ck139 = 1.8 time = 1400
* CHECK dout0_57 vdout0_57ck139 = 1.8 time = 1400
* CHECK dout0_58 vdout0_58ck139 = 1.8 time = 1400
* CHECK dout0_59 vdout0_59ck139 = 0 time = 1400
* CHECK dout0_60 vdout0_60ck139 = 1.8 time = 1400
* CHECK dout0_61 vdout0_61ck139 = 0 time = 1400
* CHECK dout0_62 vdout0_62ck139 = 0 time = 1400
* CHECK dout0_63 vdout0_63ck139 = 0 time = 1400
* CHECK dout0_0 vdout0_0ck141 = 1.8 time = 1420
* CHECK dout0_1 vdout0_1ck141 = 0 time = 1420
* CHECK dout0_2 vdout0_2ck141 = 1.8 time = 1420
* CHECK dout0_3 vdout0_3ck141 = 1.8 time = 1420
* CHECK dout0_4 vdout0_4ck141 = 0 time = 1420
* CHECK dout0_5 vdout0_5ck141 = 1.8 time = 1420
* CHECK dout0_6 vdout0_6ck141 = 0 time = 1420
* CHECK dout0_7 vdout0_7ck141 = 1.8 time = 1420
* CHECK dout0_8 vdout0_8ck141 = 0 time = 1420
* CHECK dout0_9 vdout0_9ck141 = 1.8 time = 1420
* CHECK dout0_10 vdout0_10ck141 = 0 time = 1420
* CHECK dout0_11 vdout0_11ck141 = 1.8 time = 1420
* CHECK dout0_12 vdout0_12ck141 = 1.8 time = 1420
* CHECK dout0_13 vdout0_13ck141 = 0 time = 1420
* CHECK dout0_14 vdout0_14ck141 = 1.8 time = 1420
* CHECK dout0_15 vdout0_15ck141 = 1.8 time = 1420
* CHECK dout0_16 vdout0_16ck141 = 0 time = 1420
* CHECK dout0_17 vdout0_17ck141 = 0 time = 1420
* CHECK dout0_18 vdout0_18ck141 = 1.8 time = 1420
* CHECK dout0_19 vdout0_19ck141 = 1.8 time = 1420
* CHECK dout0_20 vdout0_20ck141 = 0 time = 1420
* CHECK dout0_21 vdout0_21ck141 = 1.8 time = 1420
* CHECK dout0_22 vdout0_22ck141 = 0 time = 1420
* CHECK dout0_23 vdout0_23ck141 = 0 time = 1420
* CHECK dout0_24 vdout0_24ck141 = 1.8 time = 1420
* CHECK dout0_25 vdout0_25ck141 = 0 time = 1420
* CHECK dout0_26 vdout0_26ck141 = 1.8 time = 1420
* CHECK dout0_27 vdout0_27ck141 = 0 time = 1420
* CHECK dout0_28 vdout0_28ck141 = 1.8 time = 1420
* CHECK dout0_29 vdout0_29ck141 = 1.8 time = 1420
* CHECK dout0_30 vdout0_30ck141 = 1.8 time = 1420
* CHECK dout0_31 vdout0_31ck141 = 1.8 time = 1420
* CHECK dout0_32 vdout0_32ck141 = 0 time = 1420
* CHECK dout0_33 vdout0_33ck141 = 0 time = 1420
* CHECK dout0_34 vdout0_34ck141 = 0 time = 1420
* CHECK dout0_35 vdout0_35ck141 = 1.8 time = 1420
* CHECK dout0_36 vdout0_36ck141 = 1.8 time = 1420
* CHECK dout0_37 vdout0_37ck141 = 0 time = 1420
* CHECK dout0_38 vdout0_38ck141 = 0 time = 1420
* CHECK dout0_39 vdout0_39ck141 = 1.8 time = 1420
* CHECK dout0_40 vdout0_40ck141 = 1.8 time = 1420
* CHECK dout0_41 vdout0_41ck141 = 1.8 time = 1420
* CHECK dout0_42 vdout0_42ck141 = 0 time = 1420
* CHECK dout0_43 vdout0_43ck141 = 0 time = 1420
* CHECK dout0_44 vdout0_44ck141 = 1.8 time = 1420
* CHECK dout0_45 vdout0_45ck141 = 1.8 time = 1420
* CHECK dout0_46 vdout0_46ck141 = 0 time = 1420
* CHECK dout0_47 vdout0_47ck141 = 0 time = 1420
* CHECK dout0_48 vdout0_48ck141 = 0 time = 1420
* CHECK dout0_49 vdout0_49ck141 = 1.8 time = 1420
* CHECK dout0_50 vdout0_50ck141 = 1.8 time = 1420
* CHECK dout0_51 vdout0_51ck141 = 1.8 time = 1420
* CHECK dout0_52 vdout0_52ck141 = 0 time = 1420
* CHECK dout0_53 vdout0_53ck141 = 0 time = 1420
* CHECK dout0_54 vdout0_54ck141 = 0 time = 1420
* CHECK dout0_55 vdout0_55ck141 = 0 time = 1420
* CHECK dout0_56 vdout0_56ck141 = 1.8 time = 1420
* CHECK dout0_57 vdout0_57ck141 = 0 time = 1420
* CHECK dout0_58 vdout0_58ck141 = 1.8 time = 1420
* CHECK dout0_59 vdout0_59ck141 = 0 time = 1420
* CHECK dout0_60 vdout0_60ck141 = 0 time = 1420
* CHECK dout0_61 vdout0_61ck141 = 1.8 time = 1420
* CHECK dout0_62 vdout0_62ck141 = 1.8 time = 1420
* CHECK dout0_63 vdout0_63ck141 = 1.8 time = 1420
* CHECK dout1_0 vdout1_0ck141 = 1.8 time = 1420
* CHECK dout1_1 vdout1_1ck141 = 0 time = 1420
* CHECK dout1_2 vdout1_2ck141 = 1.8 time = 1420
* CHECK dout1_3 vdout1_3ck141 = 1.8 time = 1420
* CHECK dout1_4 vdout1_4ck141 = 0 time = 1420
* CHECK dout1_5 vdout1_5ck141 = 1.8 time = 1420
* CHECK dout1_6 vdout1_6ck141 = 0 time = 1420
* CHECK dout1_7 vdout1_7ck141 = 1.8 time = 1420
* CHECK dout1_8 vdout1_8ck141 = 0 time = 1420
* CHECK dout1_9 vdout1_9ck141 = 1.8 time = 1420
* CHECK dout1_10 vdout1_10ck141 = 0 time = 1420
* CHECK dout1_11 vdout1_11ck141 = 1.8 time = 1420
* CHECK dout1_12 vdout1_12ck141 = 1.8 time = 1420
* CHECK dout1_13 vdout1_13ck141 = 0 time = 1420
* CHECK dout1_14 vdout1_14ck141 = 1.8 time = 1420
* CHECK dout1_15 vdout1_15ck141 = 1.8 time = 1420
* CHECK dout1_16 vdout1_16ck141 = 0 time = 1420
* CHECK dout1_17 vdout1_17ck141 = 0 time = 1420
* CHECK dout1_18 vdout1_18ck141 = 1.8 time = 1420
* CHECK dout1_19 vdout1_19ck141 = 1.8 time = 1420
* CHECK dout1_20 vdout1_20ck141 = 0 time = 1420
* CHECK dout1_21 vdout1_21ck141 = 1.8 time = 1420
* CHECK dout1_22 vdout1_22ck141 = 0 time = 1420
* CHECK dout1_23 vdout1_23ck141 = 0 time = 1420
* CHECK dout1_24 vdout1_24ck141 = 1.8 time = 1420
* CHECK dout1_25 vdout1_25ck141 = 0 time = 1420
* CHECK dout1_26 vdout1_26ck141 = 1.8 time = 1420
* CHECK dout1_27 vdout1_27ck141 = 0 time = 1420
* CHECK dout1_28 vdout1_28ck141 = 1.8 time = 1420
* CHECK dout1_29 vdout1_29ck141 = 1.8 time = 1420
* CHECK dout1_30 vdout1_30ck141 = 1.8 time = 1420
* CHECK dout1_31 vdout1_31ck141 = 1.8 time = 1420
* CHECK dout1_32 vdout1_32ck141 = 0 time = 1420
* CHECK dout1_33 vdout1_33ck141 = 0 time = 1420
* CHECK dout1_34 vdout1_34ck141 = 0 time = 1420
* CHECK dout1_35 vdout1_35ck141 = 1.8 time = 1420
* CHECK dout1_36 vdout1_36ck141 = 1.8 time = 1420
* CHECK dout1_37 vdout1_37ck141 = 0 time = 1420
* CHECK dout1_38 vdout1_38ck141 = 0 time = 1420
* CHECK dout1_39 vdout1_39ck141 = 1.8 time = 1420
* CHECK dout1_40 vdout1_40ck141 = 1.8 time = 1420
* CHECK dout1_41 vdout1_41ck141 = 1.8 time = 1420
* CHECK dout1_42 vdout1_42ck141 = 0 time = 1420
* CHECK dout1_43 vdout1_43ck141 = 0 time = 1420
* CHECK dout1_44 vdout1_44ck141 = 1.8 time = 1420
* CHECK dout1_45 vdout1_45ck141 = 1.8 time = 1420
* CHECK dout1_46 vdout1_46ck141 = 0 time = 1420
* CHECK dout1_47 vdout1_47ck141 = 0 time = 1420
* CHECK dout1_48 vdout1_48ck141 = 0 time = 1420
* CHECK dout1_49 vdout1_49ck141 = 1.8 time = 1420
* CHECK dout1_50 vdout1_50ck141 = 1.8 time = 1420
* CHECK dout1_51 vdout1_51ck141 = 1.8 time = 1420
* CHECK dout1_52 vdout1_52ck141 = 0 time = 1420
* CHECK dout1_53 vdout1_53ck141 = 0 time = 1420
* CHECK dout1_54 vdout1_54ck141 = 0 time = 1420
* CHECK dout1_55 vdout1_55ck141 = 0 time = 1420
* CHECK dout1_56 vdout1_56ck141 = 1.8 time = 1420
* CHECK dout1_57 vdout1_57ck141 = 0 time = 1420
* CHECK dout1_58 vdout1_58ck141 = 1.8 time = 1420
* CHECK dout1_59 vdout1_59ck141 = 0 time = 1420
* CHECK dout1_60 vdout1_60ck141 = 0 time = 1420
* CHECK dout1_61 vdout1_61ck141 = 1.8 time = 1420
* CHECK dout1_62 vdout1_62ck141 = 1.8 time = 1420
* CHECK dout1_63 vdout1_63ck141 = 1.8 time = 1420
* CHECK dout0_0 vdout0_0ck142 = 1.8 time = 1430
* CHECK dout0_1 vdout0_1ck142 = 0 time = 1430
* CHECK dout0_2 vdout0_2ck142 = 1.8 time = 1430
* CHECK dout0_3 vdout0_3ck142 = 1.8 time = 1430
* CHECK dout0_4 vdout0_4ck142 = 0 time = 1430
* CHECK dout0_5 vdout0_5ck142 = 1.8 time = 1430
* CHECK dout0_6 vdout0_6ck142 = 0 time = 1430
* CHECK dout0_7 vdout0_7ck142 = 1.8 time = 1430
* CHECK dout0_8 vdout0_8ck142 = 0 time = 1430
* CHECK dout0_9 vdout0_9ck142 = 1.8 time = 1430
* CHECK dout0_10 vdout0_10ck142 = 0 time = 1430
* CHECK dout0_11 vdout0_11ck142 = 1.8 time = 1430
* CHECK dout0_12 vdout0_12ck142 = 1.8 time = 1430
* CHECK dout0_13 vdout0_13ck142 = 0 time = 1430
* CHECK dout0_14 vdout0_14ck142 = 1.8 time = 1430
* CHECK dout0_15 vdout0_15ck142 = 1.8 time = 1430
* CHECK dout0_16 vdout0_16ck142 = 0 time = 1430
* CHECK dout0_17 vdout0_17ck142 = 0 time = 1430
* CHECK dout0_18 vdout0_18ck142 = 1.8 time = 1430
* CHECK dout0_19 vdout0_19ck142 = 1.8 time = 1430
* CHECK dout0_20 vdout0_20ck142 = 0 time = 1430
* CHECK dout0_21 vdout0_21ck142 = 1.8 time = 1430
* CHECK dout0_22 vdout0_22ck142 = 0 time = 1430
* CHECK dout0_23 vdout0_23ck142 = 0 time = 1430
* CHECK dout0_24 vdout0_24ck142 = 1.8 time = 1430
* CHECK dout0_25 vdout0_25ck142 = 0 time = 1430
* CHECK dout0_26 vdout0_26ck142 = 1.8 time = 1430
* CHECK dout0_27 vdout0_27ck142 = 0 time = 1430
* CHECK dout0_28 vdout0_28ck142 = 1.8 time = 1430
* CHECK dout0_29 vdout0_29ck142 = 1.8 time = 1430
* CHECK dout0_30 vdout0_30ck142 = 1.8 time = 1430
* CHECK dout0_31 vdout0_31ck142 = 1.8 time = 1430
* CHECK dout0_32 vdout0_32ck142 = 0 time = 1430
* CHECK dout0_33 vdout0_33ck142 = 0 time = 1430
* CHECK dout0_34 vdout0_34ck142 = 0 time = 1430
* CHECK dout0_35 vdout0_35ck142 = 1.8 time = 1430
* CHECK dout0_36 vdout0_36ck142 = 1.8 time = 1430
* CHECK dout0_37 vdout0_37ck142 = 0 time = 1430
* CHECK dout0_38 vdout0_38ck142 = 0 time = 1430
* CHECK dout0_39 vdout0_39ck142 = 1.8 time = 1430
* CHECK dout0_40 vdout0_40ck142 = 1.8 time = 1430
* CHECK dout0_41 vdout0_41ck142 = 1.8 time = 1430
* CHECK dout0_42 vdout0_42ck142 = 0 time = 1430
* CHECK dout0_43 vdout0_43ck142 = 0 time = 1430
* CHECK dout0_44 vdout0_44ck142 = 1.8 time = 1430
* CHECK dout0_45 vdout0_45ck142 = 1.8 time = 1430
* CHECK dout0_46 vdout0_46ck142 = 0 time = 1430
* CHECK dout0_47 vdout0_47ck142 = 0 time = 1430
* CHECK dout0_48 vdout0_48ck142 = 0 time = 1430
* CHECK dout0_49 vdout0_49ck142 = 1.8 time = 1430
* CHECK dout0_50 vdout0_50ck142 = 1.8 time = 1430
* CHECK dout0_51 vdout0_51ck142 = 1.8 time = 1430
* CHECK dout0_52 vdout0_52ck142 = 0 time = 1430
* CHECK dout0_53 vdout0_53ck142 = 0 time = 1430
* CHECK dout0_54 vdout0_54ck142 = 0 time = 1430
* CHECK dout0_55 vdout0_55ck142 = 0 time = 1430
* CHECK dout0_56 vdout0_56ck142 = 1.8 time = 1430
* CHECK dout0_57 vdout0_57ck142 = 0 time = 1430
* CHECK dout0_58 vdout0_58ck142 = 1.8 time = 1430
* CHECK dout0_59 vdout0_59ck142 = 0 time = 1430
* CHECK dout0_60 vdout0_60ck142 = 0 time = 1430
* CHECK dout0_61 vdout0_61ck142 = 1.8 time = 1430
* CHECK dout0_62 vdout0_62ck142 = 1.8 time = 1430
* CHECK dout0_63 vdout0_63ck142 = 1.8 time = 1430
* CHECK dout1_0 vdout1_0ck142 = 0 time = 1430
* CHECK dout1_1 vdout1_1ck142 = 1.8 time = 1430
* CHECK dout1_2 vdout1_2ck142 = 0 time = 1430
* CHECK dout1_3 vdout1_3ck142 = 0 time = 1430
* CHECK dout1_4 vdout1_4ck142 = 1.8 time = 1430
* CHECK dout1_5 vdout1_5ck142 = 0 time = 1430
* CHECK dout1_6 vdout1_6ck142 = 0 time = 1430
* CHECK dout1_7 vdout1_7ck142 = 0 time = 1430
* CHECK dout1_8 vdout1_8ck142 = 1.8 time = 1430
* CHECK dout1_9 vdout1_9ck142 = 0 time = 1430
* CHECK dout1_10 vdout1_10ck142 = 0 time = 1430
* CHECK dout1_11 vdout1_11ck142 = 1.8 time = 1430
* CHECK dout1_12 vdout1_12ck142 = 1.8 time = 1430
* CHECK dout1_13 vdout1_13ck142 = 1.8 time = 1430
* CHECK dout1_14 vdout1_14ck142 = 1.8 time = 1430
* CHECK dout1_15 vdout1_15ck142 = 1.8 time = 1430
* CHECK dout1_16 vdout1_16ck142 = 1.8 time = 1430
* CHECK dout1_17 vdout1_17ck142 = 0 time = 1430
* CHECK dout1_18 vdout1_18ck142 = 0 time = 1430
* CHECK dout1_19 vdout1_19ck142 = 0 time = 1430
* CHECK dout1_20 vdout1_20ck142 = 1.8 time = 1430
* CHECK dout1_21 vdout1_21ck142 = 0 time = 1430
* CHECK dout1_22 vdout1_22ck142 = 1.8 time = 1430
* CHECK dout1_23 vdout1_23ck142 = 0 time = 1430
* CHECK dout1_24 vdout1_24ck142 = 0 time = 1430
* CHECK dout1_25 vdout1_25ck142 = 1.8 time = 1430
* CHECK dout1_26 vdout1_26ck142 = 1.8 time = 1430
* CHECK dout1_27 vdout1_27ck142 = 0 time = 1430
* CHECK dout1_28 vdout1_28ck142 = 0 time = 1430
* CHECK dout1_29 vdout1_29ck142 = 0 time = 1430
* CHECK dout1_30 vdout1_30ck142 = 1.8 time = 1430
* CHECK dout1_31 vdout1_31ck142 = 0 time = 1430
* CHECK dout1_32 vdout1_32ck142 = 0 time = 1430
* CHECK dout1_33 vdout1_33ck142 = 0 time = 1430
* CHECK dout1_34 vdout1_34ck142 = 1.8 time = 1430
* CHECK dout1_35 vdout1_35ck142 = 0 time = 1430
* CHECK dout1_36 vdout1_36ck142 = 0 time = 1430
* CHECK dout1_37 vdout1_37ck142 = 0 time = 1430
* CHECK dout1_38 vdout1_38ck142 = 0 time = 1430
* CHECK dout1_39 vdout1_39ck142 = 1.8 time = 1430
* CHECK dout1_40 vdout1_40ck142 = 1.8 time = 1430
* CHECK dout1_41 vdout1_41ck142 = 0 time = 1430
* CHECK dout1_42 vdout1_42ck142 = 0 time = 1430
* CHECK dout1_43 vdout1_43ck142 = 0 time = 1430
* CHECK dout1_44 vdout1_44ck142 = 0 time = 1430
* CHECK dout1_45 vdout1_45ck142 = 0 time = 1430
* CHECK dout1_46 vdout1_46ck142 = 1.8 time = 1430
* CHECK dout1_47 vdout1_47ck142 = 1.8 time = 1430
* CHECK dout1_48 vdout1_48ck142 = 1.8 time = 1430
* CHECK dout1_49 vdout1_49ck142 = 1.8 time = 1430
* CHECK dout1_50 vdout1_50ck142 = 0 time = 1430
* CHECK dout1_51 vdout1_51ck142 = 1.8 time = 1430
* CHECK dout1_52 vdout1_52ck142 = 1.8 time = 1430
* CHECK dout1_53 vdout1_53ck142 = 1.8 time = 1430
* CHECK dout1_54 vdout1_54ck142 = 1.8 time = 1430
* CHECK dout1_55 vdout1_55ck142 = 1.8 time = 1430
* CHECK dout1_56 vdout1_56ck142 = 1.8 time = 1430
* CHECK dout1_57 vdout1_57ck142 = 1.8 time = 1430
* CHECK dout1_58 vdout1_58ck142 = 0 time = 1430
* CHECK dout1_59 vdout1_59ck142 = 1.8 time = 1430
* CHECK dout1_60 vdout1_60ck142 = 1.8 time = 1430
* CHECK dout1_61 vdout1_61ck142 = 1.8 time = 1430
* CHECK dout1_62 vdout1_62ck142 = 0 time = 1430
* CHECK dout1_63 vdout1_63ck142 = 0 time = 1430
* CHECK dout0_0 vdout0_0ck144 = 1.8 time = 1450
* CHECK dout0_1 vdout0_1ck144 = 1.8 time = 1450
* CHECK dout0_2 vdout0_2ck144 = 0 time = 1450
* CHECK dout0_3 vdout0_3ck144 = 0 time = 1450
* CHECK dout0_4 vdout0_4ck144 = 0 time = 1450
* CHECK dout0_5 vdout0_5ck144 = 1.8 time = 1450
* CHECK dout0_6 vdout0_6ck144 = 0 time = 1450
* CHECK dout0_7 vdout0_7ck144 = 1.8 time = 1450
* CHECK dout0_8 vdout0_8ck144 = 0 time = 1450
* CHECK dout0_9 vdout0_9ck144 = 0 time = 1450
* CHECK dout0_10 vdout0_10ck144 = 0 time = 1450
* CHECK dout0_11 vdout0_11ck144 = 0 time = 1450
* CHECK dout0_12 vdout0_12ck144 = 0 time = 1450
* CHECK dout0_13 vdout0_13ck144 = 1.8 time = 1450
* CHECK dout0_14 vdout0_14ck144 = 0 time = 1450
* CHECK dout0_15 vdout0_15ck144 = 1.8 time = 1450
* CHECK dout0_16 vdout0_16ck144 = 0 time = 1450
* CHECK dout0_17 vdout0_17ck144 = 0 time = 1450
* CHECK dout0_18 vdout0_18ck144 = 0 time = 1450
* CHECK dout0_19 vdout0_19ck144 = 1.8 time = 1450
* CHECK dout0_20 vdout0_20ck144 = 1.8 time = 1450
* CHECK dout0_21 vdout0_21ck144 = 1.8 time = 1450
* CHECK dout0_22 vdout0_22ck144 = 1.8 time = 1450
* CHECK dout0_23 vdout0_23ck144 = 0 time = 1450
* CHECK dout0_24 vdout0_24ck144 = 1.8 time = 1450
* CHECK dout0_25 vdout0_25ck144 = 0 time = 1450
* CHECK dout0_26 vdout0_26ck144 = 0 time = 1450
* CHECK dout0_27 vdout0_27ck144 = 0 time = 1450
* CHECK dout0_28 vdout0_28ck144 = 0 time = 1450
* CHECK dout0_29 vdout0_29ck144 = 0 time = 1450
* CHECK dout0_30 vdout0_30ck144 = 0 time = 1450
* CHECK dout0_31 vdout0_31ck144 = 1.8 time = 1450
* CHECK dout0_32 vdout0_32ck144 = 1.8 time = 1450
* CHECK dout0_33 vdout0_33ck144 = 0 time = 1450
* CHECK dout0_34 vdout0_34ck144 = 1.8 time = 1450
* CHECK dout0_35 vdout0_35ck144 = 0 time = 1450
* CHECK dout0_36 vdout0_36ck144 = 1.8 time = 1450
* CHECK dout0_37 vdout0_37ck144 = 1.8 time = 1450
* CHECK dout0_38 vdout0_38ck144 = 0 time = 1450
* CHECK dout0_39 vdout0_39ck144 = 0 time = 1450
* CHECK dout0_40 vdout0_40ck144 = 0 time = 1450
* CHECK dout0_41 vdout0_41ck144 = 0 time = 1450
* CHECK dout0_42 vdout0_42ck144 = 1.8 time = 1450
* CHECK dout0_43 vdout0_43ck144 = 1.8 time = 1450
* CHECK dout0_44 vdout0_44ck144 = 1.8 time = 1450
* CHECK dout0_45 vdout0_45ck144 = 1.8 time = 1450
* CHECK dout0_46 vdout0_46ck144 = 0 time = 1450
* CHECK dout0_47 vdout0_47ck144 = 0 time = 1450
* CHECK dout0_48 vdout0_48ck144 = 1.8 time = 1450
* CHECK dout0_49 vdout0_49ck144 = 0 time = 1450
* CHECK dout0_50 vdout0_50ck144 = 0 time = 1450
* CHECK dout0_51 vdout0_51ck144 = 1.8 time = 1450
* CHECK dout0_52 vdout0_52ck144 = 1.8 time = 1450
* CHECK dout0_53 vdout0_53ck144 = 1.8 time = 1450
* CHECK dout0_54 vdout0_54ck144 = 1.8 time = 1450
* CHECK dout0_55 vdout0_55ck144 = 0 time = 1450
* CHECK dout0_56 vdout0_56ck144 = 1.8 time = 1450
* CHECK dout0_57 vdout0_57ck144 = 1.8 time = 1450
* CHECK dout0_58 vdout0_58ck144 = 0 time = 1450
* CHECK dout0_59 vdout0_59ck144 = 1.8 time = 1450
* CHECK dout0_60 vdout0_60ck144 = 1.8 time = 1450
* CHECK dout0_61 vdout0_61ck144 = 1.8 time = 1450
* CHECK dout0_62 vdout0_62ck144 = 0 time = 1450
* CHECK dout0_63 vdout0_63ck144 = 1.8 time = 1450
* CHECK dout0_0 vdout0_0ck145 = 0 time = 1460
* CHECK dout0_1 vdout0_1ck145 = 1.8 time = 1460
* CHECK dout0_2 vdout0_2ck145 = 0 time = 1460
* CHECK dout0_3 vdout0_3ck145 = 0 time = 1460
* CHECK dout0_4 vdout0_4ck145 = 1.8 time = 1460
* CHECK dout0_5 vdout0_5ck145 = 0 time = 1460
* CHECK dout0_6 vdout0_6ck145 = 0 time = 1460
* CHECK dout0_7 vdout0_7ck145 = 0 time = 1460
* CHECK dout0_8 vdout0_8ck145 = 1.8 time = 1460
* CHECK dout0_9 vdout0_9ck145 = 0 time = 1460
* CHECK dout0_10 vdout0_10ck145 = 0 time = 1460
* CHECK dout0_11 vdout0_11ck145 = 1.8 time = 1460
* CHECK dout0_12 vdout0_12ck145 = 1.8 time = 1460
* CHECK dout0_13 vdout0_13ck145 = 1.8 time = 1460
* CHECK dout0_14 vdout0_14ck145 = 1.8 time = 1460
* CHECK dout0_15 vdout0_15ck145 = 1.8 time = 1460
* CHECK dout0_16 vdout0_16ck145 = 1.8 time = 1460
* CHECK dout0_17 vdout0_17ck145 = 0 time = 1460
* CHECK dout0_18 vdout0_18ck145 = 0 time = 1460
* CHECK dout0_19 vdout0_19ck145 = 0 time = 1460
* CHECK dout0_20 vdout0_20ck145 = 1.8 time = 1460
* CHECK dout0_21 vdout0_21ck145 = 0 time = 1460
* CHECK dout0_22 vdout0_22ck145 = 1.8 time = 1460
* CHECK dout0_23 vdout0_23ck145 = 0 time = 1460
* CHECK dout0_24 vdout0_24ck145 = 0 time = 1460
* CHECK dout0_25 vdout0_25ck145 = 1.8 time = 1460
* CHECK dout0_26 vdout0_26ck145 = 1.8 time = 1460
* CHECK dout0_27 vdout0_27ck145 = 0 time = 1460
* CHECK dout0_28 vdout0_28ck145 = 0 time = 1460
* CHECK dout0_29 vdout0_29ck145 = 0 time = 1460
* CHECK dout0_30 vdout0_30ck145 = 1.8 time = 1460
* CHECK dout0_31 vdout0_31ck145 = 0 time = 1460
* CHECK dout0_32 vdout0_32ck145 = 0 time = 1460
* CHECK dout0_33 vdout0_33ck145 = 0 time = 1460
* CHECK dout0_34 vdout0_34ck145 = 1.8 time = 1460
* CHECK dout0_35 vdout0_35ck145 = 0 time = 1460
* CHECK dout0_36 vdout0_36ck145 = 0 time = 1460
* CHECK dout0_37 vdout0_37ck145 = 0 time = 1460
* CHECK dout0_38 vdout0_38ck145 = 0 time = 1460
* CHECK dout0_39 vdout0_39ck145 = 1.8 time = 1460
* CHECK dout0_40 vdout0_40ck145 = 1.8 time = 1460
* CHECK dout0_41 vdout0_41ck145 = 0 time = 1460
* CHECK dout0_42 vdout0_42ck145 = 0 time = 1460
* CHECK dout0_43 vdout0_43ck145 = 0 time = 1460
* CHECK dout0_44 vdout0_44ck145 = 0 time = 1460
* CHECK dout0_45 vdout0_45ck145 = 0 time = 1460
* CHECK dout0_46 vdout0_46ck145 = 1.8 time = 1460
* CHECK dout0_47 vdout0_47ck145 = 1.8 time = 1460
* CHECK dout0_48 vdout0_48ck145 = 1.8 time = 1460
* CHECK dout0_49 vdout0_49ck145 = 1.8 time = 1460
* CHECK dout0_50 vdout0_50ck145 = 0 time = 1460
* CHECK dout0_51 vdout0_51ck145 = 1.8 time = 1460
* CHECK dout0_52 vdout0_52ck145 = 1.8 time = 1460
* CHECK dout0_53 vdout0_53ck145 = 1.8 time = 1460
* CHECK dout0_54 vdout0_54ck145 = 1.8 time = 1460
* CHECK dout0_55 vdout0_55ck145 = 1.8 time = 1460
* CHECK dout0_56 vdout0_56ck145 = 1.8 time = 1460
* CHECK dout0_57 vdout0_57ck145 = 1.8 time = 1460
* CHECK dout0_58 vdout0_58ck145 = 0 time = 1460
* CHECK dout0_59 vdout0_59ck145 = 1.8 time = 1460
* CHECK dout0_60 vdout0_60ck145 = 1.8 time = 1460
* CHECK dout0_61 vdout0_61ck145 = 1.8 time = 1460
* CHECK dout0_62 vdout0_62ck145 = 0 time = 1460
* CHECK dout0_63 vdout0_63ck145 = 0 time = 1460
* CHECK dout0_0 vdout0_0ck146 = 1.8 time = 1470
* CHECK dout0_1 vdout0_1ck146 = 0 time = 1470
* CHECK dout0_2 vdout0_2ck146 = 1.8 time = 1470
* CHECK dout0_3 vdout0_3ck146 = 1.8 time = 1470
* CHECK dout0_4 vdout0_4ck146 = 0 time = 1470
* CHECK dout0_5 vdout0_5ck146 = 1.8 time = 1470
* CHECK dout0_6 vdout0_6ck146 = 0 time = 1470
* CHECK dout0_7 vdout0_7ck146 = 1.8 time = 1470
* CHECK dout0_8 vdout0_8ck146 = 0 time = 1470
* CHECK dout0_9 vdout0_9ck146 = 1.8 time = 1470
* CHECK dout0_10 vdout0_10ck146 = 0 time = 1470
* CHECK dout0_11 vdout0_11ck146 = 1.8 time = 1470
* CHECK dout0_12 vdout0_12ck146 = 1.8 time = 1470
* CHECK dout0_13 vdout0_13ck146 = 0 time = 1470
* CHECK dout0_14 vdout0_14ck146 = 1.8 time = 1470
* CHECK dout0_15 vdout0_15ck146 = 1.8 time = 1470
* CHECK dout0_16 vdout0_16ck146 = 0 time = 1470
* CHECK dout0_17 vdout0_17ck146 = 0 time = 1470
* CHECK dout0_18 vdout0_18ck146 = 1.8 time = 1470
* CHECK dout0_19 vdout0_19ck146 = 1.8 time = 1470
* CHECK dout0_20 vdout0_20ck146 = 0 time = 1470
* CHECK dout0_21 vdout0_21ck146 = 1.8 time = 1470
* CHECK dout0_22 vdout0_22ck146 = 0 time = 1470
* CHECK dout0_23 vdout0_23ck146 = 0 time = 1470
* CHECK dout0_24 vdout0_24ck146 = 1.8 time = 1470
* CHECK dout0_25 vdout0_25ck146 = 0 time = 1470
* CHECK dout0_26 vdout0_26ck146 = 1.8 time = 1470
* CHECK dout0_27 vdout0_27ck146 = 0 time = 1470
* CHECK dout0_28 vdout0_28ck146 = 1.8 time = 1470
* CHECK dout0_29 vdout0_29ck146 = 1.8 time = 1470
* CHECK dout0_30 vdout0_30ck146 = 1.8 time = 1470
* CHECK dout0_31 vdout0_31ck146 = 1.8 time = 1470
* CHECK dout0_32 vdout0_32ck146 = 0 time = 1470
* CHECK dout0_33 vdout0_33ck146 = 0 time = 1470
* CHECK dout0_34 vdout0_34ck146 = 0 time = 1470
* CHECK dout0_35 vdout0_35ck146 = 1.8 time = 1470
* CHECK dout0_36 vdout0_36ck146 = 1.8 time = 1470
* CHECK dout0_37 vdout0_37ck146 = 0 time = 1470
* CHECK dout0_38 vdout0_38ck146 = 0 time = 1470
* CHECK dout0_39 vdout0_39ck146 = 1.8 time = 1470
* CHECK dout0_40 vdout0_40ck146 = 1.8 time = 1470
* CHECK dout0_41 vdout0_41ck146 = 1.8 time = 1470
* CHECK dout0_42 vdout0_42ck146 = 0 time = 1470
* CHECK dout0_43 vdout0_43ck146 = 0 time = 1470
* CHECK dout0_44 vdout0_44ck146 = 1.8 time = 1470
* CHECK dout0_45 vdout0_45ck146 = 1.8 time = 1470
* CHECK dout0_46 vdout0_46ck146 = 0 time = 1470
* CHECK dout0_47 vdout0_47ck146 = 0 time = 1470
* CHECK dout0_48 vdout0_48ck146 = 0 time = 1470
* CHECK dout0_49 vdout0_49ck146 = 1.8 time = 1470
* CHECK dout0_50 vdout0_50ck146 = 1.8 time = 1470
* CHECK dout0_51 vdout0_51ck146 = 1.8 time = 1470
* CHECK dout0_52 vdout0_52ck146 = 0 time = 1470
* CHECK dout0_53 vdout0_53ck146 = 0 time = 1470
* CHECK dout0_54 vdout0_54ck146 = 0 time = 1470
* CHECK dout0_55 vdout0_55ck146 = 0 time = 1470
* CHECK dout0_56 vdout0_56ck146 = 1.8 time = 1470
* CHECK dout0_57 vdout0_57ck146 = 0 time = 1470
* CHECK dout0_58 vdout0_58ck146 = 1.8 time = 1470
* CHECK dout0_59 vdout0_59ck146 = 0 time = 1470
* CHECK dout0_60 vdout0_60ck146 = 0 time = 1470
* CHECK dout0_61 vdout0_61ck146 = 1.8 time = 1470
* CHECK dout0_62 vdout0_62ck146 = 1.8 time = 1470
* CHECK dout0_63 vdout0_63ck146 = 1.8 time = 1470
* CHECK dout1_0 vdout1_0ck146 = 0 time = 1470
* CHECK dout1_1 vdout1_1ck146 = 1.8 time = 1470
* CHECK dout1_2 vdout1_2ck146 = 0 time = 1470
* CHECK dout1_3 vdout1_3ck146 = 0 time = 1470
* CHECK dout1_4 vdout1_4ck146 = 1.8 time = 1470
* CHECK dout1_5 vdout1_5ck146 = 0 time = 1470
* CHECK dout1_6 vdout1_6ck146 = 0 time = 1470
* CHECK dout1_7 vdout1_7ck146 = 0 time = 1470
* CHECK dout1_8 vdout1_8ck146 = 1.8 time = 1470
* CHECK dout1_9 vdout1_9ck146 = 0 time = 1470
* CHECK dout1_10 vdout1_10ck146 = 0 time = 1470
* CHECK dout1_11 vdout1_11ck146 = 1.8 time = 1470
* CHECK dout1_12 vdout1_12ck146 = 1.8 time = 1470
* CHECK dout1_13 vdout1_13ck146 = 1.8 time = 1470
* CHECK dout1_14 vdout1_14ck146 = 1.8 time = 1470
* CHECK dout1_15 vdout1_15ck146 = 1.8 time = 1470
* CHECK dout1_16 vdout1_16ck146 = 1.8 time = 1470
* CHECK dout1_17 vdout1_17ck146 = 0 time = 1470
* CHECK dout1_18 vdout1_18ck146 = 0 time = 1470
* CHECK dout1_19 vdout1_19ck146 = 0 time = 1470
* CHECK dout1_20 vdout1_20ck146 = 1.8 time = 1470
* CHECK dout1_21 vdout1_21ck146 = 0 time = 1470
* CHECK dout1_22 vdout1_22ck146 = 1.8 time = 1470
* CHECK dout1_23 vdout1_23ck146 = 0 time = 1470
* CHECK dout1_24 vdout1_24ck146 = 0 time = 1470
* CHECK dout1_25 vdout1_25ck146 = 1.8 time = 1470
* CHECK dout1_26 vdout1_26ck146 = 1.8 time = 1470
* CHECK dout1_27 vdout1_27ck146 = 0 time = 1470
* CHECK dout1_28 vdout1_28ck146 = 0 time = 1470
* CHECK dout1_29 vdout1_29ck146 = 0 time = 1470
* CHECK dout1_30 vdout1_30ck146 = 1.8 time = 1470
* CHECK dout1_31 vdout1_31ck146 = 0 time = 1470
* CHECK dout1_32 vdout1_32ck146 = 0 time = 1470
* CHECK dout1_33 vdout1_33ck146 = 0 time = 1470
* CHECK dout1_34 vdout1_34ck146 = 1.8 time = 1470
* CHECK dout1_35 vdout1_35ck146 = 0 time = 1470
* CHECK dout1_36 vdout1_36ck146 = 0 time = 1470
* CHECK dout1_37 vdout1_37ck146 = 0 time = 1470
* CHECK dout1_38 vdout1_38ck146 = 0 time = 1470
* CHECK dout1_39 vdout1_39ck146 = 1.8 time = 1470
* CHECK dout1_40 vdout1_40ck146 = 1.8 time = 1470
* CHECK dout1_41 vdout1_41ck146 = 0 time = 1470
* CHECK dout1_42 vdout1_42ck146 = 0 time = 1470
* CHECK dout1_43 vdout1_43ck146 = 0 time = 1470
* CHECK dout1_44 vdout1_44ck146 = 0 time = 1470
* CHECK dout1_45 vdout1_45ck146 = 0 time = 1470
* CHECK dout1_46 vdout1_46ck146 = 1.8 time = 1470
* CHECK dout1_47 vdout1_47ck146 = 1.8 time = 1470
* CHECK dout1_48 vdout1_48ck146 = 1.8 time = 1470
* CHECK dout1_49 vdout1_49ck146 = 1.8 time = 1470
* CHECK dout1_50 vdout1_50ck146 = 0 time = 1470
* CHECK dout1_51 vdout1_51ck146 = 1.8 time = 1470
* CHECK dout1_52 vdout1_52ck146 = 1.8 time = 1470
* CHECK dout1_53 vdout1_53ck146 = 1.8 time = 1470
* CHECK dout1_54 vdout1_54ck146 = 1.8 time = 1470
* CHECK dout1_55 vdout1_55ck146 = 1.8 time = 1470
* CHECK dout1_56 vdout1_56ck146 = 1.8 time = 1470
* CHECK dout1_57 vdout1_57ck146 = 1.8 time = 1470
* CHECK dout1_58 vdout1_58ck146 = 0 time = 1470
* CHECK dout1_59 vdout1_59ck146 = 1.8 time = 1470
* CHECK dout1_60 vdout1_60ck146 = 1.8 time = 1470
* CHECK dout1_61 vdout1_61ck146 = 1.8 time = 1470
* CHECK dout1_62 vdout1_62ck146 = 0 time = 1470
* CHECK dout1_63 vdout1_63ck146 = 0 time = 1470
* CHECK dout0_0 vdout0_0ck147 = 0 time = 1480
* CHECK dout0_1 vdout0_1ck147 = 1.8 time = 1480
* CHECK dout0_2 vdout0_2ck147 = 0 time = 1480
* CHECK dout0_3 vdout0_3ck147 = 0 time = 1480
* CHECK dout0_4 vdout0_4ck147 = 1.8 time = 1480
* CHECK dout0_5 vdout0_5ck147 = 0 time = 1480
* CHECK dout0_6 vdout0_6ck147 = 0 time = 1480
* CHECK dout0_7 vdout0_7ck147 = 0 time = 1480
* CHECK dout0_8 vdout0_8ck147 = 1.8 time = 1480
* CHECK dout0_9 vdout0_9ck147 = 0 time = 1480
* CHECK dout0_10 vdout0_10ck147 = 0 time = 1480
* CHECK dout0_11 vdout0_11ck147 = 1.8 time = 1480
* CHECK dout0_12 vdout0_12ck147 = 1.8 time = 1480
* CHECK dout0_13 vdout0_13ck147 = 1.8 time = 1480
* CHECK dout0_14 vdout0_14ck147 = 1.8 time = 1480
* CHECK dout0_15 vdout0_15ck147 = 1.8 time = 1480
* CHECK dout0_16 vdout0_16ck147 = 1.8 time = 1480
* CHECK dout0_17 vdout0_17ck147 = 0 time = 1480
* CHECK dout0_18 vdout0_18ck147 = 0 time = 1480
* CHECK dout0_19 vdout0_19ck147 = 0 time = 1480
* CHECK dout0_20 vdout0_20ck147 = 1.8 time = 1480
* CHECK dout0_21 vdout0_21ck147 = 0 time = 1480
* CHECK dout0_22 vdout0_22ck147 = 1.8 time = 1480
* CHECK dout0_23 vdout0_23ck147 = 0 time = 1480
* CHECK dout0_24 vdout0_24ck147 = 0 time = 1480
* CHECK dout0_25 vdout0_25ck147 = 1.8 time = 1480
* CHECK dout0_26 vdout0_26ck147 = 1.8 time = 1480
* CHECK dout0_27 vdout0_27ck147 = 0 time = 1480
* CHECK dout0_28 vdout0_28ck147 = 0 time = 1480
* CHECK dout0_29 vdout0_29ck147 = 0 time = 1480
* CHECK dout0_30 vdout0_30ck147 = 1.8 time = 1480
* CHECK dout0_31 vdout0_31ck147 = 0 time = 1480
* CHECK dout0_32 vdout0_32ck147 = 0 time = 1480
* CHECK dout0_33 vdout0_33ck147 = 0 time = 1480
* CHECK dout0_34 vdout0_34ck147 = 1.8 time = 1480
* CHECK dout0_35 vdout0_35ck147 = 0 time = 1480
* CHECK dout0_36 vdout0_36ck147 = 0 time = 1480
* CHECK dout0_37 vdout0_37ck147 = 0 time = 1480
* CHECK dout0_38 vdout0_38ck147 = 0 time = 1480
* CHECK dout0_39 vdout0_39ck147 = 1.8 time = 1480
* CHECK dout0_40 vdout0_40ck147 = 1.8 time = 1480
* CHECK dout0_41 vdout0_41ck147 = 0 time = 1480
* CHECK dout0_42 vdout0_42ck147 = 0 time = 1480
* CHECK dout0_43 vdout0_43ck147 = 0 time = 1480
* CHECK dout0_44 vdout0_44ck147 = 0 time = 1480
* CHECK dout0_45 vdout0_45ck147 = 0 time = 1480
* CHECK dout0_46 vdout0_46ck147 = 1.8 time = 1480
* CHECK dout0_47 vdout0_47ck147 = 1.8 time = 1480
* CHECK dout0_48 vdout0_48ck147 = 1.8 time = 1480
* CHECK dout0_49 vdout0_49ck147 = 1.8 time = 1480
* CHECK dout0_50 vdout0_50ck147 = 0 time = 1480
* CHECK dout0_51 vdout0_51ck147 = 1.8 time = 1480
* CHECK dout0_52 vdout0_52ck147 = 1.8 time = 1480
* CHECK dout0_53 vdout0_53ck147 = 1.8 time = 1480
* CHECK dout0_54 vdout0_54ck147 = 1.8 time = 1480
* CHECK dout0_55 vdout0_55ck147 = 1.8 time = 1480
* CHECK dout0_56 vdout0_56ck147 = 1.8 time = 1480
* CHECK dout0_57 vdout0_57ck147 = 1.8 time = 1480
* CHECK dout0_58 vdout0_58ck147 = 0 time = 1480
* CHECK dout0_59 vdout0_59ck147 = 1.8 time = 1480
* CHECK dout0_60 vdout0_60ck147 = 1.8 time = 1480
* CHECK dout0_61 vdout0_61ck147 = 1.8 time = 1480
* CHECK dout0_62 vdout0_62ck147 = 0 time = 1480
* CHECK dout0_63 vdout0_63ck147 = 0 time = 1480
* CHECK dout1_0 vdout1_0ck147 = 1.8 time = 1480
* CHECK dout1_1 vdout1_1ck147 = 0 time = 1480
* CHECK dout1_2 vdout1_2ck147 = 1.8 time = 1480
* CHECK dout1_3 vdout1_3ck147 = 1.8 time = 1480
* CHECK dout1_4 vdout1_4ck147 = 0 time = 1480
* CHECK dout1_5 vdout1_5ck147 = 1.8 time = 1480
* CHECK dout1_6 vdout1_6ck147 = 0 time = 1480
* CHECK dout1_7 vdout1_7ck147 = 1.8 time = 1480
* CHECK dout1_8 vdout1_8ck147 = 0 time = 1480
* CHECK dout1_9 vdout1_9ck147 = 1.8 time = 1480
* CHECK dout1_10 vdout1_10ck147 = 0 time = 1480
* CHECK dout1_11 vdout1_11ck147 = 1.8 time = 1480
* CHECK dout1_12 vdout1_12ck147 = 1.8 time = 1480
* CHECK dout1_13 vdout1_13ck147 = 0 time = 1480
* CHECK dout1_14 vdout1_14ck147 = 1.8 time = 1480
* CHECK dout1_15 vdout1_15ck147 = 1.8 time = 1480
* CHECK dout1_16 vdout1_16ck147 = 0 time = 1480
* CHECK dout1_17 vdout1_17ck147 = 0 time = 1480
* CHECK dout1_18 vdout1_18ck147 = 1.8 time = 1480
* CHECK dout1_19 vdout1_19ck147 = 1.8 time = 1480
* CHECK dout1_20 vdout1_20ck147 = 0 time = 1480
* CHECK dout1_21 vdout1_21ck147 = 1.8 time = 1480
* CHECK dout1_22 vdout1_22ck147 = 0 time = 1480
* CHECK dout1_23 vdout1_23ck147 = 0 time = 1480
* CHECK dout1_24 vdout1_24ck147 = 1.8 time = 1480
* CHECK dout1_25 vdout1_25ck147 = 0 time = 1480
* CHECK dout1_26 vdout1_26ck147 = 1.8 time = 1480
* CHECK dout1_27 vdout1_27ck147 = 0 time = 1480
* CHECK dout1_28 vdout1_28ck147 = 1.8 time = 1480
* CHECK dout1_29 vdout1_29ck147 = 1.8 time = 1480
* CHECK dout1_30 vdout1_30ck147 = 1.8 time = 1480
* CHECK dout1_31 vdout1_31ck147 = 1.8 time = 1480
* CHECK dout1_32 vdout1_32ck147 = 0 time = 1480
* CHECK dout1_33 vdout1_33ck147 = 0 time = 1480
* CHECK dout1_34 vdout1_34ck147 = 0 time = 1480
* CHECK dout1_35 vdout1_35ck147 = 1.8 time = 1480
* CHECK dout1_36 vdout1_36ck147 = 1.8 time = 1480
* CHECK dout1_37 vdout1_37ck147 = 0 time = 1480
* CHECK dout1_38 vdout1_38ck147 = 0 time = 1480
* CHECK dout1_39 vdout1_39ck147 = 1.8 time = 1480
* CHECK dout1_40 vdout1_40ck147 = 1.8 time = 1480
* CHECK dout1_41 vdout1_41ck147 = 1.8 time = 1480
* CHECK dout1_42 vdout1_42ck147 = 0 time = 1480
* CHECK dout1_43 vdout1_43ck147 = 0 time = 1480
* CHECK dout1_44 vdout1_44ck147 = 1.8 time = 1480
* CHECK dout1_45 vdout1_45ck147 = 1.8 time = 1480
* CHECK dout1_46 vdout1_46ck147 = 0 time = 1480
* CHECK dout1_47 vdout1_47ck147 = 0 time = 1480
* CHECK dout1_48 vdout1_48ck147 = 0 time = 1480
* CHECK dout1_49 vdout1_49ck147 = 1.8 time = 1480
* CHECK dout1_50 vdout1_50ck147 = 1.8 time = 1480
* CHECK dout1_51 vdout1_51ck147 = 1.8 time = 1480
* CHECK dout1_52 vdout1_52ck147 = 0 time = 1480
* CHECK dout1_53 vdout1_53ck147 = 0 time = 1480
* CHECK dout1_54 vdout1_54ck147 = 0 time = 1480
* CHECK dout1_55 vdout1_55ck147 = 0 time = 1480
* CHECK dout1_56 vdout1_56ck147 = 1.8 time = 1480
* CHECK dout1_57 vdout1_57ck147 = 0 time = 1480
* CHECK dout1_58 vdout1_58ck147 = 1.8 time = 1480
* CHECK dout1_59 vdout1_59ck147 = 0 time = 1480
* CHECK dout1_60 vdout1_60ck147 = 0 time = 1480
* CHECK dout1_61 vdout1_61ck147 = 1.8 time = 1480
* CHECK dout1_62 vdout1_62ck147 = 1.8 time = 1480
* CHECK dout1_63 vdout1_63ck147 = 1.8 time = 1480
* CHECK dout1_0 vdout1_0ck148 = 0 time = 1490
* CHECK dout1_1 vdout1_1ck148 = 1.8 time = 1490
* CHECK dout1_2 vdout1_2ck148 = 0 time = 1490
* CHECK dout1_3 vdout1_3ck148 = 0 time = 1490
* CHECK dout1_4 vdout1_4ck148 = 1.8 time = 1490
* CHECK dout1_5 vdout1_5ck148 = 0 time = 1490
* CHECK dout1_6 vdout1_6ck148 = 0 time = 1490
* CHECK dout1_7 vdout1_7ck148 = 0 time = 1490
* CHECK dout1_8 vdout1_8ck148 = 1.8 time = 1490
* CHECK dout1_9 vdout1_9ck148 = 0 time = 1490
* CHECK dout1_10 vdout1_10ck148 = 0 time = 1490
* CHECK dout1_11 vdout1_11ck148 = 1.8 time = 1490
* CHECK dout1_12 vdout1_12ck148 = 1.8 time = 1490
* CHECK dout1_13 vdout1_13ck148 = 1.8 time = 1490
* CHECK dout1_14 vdout1_14ck148 = 1.8 time = 1490
* CHECK dout1_15 vdout1_15ck148 = 1.8 time = 1490
* CHECK dout1_16 vdout1_16ck148 = 1.8 time = 1490
* CHECK dout1_17 vdout1_17ck148 = 0 time = 1490
* CHECK dout1_18 vdout1_18ck148 = 0 time = 1490
* CHECK dout1_19 vdout1_19ck148 = 0 time = 1490
* CHECK dout1_20 vdout1_20ck148 = 1.8 time = 1490
* CHECK dout1_21 vdout1_21ck148 = 0 time = 1490
* CHECK dout1_22 vdout1_22ck148 = 1.8 time = 1490
* CHECK dout1_23 vdout1_23ck148 = 0 time = 1490
* CHECK dout1_24 vdout1_24ck148 = 0 time = 1490
* CHECK dout1_25 vdout1_25ck148 = 1.8 time = 1490
* CHECK dout1_26 vdout1_26ck148 = 1.8 time = 1490
* CHECK dout1_27 vdout1_27ck148 = 0 time = 1490
* CHECK dout1_28 vdout1_28ck148 = 0 time = 1490
* CHECK dout1_29 vdout1_29ck148 = 0 time = 1490
* CHECK dout1_30 vdout1_30ck148 = 1.8 time = 1490
* CHECK dout1_31 vdout1_31ck148 = 0 time = 1490
* CHECK dout1_32 vdout1_32ck148 = 0 time = 1490
* CHECK dout1_33 vdout1_33ck148 = 0 time = 1490
* CHECK dout1_34 vdout1_34ck148 = 1.8 time = 1490
* CHECK dout1_35 vdout1_35ck148 = 0 time = 1490
* CHECK dout1_36 vdout1_36ck148 = 0 time = 1490
* CHECK dout1_37 vdout1_37ck148 = 0 time = 1490
* CHECK dout1_38 vdout1_38ck148 = 0 time = 1490
* CHECK dout1_39 vdout1_39ck148 = 1.8 time = 1490
* CHECK dout1_40 vdout1_40ck148 = 1.8 time = 1490
* CHECK dout1_41 vdout1_41ck148 = 0 time = 1490
* CHECK dout1_42 vdout1_42ck148 = 0 time = 1490
* CHECK dout1_43 vdout1_43ck148 = 0 time = 1490
* CHECK dout1_44 vdout1_44ck148 = 0 time = 1490
* CHECK dout1_45 vdout1_45ck148 = 0 time = 1490
* CHECK dout1_46 vdout1_46ck148 = 1.8 time = 1490
* CHECK dout1_47 vdout1_47ck148 = 1.8 time = 1490
* CHECK dout1_48 vdout1_48ck148 = 1.8 time = 1490
* CHECK dout1_49 vdout1_49ck148 = 1.8 time = 1490
* CHECK dout1_50 vdout1_50ck148 = 0 time = 1490
* CHECK dout1_51 vdout1_51ck148 = 1.8 time = 1490
* CHECK dout1_52 vdout1_52ck148 = 1.8 time = 1490
* CHECK dout1_53 vdout1_53ck148 = 1.8 time = 1490
* CHECK dout1_54 vdout1_54ck148 = 1.8 time = 1490
* CHECK dout1_55 vdout1_55ck148 = 1.8 time = 1490
* CHECK dout1_56 vdout1_56ck148 = 1.8 time = 1490
* CHECK dout1_57 vdout1_57ck148 = 1.8 time = 1490
* CHECK dout1_58 vdout1_58ck148 = 0 time = 1490
* CHECK dout1_59 vdout1_59ck148 = 1.8 time = 1490
* CHECK dout1_60 vdout1_60ck148 = 1.8 time = 1490
* CHECK dout1_61 vdout1_61ck148 = 1.8 time = 1490
* CHECK dout1_62 vdout1_62ck148 = 0 time = 1490
* CHECK dout1_63 vdout1_63ck148 = 0 time = 1490
* CHECK dout0_0 vdout0_0ck151 = 0 time = 1520
* CHECK dout0_1 vdout0_1ck151 = 1.8 time = 1520
* CHECK dout0_2 vdout0_2ck151 = 0 time = 1520
* CHECK dout0_3 vdout0_3ck151 = 0 time = 1520
* CHECK dout0_4 vdout0_4ck151 = 0 time = 1520
* CHECK dout0_5 vdout0_5ck151 = 1.8 time = 1520
* CHECK dout0_6 vdout0_6ck151 = 1.8 time = 1520
* CHECK dout0_7 vdout0_7ck151 = 0 time = 1520
* CHECK dout0_8 vdout0_8ck151 = 1.8 time = 1520
* CHECK dout0_9 vdout0_9ck151 = 0 time = 1520
* CHECK dout0_10 vdout0_10ck151 = 1.8 time = 1520
* CHECK dout0_11 vdout0_11ck151 = 0 time = 1520
* CHECK dout0_12 vdout0_12ck151 = 1.8 time = 1520
* CHECK dout0_13 vdout0_13ck151 = 1.8 time = 1520
* CHECK dout0_14 vdout0_14ck151 = 1.8 time = 1520
* CHECK dout0_15 vdout0_15ck151 = 0 time = 1520
* CHECK dout0_16 vdout0_16ck151 = 1.8 time = 1520
* CHECK dout0_17 vdout0_17ck151 = 1.8 time = 1520
* CHECK dout0_18 vdout0_18ck151 = 0 time = 1520
* CHECK dout0_19 vdout0_19ck151 = 0 time = 1520
* CHECK dout0_20 vdout0_20ck151 = 0 time = 1520
* CHECK dout0_21 vdout0_21ck151 = 1.8 time = 1520
* CHECK dout0_22 vdout0_22ck151 = 0 time = 1520
* CHECK dout0_23 vdout0_23ck151 = 1.8 time = 1520
* CHECK dout0_24 vdout0_24ck151 = 0 time = 1520
* CHECK dout0_25 vdout0_25ck151 = 1.8 time = 1520
* CHECK dout0_26 vdout0_26ck151 = 0 time = 1520
* CHECK dout0_27 vdout0_27ck151 = 1.8 time = 1520
* CHECK dout0_28 vdout0_28ck151 = 0 time = 1520
* CHECK dout0_29 vdout0_29ck151 = 1.8 time = 1520
* CHECK dout0_30 vdout0_30ck151 = 0 time = 1520
* CHECK dout0_31 vdout0_31ck151 = 0 time = 1520
* CHECK dout0_32 vdout0_32ck151 = 1.8 time = 1520
* CHECK dout0_33 vdout0_33ck151 = 0 time = 1520
* CHECK dout0_34 vdout0_34ck151 = 1.8 time = 1520
* CHECK dout0_35 vdout0_35ck151 = 0 time = 1520
* CHECK dout0_36 vdout0_36ck151 = 1.8 time = 1520
* CHECK dout0_37 vdout0_37ck151 = 0 time = 1520
* CHECK dout0_38 vdout0_38ck151 = 0 time = 1520
* CHECK dout0_39 vdout0_39ck151 = 1.8 time = 1520
* CHECK dout0_40 vdout0_40ck151 = 1.8 time = 1520
* CHECK dout0_41 vdout0_41ck151 = 0 time = 1520
* CHECK dout0_42 vdout0_42ck151 = 1.8 time = 1520
* CHECK dout0_43 vdout0_43ck151 = 1.8 time = 1520
* CHECK dout0_44 vdout0_44ck151 = 1.8 time = 1520
* CHECK dout0_45 vdout0_45ck151 = 1.8 time = 1520
* CHECK dout0_46 vdout0_46ck151 = 0 time = 1520
* CHECK dout0_47 vdout0_47ck151 = 0 time = 1520
* CHECK dout0_48 vdout0_48ck151 = 1.8 time = 1520
* CHECK dout0_49 vdout0_49ck151 = 1.8 time = 1520
* CHECK dout0_50 vdout0_50ck151 = 1.8 time = 1520
* CHECK dout0_51 vdout0_51ck151 = 1.8 time = 1520
* CHECK dout0_52 vdout0_52ck151 = 0 time = 1520
* CHECK dout0_53 vdout0_53ck151 = 0 time = 1520
* CHECK dout0_54 vdout0_54ck151 = 0 time = 1520
* CHECK dout0_55 vdout0_55ck151 = 0 time = 1520
* CHECK dout0_56 vdout0_56ck151 = 1.8 time = 1520
* CHECK dout0_57 vdout0_57ck151 = 1.8 time = 1520
* CHECK dout0_58 vdout0_58ck151 = 0 time = 1520
* CHECK dout0_59 vdout0_59ck151 = 0 time = 1520
* CHECK dout0_60 vdout0_60ck151 = 0 time = 1520
* CHECK dout0_61 vdout0_61ck151 = 1.8 time = 1520
* CHECK dout0_62 vdout0_62ck151 = 0 time = 1520
* CHECK dout0_63 vdout0_63ck151 = 0 time = 1520
* CHECK dout1_0 vdout1_0ck151 = 0 time = 1520
* CHECK dout1_1 vdout1_1ck151 = 1.8 time = 1520
* CHECK dout1_2 vdout1_2ck151 = 0 time = 1520
* CHECK dout1_3 vdout1_3ck151 = 0 time = 1520
* CHECK dout1_4 vdout1_4ck151 = 1.8 time = 1520
* CHECK dout1_5 vdout1_5ck151 = 0 time = 1520
* CHECK dout1_6 vdout1_6ck151 = 0 time = 1520
* CHECK dout1_7 vdout1_7ck151 = 0 time = 1520
* CHECK dout1_8 vdout1_8ck151 = 1.8 time = 1520
* CHECK dout1_9 vdout1_9ck151 = 0 time = 1520
* CHECK dout1_10 vdout1_10ck151 = 0 time = 1520
* CHECK dout1_11 vdout1_11ck151 = 1.8 time = 1520
* CHECK dout1_12 vdout1_12ck151 = 1.8 time = 1520
* CHECK dout1_13 vdout1_13ck151 = 1.8 time = 1520
* CHECK dout1_14 vdout1_14ck151 = 1.8 time = 1520
* CHECK dout1_15 vdout1_15ck151 = 1.8 time = 1520
* CHECK dout1_16 vdout1_16ck151 = 1.8 time = 1520
* CHECK dout1_17 vdout1_17ck151 = 0 time = 1520
* CHECK dout1_18 vdout1_18ck151 = 0 time = 1520
* CHECK dout1_19 vdout1_19ck151 = 0 time = 1520
* CHECK dout1_20 vdout1_20ck151 = 1.8 time = 1520
* CHECK dout1_21 vdout1_21ck151 = 0 time = 1520
* CHECK dout1_22 vdout1_22ck151 = 1.8 time = 1520
* CHECK dout1_23 vdout1_23ck151 = 0 time = 1520
* CHECK dout1_24 vdout1_24ck151 = 0 time = 1520
* CHECK dout1_25 vdout1_25ck151 = 1.8 time = 1520
* CHECK dout1_26 vdout1_26ck151 = 1.8 time = 1520
* CHECK dout1_27 vdout1_27ck151 = 0 time = 1520
* CHECK dout1_28 vdout1_28ck151 = 0 time = 1520
* CHECK dout1_29 vdout1_29ck151 = 0 time = 1520
* CHECK dout1_30 vdout1_30ck151 = 1.8 time = 1520
* CHECK dout1_31 vdout1_31ck151 = 0 time = 1520
* CHECK dout1_32 vdout1_32ck151 = 0 time = 1520
* CHECK dout1_33 vdout1_33ck151 = 0 time = 1520
* CHECK dout1_34 vdout1_34ck151 = 1.8 time = 1520
* CHECK dout1_35 vdout1_35ck151 = 0 time = 1520
* CHECK dout1_36 vdout1_36ck151 = 0 time = 1520
* CHECK dout1_37 vdout1_37ck151 = 0 time = 1520
* CHECK dout1_38 vdout1_38ck151 = 0 time = 1520
* CHECK dout1_39 vdout1_39ck151 = 1.8 time = 1520
* CHECK dout1_40 vdout1_40ck151 = 1.8 time = 1520
* CHECK dout1_41 vdout1_41ck151 = 0 time = 1520
* CHECK dout1_42 vdout1_42ck151 = 0 time = 1520
* CHECK dout1_43 vdout1_43ck151 = 0 time = 1520
* CHECK dout1_44 vdout1_44ck151 = 0 time = 1520
* CHECK dout1_45 vdout1_45ck151 = 0 time = 1520
* CHECK dout1_46 vdout1_46ck151 = 1.8 time = 1520
* CHECK dout1_47 vdout1_47ck151 = 1.8 time = 1520
* CHECK dout1_48 vdout1_48ck151 = 1.8 time = 1520
* CHECK dout1_49 vdout1_49ck151 = 1.8 time = 1520
* CHECK dout1_50 vdout1_50ck151 = 0 time = 1520
* CHECK dout1_51 vdout1_51ck151 = 1.8 time = 1520
* CHECK dout1_52 vdout1_52ck151 = 1.8 time = 1520
* CHECK dout1_53 vdout1_53ck151 = 1.8 time = 1520
* CHECK dout1_54 vdout1_54ck151 = 1.8 time = 1520
* CHECK dout1_55 vdout1_55ck151 = 1.8 time = 1520
* CHECK dout1_56 vdout1_56ck151 = 1.8 time = 1520
* CHECK dout1_57 vdout1_57ck151 = 1.8 time = 1520
* CHECK dout1_58 vdout1_58ck151 = 0 time = 1520
* CHECK dout1_59 vdout1_59ck151 = 1.8 time = 1520
* CHECK dout1_60 vdout1_60ck151 = 1.8 time = 1520
* CHECK dout1_61 vdout1_61ck151 = 1.8 time = 1520
* CHECK dout1_62 vdout1_62ck151 = 0 time = 1520
* CHECK dout1_63 vdout1_63ck151 = 0 time = 1520
* CHECK dout0_0 vdout0_0ck153 = 1.8 time = 1540
* CHECK dout0_1 vdout0_1ck153 = 1.8 time = 1540
* CHECK dout0_2 vdout0_2ck153 = 0 time = 1540
* CHECK dout0_3 vdout0_3ck153 = 0 time = 1540
* CHECK dout0_4 vdout0_4ck153 = 0 time = 1540
* CHECK dout0_5 vdout0_5ck153 = 1.8 time = 1540
* CHECK dout0_6 vdout0_6ck153 = 0 time = 1540
* CHECK dout0_7 vdout0_7ck153 = 1.8 time = 1540
* CHECK dout0_8 vdout0_8ck153 = 0 time = 1540
* CHECK dout0_9 vdout0_9ck153 = 0 time = 1540
* CHECK dout0_10 vdout0_10ck153 = 0 time = 1540
* CHECK dout0_11 vdout0_11ck153 = 0 time = 1540
* CHECK dout0_12 vdout0_12ck153 = 0 time = 1540
* CHECK dout0_13 vdout0_13ck153 = 1.8 time = 1540
* CHECK dout0_14 vdout0_14ck153 = 0 time = 1540
* CHECK dout0_15 vdout0_15ck153 = 1.8 time = 1540
* CHECK dout0_16 vdout0_16ck153 = 0 time = 1540
* CHECK dout0_17 vdout0_17ck153 = 0 time = 1540
* CHECK dout0_18 vdout0_18ck153 = 0 time = 1540
* CHECK dout0_19 vdout0_19ck153 = 1.8 time = 1540
* CHECK dout0_20 vdout0_20ck153 = 1.8 time = 1540
* CHECK dout0_21 vdout0_21ck153 = 1.8 time = 1540
* CHECK dout0_22 vdout0_22ck153 = 1.8 time = 1540
* CHECK dout0_23 vdout0_23ck153 = 0 time = 1540
* CHECK dout0_24 vdout0_24ck153 = 1.8 time = 1540
* CHECK dout0_25 vdout0_25ck153 = 0 time = 1540
* CHECK dout0_26 vdout0_26ck153 = 0 time = 1540
* CHECK dout0_27 vdout0_27ck153 = 0 time = 1540
* CHECK dout0_28 vdout0_28ck153 = 0 time = 1540
* CHECK dout0_29 vdout0_29ck153 = 0 time = 1540
* CHECK dout0_30 vdout0_30ck153 = 0 time = 1540
* CHECK dout0_31 vdout0_31ck153 = 1.8 time = 1540
* CHECK dout0_32 vdout0_32ck153 = 1.8 time = 1540
* CHECK dout0_33 vdout0_33ck153 = 0 time = 1540
* CHECK dout0_34 vdout0_34ck153 = 1.8 time = 1540
* CHECK dout0_35 vdout0_35ck153 = 0 time = 1540
* CHECK dout0_36 vdout0_36ck153 = 1.8 time = 1540
* CHECK dout0_37 vdout0_37ck153 = 1.8 time = 1540
* CHECK dout0_38 vdout0_38ck153 = 0 time = 1540
* CHECK dout0_39 vdout0_39ck153 = 0 time = 1540
* CHECK dout0_40 vdout0_40ck153 = 0 time = 1540
* CHECK dout0_41 vdout0_41ck153 = 0 time = 1540
* CHECK dout0_42 vdout0_42ck153 = 1.8 time = 1540
* CHECK dout0_43 vdout0_43ck153 = 1.8 time = 1540
* CHECK dout0_44 vdout0_44ck153 = 1.8 time = 1540
* CHECK dout0_45 vdout0_45ck153 = 1.8 time = 1540
* CHECK dout0_46 vdout0_46ck153 = 0 time = 1540
* CHECK dout0_47 vdout0_47ck153 = 0 time = 1540
* CHECK dout0_48 vdout0_48ck153 = 1.8 time = 1540
* CHECK dout0_49 vdout0_49ck153 = 0 time = 1540
* CHECK dout0_50 vdout0_50ck153 = 0 time = 1540
* CHECK dout0_51 vdout0_51ck153 = 1.8 time = 1540
* CHECK dout0_52 vdout0_52ck153 = 1.8 time = 1540
* CHECK dout0_53 vdout0_53ck153 = 1.8 time = 1540
* CHECK dout0_54 vdout0_54ck153 = 1.8 time = 1540
* CHECK dout0_55 vdout0_55ck153 = 0 time = 1540
* CHECK dout0_56 vdout0_56ck153 = 1.8 time = 1540
* CHECK dout0_57 vdout0_57ck153 = 1.8 time = 1540
* CHECK dout0_58 vdout0_58ck153 = 0 time = 1540
* CHECK dout0_59 vdout0_59ck153 = 1.8 time = 1540
* CHECK dout0_60 vdout0_60ck153 = 1.8 time = 1540
* CHECK dout0_61 vdout0_61ck153 = 1.8 time = 1540
* CHECK dout0_62 vdout0_62ck153 = 0 time = 1540
* CHECK dout0_63 vdout0_63ck153 = 1.8 time = 1540
* CHECK dout1_0 vdout1_0ck154 = 0 time = 1550
* CHECK dout1_1 vdout1_1ck154 = 1.8 time = 1550
* CHECK dout1_2 vdout1_2ck154 = 0 time = 1550
* CHECK dout1_3 vdout1_3ck154 = 0 time = 1550
* CHECK dout1_4 vdout1_4ck154 = 0 time = 1550
* CHECK dout1_5 vdout1_5ck154 = 1.8 time = 1550
* CHECK dout1_6 vdout1_6ck154 = 1.8 time = 1550
* CHECK dout1_7 vdout1_7ck154 = 0 time = 1550
* CHECK dout1_8 vdout1_8ck154 = 1.8 time = 1550
* CHECK dout1_9 vdout1_9ck154 = 0 time = 1550
* CHECK dout1_10 vdout1_10ck154 = 1.8 time = 1550
* CHECK dout1_11 vdout1_11ck154 = 0 time = 1550
* CHECK dout1_12 vdout1_12ck154 = 1.8 time = 1550
* CHECK dout1_13 vdout1_13ck154 = 1.8 time = 1550
* CHECK dout1_14 vdout1_14ck154 = 1.8 time = 1550
* CHECK dout1_15 vdout1_15ck154 = 0 time = 1550
* CHECK dout1_16 vdout1_16ck154 = 1.8 time = 1550
* CHECK dout1_17 vdout1_17ck154 = 1.8 time = 1550
* CHECK dout1_18 vdout1_18ck154 = 0 time = 1550
* CHECK dout1_19 vdout1_19ck154 = 0 time = 1550
* CHECK dout1_20 vdout1_20ck154 = 0 time = 1550
* CHECK dout1_21 vdout1_21ck154 = 1.8 time = 1550
* CHECK dout1_22 vdout1_22ck154 = 0 time = 1550
* CHECK dout1_23 vdout1_23ck154 = 1.8 time = 1550
* CHECK dout1_24 vdout1_24ck154 = 0 time = 1550
* CHECK dout1_25 vdout1_25ck154 = 1.8 time = 1550
* CHECK dout1_26 vdout1_26ck154 = 0 time = 1550
* CHECK dout1_27 vdout1_27ck154 = 1.8 time = 1550
* CHECK dout1_28 vdout1_28ck154 = 0 time = 1550
* CHECK dout1_29 vdout1_29ck154 = 1.8 time = 1550
* CHECK dout1_30 vdout1_30ck154 = 0 time = 1550
* CHECK dout1_31 vdout1_31ck154 = 0 time = 1550
* CHECK dout1_32 vdout1_32ck154 = 1.8 time = 1550
* CHECK dout1_33 vdout1_33ck154 = 0 time = 1550
* CHECK dout1_34 vdout1_34ck154 = 1.8 time = 1550
* CHECK dout1_35 vdout1_35ck154 = 0 time = 1550
* CHECK dout1_36 vdout1_36ck154 = 1.8 time = 1550
* CHECK dout1_37 vdout1_37ck154 = 0 time = 1550
* CHECK dout1_38 vdout1_38ck154 = 0 time = 1550
* CHECK dout1_39 vdout1_39ck154 = 1.8 time = 1550
* CHECK dout1_40 vdout1_40ck154 = 1.8 time = 1550
* CHECK dout1_41 vdout1_41ck154 = 0 time = 1550
* CHECK dout1_42 vdout1_42ck154 = 1.8 time = 1550
* CHECK dout1_43 vdout1_43ck154 = 1.8 time = 1550
* CHECK dout1_44 vdout1_44ck154 = 1.8 time = 1550
* CHECK dout1_45 vdout1_45ck154 = 1.8 time = 1550
* CHECK dout1_46 vdout1_46ck154 = 0 time = 1550
* CHECK dout1_47 vdout1_47ck154 = 0 time = 1550
* CHECK dout1_48 vdout1_48ck154 = 1.8 time = 1550
* CHECK dout1_49 vdout1_49ck154 = 1.8 time = 1550
* CHECK dout1_50 vdout1_50ck154 = 1.8 time = 1550
* CHECK dout1_51 vdout1_51ck154 = 1.8 time = 1550
* CHECK dout1_52 vdout1_52ck154 = 0 time = 1550
* CHECK dout1_53 vdout1_53ck154 = 0 time = 1550
* CHECK dout1_54 vdout1_54ck154 = 0 time = 1550
* CHECK dout1_55 vdout1_55ck154 = 0 time = 1550
* CHECK dout1_56 vdout1_56ck154 = 1.8 time = 1550
* CHECK dout1_57 vdout1_57ck154 = 1.8 time = 1550
* CHECK dout1_58 vdout1_58ck154 = 0 time = 1550
* CHECK dout1_59 vdout1_59ck154 = 0 time = 1550
* CHECK dout1_60 vdout1_60ck154 = 0 time = 1550
* CHECK dout1_61 vdout1_61ck154 = 1.8 time = 1550
* CHECK dout1_62 vdout1_62ck154 = 0 time = 1550
* CHECK dout1_63 vdout1_63ck154 = 0 time = 1550
* CHECK dout0_0 vdout0_0ck155 = 0 time = 1560
* CHECK dout0_1 vdout0_1ck155 = 1.8 time = 1560
* CHECK dout0_2 vdout0_2ck155 = 0 time = 1560
* CHECK dout0_3 vdout0_3ck155 = 0 time = 1560
* CHECK dout0_4 vdout0_4ck155 = 0 time = 1560
* CHECK dout0_5 vdout0_5ck155 = 1.8 time = 1560
* CHECK dout0_6 vdout0_6ck155 = 1.8 time = 1560
* CHECK dout0_7 vdout0_7ck155 = 0 time = 1560
* CHECK dout0_8 vdout0_8ck155 = 1.8 time = 1560
* CHECK dout0_9 vdout0_9ck155 = 0 time = 1560
* CHECK dout0_10 vdout0_10ck155 = 1.8 time = 1560
* CHECK dout0_11 vdout0_11ck155 = 0 time = 1560
* CHECK dout0_12 vdout0_12ck155 = 1.8 time = 1560
* CHECK dout0_13 vdout0_13ck155 = 1.8 time = 1560
* CHECK dout0_14 vdout0_14ck155 = 1.8 time = 1560
* CHECK dout0_15 vdout0_15ck155 = 0 time = 1560
* CHECK dout0_16 vdout0_16ck155 = 1.8 time = 1560
* CHECK dout0_17 vdout0_17ck155 = 1.8 time = 1560
* CHECK dout0_18 vdout0_18ck155 = 0 time = 1560
* CHECK dout0_19 vdout0_19ck155 = 0 time = 1560
* CHECK dout0_20 vdout0_20ck155 = 0 time = 1560
* CHECK dout0_21 vdout0_21ck155 = 1.8 time = 1560
* CHECK dout0_22 vdout0_22ck155 = 0 time = 1560
* CHECK dout0_23 vdout0_23ck155 = 1.8 time = 1560
* CHECK dout0_24 vdout0_24ck155 = 0 time = 1560
* CHECK dout0_25 vdout0_25ck155 = 1.8 time = 1560
* CHECK dout0_26 vdout0_26ck155 = 0 time = 1560
* CHECK dout0_27 vdout0_27ck155 = 1.8 time = 1560
* CHECK dout0_28 vdout0_28ck155 = 0 time = 1560
* CHECK dout0_29 vdout0_29ck155 = 1.8 time = 1560
* CHECK dout0_30 vdout0_30ck155 = 0 time = 1560
* CHECK dout0_31 vdout0_31ck155 = 0 time = 1560
* CHECK dout0_32 vdout0_32ck155 = 1.8 time = 1560
* CHECK dout0_33 vdout0_33ck155 = 0 time = 1560
* CHECK dout0_34 vdout0_34ck155 = 1.8 time = 1560
* CHECK dout0_35 vdout0_35ck155 = 0 time = 1560
* CHECK dout0_36 vdout0_36ck155 = 1.8 time = 1560
* CHECK dout0_37 vdout0_37ck155 = 0 time = 1560
* CHECK dout0_38 vdout0_38ck155 = 0 time = 1560
* CHECK dout0_39 vdout0_39ck155 = 1.8 time = 1560
* CHECK dout0_40 vdout0_40ck155 = 1.8 time = 1560
* CHECK dout0_41 vdout0_41ck155 = 0 time = 1560
* CHECK dout0_42 vdout0_42ck155 = 1.8 time = 1560
* CHECK dout0_43 vdout0_43ck155 = 1.8 time = 1560
* CHECK dout0_44 vdout0_44ck155 = 1.8 time = 1560
* CHECK dout0_45 vdout0_45ck155 = 1.8 time = 1560
* CHECK dout0_46 vdout0_46ck155 = 0 time = 1560
* CHECK dout0_47 vdout0_47ck155 = 0 time = 1560
* CHECK dout0_48 vdout0_48ck155 = 1.8 time = 1560
* CHECK dout0_49 vdout0_49ck155 = 1.8 time = 1560
* CHECK dout0_50 vdout0_50ck155 = 1.8 time = 1560
* CHECK dout0_51 vdout0_51ck155 = 1.8 time = 1560
* CHECK dout0_52 vdout0_52ck155 = 0 time = 1560
* CHECK dout0_53 vdout0_53ck155 = 0 time = 1560
* CHECK dout0_54 vdout0_54ck155 = 0 time = 1560
* CHECK dout0_55 vdout0_55ck155 = 0 time = 1560
* CHECK dout0_56 vdout0_56ck155 = 1.8 time = 1560
* CHECK dout0_57 vdout0_57ck155 = 1.8 time = 1560
* CHECK dout0_58 vdout0_58ck155 = 0 time = 1560
* CHECK dout0_59 vdout0_59ck155 = 0 time = 1560
* CHECK dout0_60 vdout0_60ck155 = 0 time = 1560
* CHECK dout0_61 vdout0_61ck155 = 1.8 time = 1560
* CHECK dout0_62 vdout0_62ck155 = 0 time = 1560
* CHECK dout0_63 vdout0_63ck155 = 0 time = 1560
* CHECK dout1_0 vdout1_0ck155 = 1.8 time = 1560
* CHECK dout1_1 vdout1_1ck155 = 1.8 time = 1560
* CHECK dout1_2 vdout1_2ck155 = 0 time = 1560
* CHECK dout1_3 vdout1_3ck155 = 0 time = 1560
* CHECK dout1_4 vdout1_4ck155 = 0 time = 1560
* CHECK dout1_5 vdout1_5ck155 = 1.8 time = 1560
* CHECK dout1_6 vdout1_6ck155 = 1.8 time = 1560
* CHECK dout1_7 vdout1_7ck155 = 1.8 time = 1560
* CHECK dout1_8 vdout1_8ck155 = 1.8 time = 1560
* CHECK dout1_9 vdout1_9ck155 = 1.8 time = 1560
* CHECK dout1_10 vdout1_10ck155 = 1.8 time = 1560
* CHECK dout1_11 vdout1_11ck155 = 1.8 time = 1560
* CHECK dout1_12 vdout1_12ck155 = 0 time = 1560
* CHECK dout1_13 vdout1_13ck155 = 0 time = 1560
* CHECK dout1_14 vdout1_14ck155 = 0 time = 1560
* CHECK dout1_15 vdout1_15ck155 = 1.8 time = 1560
* CHECK dout1_16 vdout1_16ck155 = 1.8 time = 1560
* CHECK dout1_17 vdout1_17ck155 = 1.8 time = 1560
* CHECK dout1_18 vdout1_18ck155 = 0 time = 1560
* CHECK dout1_19 vdout1_19ck155 = 1.8 time = 1560
* CHECK dout1_20 vdout1_20ck155 = 1.8 time = 1560
* CHECK dout1_21 vdout1_21ck155 = 1.8 time = 1560
* CHECK dout1_22 vdout1_22ck155 = 1.8 time = 1560
* CHECK dout1_23 vdout1_23ck155 = 0 time = 1560
* CHECK dout1_24 vdout1_24ck155 = 1.8 time = 1560
* CHECK dout1_25 vdout1_25ck155 = 0 time = 1560
* CHECK dout1_26 vdout1_26ck155 = 1.8 time = 1560
* CHECK dout1_27 vdout1_27ck155 = 1.8 time = 1560
* CHECK dout1_28 vdout1_28ck155 = 1.8 time = 1560
* CHECK dout1_29 vdout1_29ck155 = 1.8 time = 1560
* CHECK dout1_30 vdout1_30ck155 = 0 time = 1560
* CHECK dout1_31 vdout1_31ck155 = 0 time = 1560
* CHECK dout1_32 vdout1_32ck155 = 0 time = 1560
* CHECK dout1_33 vdout1_33ck155 = 0 time = 1560
* CHECK dout1_34 vdout1_34ck155 = 1.8 time = 1560
* CHECK dout1_35 vdout1_35ck155 = 1.8 time = 1560
* CHECK dout1_36 vdout1_36ck155 = 1.8 time = 1560
* CHECK dout1_37 vdout1_37ck155 = 1.8 time = 1560
* CHECK dout1_38 vdout1_38ck155 = 0 time = 1560
* CHECK dout1_39 vdout1_39ck155 = 0 time = 1560
* CHECK dout1_40 vdout1_40ck155 = 1.8 time = 1560
* CHECK dout1_41 vdout1_41ck155 = 1.8 time = 1560
* CHECK dout1_42 vdout1_42ck155 = 0 time = 1560
* CHECK dout1_43 vdout1_43ck155 = 1.8 time = 1560
* CHECK dout1_44 vdout1_44ck155 = 1.8 time = 1560
* CHECK dout1_45 vdout1_45ck155 = 1.8 time = 1560
* CHECK dout1_46 vdout1_46ck155 = 0 time = 1560
* CHECK dout1_47 vdout1_47ck155 = 1.8 time = 1560
* CHECK dout1_48 vdout1_48ck155 = 1.8 time = 1560
* CHECK dout1_49 vdout1_49ck155 = 0 time = 1560
* CHECK dout1_50 vdout1_50ck155 = 1.8 time = 1560
* CHECK dout1_51 vdout1_51ck155 = 1.8 time = 1560
* CHECK dout1_52 vdout1_52ck155 = 1.8 time = 1560
* CHECK dout1_53 vdout1_53ck155 = 1.8 time = 1560
* CHECK dout1_54 vdout1_54ck155 = 1.8 time = 1560
* CHECK dout1_55 vdout1_55ck155 = 1.8 time = 1560
* CHECK dout1_56 vdout1_56ck155 = 0 time = 1560
* CHECK dout1_57 vdout1_57ck155 = 0 time = 1560
* CHECK dout1_58 vdout1_58ck155 = 0 time = 1560
* CHECK dout1_59 vdout1_59ck155 = 0 time = 1560
* CHECK dout1_60 vdout1_60ck155 = 0 time = 1560
* CHECK dout1_61 vdout1_61ck155 = 0 time = 1560
* CHECK dout1_62 vdout1_62ck155 = 1.8 time = 1560
* CHECK dout1_63 vdout1_63ck155 = 0 time = 1560
* CHECK dout0_0 vdout0_0ck156 = 1.8 time = 1570
* CHECK dout0_1 vdout0_1ck156 = 1.8 time = 1570
* CHECK dout0_2 vdout0_2ck156 = 0 time = 1570
* CHECK dout0_3 vdout0_3ck156 = 0 time = 1570
* CHECK dout0_4 vdout0_4ck156 = 0 time = 1570
* CHECK dout0_5 vdout0_5ck156 = 1.8 time = 1570
* CHECK dout0_6 vdout0_6ck156 = 1.8 time = 1570
* CHECK dout0_7 vdout0_7ck156 = 1.8 time = 1570
* CHECK dout0_8 vdout0_8ck156 = 1.8 time = 1570
* CHECK dout0_9 vdout0_9ck156 = 1.8 time = 1570
* CHECK dout0_10 vdout0_10ck156 = 1.8 time = 1570
* CHECK dout0_11 vdout0_11ck156 = 1.8 time = 1570
* CHECK dout0_12 vdout0_12ck156 = 0 time = 1570
* CHECK dout0_13 vdout0_13ck156 = 0 time = 1570
* CHECK dout0_14 vdout0_14ck156 = 0 time = 1570
* CHECK dout0_15 vdout0_15ck156 = 1.8 time = 1570
* CHECK dout0_16 vdout0_16ck156 = 1.8 time = 1570
* CHECK dout0_17 vdout0_17ck156 = 1.8 time = 1570
* CHECK dout0_18 vdout0_18ck156 = 0 time = 1570
* CHECK dout0_19 vdout0_19ck156 = 1.8 time = 1570
* CHECK dout0_20 vdout0_20ck156 = 1.8 time = 1570
* CHECK dout0_21 vdout0_21ck156 = 1.8 time = 1570
* CHECK dout0_22 vdout0_22ck156 = 1.8 time = 1570
* CHECK dout0_23 vdout0_23ck156 = 0 time = 1570
* CHECK dout0_24 vdout0_24ck156 = 1.8 time = 1570
* CHECK dout0_25 vdout0_25ck156 = 0 time = 1570
* CHECK dout0_26 vdout0_26ck156 = 1.8 time = 1570
* CHECK dout0_27 vdout0_27ck156 = 1.8 time = 1570
* CHECK dout0_28 vdout0_28ck156 = 1.8 time = 1570
* CHECK dout0_29 vdout0_29ck156 = 1.8 time = 1570
* CHECK dout0_30 vdout0_30ck156 = 0 time = 1570
* CHECK dout0_31 vdout0_31ck156 = 0 time = 1570
* CHECK dout0_32 vdout0_32ck156 = 0 time = 1570
* CHECK dout0_33 vdout0_33ck156 = 0 time = 1570
* CHECK dout0_34 vdout0_34ck156 = 1.8 time = 1570
* CHECK dout0_35 vdout0_35ck156 = 1.8 time = 1570
* CHECK dout0_36 vdout0_36ck156 = 1.8 time = 1570
* CHECK dout0_37 vdout0_37ck156 = 1.8 time = 1570
* CHECK dout0_38 vdout0_38ck156 = 0 time = 1570
* CHECK dout0_39 vdout0_39ck156 = 0 time = 1570
* CHECK dout0_40 vdout0_40ck156 = 1.8 time = 1570
* CHECK dout0_41 vdout0_41ck156 = 1.8 time = 1570
* CHECK dout0_42 vdout0_42ck156 = 0 time = 1570
* CHECK dout0_43 vdout0_43ck156 = 1.8 time = 1570
* CHECK dout0_44 vdout0_44ck156 = 1.8 time = 1570
* CHECK dout0_45 vdout0_45ck156 = 1.8 time = 1570
* CHECK dout0_46 vdout0_46ck156 = 0 time = 1570
* CHECK dout0_47 vdout0_47ck156 = 1.8 time = 1570
* CHECK dout0_48 vdout0_48ck156 = 1.8 time = 1570
* CHECK dout0_49 vdout0_49ck156 = 0 time = 1570
* CHECK dout0_50 vdout0_50ck156 = 1.8 time = 1570
* CHECK dout0_51 vdout0_51ck156 = 1.8 time = 1570
* CHECK dout0_52 vdout0_52ck156 = 1.8 time = 1570
* CHECK dout0_53 vdout0_53ck156 = 1.8 time = 1570
* CHECK dout0_54 vdout0_54ck156 = 1.8 time = 1570
* CHECK dout0_55 vdout0_55ck156 = 1.8 time = 1570
* CHECK dout0_56 vdout0_56ck156 = 0 time = 1570
* CHECK dout0_57 vdout0_57ck156 = 0 time = 1570
* CHECK dout0_58 vdout0_58ck156 = 0 time = 1570
* CHECK dout0_59 vdout0_59ck156 = 0 time = 1570
* CHECK dout0_60 vdout0_60ck156 = 0 time = 1570
* CHECK dout0_61 vdout0_61ck156 = 0 time = 1570
* CHECK dout0_62 vdout0_62ck156 = 1.8 time = 1570
* CHECK dout0_63 vdout0_63ck156 = 0 time = 1570
* CHECK dout1_0 vdout1_0ck159 = 0 time = 1600
* CHECK dout1_1 vdout1_1ck159 = 1.8 time = 1600
* CHECK dout1_2 vdout1_2ck159 = 1.8 time = 1600
* CHECK dout1_3 vdout1_3ck159 = 1.8 time = 1600
* CHECK dout1_4 vdout1_4ck159 = 1.8 time = 1600
* CHECK dout1_5 vdout1_5ck159 = 1.8 time = 1600
* CHECK dout1_6 vdout1_6ck159 = 0 time = 1600
* CHECK dout1_7 vdout1_7ck159 = 0 time = 1600
* CHECK dout1_8 vdout1_8ck159 = 1.8 time = 1600
* CHECK dout1_9 vdout1_9ck159 = 0 time = 1600
* CHECK dout1_10 vdout1_10ck159 = 1.8 time = 1600
* CHECK dout1_11 vdout1_11ck159 = 1.8 time = 1600
* CHECK dout1_12 vdout1_12ck159 = 1.8 time = 1600
* CHECK dout1_13 vdout1_13ck159 = 0 time = 1600
* CHECK dout1_14 vdout1_14ck159 = 0 time = 1600
* CHECK dout1_15 vdout1_15ck159 = 0 time = 1600
* CHECK dout1_16 vdout1_16ck159 = 1.8 time = 1600
* CHECK dout1_17 vdout1_17ck159 = 1.8 time = 1600
* CHECK dout1_18 vdout1_18ck159 = 1.8 time = 1600
* CHECK dout1_19 vdout1_19ck159 = 0 time = 1600
* CHECK dout1_20 vdout1_20ck159 = 0 time = 1600
* CHECK dout1_21 vdout1_21ck159 = 0 time = 1600
* CHECK dout1_22 vdout1_22ck159 = 0 time = 1600
* CHECK dout1_23 vdout1_23ck159 = 0 time = 1600
* CHECK dout1_24 vdout1_24ck159 = 0 time = 1600
* CHECK dout1_25 vdout1_25ck159 = 1.8 time = 1600
* CHECK dout1_26 vdout1_26ck159 = 1.8 time = 1600
* CHECK dout1_27 vdout1_27ck159 = 1.8 time = 1600
* CHECK dout1_28 vdout1_28ck159 = 1.8 time = 1600
* CHECK dout1_29 vdout1_29ck159 = 1.8 time = 1600
* CHECK dout1_30 vdout1_30ck159 = 1.8 time = 1600
* CHECK dout1_31 vdout1_31ck159 = 1.8 time = 1600
* CHECK dout1_32 vdout1_32ck159 = 0 time = 1600
* CHECK dout1_33 vdout1_33ck159 = 0 time = 1600
* CHECK dout1_34 vdout1_34ck159 = 0 time = 1600
* CHECK dout1_35 vdout1_35ck159 = 1.8 time = 1600
* CHECK dout1_36 vdout1_36ck159 = 1.8 time = 1600
* CHECK dout1_37 vdout1_37ck159 = 1.8 time = 1600
* CHECK dout1_38 vdout1_38ck159 = 0 time = 1600
* CHECK dout1_39 vdout1_39ck159 = 1.8 time = 1600
* CHECK dout1_40 vdout1_40ck159 = 1.8 time = 1600
* CHECK dout1_41 vdout1_41ck159 = 1.8 time = 1600
* CHECK dout1_42 vdout1_42ck159 = 0 time = 1600
* CHECK dout1_43 vdout1_43ck159 = 1.8 time = 1600
* CHECK dout1_44 vdout1_44ck159 = 1.8 time = 1600
* CHECK dout1_45 vdout1_45ck159 = 0 time = 1600
* CHECK dout1_46 vdout1_46ck159 = 0 time = 1600
* CHECK dout1_47 vdout1_47ck159 = 0 time = 1600
* CHECK dout1_48 vdout1_48ck159 = 0 time = 1600
* CHECK dout1_49 vdout1_49ck159 = 1.8 time = 1600
* CHECK dout1_50 vdout1_50ck159 = 0 time = 1600
* CHECK dout1_51 vdout1_51ck159 = 0 time = 1600
* CHECK dout1_52 vdout1_52ck159 = 0 time = 1600
* CHECK dout1_53 vdout1_53ck159 = 0 time = 1600
* CHECK dout1_54 vdout1_54ck159 = 0 time = 1600
* CHECK dout1_55 vdout1_55ck159 = 0 time = 1600
* CHECK dout1_56 vdout1_56ck159 = 0 time = 1600
* CHECK dout1_57 vdout1_57ck159 = 0 time = 1600
* CHECK dout1_58 vdout1_58ck159 = 0 time = 1600
* CHECK dout1_59 vdout1_59ck159 = 0 time = 1600
* CHECK dout1_60 vdout1_60ck159 = 1.8 time = 1600
* CHECK dout1_61 vdout1_61ck159 = 1.8 time = 1600
* CHECK dout1_62 vdout1_62ck159 = 1.8 time = 1600
* CHECK dout1_63 vdout1_63ck159 = 1.8 time = 1600
* CHECK dout0_0 vdout0_0ck160 = 1.8 time = 1610
* CHECK dout0_1 vdout0_1ck160 = 1.8 time = 1610
* CHECK dout0_2 vdout0_2ck160 = 0 time = 1610
* CHECK dout0_3 vdout0_3ck160 = 0 time = 1610
* CHECK dout0_4 vdout0_4ck160 = 0 time = 1610
* CHECK dout0_5 vdout0_5ck160 = 1.8 time = 1610
* CHECK dout0_6 vdout0_6ck160 = 0 time = 1610
* CHECK dout0_7 vdout0_7ck160 = 1.8 time = 1610
* CHECK dout0_8 vdout0_8ck160 = 0 time = 1610
* CHECK dout0_9 vdout0_9ck160 = 0 time = 1610
* CHECK dout0_10 vdout0_10ck160 = 0 time = 1610
* CHECK dout0_11 vdout0_11ck160 = 0 time = 1610
* CHECK dout0_12 vdout0_12ck160 = 0 time = 1610
* CHECK dout0_13 vdout0_13ck160 = 1.8 time = 1610
* CHECK dout0_14 vdout0_14ck160 = 0 time = 1610
* CHECK dout0_15 vdout0_15ck160 = 1.8 time = 1610
* CHECK dout0_16 vdout0_16ck160 = 0 time = 1610
* CHECK dout0_17 vdout0_17ck160 = 0 time = 1610
* CHECK dout0_18 vdout0_18ck160 = 0 time = 1610
* CHECK dout0_19 vdout0_19ck160 = 1.8 time = 1610
* CHECK dout0_20 vdout0_20ck160 = 1.8 time = 1610
* CHECK dout0_21 vdout0_21ck160 = 1.8 time = 1610
* CHECK dout0_22 vdout0_22ck160 = 1.8 time = 1610
* CHECK dout0_23 vdout0_23ck160 = 0 time = 1610
* CHECK dout0_24 vdout0_24ck160 = 1.8 time = 1610
* CHECK dout0_25 vdout0_25ck160 = 0 time = 1610
* CHECK dout0_26 vdout0_26ck160 = 0 time = 1610
* CHECK dout0_27 vdout0_27ck160 = 0 time = 1610
* CHECK dout0_28 vdout0_28ck160 = 0 time = 1610
* CHECK dout0_29 vdout0_29ck160 = 0 time = 1610
* CHECK dout0_30 vdout0_30ck160 = 0 time = 1610
* CHECK dout0_31 vdout0_31ck160 = 1.8 time = 1610
* CHECK dout0_32 vdout0_32ck160 = 1.8 time = 1610
* CHECK dout0_33 vdout0_33ck160 = 0 time = 1610
* CHECK dout0_34 vdout0_34ck160 = 1.8 time = 1610
* CHECK dout0_35 vdout0_35ck160 = 0 time = 1610
* CHECK dout0_36 vdout0_36ck160 = 1.8 time = 1610
* CHECK dout0_37 vdout0_37ck160 = 1.8 time = 1610
* CHECK dout0_38 vdout0_38ck160 = 0 time = 1610
* CHECK dout0_39 vdout0_39ck160 = 0 time = 1610
* CHECK dout0_40 vdout0_40ck160 = 0 time = 1610
* CHECK dout0_41 vdout0_41ck160 = 0 time = 1610
* CHECK dout0_42 vdout0_42ck160 = 1.8 time = 1610
* CHECK dout0_43 vdout0_43ck160 = 1.8 time = 1610
* CHECK dout0_44 vdout0_44ck160 = 1.8 time = 1610
* CHECK dout0_45 vdout0_45ck160 = 1.8 time = 1610
* CHECK dout0_46 vdout0_46ck160 = 0 time = 1610
* CHECK dout0_47 vdout0_47ck160 = 0 time = 1610
* CHECK dout0_48 vdout0_48ck160 = 1.8 time = 1610
* CHECK dout0_49 vdout0_49ck160 = 0 time = 1610
* CHECK dout0_50 vdout0_50ck160 = 0 time = 1610
* CHECK dout0_51 vdout0_51ck160 = 1.8 time = 1610
* CHECK dout0_52 vdout0_52ck160 = 1.8 time = 1610
* CHECK dout0_53 vdout0_53ck160 = 1.8 time = 1610
* CHECK dout0_54 vdout0_54ck160 = 1.8 time = 1610
* CHECK dout0_55 vdout0_55ck160 = 0 time = 1610
* CHECK dout0_56 vdout0_56ck160 = 1.8 time = 1610
* CHECK dout0_57 vdout0_57ck160 = 1.8 time = 1610
* CHECK dout0_58 vdout0_58ck160 = 0 time = 1610
* CHECK dout0_59 vdout0_59ck160 = 1.8 time = 1610
* CHECK dout0_60 vdout0_60ck160 = 1.8 time = 1610
* CHECK dout0_61 vdout0_61ck160 = 1.8 time = 1610
* CHECK dout0_62 vdout0_62ck160 = 0 time = 1610
* CHECK dout0_63 vdout0_63ck160 = 1.8 time = 1610
* CHECK dout1_0 vdout1_0ck160 = 0 time = 1610
* CHECK dout1_1 vdout1_1ck160 = 1.8 time = 1610
* CHECK dout1_2 vdout1_2ck160 = 1.8 time = 1610
* CHECK dout1_3 vdout1_3ck160 = 1.8 time = 1610
* CHECK dout1_4 vdout1_4ck160 = 1.8 time = 1610
* CHECK dout1_5 vdout1_5ck160 = 1.8 time = 1610
* CHECK dout1_6 vdout1_6ck160 = 0 time = 1610
* CHECK dout1_7 vdout1_7ck160 = 0 time = 1610
* CHECK dout1_8 vdout1_8ck160 = 1.8 time = 1610
* CHECK dout1_9 vdout1_9ck160 = 0 time = 1610
* CHECK dout1_10 vdout1_10ck160 = 1.8 time = 1610
* CHECK dout1_11 vdout1_11ck160 = 1.8 time = 1610
* CHECK dout1_12 vdout1_12ck160 = 1.8 time = 1610
* CHECK dout1_13 vdout1_13ck160 = 0 time = 1610
* CHECK dout1_14 vdout1_14ck160 = 0 time = 1610
* CHECK dout1_15 vdout1_15ck160 = 0 time = 1610
* CHECK dout1_16 vdout1_16ck160 = 1.8 time = 1610
* CHECK dout1_17 vdout1_17ck160 = 1.8 time = 1610
* CHECK dout1_18 vdout1_18ck160 = 1.8 time = 1610
* CHECK dout1_19 vdout1_19ck160 = 0 time = 1610
* CHECK dout1_20 vdout1_20ck160 = 0 time = 1610
* CHECK dout1_21 vdout1_21ck160 = 0 time = 1610
* CHECK dout1_22 vdout1_22ck160 = 0 time = 1610
* CHECK dout1_23 vdout1_23ck160 = 0 time = 1610
* CHECK dout1_24 vdout1_24ck160 = 0 time = 1610
* CHECK dout1_25 vdout1_25ck160 = 1.8 time = 1610
* CHECK dout1_26 vdout1_26ck160 = 1.8 time = 1610
* CHECK dout1_27 vdout1_27ck160 = 1.8 time = 1610
* CHECK dout1_28 vdout1_28ck160 = 1.8 time = 1610
* CHECK dout1_29 vdout1_29ck160 = 1.8 time = 1610
* CHECK dout1_30 vdout1_30ck160 = 1.8 time = 1610
* CHECK dout1_31 vdout1_31ck160 = 1.8 time = 1610
* CHECK dout1_32 vdout1_32ck160 = 0 time = 1610
* CHECK dout1_33 vdout1_33ck160 = 0 time = 1610
* CHECK dout1_34 vdout1_34ck160 = 0 time = 1610
* CHECK dout1_35 vdout1_35ck160 = 1.8 time = 1610
* CHECK dout1_36 vdout1_36ck160 = 1.8 time = 1610
* CHECK dout1_37 vdout1_37ck160 = 1.8 time = 1610
* CHECK dout1_38 vdout1_38ck160 = 0 time = 1610
* CHECK dout1_39 vdout1_39ck160 = 1.8 time = 1610
* CHECK dout1_40 vdout1_40ck160 = 1.8 time = 1610
* CHECK dout1_41 vdout1_41ck160 = 1.8 time = 1610
* CHECK dout1_42 vdout1_42ck160 = 0 time = 1610
* CHECK dout1_43 vdout1_43ck160 = 1.8 time = 1610
* CHECK dout1_44 vdout1_44ck160 = 1.8 time = 1610
* CHECK dout1_45 vdout1_45ck160 = 0 time = 1610
* CHECK dout1_46 vdout1_46ck160 = 0 time = 1610
* CHECK dout1_47 vdout1_47ck160 = 0 time = 1610
* CHECK dout1_48 vdout1_48ck160 = 0 time = 1610
* CHECK dout1_49 vdout1_49ck160 = 1.8 time = 1610
* CHECK dout1_50 vdout1_50ck160 = 0 time = 1610
* CHECK dout1_51 vdout1_51ck160 = 0 time = 1610
* CHECK dout1_52 vdout1_52ck160 = 0 time = 1610
* CHECK dout1_53 vdout1_53ck160 = 0 time = 1610
* CHECK dout1_54 vdout1_54ck160 = 0 time = 1610
* CHECK dout1_55 vdout1_55ck160 = 0 time = 1610
* CHECK dout1_56 vdout1_56ck160 = 0 time = 1610
* CHECK dout1_57 vdout1_57ck160 = 0 time = 1610
* CHECK dout1_58 vdout1_58ck160 = 0 time = 1610
* CHECK dout1_59 vdout1_59ck160 = 0 time = 1610
* CHECK dout1_60 vdout1_60ck160 = 1.8 time = 1610
* CHECK dout1_61 vdout1_61ck160 = 1.8 time = 1610
* CHECK dout1_62 vdout1_62ck160 = 1.8 time = 1610
* CHECK dout1_63 vdout1_63ck160 = 1.8 time = 1610
* CHECK dout1_0 vdout1_0ck161 = 1.8 time = 1620
* CHECK dout1_1 vdout1_1ck161 = 1.8 time = 1620
* CHECK dout1_2 vdout1_2ck161 = 0 time = 1620
* CHECK dout1_3 vdout1_3ck161 = 0 time = 1620
* CHECK dout1_4 vdout1_4ck161 = 0 time = 1620
* CHECK dout1_5 vdout1_5ck161 = 1.8 time = 1620
* CHECK dout1_6 vdout1_6ck161 = 0 time = 1620
* CHECK dout1_7 vdout1_7ck161 = 1.8 time = 1620
* CHECK dout1_8 vdout1_8ck161 = 0 time = 1620
* CHECK dout1_9 vdout1_9ck161 = 0 time = 1620
* CHECK dout1_10 vdout1_10ck161 = 0 time = 1620
* CHECK dout1_11 vdout1_11ck161 = 0 time = 1620
* CHECK dout1_12 vdout1_12ck161 = 0 time = 1620
* CHECK dout1_13 vdout1_13ck161 = 1.8 time = 1620
* CHECK dout1_14 vdout1_14ck161 = 0 time = 1620
* CHECK dout1_15 vdout1_15ck161 = 1.8 time = 1620
* CHECK dout1_16 vdout1_16ck161 = 0 time = 1620
* CHECK dout1_17 vdout1_17ck161 = 0 time = 1620
* CHECK dout1_18 vdout1_18ck161 = 0 time = 1620
* CHECK dout1_19 vdout1_19ck161 = 1.8 time = 1620
* CHECK dout1_20 vdout1_20ck161 = 1.8 time = 1620
* CHECK dout1_21 vdout1_21ck161 = 1.8 time = 1620
* CHECK dout1_22 vdout1_22ck161 = 1.8 time = 1620
* CHECK dout1_23 vdout1_23ck161 = 0 time = 1620
* CHECK dout1_24 vdout1_24ck161 = 1.8 time = 1620
* CHECK dout1_25 vdout1_25ck161 = 0 time = 1620
* CHECK dout1_26 vdout1_26ck161 = 0 time = 1620
* CHECK dout1_27 vdout1_27ck161 = 0 time = 1620
* CHECK dout1_28 vdout1_28ck161 = 0 time = 1620
* CHECK dout1_29 vdout1_29ck161 = 0 time = 1620
* CHECK dout1_30 vdout1_30ck161 = 0 time = 1620
* CHECK dout1_31 vdout1_31ck161 = 1.8 time = 1620
* CHECK dout1_32 vdout1_32ck161 = 1.8 time = 1620
* CHECK dout1_33 vdout1_33ck161 = 0 time = 1620
* CHECK dout1_34 vdout1_34ck161 = 1.8 time = 1620
* CHECK dout1_35 vdout1_35ck161 = 0 time = 1620
* CHECK dout1_36 vdout1_36ck161 = 1.8 time = 1620
* CHECK dout1_37 vdout1_37ck161 = 1.8 time = 1620
* CHECK dout1_38 vdout1_38ck161 = 0 time = 1620
* CHECK dout1_39 vdout1_39ck161 = 0 time = 1620
* CHECK dout1_40 vdout1_40ck161 = 0 time = 1620
* CHECK dout1_41 vdout1_41ck161 = 0 time = 1620
* CHECK dout1_42 vdout1_42ck161 = 1.8 time = 1620
* CHECK dout1_43 vdout1_43ck161 = 1.8 time = 1620
* CHECK dout1_44 vdout1_44ck161 = 1.8 time = 1620
* CHECK dout1_45 vdout1_45ck161 = 1.8 time = 1620
* CHECK dout1_46 vdout1_46ck161 = 0 time = 1620
* CHECK dout1_47 vdout1_47ck161 = 0 time = 1620
* CHECK dout1_48 vdout1_48ck161 = 1.8 time = 1620
* CHECK dout1_49 vdout1_49ck161 = 0 time = 1620
* CHECK dout1_50 vdout1_50ck161 = 0 time = 1620
* CHECK dout1_51 vdout1_51ck161 = 1.8 time = 1620
* CHECK dout1_52 vdout1_52ck161 = 1.8 time = 1620
* CHECK dout1_53 vdout1_53ck161 = 1.8 time = 1620
* CHECK dout1_54 vdout1_54ck161 = 1.8 time = 1620
* CHECK dout1_55 vdout1_55ck161 = 0 time = 1620
* CHECK dout1_56 vdout1_56ck161 = 1.8 time = 1620
* CHECK dout1_57 vdout1_57ck161 = 1.8 time = 1620
* CHECK dout1_58 vdout1_58ck161 = 0 time = 1620
* CHECK dout1_59 vdout1_59ck161 = 1.8 time = 1620
* CHECK dout1_60 vdout1_60ck161 = 1.8 time = 1620
* CHECK dout1_61 vdout1_61ck161 = 1.8 time = 1620
* CHECK dout1_62 vdout1_62ck161 = 0 time = 1620
* CHECK dout1_63 vdout1_63ck161 = 1.8 time = 1620
* CHECK dout1_0 vdout1_0ck162 = 0 time = 1630
* CHECK dout1_1 vdout1_1ck162 = 1.8 time = 1630
* CHECK dout1_2 vdout1_2ck162 = 1.8 time = 1630
* CHECK dout1_3 vdout1_3ck162 = 1.8 time = 1630
* CHECK dout1_4 vdout1_4ck162 = 1.8 time = 1630
* CHECK dout1_5 vdout1_5ck162 = 1.8 time = 1630
* CHECK dout1_6 vdout1_6ck162 = 0 time = 1630
* CHECK dout1_7 vdout1_7ck162 = 0 time = 1630
* CHECK dout1_8 vdout1_8ck162 = 1.8 time = 1630
* CHECK dout1_9 vdout1_9ck162 = 0 time = 1630
* CHECK dout1_10 vdout1_10ck162 = 1.8 time = 1630
* CHECK dout1_11 vdout1_11ck162 = 1.8 time = 1630
* CHECK dout1_12 vdout1_12ck162 = 1.8 time = 1630
* CHECK dout1_13 vdout1_13ck162 = 0 time = 1630
* CHECK dout1_14 vdout1_14ck162 = 0 time = 1630
* CHECK dout1_15 vdout1_15ck162 = 0 time = 1630
* CHECK dout1_16 vdout1_16ck162 = 1.8 time = 1630
* CHECK dout1_17 vdout1_17ck162 = 1.8 time = 1630
* CHECK dout1_18 vdout1_18ck162 = 1.8 time = 1630
* CHECK dout1_19 vdout1_19ck162 = 0 time = 1630
* CHECK dout1_20 vdout1_20ck162 = 0 time = 1630
* CHECK dout1_21 vdout1_21ck162 = 0 time = 1630
* CHECK dout1_22 vdout1_22ck162 = 0 time = 1630
* CHECK dout1_23 vdout1_23ck162 = 0 time = 1630
* CHECK dout1_24 vdout1_24ck162 = 0 time = 1630
* CHECK dout1_25 vdout1_25ck162 = 1.8 time = 1630
* CHECK dout1_26 vdout1_26ck162 = 1.8 time = 1630
* CHECK dout1_27 vdout1_27ck162 = 1.8 time = 1630
* CHECK dout1_28 vdout1_28ck162 = 1.8 time = 1630
* CHECK dout1_29 vdout1_29ck162 = 1.8 time = 1630
* CHECK dout1_30 vdout1_30ck162 = 1.8 time = 1630
* CHECK dout1_31 vdout1_31ck162 = 1.8 time = 1630
* CHECK dout1_32 vdout1_32ck162 = 0 time = 1630
* CHECK dout1_33 vdout1_33ck162 = 0 time = 1630
* CHECK dout1_34 vdout1_34ck162 = 0 time = 1630
* CHECK dout1_35 vdout1_35ck162 = 1.8 time = 1630
* CHECK dout1_36 vdout1_36ck162 = 1.8 time = 1630
* CHECK dout1_37 vdout1_37ck162 = 1.8 time = 1630
* CHECK dout1_38 vdout1_38ck162 = 0 time = 1630
* CHECK dout1_39 vdout1_39ck162 = 1.8 time = 1630
* CHECK dout1_40 vdout1_40ck162 = 1.8 time = 1630
* CHECK dout1_41 vdout1_41ck162 = 1.8 time = 1630
* CHECK dout1_42 vdout1_42ck162 = 0 time = 1630
* CHECK dout1_43 vdout1_43ck162 = 1.8 time = 1630
* CHECK dout1_44 vdout1_44ck162 = 1.8 time = 1630
* CHECK dout1_45 vdout1_45ck162 = 0 time = 1630
* CHECK dout1_46 vdout1_46ck162 = 0 time = 1630
* CHECK dout1_47 vdout1_47ck162 = 0 time = 1630
* CHECK dout1_48 vdout1_48ck162 = 0 time = 1630
* CHECK dout1_49 vdout1_49ck162 = 1.8 time = 1630
* CHECK dout1_50 vdout1_50ck162 = 0 time = 1630
* CHECK dout1_51 vdout1_51ck162 = 0 time = 1630
* CHECK dout1_52 vdout1_52ck162 = 0 time = 1630
* CHECK dout1_53 vdout1_53ck162 = 0 time = 1630
* CHECK dout1_54 vdout1_54ck162 = 0 time = 1630
* CHECK dout1_55 vdout1_55ck162 = 0 time = 1630
* CHECK dout1_56 vdout1_56ck162 = 0 time = 1630
* CHECK dout1_57 vdout1_57ck162 = 0 time = 1630
* CHECK dout1_58 vdout1_58ck162 = 0 time = 1630
* CHECK dout1_59 vdout1_59ck162 = 0 time = 1630
* CHECK dout1_60 vdout1_60ck162 = 1.8 time = 1630
* CHECK dout1_61 vdout1_61ck162 = 1.8 time = 1630
* CHECK dout1_62 vdout1_62ck162 = 1.8 time = 1630
* CHECK dout1_63 vdout1_63ck162 = 1.8 time = 1630
* CHECK dout0_0 vdout0_0ck163 = 0 time = 1640
* CHECK dout0_1 vdout0_1ck163 = 0 time = 1640
* CHECK dout0_2 vdout0_2ck163 = 1.8 time = 1640
* CHECK dout0_3 vdout0_3ck163 = 1.8 time = 1640
* CHECK dout0_4 vdout0_4ck163 = 0 time = 1640
* CHECK dout0_5 vdout0_5ck163 = 1.8 time = 1640
* CHECK dout0_6 vdout0_6ck163 = 0 time = 1640
* CHECK dout0_7 vdout0_7ck163 = 0 time = 1640
* CHECK dout0_8 vdout0_8ck163 = 0 time = 1640
* CHECK dout0_9 vdout0_9ck163 = 0 time = 1640
* CHECK dout0_10 vdout0_10ck163 = 0 time = 1640
* CHECK dout0_11 vdout0_11ck163 = 0 time = 1640
* CHECK dout0_12 vdout0_12ck163 = 0 time = 1640
* CHECK dout0_13 vdout0_13ck163 = 1.8 time = 1640
* CHECK dout0_14 vdout0_14ck163 = 1.8 time = 1640
* CHECK dout0_15 vdout0_15ck163 = 1.8 time = 1640
* CHECK dout0_16 vdout0_16ck163 = 1.8 time = 1640
* CHECK dout0_17 vdout0_17ck163 = 0 time = 1640
* CHECK dout0_18 vdout0_18ck163 = 0 time = 1640
* CHECK dout0_19 vdout0_19ck163 = 0 time = 1640
* CHECK dout0_20 vdout0_20ck163 = 1.8 time = 1640
* CHECK dout0_21 vdout0_21ck163 = 0 time = 1640
* CHECK dout0_22 vdout0_22ck163 = 0 time = 1640
* CHECK dout0_23 vdout0_23ck163 = 1.8 time = 1640
* CHECK dout0_24 vdout0_24ck163 = 0 time = 1640
* CHECK dout0_25 vdout0_25ck163 = 0 time = 1640
* CHECK dout0_26 vdout0_26ck163 = 0 time = 1640
* CHECK dout0_27 vdout0_27ck163 = 0 time = 1640
* CHECK dout0_28 vdout0_28ck163 = 0 time = 1640
* CHECK dout0_29 vdout0_29ck163 = 0 time = 1640
* CHECK dout0_30 vdout0_30ck163 = 1.8 time = 1640
* CHECK dout0_31 vdout0_31ck163 = 0 time = 1640
* CHECK dout0_32 vdout0_32ck163 = 0 time = 1640
* CHECK dout0_33 vdout0_33ck163 = 1.8 time = 1640
* CHECK dout0_34 vdout0_34ck163 = 1.8 time = 1640
* CHECK dout0_35 vdout0_35ck163 = 0 time = 1640
* CHECK dout0_36 vdout0_36ck163 = 1.8 time = 1640
* CHECK dout0_37 vdout0_37ck163 = 0 time = 1640
* CHECK dout0_38 vdout0_38ck163 = 1.8 time = 1640
* CHECK dout0_39 vdout0_39ck163 = 0 time = 1640
* CHECK dout0_40 vdout0_40ck163 = 1.8 time = 1640
* CHECK dout0_41 vdout0_41ck163 = 0 time = 1640
* CHECK dout0_42 vdout0_42ck163 = 0 time = 1640
* CHECK dout0_43 vdout0_43ck163 = 0 time = 1640
* CHECK dout0_44 vdout0_44ck163 = 0 time = 1640
* CHECK dout0_45 vdout0_45ck163 = 0 time = 1640
* CHECK dout0_46 vdout0_46ck163 = 0 time = 1640
* CHECK dout0_47 vdout0_47ck163 = 1.8 time = 1640
* CHECK dout0_48 vdout0_48ck163 = 0 time = 1640
* CHECK dout0_49 vdout0_49ck163 = 1.8 time = 1640
* CHECK dout0_50 vdout0_50ck163 = 1.8 time = 1640
* CHECK dout0_51 vdout0_51ck163 = 0 time = 1640
* CHECK dout0_52 vdout0_52ck163 = 0 time = 1640
* CHECK dout0_53 vdout0_53ck163 = 0 time = 1640
* CHECK dout0_54 vdout0_54ck163 = 0 time = 1640
* CHECK dout0_55 vdout0_55ck163 = 0 time = 1640
* CHECK dout0_56 vdout0_56ck163 = 0 time = 1640
* CHECK dout0_57 vdout0_57ck163 = 0 time = 1640
* CHECK dout0_58 vdout0_58ck163 = 1.8 time = 1640
* CHECK dout0_59 vdout0_59ck163 = 1.8 time = 1640
* CHECK dout0_60 vdout0_60ck163 = 1.8 time = 1640
* CHECK dout0_61 vdout0_61ck163 = 1.8 time = 1640
* CHECK dout0_62 vdout0_62ck163 = 1.8 time = 1640
* CHECK dout0_63 vdout0_63ck163 = 1.8 time = 1640
* CHECK dout1_0 vdout1_0ck163 = 0 time = 1640
* CHECK dout1_1 vdout1_1ck163 = 0 time = 1640
* CHECK dout1_2 vdout1_2ck163 = 0 time = 1640
* CHECK dout1_3 vdout1_3ck163 = 1.8 time = 1640
* CHECK dout1_4 vdout1_4ck163 = 0 time = 1640
* CHECK dout1_5 vdout1_5ck163 = 0 time = 1640
* CHECK dout1_6 vdout1_6ck163 = 0 time = 1640
* CHECK dout1_7 vdout1_7ck163 = 0 time = 1640
* CHECK dout1_8 vdout1_8ck163 = 0 time = 1640
* CHECK dout1_9 vdout1_9ck163 = 0 time = 1640
* CHECK dout1_10 vdout1_10ck163 = 1.8 time = 1640
* CHECK dout1_11 vdout1_11ck163 = 1.8 time = 1640
* CHECK dout1_12 vdout1_12ck163 = 0 time = 1640
* CHECK dout1_13 vdout1_13ck163 = 0 time = 1640
* CHECK dout1_14 vdout1_14ck163 = 0 time = 1640
* CHECK dout1_15 vdout1_15ck163 = 0 time = 1640
* CHECK dout1_16 vdout1_16ck163 = 0 time = 1640
* CHECK dout1_17 vdout1_17ck163 = 1.8 time = 1640
* CHECK dout1_18 vdout1_18ck163 = 1.8 time = 1640
* CHECK dout1_19 vdout1_19ck163 = 1.8 time = 1640
* CHECK dout1_20 vdout1_20ck163 = 1.8 time = 1640
* CHECK dout1_21 vdout1_21ck163 = 1.8 time = 1640
* CHECK dout1_22 vdout1_22ck163 = 1.8 time = 1640
* CHECK dout1_23 vdout1_23ck163 = 0 time = 1640
* CHECK dout1_24 vdout1_24ck163 = 0 time = 1640
* CHECK dout1_25 vdout1_25ck163 = 1.8 time = 1640
* CHECK dout1_26 vdout1_26ck163 = 1.8 time = 1640
* CHECK dout1_27 vdout1_27ck163 = 1.8 time = 1640
* CHECK dout1_28 vdout1_28ck163 = 1.8 time = 1640
* CHECK dout1_29 vdout1_29ck163 = 0 time = 1640
* CHECK dout1_30 vdout1_30ck163 = 1.8 time = 1640
* CHECK dout1_31 vdout1_31ck163 = 1.8 time = 1640
* CHECK dout1_32 vdout1_32ck163 = 0 time = 1640
* CHECK dout1_33 vdout1_33ck163 = 0 time = 1640
* CHECK dout1_34 vdout1_34ck163 = 0 time = 1640
* CHECK dout1_35 vdout1_35ck163 = 0 time = 1640
* CHECK dout1_36 vdout1_36ck163 = 1.8 time = 1640
* CHECK dout1_37 vdout1_37ck163 = 0 time = 1640
* CHECK dout1_38 vdout1_38ck163 = 0 time = 1640
* CHECK dout1_39 vdout1_39ck163 = 0 time = 1640
* CHECK dout1_40 vdout1_40ck163 = 1.8 time = 1640
* CHECK dout1_41 vdout1_41ck163 = 0 time = 1640
* CHECK dout1_42 vdout1_42ck163 = 1.8 time = 1640
* CHECK dout1_43 vdout1_43ck163 = 0 time = 1640
* CHECK dout1_44 vdout1_44ck163 = 1.8 time = 1640
* CHECK dout1_45 vdout1_45ck163 = 0 time = 1640
* CHECK dout1_46 vdout1_46ck163 = 0 time = 1640
* CHECK dout1_47 vdout1_47ck163 = 1.8 time = 1640
* CHECK dout1_48 vdout1_48ck163 = 1.8 time = 1640
* CHECK dout1_49 vdout1_49ck163 = 0 time = 1640
* CHECK dout1_50 vdout1_50ck163 = 0 time = 1640
* CHECK dout1_51 vdout1_51ck163 = 1.8 time = 1640
* CHECK dout1_52 vdout1_52ck163 = 0 time = 1640
* CHECK dout1_53 vdout1_53ck163 = 0 time = 1640
* CHECK dout1_54 vdout1_54ck163 = 1.8 time = 1640
* CHECK dout1_55 vdout1_55ck163 = 1.8 time = 1640
* CHECK dout1_56 vdout1_56ck163 = 0 time = 1640
* CHECK dout1_57 vdout1_57ck163 = 0 time = 1640
* CHECK dout1_58 vdout1_58ck163 = 0 time = 1640
* CHECK dout1_59 vdout1_59ck163 = 0 time = 1640
* CHECK dout1_60 vdout1_60ck163 = 0 time = 1640
* CHECK dout1_61 vdout1_61ck163 = 0 time = 1640
* CHECK dout1_62 vdout1_62ck163 = 1.8 time = 1640
* CHECK dout1_63 vdout1_63ck163 = 0 time = 1640
* CHECK dout0_0 vdout0_0ck164 = 0 time = 1650
* CHECK dout0_1 vdout0_1ck164 = 0 time = 1650
* CHECK dout0_2 vdout0_2ck164 = 1.8 time = 1650
* CHECK dout0_3 vdout0_3ck164 = 1.8 time = 1650
* CHECK dout0_4 vdout0_4ck164 = 0 time = 1650
* CHECK dout0_5 vdout0_5ck164 = 1.8 time = 1650
* CHECK dout0_6 vdout0_6ck164 = 0 time = 1650
* CHECK dout0_7 vdout0_7ck164 = 0 time = 1650
* CHECK dout0_8 vdout0_8ck164 = 0 time = 1650
* CHECK dout0_9 vdout0_9ck164 = 0 time = 1650
* CHECK dout0_10 vdout0_10ck164 = 0 time = 1650
* CHECK dout0_11 vdout0_11ck164 = 0 time = 1650
* CHECK dout0_12 vdout0_12ck164 = 0 time = 1650
* CHECK dout0_13 vdout0_13ck164 = 1.8 time = 1650
* CHECK dout0_14 vdout0_14ck164 = 1.8 time = 1650
* CHECK dout0_15 vdout0_15ck164 = 1.8 time = 1650
* CHECK dout0_16 vdout0_16ck164 = 1.8 time = 1650
* CHECK dout0_17 vdout0_17ck164 = 0 time = 1650
* CHECK dout0_18 vdout0_18ck164 = 0 time = 1650
* CHECK dout0_19 vdout0_19ck164 = 0 time = 1650
* CHECK dout0_20 vdout0_20ck164 = 1.8 time = 1650
* CHECK dout0_21 vdout0_21ck164 = 0 time = 1650
* CHECK dout0_22 vdout0_22ck164 = 0 time = 1650
* CHECK dout0_23 vdout0_23ck164 = 1.8 time = 1650
* CHECK dout0_24 vdout0_24ck164 = 0 time = 1650
* CHECK dout0_25 vdout0_25ck164 = 0 time = 1650
* CHECK dout0_26 vdout0_26ck164 = 0 time = 1650
* CHECK dout0_27 vdout0_27ck164 = 0 time = 1650
* CHECK dout0_28 vdout0_28ck164 = 0 time = 1650
* CHECK dout0_29 vdout0_29ck164 = 0 time = 1650
* CHECK dout0_30 vdout0_30ck164 = 1.8 time = 1650
* CHECK dout0_31 vdout0_31ck164 = 0 time = 1650
* CHECK dout0_32 vdout0_32ck164 = 0 time = 1650
* CHECK dout0_33 vdout0_33ck164 = 1.8 time = 1650
* CHECK dout0_34 vdout0_34ck164 = 1.8 time = 1650
* CHECK dout0_35 vdout0_35ck164 = 0 time = 1650
* CHECK dout0_36 vdout0_36ck164 = 1.8 time = 1650
* CHECK dout0_37 vdout0_37ck164 = 0 time = 1650
* CHECK dout0_38 vdout0_38ck164 = 1.8 time = 1650
* CHECK dout0_39 vdout0_39ck164 = 0 time = 1650
* CHECK dout0_40 vdout0_40ck164 = 1.8 time = 1650
* CHECK dout0_41 vdout0_41ck164 = 0 time = 1650
* CHECK dout0_42 vdout0_42ck164 = 0 time = 1650
* CHECK dout0_43 vdout0_43ck164 = 0 time = 1650
* CHECK dout0_44 vdout0_44ck164 = 0 time = 1650
* CHECK dout0_45 vdout0_45ck164 = 0 time = 1650
* CHECK dout0_46 vdout0_46ck164 = 0 time = 1650
* CHECK dout0_47 vdout0_47ck164 = 1.8 time = 1650
* CHECK dout0_48 vdout0_48ck164 = 0 time = 1650
* CHECK dout0_49 vdout0_49ck164 = 1.8 time = 1650
* CHECK dout0_50 vdout0_50ck164 = 1.8 time = 1650
* CHECK dout0_51 vdout0_51ck164 = 0 time = 1650
* CHECK dout0_52 vdout0_52ck164 = 0 time = 1650
* CHECK dout0_53 vdout0_53ck164 = 0 time = 1650
* CHECK dout0_54 vdout0_54ck164 = 0 time = 1650
* CHECK dout0_55 vdout0_55ck164 = 0 time = 1650
* CHECK dout0_56 vdout0_56ck164 = 0 time = 1650
* CHECK dout0_57 vdout0_57ck164 = 0 time = 1650
* CHECK dout0_58 vdout0_58ck164 = 1.8 time = 1650
* CHECK dout0_59 vdout0_59ck164 = 1.8 time = 1650
* CHECK dout0_60 vdout0_60ck164 = 1.8 time = 1650
* CHECK dout0_61 vdout0_61ck164 = 1.8 time = 1650
* CHECK dout0_62 vdout0_62ck164 = 1.8 time = 1650
* CHECK dout0_63 vdout0_63ck164 = 1.8 time = 1650
* CHECK dout0_0 vdout0_0ck165 = 0 time = 1660
* CHECK dout0_1 vdout0_1ck165 = 0 time = 1660
* CHECK dout0_2 vdout0_2ck165 = 0 time = 1660
* CHECK dout0_3 vdout0_3ck165 = 1.8 time = 1660
* CHECK dout0_4 vdout0_4ck165 = 0 time = 1660
* CHECK dout0_5 vdout0_5ck165 = 0 time = 1660
* CHECK dout0_6 vdout0_6ck165 = 0 time = 1660
* CHECK dout0_7 vdout0_7ck165 = 0 time = 1660
* CHECK dout0_8 vdout0_8ck165 = 0 time = 1660
* CHECK dout0_9 vdout0_9ck165 = 0 time = 1660
* CHECK dout0_10 vdout0_10ck165 = 1.8 time = 1660
* CHECK dout0_11 vdout0_11ck165 = 1.8 time = 1660
* CHECK dout0_12 vdout0_12ck165 = 0 time = 1660
* CHECK dout0_13 vdout0_13ck165 = 0 time = 1660
* CHECK dout0_14 vdout0_14ck165 = 0 time = 1660
* CHECK dout0_15 vdout0_15ck165 = 0 time = 1660
* CHECK dout0_16 vdout0_16ck165 = 0 time = 1660
* CHECK dout0_17 vdout0_17ck165 = 1.8 time = 1660
* CHECK dout0_18 vdout0_18ck165 = 1.8 time = 1660
* CHECK dout0_19 vdout0_19ck165 = 1.8 time = 1660
* CHECK dout0_20 vdout0_20ck165 = 1.8 time = 1660
* CHECK dout0_21 vdout0_21ck165 = 1.8 time = 1660
* CHECK dout0_22 vdout0_22ck165 = 1.8 time = 1660
* CHECK dout0_23 vdout0_23ck165 = 0 time = 1660
* CHECK dout0_24 vdout0_24ck165 = 0 time = 1660
* CHECK dout0_25 vdout0_25ck165 = 1.8 time = 1660
* CHECK dout0_26 vdout0_26ck165 = 1.8 time = 1660
* CHECK dout0_27 vdout0_27ck165 = 1.8 time = 1660
* CHECK dout0_28 vdout0_28ck165 = 1.8 time = 1660
* CHECK dout0_29 vdout0_29ck165 = 0 time = 1660
* CHECK dout0_30 vdout0_30ck165 = 1.8 time = 1660
* CHECK dout0_31 vdout0_31ck165 = 1.8 time = 1660
* CHECK dout0_32 vdout0_32ck165 = 0 time = 1660
* CHECK dout0_33 vdout0_33ck165 = 0 time = 1660
* CHECK dout0_34 vdout0_34ck165 = 0 time = 1660
* CHECK dout0_35 vdout0_35ck165 = 0 time = 1660
* CHECK dout0_36 vdout0_36ck165 = 1.8 time = 1660
* CHECK dout0_37 vdout0_37ck165 = 0 time = 1660
* CHECK dout0_38 vdout0_38ck165 = 0 time = 1660
* CHECK dout0_39 vdout0_39ck165 = 0 time = 1660
* CHECK dout0_40 vdout0_40ck165 = 1.8 time = 1660
* CHECK dout0_41 vdout0_41ck165 = 0 time = 1660
* CHECK dout0_42 vdout0_42ck165 = 1.8 time = 1660
* CHECK dout0_43 vdout0_43ck165 = 0 time = 1660
* CHECK dout0_44 vdout0_44ck165 = 1.8 time = 1660
* CHECK dout0_45 vdout0_45ck165 = 0 time = 1660
* CHECK dout0_46 vdout0_46ck165 = 0 time = 1660
* CHECK dout0_47 vdout0_47ck165 = 1.8 time = 1660
* CHECK dout0_48 vdout0_48ck165 = 1.8 time = 1660
* CHECK dout0_49 vdout0_49ck165 = 0 time = 1660
* CHECK dout0_50 vdout0_50ck165 = 0 time = 1660
* CHECK dout0_51 vdout0_51ck165 = 1.8 time = 1660
* CHECK dout0_52 vdout0_52ck165 = 0 time = 1660
* CHECK dout0_53 vdout0_53ck165 = 0 time = 1660
* CHECK dout0_54 vdout0_54ck165 = 1.8 time = 1660
* CHECK dout0_55 vdout0_55ck165 = 1.8 time = 1660
* CHECK dout0_56 vdout0_56ck165 = 0 time = 1660
* CHECK dout0_57 vdout0_57ck165 = 0 time = 1660
* CHECK dout0_58 vdout0_58ck165 = 0 time = 1660
* CHECK dout0_59 vdout0_59ck165 = 0 time = 1660
* CHECK dout0_60 vdout0_60ck165 = 0 time = 1660
* CHECK dout0_61 vdout0_61ck165 = 0 time = 1660
* CHECK dout0_62 vdout0_62ck165 = 1.8 time = 1660
* CHECK dout0_63 vdout0_63ck165 = 0 time = 1660
* CHECK dout1_0 vdout1_0ck166 = 0 time = 1670
* CHECK dout1_1 vdout1_1ck166 = 0 time = 1670
* CHECK dout1_2 vdout1_2ck166 = 0 time = 1670
* CHECK dout1_3 vdout1_3ck166 = 1.8 time = 1670
* CHECK dout1_4 vdout1_4ck166 = 0 time = 1670
* CHECK dout1_5 vdout1_5ck166 = 0 time = 1670
* CHECK dout1_6 vdout1_6ck166 = 0 time = 1670
* CHECK dout1_7 vdout1_7ck166 = 0 time = 1670
* CHECK dout1_8 vdout1_8ck166 = 0 time = 1670
* CHECK dout1_9 vdout1_9ck166 = 0 time = 1670
* CHECK dout1_10 vdout1_10ck166 = 1.8 time = 1670
* CHECK dout1_11 vdout1_11ck166 = 1.8 time = 1670
* CHECK dout1_12 vdout1_12ck166 = 0 time = 1670
* CHECK dout1_13 vdout1_13ck166 = 0 time = 1670
* CHECK dout1_14 vdout1_14ck166 = 0 time = 1670
* CHECK dout1_15 vdout1_15ck166 = 0 time = 1670
* CHECK dout1_16 vdout1_16ck166 = 0 time = 1670
* CHECK dout1_17 vdout1_17ck166 = 1.8 time = 1670
* CHECK dout1_18 vdout1_18ck166 = 1.8 time = 1670
* CHECK dout1_19 vdout1_19ck166 = 1.8 time = 1670
* CHECK dout1_20 vdout1_20ck166 = 1.8 time = 1670
* CHECK dout1_21 vdout1_21ck166 = 1.8 time = 1670
* CHECK dout1_22 vdout1_22ck166 = 1.8 time = 1670
* CHECK dout1_23 vdout1_23ck166 = 0 time = 1670
* CHECK dout1_24 vdout1_24ck166 = 0 time = 1670
* CHECK dout1_25 vdout1_25ck166 = 1.8 time = 1670
* CHECK dout1_26 vdout1_26ck166 = 1.8 time = 1670
* CHECK dout1_27 vdout1_27ck166 = 1.8 time = 1670
* CHECK dout1_28 vdout1_28ck166 = 1.8 time = 1670
* CHECK dout1_29 vdout1_29ck166 = 0 time = 1670
* CHECK dout1_30 vdout1_30ck166 = 1.8 time = 1670
* CHECK dout1_31 vdout1_31ck166 = 1.8 time = 1670
* CHECK dout1_32 vdout1_32ck166 = 0 time = 1670
* CHECK dout1_33 vdout1_33ck166 = 0 time = 1670
* CHECK dout1_34 vdout1_34ck166 = 0 time = 1670
* CHECK dout1_35 vdout1_35ck166 = 0 time = 1670
* CHECK dout1_36 vdout1_36ck166 = 1.8 time = 1670
* CHECK dout1_37 vdout1_37ck166 = 0 time = 1670
* CHECK dout1_38 vdout1_38ck166 = 0 time = 1670
* CHECK dout1_39 vdout1_39ck166 = 0 time = 1670
* CHECK dout1_40 vdout1_40ck166 = 1.8 time = 1670
* CHECK dout1_41 vdout1_41ck166 = 0 time = 1670
* CHECK dout1_42 vdout1_42ck166 = 1.8 time = 1670
* CHECK dout1_43 vdout1_43ck166 = 0 time = 1670
* CHECK dout1_44 vdout1_44ck166 = 1.8 time = 1670
* CHECK dout1_45 vdout1_45ck166 = 0 time = 1670
* CHECK dout1_46 vdout1_46ck166 = 0 time = 1670
* CHECK dout1_47 vdout1_47ck166 = 1.8 time = 1670
* CHECK dout1_48 vdout1_48ck166 = 1.8 time = 1670
* CHECK dout1_49 vdout1_49ck166 = 0 time = 1670
* CHECK dout1_50 vdout1_50ck166 = 0 time = 1670
* CHECK dout1_51 vdout1_51ck166 = 1.8 time = 1670
* CHECK dout1_52 vdout1_52ck166 = 0 time = 1670
* CHECK dout1_53 vdout1_53ck166 = 0 time = 1670
* CHECK dout1_54 vdout1_54ck166 = 1.8 time = 1670
* CHECK dout1_55 vdout1_55ck166 = 1.8 time = 1670
* CHECK dout1_56 vdout1_56ck166 = 0 time = 1670
* CHECK dout1_57 vdout1_57ck166 = 0 time = 1670
* CHECK dout1_58 vdout1_58ck166 = 0 time = 1670
* CHECK dout1_59 vdout1_59ck166 = 0 time = 1670
* CHECK dout1_60 vdout1_60ck166 = 0 time = 1670
* CHECK dout1_61 vdout1_61ck166 = 0 time = 1670
* CHECK dout1_62 vdout1_62ck166 = 1.8 time = 1670
* CHECK dout1_63 vdout1_63ck166 = 0 time = 1670
* CHECK dout0_0 vdout0_0ck168 = 0 time = 1690
* CHECK dout0_1 vdout0_1ck168 = 1.8 time = 1690
* CHECK dout0_2 vdout0_2ck168 = 1.8 time = 1690
* CHECK dout0_3 vdout0_3ck168 = 1.8 time = 1690
* CHECK dout0_4 vdout0_4ck168 = 1.8 time = 1690
* CHECK dout0_5 vdout0_5ck168 = 1.8 time = 1690
* CHECK dout0_6 vdout0_6ck168 = 0 time = 1690
* CHECK dout0_7 vdout0_7ck168 = 0 time = 1690
* CHECK dout0_8 vdout0_8ck168 = 1.8 time = 1690
* CHECK dout0_9 vdout0_9ck168 = 0 time = 1690
* CHECK dout0_10 vdout0_10ck168 = 1.8 time = 1690
* CHECK dout0_11 vdout0_11ck168 = 1.8 time = 1690
* CHECK dout0_12 vdout0_12ck168 = 1.8 time = 1690
* CHECK dout0_13 vdout0_13ck168 = 0 time = 1690
* CHECK dout0_14 vdout0_14ck168 = 0 time = 1690
* CHECK dout0_15 vdout0_15ck168 = 0 time = 1690
* CHECK dout0_16 vdout0_16ck168 = 1.8 time = 1690
* CHECK dout0_17 vdout0_17ck168 = 1.8 time = 1690
* CHECK dout0_18 vdout0_18ck168 = 1.8 time = 1690
* CHECK dout0_19 vdout0_19ck168 = 0 time = 1690
* CHECK dout0_20 vdout0_20ck168 = 0 time = 1690
* CHECK dout0_21 vdout0_21ck168 = 0 time = 1690
* CHECK dout0_22 vdout0_22ck168 = 0 time = 1690
* CHECK dout0_23 vdout0_23ck168 = 0 time = 1690
* CHECK dout0_24 vdout0_24ck168 = 0 time = 1690
* CHECK dout0_25 vdout0_25ck168 = 1.8 time = 1690
* CHECK dout0_26 vdout0_26ck168 = 1.8 time = 1690
* CHECK dout0_27 vdout0_27ck168 = 1.8 time = 1690
* CHECK dout0_28 vdout0_28ck168 = 1.8 time = 1690
* CHECK dout0_29 vdout0_29ck168 = 1.8 time = 1690
* CHECK dout0_30 vdout0_30ck168 = 1.8 time = 1690
* CHECK dout0_31 vdout0_31ck168 = 1.8 time = 1690
* CHECK dout0_32 vdout0_32ck168 = 0 time = 1690
* CHECK dout0_33 vdout0_33ck168 = 0 time = 1690
* CHECK dout0_34 vdout0_34ck168 = 0 time = 1690
* CHECK dout0_35 vdout0_35ck168 = 1.8 time = 1690
* CHECK dout0_36 vdout0_36ck168 = 1.8 time = 1690
* CHECK dout0_37 vdout0_37ck168 = 1.8 time = 1690
* CHECK dout0_38 vdout0_38ck168 = 0 time = 1690
* CHECK dout0_39 vdout0_39ck168 = 1.8 time = 1690
* CHECK dout0_40 vdout0_40ck168 = 1.8 time = 1690
* CHECK dout0_41 vdout0_41ck168 = 1.8 time = 1690
* CHECK dout0_42 vdout0_42ck168 = 0 time = 1690
* CHECK dout0_43 vdout0_43ck168 = 1.8 time = 1690
* CHECK dout0_44 vdout0_44ck168 = 1.8 time = 1690
* CHECK dout0_45 vdout0_45ck168 = 0 time = 1690
* CHECK dout0_46 vdout0_46ck168 = 0 time = 1690
* CHECK dout0_47 vdout0_47ck168 = 0 time = 1690
* CHECK dout0_48 vdout0_48ck168 = 0 time = 1690
* CHECK dout0_49 vdout0_49ck168 = 1.8 time = 1690
* CHECK dout0_50 vdout0_50ck168 = 0 time = 1690
* CHECK dout0_51 vdout0_51ck168 = 0 time = 1690
* CHECK dout0_52 vdout0_52ck168 = 0 time = 1690
* CHECK dout0_53 vdout0_53ck168 = 0 time = 1690
* CHECK dout0_54 vdout0_54ck168 = 0 time = 1690
* CHECK dout0_55 vdout0_55ck168 = 0 time = 1690
* CHECK dout0_56 vdout0_56ck168 = 0 time = 1690
* CHECK dout0_57 vdout0_57ck168 = 0 time = 1690
* CHECK dout0_58 vdout0_58ck168 = 0 time = 1690
* CHECK dout0_59 vdout0_59ck168 = 0 time = 1690
* CHECK dout0_60 vdout0_60ck168 = 1.8 time = 1690
* CHECK dout0_61 vdout0_61ck168 = 1.8 time = 1690
* CHECK dout0_62 vdout0_62ck168 = 1.8 time = 1690
* CHECK dout0_63 vdout0_63ck168 = 1.8 time = 1690
* CHECK dout0_0 vdout0_0ck170 = 0 time = 1710
* CHECK dout0_1 vdout0_1ck170 = 1.8 time = 1710
* CHECK dout0_2 vdout0_2ck170 = 1.8 time = 1710
* CHECK dout0_3 vdout0_3ck170 = 1.8 time = 1710
* CHECK dout0_4 vdout0_4ck170 = 1.8 time = 1710
* CHECK dout0_5 vdout0_5ck170 = 0 time = 1710
* CHECK dout0_6 vdout0_6ck170 = 0 time = 1710
* CHECK dout0_7 vdout0_7ck170 = 0 time = 1710
* CHECK dout0_8 vdout0_8ck170 = 1.8 time = 1710
* CHECK dout0_9 vdout0_9ck170 = 0 time = 1710
* CHECK dout0_10 vdout0_10ck170 = 0 time = 1710
* CHECK dout0_11 vdout0_11ck170 = 1.8 time = 1710
* CHECK dout0_12 vdout0_12ck170 = 0 time = 1710
* CHECK dout0_13 vdout0_13ck170 = 0 time = 1710
* CHECK dout0_14 vdout0_14ck170 = 1.8 time = 1710
* CHECK dout0_15 vdout0_15ck170 = 0 time = 1710
* CHECK dout0_16 vdout0_16ck170 = 1.8 time = 1710
* CHECK dout0_17 vdout0_17ck170 = 0 time = 1710
* CHECK dout0_18 vdout0_18ck170 = 0 time = 1710
* CHECK dout0_19 vdout0_19ck170 = 1.8 time = 1710
* CHECK dout0_20 vdout0_20ck170 = 1.8 time = 1710
* CHECK dout0_21 vdout0_21ck170 = 0 time = 1710
* CHECK dout0_22 vdout0_22ck170 = 0 time = 1710
* CHECK dout0_23 vdout0_23ck170 = 1.8 time = 1710
* CHECK dout0_24 vdout0_24ck170 = 0 time = 1710
* CHECK dout0_25 vdout0_25ck170 = 1.8 time = 1710
* CHECK dout0_26 vdout0_26ck170 = 0 time = 1710
* CHECK dout0_27 vdout0_27ck170 = 1.8 time = 1710
* CHECK dout0_28 vdout0_28ck170 = 0 time = 1710
* CHECK dout0_29 vdout0_29ck170 = 0 time = 1710
* CHECK dout0_30 vdout0_30ck170 = 0 time = 1710
* CHECK dout0_31 vdout0_31ck170 = 1.8 time = 1710
* CHECK dout0_32 vdout0_32ck170 = 0 time = 1710
* CHECK dout0_33 vdout0_33ck170 = 1.8 time = 1710
* CHECK dout0_34 vdout0_34ck170 = 1.8 time = 1710
* CHECK dout0_35 vdout0_35ck170 = 0 time = 1710
* CHECK dout0_36 vdout0_36ck170 = 0 time = 1710
* CHECK dout0_37 vdout0_37ck170 = 0 time = 1710
* CHECK dout0_38 vdout0_38ck170 = 0 time = 1710
* CHECK dout0_39 vdout0_39ck170 = 0 time = 1710
* CHECK dout0_40 vdout0_40ck170 = 1.8 time = 1710
* CHECK dout0_41 vdout0_41ck170 = 1.8 time = 1710
* CHECK dout0_42 vdout0_42ck170 = 0 time = 1710
* CHECK dout0_43 vdout0_43ck170 = 0 time = 1710
* CHECK dout0_44 vdout0_44ck170 = 0 time = 1710
* CHECK dout0_45 vdout0_45ck170 = 0 time = 1710
* CHECK dout0_46 vdout0_46ck170 = 1.8 time = 1710
* CHECK dout0_47 vdout0_47ck170 = 0 time = 1710
* CHECK dout0_48 vdout0_48ck170 = 0 time = 1710
* CHECK dout0_49 vdout0_49ck170 = 0 time = 1710
* CHECK dout0_50 vdout0_50ck170 = 1.8 time = 1710
* CHECK dout0_51 vdout0_51ck170 = 0 time = 1710
* CHECK dout0_52 vdout0_52ck170 = 0 time = 1710
* CHECK dout0_53 vdout0_53ck170 = 1.8 time = 1710
* CHECK dout0_54 vdout0_54ck170 = 0 time = 1710
* CHECK dout0_55 vdout0_55ck170 = 0 time = 1710
* CHECK dout0_56 vdout0_56ck170 = 0 time = 1710
* CHECK dout0_57 vdout0_57ck170 = 0 time = 1710
* CHECK dout0_58 vdout0_58ck170 = 0 time = 1710
* CHECK dout0_59 vdout0_59ck170 = 0 time = 1710
* CHECK dout0_60 vdout0_60ck170 = 1.8 time = 1710
* CHECK dout0_61 vdout0_61ck170 = 0 time = 1710
* CHECK dout0_62 vdout0_62ck170 = 0 time = 1710
* CHECK dout0_63 vdout0_63ck170 = 1.8 time = 1710
* CHECK dout0_0 vdout0_0ck172 = 0 time = 1730
* CHECK dout0_1 vdout0_1ck172 = 0 time = 1730
* CHECK dout0_2 vdout0_2ck172 = 0 time = 1730
* CHECK dout0_3 vdout0_3ck172 = 1.8 time = 1730
* CHECK dout0_4 vdout0_4ck172 = 0 time = 1730
* CHECK dout0_5 vdout0_5ck172 = 0 time = 1730
* CHECK dout0_6 vdout0_6ck172 = 0 time = 1730
* CHECK dout0_7 vdout0_7ck172 = 0 time = 1730
* CHECK dout0_8 vdout0_8ck172 = 0 time = 1730
* CHECK dout0_9 vdout0_9ck172 = 0 time = 1730
* CHECK dout0_10 vdout0_10ck172 = 1.8 time = 1730
* CHECK dout0_11 vdout0_11ck172 = 1.8 time = 1730
* CHECK dout0_12 vdout0_12ck172 = 0 time = 1730
* CHECK dout0_13 vdout0_13ck172 = 0 time = 1730
* CHECK dout0_14 vdout0_14ck172 = 0 time = 1730
* CHECK dout0_15 vdout0_15ck172 = 0 time = 1730
* CHECK dout0_16 vdout0_16ck172 = 0 time = 1730
* CHECK dout0_17 vdout0_17ck172 = 1.8 time = 1730
* CHECK dout0_18 vdout0_18ck172 = 1.8 time = 1730
* CHECK dout0_19 vdout0_19ck172 = 1.8 time = 1730
* CHECK dout0_20 vdout0_20ck172 = 1.8 time = 1730
* CHECK dout0_21 vdout0_21ck172 = 1.8 time = 1730
* CHECK dout0_22 vdout0_22ck172 = 1.8 time = 1730
* CHECK dout0_23 vdout0_23ck172 = 0 time = 1730
* CHECK dout0_24 vdout0_24ck172 = 0 time = 1730
* CHECK dout0_25 vdout0_25ck172 = 1.8 time = 1730
* CHECK dout0_26 vdout0_26ck172 = 1.8 time = 1730
* CHECK dout0_27 vdout0_27ck172 = 1.8 time = 1730
* CHECK dout0_28 vdout0_28ck172 = 1.8 time = 1730
* CHECK dout0_29 vdout0_29ck172 = 0 time = 1730
* CHECK dout0_30 vdout0_30ck172 = 1.8 time = 1730
* CHECK dout0_31 vdout0_31ck172 = 1.8 time = 1730
* CHECK dout0_32 vdout0_32ck172 = 0 time = 1730
* CHECK dout0_33 vdout0_33ck172 = 0 time = 1730
* CHECK dout0_34 vdout0_34ck172 = 0 time = 1730
* CHECK dout0_35 vdout0_35ck172 = 0 time = 1730
* CHECK dout0_36 vdout0_36ck172 = 1.8 time = 1730
* CHECK dout0_37 vdout0_37ck172 = 0 time = 1730
* CHECK dout0_38 vdout0_38ck172 = 0 time = 1730
* CHECK dout0_39 vdout0_39ck172 = 0 time = 1730
* CHECK dout0_40 vdout0_40ck172 = 1.8 time = 1730
* CHECK dout0_41 vdout0_41ck172 = 0 time = 1730
* CHECK dout0_42 vdout0_42ck172 = 1.8 time = 1730
* CHECK dout0_43 vdout0_43ck172 = 0 time = 1730
* CHECK dout0_44 vdout0_44ck172 = 1.8 time = 1730
* CHECK dout0_45 vdout0_45ck172 = 0 time = 1730
* CHECK dout0_46 vdout0_46ck172 = 0 time = 1730
* CHECK dout0_47 vdout0_47ck172 = 1.8 time = 1730
* CHECK dout0_48 vdout0_48ck172 = 1.8 time = 1730
* CHECK dout0_49 vdout0_49ck172 = 0 time = 1730
* CHECK dout0_50 vdout0_50ck172 = 0 time = 1730
* CHECK dout0_51 vdout0_51ck172 = 1.8 time = 1730
* CHECK dout0_52 vdout0_52ck172 = 0 time = 1730
* CHECK dout0_53 vdout0_53ck172 = 0 time = 1730
* CHECK dout0_54 vdout0_54ck172 = 1.8 time = 1730
* CHECK dout0_55 vdout0_55ck172 = 1.8 time = 1730
* CHECK dout0_56 vdout0_56ck172 = 0 time = 1730
* CHECK dout0_57 vdout0_57ck172 = 0 time = 1730
* CHECK dout0_58 vdout0_58ck172 = 0 time = 1730
* CHECK dout0_59 vdout0_59ck172 = 0 time = 1730
* CHECK dout0_60 vdout0_60ck172 = 0 time = 1730
* CHECK dout0_61 vdout0_61ck172 = 0 time = 1730
* CHECK dout0_62 vdout0_62ck172 = 1.8 time = 1730
* CHECK dout0_63 vdout0_63ck172 = 0 time = 1730
* CHECK dout1_0 vdout1_0ck173 = 0 time = 1740
* CHECK dout1_1 vdout1_1ck173 = 1.8 time = 1740
* CHECK dout1_2 vdout1_2ck173 = 1.8 time = 1740
* CHECK dout1_3 vdout1_3ck173 = 1.8 time = 1740
* CHECK dout1_4 vdout1_4ck173 = 1.8 time = 1740
* CHECK dout1_5 vdout1_5ck173 = 0 time = 1740
* CHECK dout1_6 vdout1_6ck173 = 0 time = 1740
* CHECK dout1_7 vdout1_7ck173 = 0 time = 1740
* CHECK dout1_8 vdout1_8ck173 = 1.8 time = 1740
* CHECK dout1_9 vdout1_9ck173 = 0 time = 1740
* CHECK dout1_10 vdout1_10ck173 = 0 time = 1740
* CHECK dout1_11 vdout1_11ck173 = 1.8 time = 1740
* CHECK dout1_12 vdout1_12ck173 = 0 time = 1740
* CHECK dout1_13 vdout1_13ck173 = 0 time = 1740
* CHECK dout1_14 vdout1_14ck173 = 1.8 time = 1740
* CHECK dout1_15 vdout1_15ck173 = 0 time = 1740
* CHECK dout1_16 vdout1_16ck173 = 1.8 time = 1740
* CHECK dout1_17 vdout1_17ck173 = 0 time = 1740
* CHECK dout1_18 vdout1_18ck173 = 0 time = 1740
* CHECK dout1_19 vdout1_19ck173 = 1.8 time = 1740
* CHECK dout1_20 vdout1_20ck173 = 1.8 time = 1740
* CHECK dout1_21 vdout1_21ck173 = 0 time = 1740
* CHECK dout1_22 vdout1_22ck173 = 0 time = 1740
* CHECK dout1_23 vdout1_23ck173 = 1.8 time = 1740
* CHECK dout1_24 vdout1_24ck173 = 0 time = 1740
* CHECK dout1_25 vdout1_25ck173 = 1.8 time = 1740
* CHECK dout1_26 vdout1_26ck173 = 0 time = 1740
* CHECK dout1_27 vdout1_27ck173 = 1.8 time = 1740
* CHECK dout1_28 vdout1_28ck173 = 0 time = 1740
* CHECK dout1_29 vdout1_29ck173 = 0 time = 1740
* CHECK dout1_30 vdout1_30ck173 = 0 time = 1740
* CHECK dout1_31 vdout1_31ck173 = 1.8 time = 1740
* CHECK dout1_32 vdout1_32ck173 = 0 time = 1740
* CHECK dout1_33 vdout1_33ck173 = 1.8 time = 1740
* CHECK dout1_34 vdout1_34ck173 = 1.8 time = 1740
* CHECK dout1_35 vdout1_35ck173 = 0 time = 1740
* CHECK dout1_36 vdout1_36ck173 = 0 time = 1740
* CHECK dout1_37 vdout1_37ck173 = 0 time = 1740
* CHECK dout1_38 vdout1_38ck173 = 0 time = 1740
* CHECK dout1_39 vdout1_39ck173 = 0 time = 1740
* CHECK dout1_40 vdout1_40ck173 = 1.8 time = 1740
* CHECK dout1_41 vdout1_41ck173 = 1.8 time = 1740
* CHECK dout1_42 vdout1_42ck173 = 0 time = 1740
* CHECK dout1_43 vdout1_43ck173 = 0 time = 1740
* CHECK dout1_44 vdout1_44ck173 = 0 time = 1740
* CHECK dout1_45 vdout1_45ck173 = 0 time = 1740
* CHECK dout1_46 vdout1_46ck173 = 1.8 time = 1740
* CHECK dout1_47 vdout1_47ck173 = 0 time = 1740
* CHECK dout1_48 vdout1_48ck173 = 0 time = 1740
* CHECK dout1_49 vdout1_49ck173 = 0 time = 1740
* CHECK dout1_50 vdout1_50ck173 = 1.8 time = 1740
* CHECK dout1_51 vdout1_51ck173 = 0 time = 1740
* CHECK dout1_52 vdout1_52ck173 = 0 time = 1740
* CHECK dout1_53 vdout1_53ck173 = 1.8 time = 1740
* CHECK dout1_54 vdout1_54ck173 = 0 time = 1740
* CHECK dout1_55 vdout1_55ck173 = 0 time = 1740
* CHECK dout1_56 vdout1_56ck173 = 0 time = 1740
* CHECK dout1_57 vdout1_57ck173 = 0 time = 1740
* CHECK dout1_58 vdout1_58ck173 = 0 time = 1740
* CHECK dout1_59 vdout1_59ck173 = 0 time = 1740
* CHECK dout1_60 vdout1_60ck173 = 1.8 time = 1740
* CHECK dout1_61 vdout1_61ck173 = 0 time = 1740
* CHECK dout1_62 vdout1_62ck173 = 0 time = 1740
* CHECK dout1_63 vdout1_63ck173 = 1.8 time = 1740
* CHECK dout1_0 vdout1_0ck174 = 0 time = 1750
* CHECK dout1_1 vdout1_1ck174 = 0 time = 1750
* CHECK dout1_2 vdout1_2ck174 = 0 time = 1750
* CHECK dout1_3 vdout1_3ck174 = 1.8 time = 1750
* CHECK dout1_4 vdout1_4ck174 = 1.8 time = 1750
* CHECK dout1_5 vdout1_5ck174 = 1.8 time = 1750
* CHECK dout1_6 vdout1_6ck174 = 1.8 time = 1750
* CHECK dout1_7 vdout1_7ck174 = 1.8 time = 1750
* CHECK dout1_8 vdout1_8ck174 = 0 time = 1750
* CHECK dout1_9 vdout1_9ck174 = 0 time = 1750
* CHECK dout1_10 vdout1_10ck174 = 0 time = 1750
* CHECK dout1_11 vdout1_11ck174 = 0 time = 1750
* CHECK dout1_12 vdout1_12ck174 = 1.8 time = 1750
* CHECK dout1_13 vdout1_13ck174 = 1.8 time = 1750
* CHECK dout1_14 vdout1_14ck174 = 1.8 time = 1750
* CHECK dout1_15 vdout1_15ck174 = 0 time = 1750
* CHECK dout1_16 vdout1_16ck174 = 0 time = 1750
* CHECK dout1_17 vdout1_17ck174 = 0 time = 1750
* CHECK dout1_18 vdout1_18ck174 = 1.8 time = 1750
* CHECK dout1_19 vdout1_19ck174 = 1.8 time = 1750
* CHECK dout1_20 vdout1_20ck174 = 0 time = 1750
* CHECK dout1_21 vdout1_21ck174 = 0 time = 1750
* CHECK dout1_22 vdout1_22ck174 = 0 time = 1750
* CHECK dout1_23 vdout1_23ck174 = 0 time = 1750
* CHECK dout1_24 vdout1_24ck174 = 1.8 time = 1750
* CHECK dout1_25 vdout1_25ck174 = 0 time = 1750
* CHECK dout1_26 vdout1_26ck174 = 1.8 time = 1750
* CHECK dout1_27 vdout1_27ck174 = 1.8 time = 1750
* CHECK dout1_28 vdout1_28ck174 = 1.8 time = 1750
* CHECK dout1_29 vdout1_29ck174 = 1.8 time = 1750
* CHECK dout1_30 vdout1_30ck174 = 0 time = 1750
* CHECK dout1_31 vdout1_31ck174 = 0 time = 1750
* CHECK dout1_32 vdout1_32ck174 = 0 time = 1750
* CHECK dout1_33 vdout1_33ck174 = 1.8 time = 1750
* CHECK dout1_34 vdout1_34ck174 = 1.8 time = 1750
* CHECK dout1_35 vdout1_35ck174 = 1.8 time = 1750
* CHECK dout1_36 vdout1_36ck174 = 1.8 time = 1750
* CHECK dout1_37 vdout1_37ck174 = 1.8 time = 1750
* CHECK dout1_38 vdout1_38ck174 = 0 time = 1750
* CHECK dout1_39 vdout1_39ck174 = 1.8 time = 1750
* CHECK dout1_40 vdout1_40ck174 = 0 time = 1750
* CHECK dout1_41 vdout1_41ck174 = 1.8 time = 1750
* CHECK dout1_42 vdout1_42ck174 = 0 time = 1750
* CHECK dout1_43 vdout1_43ck174 = 1.8 time = 1750
* CHECK dout1_44 vdout1_44ck174 = 0 time = 1750
* CHECK dout1_45 vdout1_45ck174 = 1.8 time = 1750
* CHECK dout1_46 vdout1_46ck174 = 0 time = 1750
* CHECK dout1_47 vdout1_47ck174 = 1.8 time = 1750
* CHECK dout1_48 vdout1_48ck174 = 0 time = 1750
* CHECK dout1_49 vdout1_49ck174 = 1.8 time = 1750
* CHECK dout1_50 vdout1_50ck174 = 0 time = 1750
* CHECK dout1_51 vdout1_51ck174 = 1.8 time = 1750
* CHECK dout1_52 vdout1_52ck174 = 0 time = 1750
* CHECK dout1_53 vdout1_53ck174 = 0 time = 1750
* CHECK dout1_54 vdout1_54ck174 = 1.8 time = 1750
* CHECK dout1_55 vdout1_55ck174 = 1.8 time = 1750
* CHECK dout1_56 vdout1_56ck174 = 1.8 time = 1750
* CHECK dout1_57 vdout1_57ck174 = 1.8 time = 1750
* CHECK dout1_58 vdout1_58ck174 = 1.8 time = 1750
* CHECK dout1_59 vdout1_59ck174 = 0 time = 1750
* CHECK dout1_60 vdout1_60ck174 = 0 time = 1750
* CHECK dout1_61 vdout1_61ck174 = 0 time = 1750
* CHECK dout1_62 vdout1_62ck174 = 0 time = 1750
* CHECK dout1_63 vdout1_63ck174 = 0 time = 1750
* CHECK dout0_0 vdout0_0ck176 = 0 time = 1770
* CHECK dout0_1 vdout0_1ck176 = 0 time = 1770
* CHECK dout0_2 vdout0_2ck176 = 0 time = 1770
* CHECK dout0_3 vdout0_3ck176 = 1.8 time = 1770
* CHECK dout0_4 vdout0_4ck176 = 1.8 time = 1770
* CHECK dout0_5 vdout0_5ck176 = 1.8 time = 1770
* CHECK dout0_6 vdout0_6ck176 = 1.8 time = 1770
* CHECK dout0_7 vdout0_7ck176 = 1.8 time = 1770
* CHECK dout0_8 vdout0_8ck176 = 0 time = 1770
* CHECK dout0_9 vdout0_9ck176 = 0 time = 1770
* CHECK dout0_10 vdout0_10ck176 = 0 time = 1770
* CHECK dout0_11 vdout0_11ck176 = 0 time = 1770
* CHECK dout0_12 vdout0_12ck176 = 1.8 time = 1770
* CHECK dout0_13 vdout0_13ck176 = 1.8 time = 1770
* CHECK dout0_14 vdout0_14ck176 = 1.8 time = 1770
* CHECK dout0_15 vdout0_15ck176 = 0 time = 1770
* CHECK dout0_16 vdout0_16ck176 = 0 time = 1770
* CHECK dout0_17 vdout0_17ck176 = 0 time = 1770
* CHECK dout0_18 vdout0_18ck176 = 1.8 time = 1770
* CHECK dout0_19 vdout0_19ck176 = 1.8 time = 1770
* CHECK dout0_20 vdout0_20ck176 = 0 time = 1770
* CHECK dout0_21 vdout0_21ck176 = 0 time = 1770
* CHECK dout0_22 vdout0_22ck176 = 0 time = 1770
* CHECK dout0_23 vdout0_23ck176 = 0 time = 1770
* CHECK dout0_24 vdout0_24ck176 = 1.8 time = 1770
* CHECK dout0_25 vdout0_25ck176 = 0 time = 1770
* CHECK dout0_26 vdout0_26ck176 = 1.8 time = 1770
* CHECK dout0_27 vdout0_27ck176 = 1.8 time = 1770
* CHECK dout0_28 vdout0_28ck176 = 1.8 time = 1770
* CHECK dout0_29 vdout0_29ck176 = 1.8 time = 1770
* CHECK dout0_30 vdout0_30ck176 = 0 time = 1770
* CHECK dout0_31 vdout0_31ck176 = 0 time = 1770
* CHECK dout0_32 vdout0_32ck176 = 0 time = 1770
* CHECK dout0_33 vdout0_33ck176 = 1.8 time = 1770
* CHECK dout0_34 vdout0_34ck176 = 1.8 time = 1770
* CHECK dout0_35 vdout0_35ck176 = 1.8 time = 1770
* CHECK dout0_36 vdout0_36ck176 = 1.8 time = 1770
* CHECK dout0_37 vdout0_37ck176 = 1.8 time = 1770
* CHECK dout0_38 vdout0_38ck176 = 0 time = 1770
* CHECK dout0_39 vdout0_39ck176 = 1.8 time = 1770
* CHECK dout0_40 vdout0_40ck176 = 0 time = 1770
* CHECK dout0_41 vdout0_41ck176 = 1.8 time = 1770
* CHECK dout0_42 vdout0_42ck176 = 0 time = 1770
* CHECK dout0_43 vdout0_43ck176 = 1.8 time = 1770
* CHECK dout0_44 vdout0_44ck176 = 0 time = 1770
* CHECK dout0_45 vdout0_45ck176 = 1.8 time = 1770
* CHECK dout0_46 vdout0_46ck176 = 0 time = 1770
* CHECK dout0_47 vdout0_47ck176 = 1.8 time = 1770
* CHECK dout0_48 vdout0_48ck176 = 0 time = 1770
* CHECK dout0_49 vdout0_49ck176 = 1.8 time = 1770
* CHECK dout0_50 vdout0_50ck176 = 0 time = 1770
* CHECK dout0_51 vdout0_51ck176 = 1.8 time = 1770
* CHECK dout0_52 vdout0_52ck176 = 0 time = 1770
* CHECK dout0_53 vdout0_53ck176 = 0 time = 1770
* CHECK dout0_54 vdout0_54ck176 = 1.8 time = 1770
* CHECK dout0_55 vdout0_55ck176 = 1.8 time = 1770
* CHECK dout0_56 vdout0_56ck176 = 1.8 time = 1770
* CHECK dout0_57 vdout0_57ck176 = 1.8 time = 1770
* CHECK dout0_58 vdout0_58ck176 = 1.8 time = 1770
* CHECK dout0_59 vdout0_59ck176 = 0 time = 1770
* CHECK dout0_60 vdout0_60ck176 = 0 time = 1770
* CHECK dout0_61 vdout0_61ck176 = 0 time = 1770
* CHECK dout0_62 vdout0_62ck176 = 0 time = 1770
* CHECK dout0_63 vdout0_63ck176 = 0 time = 1770
* CHECK dout1_0 vdout1_0ck177 = 0 time = 1780
* CHECK dout1_1 vdout1_1ck177 = 1.8 time = 1780
* CHECK dout1_2 vdout1_2ck177 = 1.8 time = 1780
* CHECK dout1_3 vdout1_3ck177 = 1.8 time = 1780
* CHECK dout1_4 vdout1_4ck177 = 1.8 time = 1780
* CHECK dout1_5 vdout1_5ck177 = 0 time = 1780
* CHECK dout1_6 vdout1_6ck177 = 0 time = 1780
* CHECK dout1_7 vdout1_7ck177 = 0 time = 1780
* CHECK dout1_8 vdout1_8ck177 = 1.8 time = 1780
* CHECK dout1_9 vdout1_9ck177 = 0 time = 1780
* CHECK dout1_10 vdout1_10ck177 = 0 time = 1780
* CHECK dout1_11 vdout1_11ck177 = 1.8 time = 1780
* CHECK dout1_12 vdout1_12ck177 = 0 time = 1780
* CHECK dout1_13 vdout1_13ck177 = 0 time = 1780
* CHECK dout1_14 vdout1_14ck177 = 1.8 time = 1780
* CHECK dout1_15 vdout1_15ck177 = 0 time = 1780
* CHECK dout1_16 vdout1_16ck177 = 1.8 time = 1780
* CHECK dout1_17 vdout1_17ck177 = 0 time = 1780
* CHECK dout1_18 vdout1_18ck177 = 0 time = 1780
* CHECK dout1_19 vdout1_19ck177 = 1.8 time = 1780
* CHECK dout1_20 vdout1_20ck177 = 1.8 time = 1780
* CHECK dout1_21 vdout1_21ck177 = 0 time = 1780
* CHECK dout1_22 vdout1_22ck177 = 0 time = 1780
* CHECK dout1_23 vdout1_23ck177 = 1.8 time = 1780
* CHECK dout1_24 vdout1_24ck177 = 0 time = 1780
* CHECK dout1_25 vdout1_25ck177 = 1.8 time = 1780
* CHECK dout1_26 vdout1_26ck177 = 0 time = 1780
* CHECK dout1_27 vdout1_27ck177 = 1.8 time = 1780
* CHECK dout1_28 vdout1_28ck177 = 0 time = 1780
* CHECK dout1_29 vdout1_29ck177 = 0 time = 1780
* CHECK dout1_30 vdout1_30ck177 = 0 time = 1780
* CHECK dout1_31 vdout1_31ck177 = 1.8 time = 1780
* CHECK dout1_32 vdout1_32ck177 = 0 time = 1780
* CHECK dout1_33 vdout1_33ck177 = 1.8 time = 1780
* CHECK dout1_34 vdout1_34ck177 = 1.8 time = 1780
* CHECK dout1_35 vdout1_35ck177 = 0 time = 1780
* CHECK dout1_36 vdout1_36ck177 = 0 time = 1780
* CHECK dout1_37 vdout1_37ck177 = 0 time = 1780
* CHECK dout1_38 vdout1_38ck177 = 0 time = 1780
* CHECK dout1_39 vdout1_39ck177 = 0 time = 1780
* CHECK dout1_40 vdout1_40ck177 = 1.8 time = 1780
* CHECK dout1_41 vdout1_41ck177 = 1.8 time = 1780
* CHECK dout1_42 vdout1_42ck177 = 0 time = 1780
* CHECK dout1_43 vdout1_43ck177 = 0 time = 1780
* CHECK dout1_44 vdout1_44ck177 = 0 time = 1780
* CHECK dout1_45 vdout1_45ck177 = 0 time = 1780
* CHECK dout1_46 vdout1_46ck177 = 1.8 time = 1780
* CHECK dout1_47 vdout1_47ck177 = 0 time = 1780
* CHECK dout1_48 vdout1_48ck177 = 0 time = 1780
* CHECK dout1_49 vdout1_49ck177 = 0 time = 1780
* CHECK dout1_50 vdout1_50ck177 = 1.8 time = 1780
* CHECK dout1_51 vdout1_51ck177 = 0 time = 1780
* CHECK dout1_52 vdout1_52ck177 = 0 time = 1780
* CHECK dout1_53 vdout1_53ck177 = 1.8 time = 1780
* CHECK dout1_54 vdout1_54ck177 = 0 time = 1780
* CHECK dout1_55 vdout1_55ck177 = 0 time = 1780
* CHECK dout1_56 vdout1_56ck177 = 0 time = 1780
* CHECK dout1_57 vdout1_57ck177 = 0 time = 1780
* CHECK dout1_58 vdout1_58ck177 = 0 time = 1780
* CHECK dout1_59 vdout1_59ck177 = 0 time = 1780
* CHECK dout1_60 vdout1_60ck177 = 1.8 time = 1780
* CHECK dout1_61 vdout1_61ck177 = 0 time = 1780
* CHECK dout1_62 vdout1_62ck177 = 0 time = 1780
* CHECK dout1_63 vdout1_63ck177 = 1.8 time = 1780
* CHECK dout0_0 vdout0_0ck178 = 0 time = 1790
* CHECK dout0_1 vdout0_1ck178 = 0 time = 1790
* CHECK dout0_2 vdout0_2ck178 = 0 time = 1790
* CHECK dout0_3 vdout0_3ck178 = 1.8 time = 1790
* CHECK dout0_4 vdout0_4ck178 = 1.8 time = 1790
* CHECK dout0_5 vdout0_5ck178 = 1.8 time = 1790
* CHECK dout0_6 vdout0_6ck178 = 1.8 time = 1790
* CHECK dout0_7 vdout0_7ck178 = 1.8 time = 1790
* CHECK dout0_8 vdout0_8ck178 = 0 time = 1790
* CHECK dout0_9 vdout0_9ck178 = 0 time = 1790
* CHECK dout0_10 vdout0_10ck178 = 0 time = 1790
* CHECK dout0_11 vdout0_11ck178 = 0 time = 1790
* CHECK dout0_12 vdout0_12ck178 = 1.8 time = 1790
* CHECK dout0_13 vdout0_13ck178 = 1.8 time = 1790
* CHECK dout0_14 vdout0_14ck178 = 1.8 time = 1790
* CHECK dout0_15 vdout0_15ck178 = 0 time = 1790
* CHECK dout0_16 vdout0_16ck178 = 0 time = 1790
* CHECK dout0_17 vdout0_17ck178 = 0 time = 1790
* CHECK dout0_18 vdout0_18ck178 = 1.8 time = 1790
* CHECK dout0_19 vdout0_19ck178 = 1.8 time = 1790
* CHECK dout0_20 vdout0_20ck178 = 0 time = 1790
* CHECK dout0_21 vdout0_21ck178 = 0 time = 1790
* CHECK dout0_22 vdout0_22ck178 = 0 time = 1790
* CHECK dout0_23 vdout0_23ck178 = 0 time = 1790
* CHECK dout0_24 vdout0_24ck178 = 1.8 time = 1790
* CHECK dout0_25 vdout0_25ck178 = 0 time = 1790
* CHECK dout0_26 vdout0_26ck178 = 1.8 time = 1790
* CHECK dout0_27 vdout0_27ck178 = 1.8 time = 1790
* CHECK dout0_28 vdout0_28ck178 = 1.8 time = 1790
* CHECK dout0_29 vdout0_29ck178 = 1.8 time = 1790
* CHECK dout0_30 vdout0_30ck178 = 0 time = 1790
* CHECK dout0_31 vdout0_31ck178 = 0 time = 1790
* CHECK dout0_32 vdout0_32ck178 = 0 time = 1790
* CHECK dout0_33 vdout0_33ck178 = 1.8 time = 1790
* CHECK dout0_34 vdout0_34ck178 = 1.8 time = 1790
* CHECK dout0_35 vdout0_35ck178 = 1.8 time = 1790
* CHECK dout0_36 vdout0_36ck178 = 1.8 time = 1790
* CHECK dout0_37 vdout0_37ck178 = 1.8 time = 1790
* CHECK dout0_38 vdout0_38ck178 = 0 time = 1790
* CHECK dout0_39 vdout0_39ck178 = 1.8 time = 1790
* CHECK dout0_40 vdout0_40ck178 = 0 time = 1790
* CHECK dout0_41 vdout0_41ck178 = 1.8 time = 1790
* CHECK dout0_42 vdout0_42ck178 = 0 time = 1790
* CHECK dout0_43 vdout0_43ck178 = 1.8 time = 1790
* CHECK dout0_44 vdout0_44ck178 = 0 time = 1790
* CHECK dout0_45 vdout0_45ck178 = 1.8 time = 1790
* CHECK dout0_46 vdout0_46ck178 = 0 time = 1790
* CHECK dout0_47 vdout0_47ck178 = 1.8 time = 1790
* CHECK dout0_48 vdout0_48ck178 = 0 time = 1790
* CHECK dout0_49 vdout0_49ck178 = 1.8 time = 1790
* CHECK dout0_50 vdout0_50ck178 = 0 time = 1790
* CHECK dout0_51 vdout0_51ck178 = 1.8 time = 1790
* CHECK dout0_52 vdout0_52ck178 = 0 time = 1790
* CHECK dout0_53 vdout0_53ck178 = 0 time = 1790
* CHECK dout0_54 vdout0_54ck178 = 1.8 time = 1790
* CHECK dout0_55 vdout0_55ck178 = 1.8 time = 1790
* CHECK dout0_56 vdout0_56ck178 = 1.8 time = 1790
* CHECK dout0_57 vdout0_57ck178 = 1.8 time = 1790
* CHECK dout0_58 vdout0_58ck178 = 1.8 time = 1790
* CHECK dout0_59 vdout0_59ck178 = 0 time = 1790
* CHECK dout0_60 vdout0_60ck178 = 0 time = 1790
* CHECK dout0_61 vdout0_61ck178 = 0 time = 1790
* CHECK dout0_62 vdout0_62ck178 = 0 time = 1790
* CHECK dout0_63 vdout0_63ck178 = 0 time = 1790
* CHECK dout0_0 vdout0_0ck180 = 1.8 time = 1810
* CHECK dout0_1 vdout0_1ck180 = 0 time = 1810
* CHECK dout0_2 vdout0_2ck180 = 1.8 time = 1810
* CHECK dout0_3 vdout0_3ck180 = 0 time = 1810
* CHECK dout0_4 vdout0_4ck180 = 1.8 time = 1810
* CHECK dout0_5 vdout0_5ck180 = 0 time = 1810
* CHECK dout0_6 vdout0_6ck180 = 0 time = 1810
* CHECK dout0_7 vdout0_7ck180 = 1.8 time = 1810
* CHECK dout0_8 vdout0_8ck180 = 0 time = 1810
* CHECK dout0_9 vdout0_9ck180 = 0 time = 1810
* CHECK dout0_10 vdout0_10ck180 = 0 time = 1810
* CHECK dout0_11 vdout0_11ck180 = 0 time = 1810
* CHECK dout0_12 vdout0_12ck180 = 0 time = 1810
* CHECK dout0_13 vdout0_13ck180 = 1.8 time = 1810
* CHECK dout0_14 vdout0_14ck180 = 1.8 time = 1810
* CHECK dout0_15 vdout0_15ck180 = 0 time = 1810
* CHECK dout0_16 vdout0_16ck180 = 0 time = 1810
* CHECK dout0_17 vdout0_17ck180 = 1.8 time = 1810
* CHECK dout0_18 vdout0_18ck180 = 0 time = 1810
* CHECK dout0_19 vdout0_19ck180 = 0 time = 1810
* CHECK dout0_20 vdout0_20ck180 = 0 time = 1810
* CHECK dout0_21 vdout0_21ck180 = 1.8 time = 1810
* CHECK dout0_22 vdout0_22ck180 = 1.8 time = 1810
* CHECK dout0_23 vdout0_23ck180 = 0 time = 1810
* CHECK dout0_24 vdout0_24ck180 = 0 time = 1810
* CHECK dout0_25 vdout0_25ck180 = 0 time = 1810
* CHECK dout0_26 vdout0_26ck180 = 1.8 time = 1810
* CHECK dout0_27 vdout0_27ck180 = 0 time = 1810
* CHECK dout0_28 vdout0_28ck180 = 0 time = 1810
* CHECK dout0_29 vdout0_29ck180 = 0 time = 1810
* CHECK dout0_30 vdout0_30ck180 = 1.8 time = 1810
* CHECK dout0_31 vdout0_31ck180 = 0 time = 1810
* CHECK dout0_32 vdout0_32ck180 = 1.8 time = 1810
* CHECK dout0_33 vdout0_33ck180 = 0 time = 1810
* CHECK dout0_34 vdout0_34ck180 = 0 time = 1810
* CHECK dout0_35 vdout0_35ck180 = 1.8 time = 1810
* CHECK dout0_36 vdout0_36ck180 = 1.8 time = 1810
* CHECK dout0_37 vdout0_37ck180 = 0 time = 1810
* CHECK dout0_38 vdout0_38ck180 = 1.8 time = 1810
* CHECK dout0_39 vdout0_39ck180 = 1.8 time = 1810
* CHECK dout0_40 vdout0_40ck180 = 0 time = 1810
* CHECK dout0_41 vdout0_41ck180 = 1.8 time = 1810
* CHECK dout0_42 vdout0_42ck180 = 1.8 time = 1810
* CHECK dout0_43 vdout0_43ck180 = 1.8 time = 1810
* CHECK dout0_44 vdout0_44ck180 = 0 time = 1810
* CHECK dout0_45 vdout0_45ck180 = 1.8 time = 1810
* CHECK dout0_46 vdout0_46ck180 = 1.8 time = 1810
* CHECK dout0_47 vdout0_47ck180 = 1.8 time = 1810
* CHECK dout0_48 vdout0_48ck180 = 1.8 time = 1810
* CHECK dout0_49 vdout0_49ck180 = 1.8 time = 1810
* CHECK dout0_50 vdout0_50ck180 = 0 time = 1810
* CHECK dout0_51 vdout0_51ck180 = 0 time = 1810
* CHECK dout0_52 vdout0_52ck180 = 0 time = 1810
* CHECK dout0_53 vdout0_53ck180 = 1.8 time = 1810
* CHECK dout0_54 vdout0_54ck180 = 1.8 time = 1810
* CHECK dout0_55 vdout0_55ck180 = 0 time = 1810
* CHECK dout0_56 vdout0_56ck180 = 0 time = 1810
* CHECK dout0_57 vdout0_57ck180 = 1.8 time = 1810
* CHECK dout0_58 vdout0_58ck180 = 0 time = 1810
* CHECK dout0_59 vdout0_59ck180 = 1.8 time = 1810
* CHECK dout0_60 vdout0_60ck180 = 0 time = 1810
* CHECK dout0_61 vdout0_61ck180 = 1.8 time = 1810
* CHECK dout0_62 vdout0_62ck180 = 1.8 time = 1810
* CHECK dout0_63 vdout0_63ck180 = 1.8 time = 1810
* CHECK dout1_0 vdout1_0ck180 = 0 time = 1810
* CHECK dout1_1 vdout1_1ck180 = 0 time = 1810
* CHECK dout1_2 vdout1_2ck180 = 0 time = 1810
* CHECK dout1_3 vdout1_3ck180 = 1.8 time = 1810
* CHECK dout1_4 vdout1_4ck180 = 1.8 time = 1810
* CHECK dout1_5 vdout1_5ck180 = 1.8 time = 1810
* CHECK dout1_6 vdout1_6ck180 = 1.8 time = 1810
* CHECK dout1_7 vdout1_7ck180 = 1.8 time = 1810
* CHECK dout1_8 vdout1_8ck180 = 0 time = 1810
* CHECK dout1_9 vdout1_9ck180 = 0 time = 1810
* CHECK dout1_10 vdout1_10ck180 = 0 time = 1810
* CHECK dout1_11 vdout1_11ck180 = 0 time = 1810
* CHECK dout1_12 vdout1_12ck180 = 1.8 time = 1810
* CHECK dout1_13 vdout1_13ck180 = 1.8 time = 1810
* CHECK dout1_14 vdout1_14ck180 = 1.8 time = 1810
* CHECK dout1_15 vdout1_15ck180 = 0 time = 1810
* CHECK dout1_16 vdout1_16ck180 = 0 time = 1810
* CHECK dout1_17 vdout1_17ck180 = 0 time = 1810
* CHECK dout1_18 vdout1_18ck180 = 1.8 time = 1810
* CHECK dout1_19 vdout1_19ck180 = 1.8 time = 1810
* CHECK dout1_20 vdout1_20ck180 = 0 time = 1810
* CHECK dout1_21 vdout1_21ck180 = 0 time = 1810
* CHECK dout1_22 vdout1_22ck180 = 0 time = 1810
* CHECK dout1_23 vdout1_23ck180 = 0 time = 1810
* CHECK dout1_24 vdout1_24ck180 = 1.8 time = 1810
* CHECK dout1_25 vdout1_25ck180 = 0 time = 1810
* CHECK dout1_26 vdout1_26ck180 = 1.8 time = 1810
* CHECK dout1_27 vdout1_27ck180 = 1.8 time = 1810
* CHECK dout1_28 vdout1_28ck180 = 1.8 time = 1810
* CHECK dout1_29 vdout1_29ck180 = 1.8 time = 1810
* CHECK dout1_30 vdout1_30ck180 = 0 time = 1810
* CHECK dout1_31 vdout1_31ck180 = 0 time = 1810
* CHECK dout1_32 vdout1_32ck180 = 0 time = 1810
* CHECK dout1_33 vdout1_33ck180 = 1.8 time = 1810
* CHECK dout1_34 vdout1_34ck180 = 1.8 time = 1810
* CHECK dout1_35 vdout1_35ck180 = 1.8 time = 1810
* CHECK dout1_36 vdout1_36ck180 = 1.8 time = 1810
* CHECK dout1_37 vdout1_37ck180 = 1.8 time = 1810
* CHECK dout1_38 vdout1_38ck180 = 0 time = 1810
* CHECK dout1_39 vdout1_39ck180 = 1.8 time = 1810
* CHECK dout1_40 vdout1_40ck180 = 0 time = 1810
* CHECK dout1_41 vdout1_41ck180 = 1.8 time = 1810
* CHECK dout1_42 vdout1_42ck180 = 0 time = 1810
* CHECK dout1_43 vdout1_43ck180 = 1.8 time = 1810
* CHECK dout1_44 vdout1_44ck180 = 0 time = 1810
* CHECK dout1_45 vdout1_45ck180 = 1.8 time = 1810
* CHECK dout1_46 vdout1_46ck180 = 0 time = 1810
* CHECK dout1_47 vdout1_47ck180 = 1.8 time = 1810
* CHECK dout1_48 vdout1_48ck180 = 0 time = 1810
* CHECK dout1_49 vdout1_49ck180 = 1.8 time = 1810
* CHECK dout1_50 vdout1_50ck180 = 0 time = 1810
* CHECK dout1_51 vdout1_51ck180 = 1.8 time = 1810
* CHECK dout1_52 vdout1_52ck180 = 0 time = 1810
* CHECK dout1_53 vdout1_53ck180 = 0 time = 1810
* CHECK dout1_54 vdout1_54ck180 = 1.8 time = 1810
* CHECK dout1_55 vdout1_55ck180 = 1.8 time = 1810
* CHECK dout1_56 vdout1_56ck180 = 1.8 time = 1810
* CHECK dout1_57 vdout1_57ck180 = 1.8 time = 1810
* CHECK dout1_58 vdout1_58ck180 = 1.8 time = 1810
* CHECK dout1_59 vdout1_59ck180 = 0 time = 1810
* CHECK dout1_60 vdout1_60ck180 = 0 time = 1810
* CHECK dout1_61 vdout1_61ck180 = 0 time = 1810
* CHECK dout1_62 vdout1_62ck180 = 0 time = 1810
* CHECK dout1_63 vdout1_63ck180 = 0 time = 1810
* CHECK dout1_0 vdout1_0ck181 = 1.8 time = 1820
* CHECK dout1_1 vdout1_1ck181 = 0 time = 1820
* CHECK dout1_2 vdout1_2ck181 = 1.8 time = 1820
* CHECK dout1_3 vdout1_3ck181 = 0 time = 1820
* CHECK dout1_4 vdout1_4ck181 = 1.8 time = 1820
* CHECK dout1_5 vdout1_5ck181 = 0 time = 1820
* CHECK dout1_6 vdout1_6ck181 = 0 time = 1820
* CHECK dout1_7 vdout1_7ck181 = 1.8 time = 1820
* CHECK dout1_8 vdout1_8ck181 = 0 time = 1820
* CHECK dout1_9 vdout1_9ck181 = 0 time = 1820
* CHECK dout1_10 vdout1_10ck181 = 0 time = 1820
* CHECK dout1_11 vdout1_11ck181 = 0 time = 1820
* CHECK dout1_12 vdout1_12ck181 = 0 time = 1820
* CHECK dout1_13 vdout1_13ck181 = 1.8 time = 1820
* CHECK dout1_14 vdout1_14ck181 = 1.8 time = 1820
* CHECK dout1_15 vdout1_15ck181 = 0 time = 1820
* CHECK dout1_16 vdout1_16ck181 = 0 time = 1820
* CHECK dout1_17 vdout1_17ck181 = 1.8 time = 1820
* CHECK dout1_18 vdout1_18ck181 = 0 time = 1820
* CHECK dout1_19 vdout1_19ck181 = 0 time = 1820
* CHECK dout1_20 vdout1_20ck181 = 0 time = 1820
* CHECK dout1_21 vdout1_21ck181 = 1.8 time = 1820
* CHECK dout1_22 vdout1_22ck181 = 1.8 time = 1820
* CHECK dout1_23 vdout1_23ck181 = 0 time = 1820
* CHECK dout1_24 vdout1_24ck181 = 0 time = 1820
* CHECK dout1_25 vdout1_25ck181 = 0 time = 1820
* CHECK dout1_26 vdout1_26ck181 = 1.8 time = 1820
* CHECK dout1_27 vdout1_27ck181 = 0 time = 1820
* CHECK dout1_28 vdout1_28ck181 = 0 time = 1820
* CHECK dout1_29 vdout1_29ck181 = 0 time = 1820
* CHECK dout1_30 vdout1_30ck181 = 1.8 time = 1820
* CHECK dout1_31 vdout1_31ck181 = 0 time = 1820
* CHECK dout1_32 vdout1_32ck181 = 1.8 time = 1820
* CHECK dout1_33 vdout1_33ck181 = 0 time = 1820
* CHECK dout1_34 vdout1_34ck181 = 0 time = 1820
* CHECK dout1_35 vdout1_35ck181 = 1.8 time = 1820
* CHECK dout1_36 vdout1_36ck181 = 1.8 time = 1820
* CHECK dout1_37 vdout1_37ck181 = 0 time = 1820
* CHECK dout1_38 vdout1_38ck181 = 1.8 time = 1820
* CHECK dout1_39 vdout1_39ck181 = 1.8 time = 1820
* CHECK dout1_40 vdout1_40ck181 = 0 time = 1820
* CHECK dout1_41 vdout1_41ck181 = 1.8 time = 1820
* CHECK dout1_42 vdout1_42ck181 = 1.8 time = 1820
* CHECK dout1_43 vdout1_43ck181 = 1.8 time = 1820
* CHECK dout1_44 vdout1_44ck181 = 0 time = 1820
* CHECK dout1_45 vdout1_45ck181 = 1.8 time = 1820
* CHECK dout1_46 vdout1_46ck181 = 1.8 time = 1820
* CHECK dout1_47 vdout1_47ck181 = 1.8 time = 1820
* CHECK dout1_48 vdout1_48ck181 = 1.8 time = 1820
* CHECK dout1_49 vdout1_49ck181 = 1.8 time = 1820
* CHECK dout1_50 vdout1_50ck181 = 0 time = 1820
* CHECK dout1_51 vdout1_51ck181 = 0 time = 1820
* CHECK dout1_52 vdout1_52ck181 = 0 time = 1820
* CHECK dout1_53 vdout1_53ck181 = 1.8 time = 1820
* CHECK dout1_54 vdout1_54ck181 = 1.8 time = 1820
* CHECK dout1_55 vdout1_55ck181 = 0 time = 1820
* CHECK dout1_56 vdout1_56ck181 = 0 time = 1820
* CHECK dout1_57 vdout1_57ck181 = 1.8 time = 1820
* CHECK dout1_58 vdout1_58ck181 = 0 time = 1820
* CHECK dout1_59 vdout1_59ck181 = 1.8 time = 1820
* CHECK dout1_60 vdout1_60ck181 = 0 time = 1820
* CHECK dout1_61 vdout1_61ck181 = 1.8 time = 1820
* CHECK dout1_62 vdout1_62ck181 = 1.8 time = 1820
* CHECK dout1_63 vdout1_63ck181 = 1.8 time = 1820
* CHECK dout0_0 vdout0_0ck182 = 0 time = 1830
* CHECK dout0_1 vdout0_1ck182 = 1.8 time = 1830
* CHECK dout0_2 vdout0_2ck182 = 1.8 time = 1830
* CHECK dout0_3 vdout0_3ck182 = 1.8 time = 1830
* CHECK dout0_4 vdout0_4ck182 = 1.8 time = 1830
* CHECK dout0_5 vdout0_5ck182 = 0 time = 1830
* CHECK dout0_6 vdout0_6ck182 = 0 time = 1830
* CHECK dout0_7 vdout0_7ck182 = 0 time = 1830
* CHECK dout0_8 vdout0_8ck182 = 1.8 time = 1830
* CHECK dout0_9 vdout0_9ck182 = 0 time = 1830
* CHECK dout0_10 vdout0_10ck182 = 0 time = 1830
* CHECK dout0_11 vdout0_11ck182 = 1.8 time = 1830
* CHECK dout0_12 vdout0_12ck182 = 0 time = 1830
* CHECK dout0_13 vdout0_13ck182 = 0 time = 1830
* CHECK dout0_14 vdout0_14ck182 = 1.8 time = 1830
* CHECK dout0_15 vdout0_15ck182 = 0 time = 1830
* CHECK dout0_16 vdout0_16ck182 = 1.8 time = 1830
* CHECK dout0_17 vdout0_17ck182 = 0 time = 1830
* CHECK dout0_18 vdout0_18ck182 = 0 time = 1830
* CHECK dout0_19 vdout0_19ck182 = 1.8 time = 1830
* CHECK dout0_20 vdout0_20ck182 = 1.8 time = 1830
* CHECK dout0_21 vdout0_21ck182 = 0 time = 1830
* CHECK dout0_22 vdout0_22ck182 = 0 time = 1830
* CHECK dout0_23 vdout0_23ck182 = 1.8 time = 1830
* CHECK dout0_24 vdout0_24ck182 = 0 time = 1830
* CHECK dout0_25 vdout0_25ck182 = 1.8 time = 1830
* CHECK dout0_26 vdout0_26ck182 = 0 time = 1830
* CHECK dout0_27 vdout0_27ck182 = 1.8 time = 1830
* CHECK dout0_28 vdout0_28ck182 = 0 time = 1830
* CHECK dout0_29 vdout0_29ck182 = 0 time = 1830
* CHECK dout0_30 vdout0_30ck182 = 0 time = 1830
* CHECK dout0_31 vdout0_31ck182 = 1.8 time = 1830
* CHECK dout0_32 vdout0_32ck182 = 0 time = 1830
* CHECK dout0_33 vdout0_33ck182 = 1.8 time = 1830
* CHECK dout0_34 vdout0_34ck182 = 1.8 time = 1830
* CHECK dout0_35 vdout0_35ck182 = 0 time = 1830
* CHECK dout0_36 vdout0_36ck182 = 0 time = 1830
* CHECK dout0_37 vdout0_37ck182 = 0 time = 1830
* CHECK dout0_38 vdout0_38ck182 = 0 time = 1830
* CHECK dout0_39 vdout0_39ck182 = 0 time = 1830
* CHECK dout0_40 vdout0_40ck182 = 1.8 time = 1830
* CHECK dout0_41 vdout0_41ck182 = 1.8 time = 1830
* CHECK dout0_42 vdout0_42ck182 = 0 time = 1830
* CHECK dout0_43 vdout0_43ck182 = 0 time = 1830
* CHECK dout0_44 vdout0_44ck182 = 0 time = 1830
* CHECK dout0_45 vdout0_45ck182 = 0 time = 1830
* CHECK dout0_46 vdout0_46ck182 = 1.8 time = 1830
* CHECK dout0_47 vdout0_47ck182 = 0 time = 1830
* CHECK dout0_48 vdout0_48ck182 = 0 time = 1830
* CHECK dout0_49 vdout0_49ck182 = 0 time = 1830
* CHECK dout0_50 vdout0_50ck182 = 1.8 time = 1830
* CHECK dout0_51 vdout0_51ck182 = 0 time = 1830
* CHECK dout0_52 vdout0_52ck182 = 0 time = 1830
* CHECK dout0_53 vdout0_53ck182 = 1.8 time = 1830
* CHECK dout0_54 vdout0_54ck182 = 0 time = 1830
* CHECK dout0_55 vdout0_55ck182 = 0 time = 1830
* CHECK dout0_56 vdout0_56ck182 = 0 time = 1830
* CHECK dout0_57 vdout0_57ck182 = 0 time = 1830
* CHECK dout0_58 vdout0_58ck182 = 0 time = 1830
* CHECK dout0_59 vdout0_59ck182 = 0 time = 1830
* CHECK dout0_60 vdout0_60ck182 = 1.8 time = 1830
* CHECK dout0_61 vdout0_61ck182 = 0 time = 1830
* CHECK dout0_62 vdout0_62ck182 = 0 time = 1830
* CHECK dout0_63 vdout0_63ck182 = 1.8 time = 1830
* CHECK dout0_0 vdout0_0ck183 = 1.8 time = 1840
* CHECK dout0_1 vdout0_1ck183 = 0 time = 1840
* CHECK dout0_2 vdout0_2ck183 = 1.8 time = 1840
* CHECK dout0_3 vdout0_3ck183 = 0 time = 1840
* CHECK dout0_4 vdout0_4ck183 = 1.8 time = 1840
* CHECK dout0_5 vdout0_5ck183 = 0 time = 1840
* CHECK dout0_6 vdout0_6ck183 = 0 time = 1840
* CHECK dout0_7 vdout0_7ck183 = 1.8 time = 1840
* CHECK dout0_8 vdout0_8ck183 = 0 time = 1840
* CHECK dout0_9 vdout0_9ck183 = 0 time = 1840
* CHECK dout0_10 vdout0_10ck183 = 0 time = 1840
* CHECK dout0_11 vdout0_11ck183 = 0 time = 1840
* CHECK dout0_12 vdout0_12ck183 = 0 time = 1840
* CHECK dout0_13 vdout0_13ck183 = 1.8 time = 1840
* CHECK dout0_14 vdout0_14ck183 = 1.8 time = 1840
* CHECK dout0_15 vdout0_15ck183 = 0 time = 1840
* CHECK dout0_16 vdout0_16ck183 = 0 time = 1840
* CHECK dout0_17 vdout0_17ck183 = 1.8 time = 1840
* CHECK dout0_18 vdout0_18ck183 = 0 time = 1840
* CHECK dout0_19 vdout0_19ck183 = 0 time = 1840
* CHECK dout0_20 vdout0_20ck183 = 0 time = 1840
* CHECK dout0_21 vdout0_21ck183 = 1.8 time = 1840
* CHECK dout0_22 vdout0_22ck183 = 1.8 time = 1840
* CHECK dout0_23 vdout0_23ck183 = 0 time = 1840
* CHECK dout0_24 vdout0_24ck183 = 0 time = 1840
* CHECK dout0_25 vdout0_25ck183 = 0 time = 1840
* CHECK dout0_26 vdout0_26ck183 = 1.8 time = 1840
* CHECK dout0_27 vdout0_27ck183 = 0 time = 1840
* CHECK dout0_28 vdout0_28ck183 = 0 time = 1840
* CHECK dout0_29 vdout0_29ck183 = 0 time = 1840
* CHECK dout0_30 vdout0_30ck183 = 1.8 time = 1840
* CHECK dout0_31 vdout0_31ck183 = 0 time = 1840
* CHECK dout0_32 vdout0_32ck183 = 1.8 time = 1840
* CHECK dout0_33 vdout0_33ck183 = 0 time = 1840
* CHECK dout0_34 vdout0_34ck183 = 0 time = 1840
* CHECK dout0_35 vdout0_35ck183 = 1.8 time = 1840
* CHECK dout0_36 vdout0_36ck183 = 1.8 time = 1840
* CHECK dout0_37 vdout0_37ck183 = 0 time = 1840
* CHECK dout0_38 vdout0_38ck183 = 1.8 time = 1840
* CHECK dout0_39 vdout0_39ck183 = 1.8 time = 1840
* CHECK dout0_40 vdout0_40ck183 = 0 time = 1840
* CHECK dout0_41 vdout0_41ck183 = 1.8 time = 1840
* CHECK dout0_42 vdout0_42ck183 = 1.8 time = 1840
* CHECK dout0_43 vdout0_43ck183 = 1.8 time = 1840
* CHECK dout0_44 vdout0_44ck183 = 0 time = 1840
* CHECK dout0_45 vdout0_45ck183 = 1.8 time = 1840
* CHECK dout0_46 vdout0_46ck183 = 1.8 time = 1840
* CHECK dout0_47 vdout0_47ck183 = 1.8 time = 1840
* CHECK dout0_48 vdout0_48ck183 = 1.8 time = 1840
* CHECK dout0_49 vdout0_49ck183 = 1.8 time = 1840
* CHECK dout0_50 vdout0_50ck183 = 0 time = 1840
* CHECK dout0_51 vdout0_51ck183 = 0 time = 1840
* CHECK dout0_52 vdout0_52ck183 = 0 time = 1840
* CHECK dout0_53 vdout0_53ck183 = 1.8 time = 1840
* CHECK dout0_54 vdout0_54ck183 = 1.8 time = 1840
* CHECK dout0_55 vdout0_55ck183 = 0 time = 1840
* CHECK dout0_56 vdout0_56ck183 = 0 time = 1840
* CHECK dout0_57 vdout0_57ck183 = 1.8 time = 1840
* CHECK dout0_58 vdout0_58ck183 = 0 time = 1840
* CHECK dout0_59 vdout0_59ck183 = 1.8 time = 1840
* CHECK dout0_60 vdout0_60ck183 = 0 time = 1840
* CHECK dout0_61 vdout0_61ck183 = 1.8 time = 1840
* CHECK dout0_62 vdout0_62ck183 = 1.8 time = 1840
* CHECK dout0_63 vdout0_63ck183 = 1.8 time = 1840
* CHECK dout1_0 vdout1_0ck184 = 0 time = 1850
* CHECK dout1_1 vdout1_1ck184 = 1.8 time = 1850
* CHECK dout1_2 vdout1_2ck184 = 0 time = 1850
* CHECK dout1_3 vdout1_3ck184 = 1.8 time = 1850
* CHECK dout1_4 vdout1_4ck184 = 1.8 time = 1850
* CHECK dout1_5 vdout1_5ck184 = 0 time = 1850
* CHECK dout1_6 vdout1_6ck184 = 1.8 time = 1850
* CHECK dout1_7 vdout1_7ck184 = 0 time = 1850
* CHECK dout1_8 vdout1_8ck184 = 0 time = 1850
* CHECK dout1_9 vdout1_9ck184 = 0 time = 1850
* CHECK dout1_10 vdout1_10ck184 = 0 time = 1850
* CHECK dout1_11 vdout1_11ck184 = 1.8 time = 1850
* CHECK dout1_12 vdout1_12ck184 = 1.8 time = 1850
* CHECK dout1_13 vdout1_13ck184 = 1.8 time = 1850
* CHECK dout1_14 vdout1_14ck184 = 0 time = 1850
* CHECK dout1_15 vdout1_15ck184 = 0 time = 1850
* CHECK dout1_16 vdout1_16ck184 = 1.8 time = 1850
* CHECK dout1_17 vdout1_17ck184 = 0 time = 1850
* CHECK dout1_18 vdout1_18ck184 = 0 time = 1850
* CHECK dout1_19 vdout1_19ck184 = 1.8 time = 1850
* CHECK dout1_20 vdout1_20ck184 = 1.8 time = 1850
* CHECK dout1_21 vdout1_21ck184 = 0 time = 1850
* CHECK dout1_22 vdout1_22ck184 = 1.8 time = 1850
* CHECK dout1_23 vdout1_23ck184 = 0 time = 1850
* CHECK dout1_24 vdout1_24ck184 = 0 time = 1850
* CHECK dout1_25 vdout1_25ck184 = 0 time = 1850
* CHECK dout1_26 vdout1_26ck184 = 1.8 time = 1850
* CHECK dout1_27 vdout1_27ck184 = 0 time = 1850
* CHECK dout1_28 vdout1_28ck184 = 1.8 time = 1850
* CHECK dout1_29 vdout1_29ck184 = 0 time = 1850
* CHECK dout1_30 vdout1_30ck184 = 0 time = 1850
* CHECK dout1_31 vdout1_31ck184 = 0 time = 1850
* CHECK dout1_32 vdout1_32ck184 = 1.8 time = 1850
* CHECK dout1_33 vdout1_33ck184 = 0 time = 1850
* CHECK dout1_34 vdout1_34ck184 = 1.8 time = 1850
* CHECK dout1_35 vdout1_35ck184 = 1.8 time = 1850
* CHECK dout1_36 vdout1_36ck184 = 1.8 time = 1850
* CHECK dout1_37 vdout1_37ck184 = 1.8 time = 1850
* CHECK dout1_38 vdout1_38ck184 = 1.8 time = 1850
* CHECK dout1_39 vdout1_39ck184 = 0 time = 1850
* CHECK dout1_40 vdout1_40ck184 = 1.8 time = 1850
* CHECK dout1_41 vdout1_41ck184 = 1.8 time = 1850
* CHECK dout1_42 vdout1_42ck184 = 0 time = 1850
* CHECK dout1_43 vdout1_43ck184 = 1.8 time = 1850
* CHECK dout1_44 vdout1_44ck184 = 1.8 time = 1850
* CHECK dout1_45 vdout1_45ck184 = 0 time = 1850
* CHECK dout1_46 vdout1_46ck184 = 0 time = 1850
* CHECK dout1_47 vdout1_47ck184 = 0 time = 1850
* CHECK dout1_48 vdout1_48ck184 = 0 time = 1850
* CHECK dout1_49 vdout1_49ck184 = 1.8 time = 1850
* CHECK dout1_50 vdout1_50ck184 = 0 time = 1850
* CHECK dout1_51 vdout1_51ck184 = 0 time = 1850
* CHECK dout1_52 vdout1_52ck184 = 0 time = 1850
* CHECK dout1_53 vdout1_53ck184 = 0 time = 1850
* CHECK dout1_54 vdout1_54ck184 = 0 time = 1850
* CHECK dout1_55 vdout1_55ck184 = 1.8 time = 1850
* CHECK dout1_56 vdout1_56ck184 = 0 time = 1850
* CHECK dout1_57 vdout1_57ck184 = 0 time = 1850
* CHECK dout1_58 vdout1_58ck184 = 0 time = 1850
* CHECK dout1_59 vdout1_59ck184 = 1.8 time = 1850
* CHECK dout1_60 vdout1_60ck184 = 1.8 time = 1850
* CHECK dout1_61 vdout1_61ck184 = 0 time = 1850
* CHECK dout1_62 vdout1_62ck184 = 0 time = 1850
* CHECK dout1_63 vdout1_63ck184 = 0 time = 1850
* CHECK dout1_0 vdout1_0ck185 = 0 time = 1860
* CHECK dout1_1 vdout1_1ck185 = 0 time = 1860
* CHECK dout1_2 vdout1_2ck185 = 0 time = 1860
* CHECK dout1_3 vdout1_3ck185 = 1.8 time = 1860
* CHECK dout1_4 vdout1_4ck185 = 1.8 time = 1860
* CHECK dout1_5 vdout1_5ck185 = 1.8 time = 1860
* CHECK dout1_6 vdout1_6ck185 = 1.8 time = 1860
* CHECK dout1_7 vdout1_7ck185 = 1.8 time = 1860
* CHECK dout1_8 vdout1_8ck185 = 0 time = 1860
* CHECK dout1_9 vdout1_9ck185 = 0 time = 1860
* CHECK dout1_10 vdout1_10ck185 = 0 time = 1860
* CHECK dout1_11 vdout1_11ck185 = 0 time = 1860
* CHECK dout1_12 vdout1_12ck185 = 1.8 time = 1860
* CHECK dout1_13 vdout1_13ck185 = 1.8 time = 1860
* CHECK dout1_14 vdout1_14ck185 = 1.8 time = 1860
* CHECK dout1_15 vdout1_15ck185 = 0 time = 1860
* CHECK dout1_16 vdout1_16ck185 = 0 time = 1860
* CHECK dout1_17 vdout1_17ck185 = 0 time = 1860
* CHECK dout1_18 vdout1_18ck185 = 1.8 time = 1860
* CHECK dout1_19 vdout1_19ck185 = 1.8 time = 1860
* CHECK dout1_20 vdout1_20ck185 = 0 time = 1860
* CHECK dout1_21 vdout1_21ck185 = 0 time = 1860
* CHECK dout1_22 vdout1_22ck185 = 0 time = 1860
* CHECK dout1_23 vdout1_23ck185 = 0 time = 1860
* CHECK dout1_24 vdout1_24ck185 = 1.8 time = 1860
* CHECK dout1_25 vdout1_25ck185 = 0 time = 1860
* CHECK dout1_26 vdout1_26ck185 = 1.8 time = 1860
* CHECK dout1_27 vdout1_27ck185 = 1.8 time = 1860
* CHECK dout1_28 vdout1_28ck185 = 1.8 time = 1860
* CHECK dout1_29 vdout1_29ck185 = 1.8 time = 1860
* CHECK dout1_30 vdout1_30ck185 = 0 time = 1860
* CHECK dout1_31 vdout1_31ck185 = 0 time = 1860
* CHECK dout1_32 vdout1_32ck185 = 0 time = 1860
* CHECK dout1_33 vdout1_33ck185 = 1.8 time = 1860
* CHECK dout1_34 vdout1_34ck185 = 1.8 time = 1860
* CHECK dout1_35 vdout1_35ck185 = 1.8 time = 1860
* CHECK dout1_36 vdout1_36ck185 = 1.8 time = 1860
* CHECK dout1_37 vdout1_37ck185 = 1.8 time = 1860
* CHECK dout1_38 vdout1_38ck185 = 0 time = 1860
* CHECK dout1_39 vdout1_39ck185 = 1.8 time = 1860
* CHECK dout1_40 vdout1_40ck185 = 0 time = 1860
* CHECK dout1_41 vdout1_41ck185 = 1.8 time = 1860
* CHECK dout1_42 vdout1_42ck185 = 0 time = 1860
* CHECK dout1_43 vdout1_43ck185 = 1.8 time = 1860
* CHECK dout1_44 vdout1_44ck185 = 0 time = 1860
* CHECK dout1_45 vdout1_45ck185 = 1.8 time = 1860
* CHECK dout1_46 vdout1_46ck185 = 0 time = 1860
* CHECK dout1_47 vdout1_47ck185 = 1.8 time = 1860
* CHECK dout1_48 vdout1_48ck185 = 0 time = 1860
* CHECK dout1_49 vdout1_49ck185 = 1.8 time = 1860
* CHECK dout1_50 vdout1_50ck185 = 0 time = 1860
* CHECK dout1_51 vdout1_51ck185 = 1.8 time = 1860
* CHECK dout1_52 vdout1_52ck185 = 0 time = 1860
* CHECK dout1_53 vdout1_53ck185 = 0 time = 1860
* CHECK dout1_54 vdout1_54ck185 = 1.8 time = 1860
* CHECK dout1_55 vdout1_55ck185 = 1.8 time = 1860
* CHECK dout1_56 vdout1_56ck185 = 1.8 time = 1860
* CHECK dout1_57 vdout1_57ck185 = 1.8 time = 1860
* CHECK dout1_58 vdout1_58ck185 = 1.8 time = 1860
* CHECK dout1_59 vdout1_59ck185 = 0 time = 1860
* CHECK dout1_60 vdout1_60ck185 = 0 time = 1860
* CHECK dout1_61 vdout1_61ck185 = 0 time = 1860
* CHECK dout1_62 vdout1_62ck185 = 0 time = 1860
* CHECK dout1_63 vdout1_63ck185 = 0 time = 1860
* CHECK dout1_0 vdout1_0ck188 = 1.8 time = 1890
* CHECK dout1_1 vdout1_1ck188 = 0 time = 1890
* CHECK dout1_2 vdout1_2ck188 = 0 time = 1890
* CHECK dout1_3 vdout1_3ck188 = 1.8 time = 1890
* CHECK dout1_4 vdout1_4ck188 = 0 time = 1890
* CHECK dout1_5 vdout1_5ck188 = 0 time = 1890
* CHECK dout1_6 vdout1_6ck188 = 0 time = 1890
* CHECK dout1_7 vdout1_7ck188 = 0 time = 1890
* CHECK dout1_8 vdout1_8ck188 = 0 time = 1890
* CHECK dout1_9 vdout1_9ck188 = 0 time = 1890
* CHECK dout1_10 vdout1_10ck188 = 1.8 time = 1890
* CHECK dout1_11 vdout1_11ck188 = 0 time = 1890
* CHECK dout1_12 vdout1_12ck188 = 1.8 time = 1890
* CHECK dout1_13 vdout1_13ck188 = 0 time = 1890
* CHECK dout1_14 vdout1_14ck188 = 1.8 time = 1890
* CHECK dout1_15 vdout1_15ck188 = 0 time = 1890
* CHECK dout1_16 vdout1_16ck188 = 1.8 time = 1890
* CHECK dout1_17 vdout1_17ck188 = 1.8 time = 1890
* CHECK dout1_18 vdout1_18ck188 = 0 time = 1890
* CHECK dout1_19 vdout1_19ck188 = 1.8 time = 1890
* CHECK dout1_20 vdout1_20ck188 = 0 time = 1890
* CHECK dout1_21 vdout1_21ck188 = 0 time = 1890
* CHECK dout1_22 vdout1_22ck188 = 0 time = 1890
* CHECK dout1_23 vdout1_23ck188 = 0 time = 1890
* CHECK dout1_24 vdout1_24ck188 = 1.8 time = 1890
* CHECK dout1_25 vdout1_25ck188 = 1.8 time = 1890
* CHECK dout1_26 vdout1_26ck188 = 1.8 time = 1890
* CHECK dout1_27 vdout1_27ck188 = 0 time = 1890
* CHECK dout1_28 vdout1_28ck188 = 1.8 time = 1890
* CHECK dout1_29 vdout1_29ck188 = 1.8 time = 1890
* CHECK dout1_30 vdout1_30ck188 = 1.8 time = 1890
* CHECK dout1_31 vdout1_31ck188 = 1.8 time = 1890
* CHECK dout1_32 vdout1_32ck188 = 1.8 time = 1890
* CHECK dout1_33 vdout1_33ck188 = 0 time = 1890
* CHECK dout1_34 vdout1_34ck188 = 1.8 time = 1890
* CHECK dout1_35 vdout1_35ck188 = 1.8 time = 1890
* CHECK dout1_36 vdout1_36ck188 = 0 time = 1890
* CHECK dout1_37 vdout1_37ck188 = 1.8 time = 1890
* CHECK dout1_38 vdout1_38ck188 = 1.8 time = 1890
* CHECK dout1_39 vdout1_39ck188 = 0 time = 1890
* CHECK dout1_40 vdout1_40ck188 = 0 time = 1890
* CHECK dout1_41 vdout1_41ck188 = 1.8 time = 1890
* CHECK dout1_42 vdout1_42ck188 = 0 time = 1890
* CHECK dout1_43 vdout1_43ck188 = 1.8 time = 1890
* CHECK dout1_44 vdout1_44ck188 = 0 time = 1890
* CHECK dout1_45 vdout1_45ck188 = 1.8 time = 1890
* CHECK dout1_46 vdout1_46ck188 = 1.8 time = 1890
* CHECK dout1_47 vdout1_47ck188 = 1.8 time = 1890
* CHECK dout1_48 vdout1_48ck188 = 1.8 time = 1890
* CHECK dout1_49 vdout1_49ck188 = 1.8 time = 1890
* CHECK dout1_50 vdout1_50ck188 = 1.8 time = 1890
* CHECK dout1_51 vdout1_51ck188 = 1.8 time = 1890
* CHECK dout1_52 vdout1_52ck188 = 0 time = 1890
* CHECK dout1_53 vdout1_53ck188 = 0 time = 1890
* CHECK dout1_54 vdout1_54ck188 = 1.8 time = 1890
* CHECK dout1_55 vdout1_55ck188 = 1.8 time = 1890
* CHECK dout1_56 vdout1_56ck188 = 1.8 time = 1890
* CHECK dout1_57 vdout1_57ck188 = 1.8 time = 1890
* CHECK dout1_58 vdout1_58ck188 = 1.8 time = 1890
* CHECK dout1_59 vdout1_59ck188 = 1.8 time = 1890
* CHECK dout1_60 vdout1_60ck188 = 0 time = 1890
* CHECK dout1_61 vdout1_61ck188 = 0 time = 1890
* CHECK dout1_62 vdout1_62ck188 = 1.8 time = 1890
* CHECK dout1_63 vdout1_63ck188 = 0 time = 1890
* CHECK dout1_0 vdout1_0ck190 = 0 time = 1910
* CHECK dout1_1 vdout1_1ck190 = 0 time = 1910
* CHECK dout1_2 vdout1_2ck190 = 0 time = 1910
* CHECK dout1_3 vdout1_3ck190 = 1.8 time = 1910
* CHECK dout1_4 vdout1_4ck190 = 1.8 time = 1910
* CHECK dout1_5 vdout1_5ck190 = 1.8 time = 1910
* CHECK dout1_6 vdout1_6ck190 = 1.8 time = 1910
* CHECK dout1_7 vdout1_7ck190 = 1.8 time = 1910
* CHECK dout1_8 vdout1_8ck190 = 0 time = 1910
* CHECK dout1_9 vdout1_9ck190 = 0 time = 1910
* CHECK dout1_10 vdout1_10ck190 = 0 time = 1910
* CHECK dout1_11 vdout1_11ck190 = 0 time = 1910
* CHECK dout1_12 vdout1_12ck190 = 1.8 time = 1910
* CHECK dout1_13 vdout1_13ck190 = 1.8 time = 1910
* CHECK dout1_14 vdout1_14ck190 = 1.8 time = 1910
* CHECK dout1_15 vdout1_15ck190 = 0 time = 1910
* CHECK dout1_16 vdout1_16ck190 = 0 time = 1910
* CHECK dout1_17 vdout1_17ck190 = 0 time = 1910
* CHECK dout1_18 vdout1_18ck190 = 1.8 time = 1910
* CHECK dout1_19 vdout1_19ck190 = 1.8 time = 1910
* CHECK dout1_20 vdout1_20ck190 = 0 time = 1910
* CHECK dout1_21 vdout1_21ck190 = 0 time = 1910
* CHECK dout1_22 vdout1_22ck190 = 0 time = 1910
* CHECK dout1_23 vdout1_23ck190 = 0 time = 1910
* CHECK dout1_24 vdout1_24ck190 = 1.8 time = 1910
* CHECK dout1_25 vdout1_25ck190 = 0 time = 1910
* CHECK dout1_26 vdout1_26ck190 = 1.8 time = 1910
* CHECK dout1_27 vdout1_27ck190 = 1.8 time = 1910
* CHECK dout1_28 vdout1_28ck190 = 1.8 time = 1910
* CHECK dout1_29 vdout1_29ck190 = 1.8 time = 1910
* CHECK dout1_30 vdout1_30ck190 = 0 time = 1910
* CHECK dout1_31 vdout1_31ck190 = 0 time = 1910
* CHECK dout1_32 vdout1_32ck190 = 0 time = 1910
* CHECK dout1_33 vdout1_33ck190 = 1.8 time = 1910
* CHECK dout1_34 vdout1_34ck190 = 1.8 time = 1910
* CHECK dout1_35 vdout1_35ck190 = 1.8 time = 1910
* CHECK dout1_36 vdout1_36ck190 = 1.8 time = 1910
* CHECK dout1_37 vdout1_37ck190 = 1.8 time = 1910
* CHECK dout1_38 vdout1_38ck190 = 0 time = 1910
* CHECK dout1_39 vdout1_39ck190 = 1.8 time = 1910
* CHECK dout1_40 vdout1_40ck190 = 0 time = 1910
* CHECK dout1_41 vdout1_41ck190 = 1.8 time = 1910
* CHECK dout1_42 vdout1_42ck190 = 0 time = 1910
* CHECK dout1_43 vdout1_43ck190 = 1.8 time = 1910
* CHECK dout1_44 vdout1_44ck190 = 0 time = 1910
* CHECK dout1_45 vdout1_45ck190 = 1.8 time = 1910
* CHECK dout1_46 vdout1_46ck190 = 0 time = 1910
* CHECK dout1_47 vdout1_47ck190 = 1.8 time = 1910
* CHECK dout1_48 vdout1_48ck190 = 0 time = 1910
* CHECK dout1_49 vdout1_49ck190 = 1.8 time = 1910
* CHECK dout1_50 vdout1_50ck190 = 0 time = 1910
* CHECK dout1_51 vdout1_51ck190 = 1.8 time = 1910
* CHECK dout1_52 vdout1_52ck190 = 0 time = 1910
* CHECK dout1_53 vdout1_53ck190 = 0 time = 1910
* CHECK dout1_54 vdout1_54ck190 = 1.8 time = 1910
* CHECK dout1_55 vdout1_55ck190 = 1.8 time = 1910
* CHECK dout1_56 vdout1_56ck190 = 1.8 time = 1910
* CHECK dout1_57 vdout1_57ck190 = 1.8 time = 1910
* CHECK dout1_58 vdout1_58ck190 = 1.8 time = 1910
* CHECK dout1_59 vdout1_59ck190 = 0 time = 1910
* CHECK dout1_60 vdout1_60ck190 = 0 time = 1910
* CHECK dout1_61 vdout1_61ck190 = 0 time = 1910
* CHECK dout1_62 vdout1_62ck190 = 0 time = 1910
* CHECK dout1_63 vdout1_63ck190 = 0 time = 1910
* CHECK dout0_0 vdout0_0ck192 = 1.8 time = 1930
* CHECK dout0_1 vdout0_1ck192 = 0 time = 1930
* CHECK dout0_2 vdout0_2ck192 = 1.8 time = 1930
* CHECK dout0_3 vdout0_3ck192 = 0 time = 1930
* CHECK dout0_4 vdout0_4ck192 = 1.8 time = 1930
* CHECK dout0_5 vdout0_5ck192 = 0 time = 1930
* CHECK dout0_6 vdout0_6ck192 = 0 time = 1930
* CHECK dout0_7 vdout0_7ck192 = 1.8 time = 1930
* CHECK dout0_8 vdout0_8ck192 = 0 time = 1930
* CHECK dout0_9 vdout0_9ck192 = 0 time = 1930
* CHECK dout0_10 vdout0_10ck192 = 0 time = 1930
* CHECK dout0_11 vdout0_11ck192 = 0 time = 1930
* CHECK dout0_12 vdout0_12ck192 = 0 time = 1930
* CHECK dout0_13 vdout0_13ck192 = 1.8 time = 1930
* CHECK dout0_14 vdout0_14ck192 = 1.8 time = 1930
* CHECK dout0_15 vdout0_15ck192 = 0 time = 1930
* CHECK dout0_16 vdout0_16ck192 = 0 time = 1930
* CHECK dout0_17 vdout0_17ck192 = 1.8 time = 1930
* CHECK dout0_18 vdout0_18ck192 = 0 time = 1930
* CHECK dout0_19 vdout0_19ck192 = 0 time = 1930
* CHECK dout0_20 vdout0_20ck192 = 0 time = 1930
* CHECK dout0_21 vdout0_21ck192 = 1.8 time = 1930
* CHECK dout0_22 vdout0_22ck192 = 1.8 time = 1930
* CHECK dout0_23 vdout0_23ck192 = 0 time = 1930
* CHECK dout0_24 vdout0_24ck192 = 0 time = 1930
* CHECK dout0_25 vdout0_25ck192 = 0 time = 1930
* CHECK dout0_26 vdout0_26ck192 = 1.8 time = 1930
* CHECK dout0_27 vdout0_27ck192 = 0 time = 1930
* CHECK dout0_28 vdout0_28ck192 = 0 time = 1930
* CHECK dout0_29 vdout0_29ck192 = 0 time = 1930
* CHECK dout0_30 vdout0_30ck192 = 1.8 time = 1930
* CHECK dout0_31 vdout0_31ck192 = 0 time = 1930
* CHECK dout0_32 vdout0_32ck192 = 1.8 time = 1930
* CHECK dout0_33 vdout0_33ck192 = 0 time = 1930
* CHECK dout0_34 vdout0_34ck192 = 0 time = 1930
* CHECK dout0_35 vdout0_35ck192 = 1.8 time = 1930
* CHECK dout0_36 vdout0_36ck192 = 1.8 time = 1930
* CHECK dout0_37 vdout0_37ck192 = 0 time = 1930
* CHECK dout0_38 vdout0_38ck192 = 1.8 time = 1930
* CHECK dout0_39 vdout0_39ck192 = 1.8 time = 1930
* CHECK dout0_40 vdout0_40ck192 = 0 time = 1930
* CHECK dout0_41 vdout0_41ck192 = 1.8 time = 1930
* CHECK dout0_42 vdout0_42ck192 = 1.8 time = 1930
* CHECK dout0_43 vdout0_43ck192 = 1.8 time = 1930
* CHECK dout0_44 vdout0_44ck192 = 0 time = 1930
* CHECK dout0_45 vdout0_45ck192 = 1.8 time = 1930
* CHECK dout0_46 vdout0_46ck192 = 1.8 time = 1930
* CHECK dout0_47 vdout0_47ck192 = 1.8 time = 1930
* CHECK dout0_48 vdout0_48ck192 = 1.8 time = 1930
* CHECK dout0_49 vdout0_49ck192 = 1.8 time = 1930
* CHECK dout0_50 vdout0_50ck192 = 0 time = 1930
* CHECK dout0_51 vdout0_51ck192 = 0 time = 1930
* CHECK dout0_52 vdout0_52ck192 = 0 time = 1930
* CHECK dout0_53 vdout0_53ck192 = 1.8 time = 1930
* CHECK dout0_54 vdout0_54ck192 = 1.8 time = 1930
* CHECK dout0_55 vdout0_55ck192 = 0 time = 1930
* CHECK dout0_56 vdout0_56ck192 = 0 time = 1930
* CHECK dout0_57 vdout0_57ck192 = 1.8 time = 1930
* CHECK dout0_58 vdout0_58ck192 = 0 time = 1930
* CHECK dout0_59 vdout0_59ck192 = 1.8 time = 1930
* CHECK dout0_60 vdout0_60ck192 = 0 time = 1930
* CHECK dout0_61 vdout0_61ck192 = 1.8 time = 1930
* CHECK dout0_62 vdout0_62ck192 = 1.8 time = 1930
* CHECK dout0_63 vdout0_63ck192 = 1.8 time = 1930
* CHECK dout0_0 vdout0_0ck194 = 1.8 time = 1950
* CHECK dout0_1 vdout0_1ck194 = 0 time = 1950
* CHECK dout0_2 vdout0_2ck194 = 1.8 time = 1950
* CHECK dout0_3 vdout0_3ck194 = 0 time = 1950
* CHECK dout0_4 vdout0_4ck194 = 1.8 time = 1950
* CHECK dout0_5 vdout0_5ck194 = 0 time = 1950
* CHECK dout0_6 vdout0_6ck194 = 0 time = 1950
* CHECK dout0_7 vdout0_7ck194 = 1.8 time = 1950
* CHECK dout0_8 vdout0_8ck194 = 0 time = 1950
* CHECK dout0_9 vdout0_9ck194 = 0 time = 1950
* CHECK dout0_10 vdout0_10ck194 = 0 time = 1950
* CHECK dout0_11 vdout0_11ck194 = 0 time = 1950
* CHECK dout0_12 vdout0_12ck194 = 0 time = 1950
* CHECK dout0_13 vdout0_13ck194 = 1.8 time = 1950
* CHECK dout0_14 vdout0_14ck194 = 1.8 time = 1950
* CHECK dout0_15 vdout0_15ck194 = 0 time = 1950
* CHECK dout0_16 vdout0_16ck194 = 0 time = 1950
* CHECK dout0_17 vdout0_17ck194 = 1.8 time = 1950
* CHECK dout0_18 vdout0_18ck194 = 0 time = 1950
* CHECK dout0_19 vdout0_19ck194 = 0 time = 1950
* CHECK dout0_20 vdout0_20ck194 = 0 time = 1950
* CHECK dout0_21 vdout0_21ck194 = 1.8 time = 1950
* CHECK dout0_22 vdout0_22ck194 = 1.8 time = 1950
* CHECK dout0_23 vdout0_23ck194 = 0 time = 1950
* CHECK dout0_24 vdout0_24ck194 = 0 time = 1950
* CHECK dout0_25 vdout0_25ck194 = 0 time = 1950
* CHECK dout0_26 vdout0_26ck194 = 1.8 time = 1950
* CHECK dout0_27 vdout0_27ck194 = 0 time = 1950
* CHECK dout0_28 vdout0_28ck194 = 0 time = 1950
* CHECK dout0_29 vdout0_29ck194 = 0 time = 1950
* CHECK dout0_30 vdout0_30ck194 = 1.8 time = 1950
* CHECK dout0_31 vdout0_31ck194 = 0 time = 1950
* CHECK dout0_32 vdout0_32ck194 = 1.8 time = 1950
* CHECK dout0_33 vdout0_33ck194 = 0 time = 1950
* CHECK dout0_34 vdout0_34ck194 = 0 time = 1950
* CHECK dout0_35 vdout0_35ck194 = 1.8 time = 1950
* CHECK dout0_36 vdout0_36ck194 = 1.8 time = 1950
* CHECK dout0_37 vdout0_37ck194 = 0 time = 1950
* CHECK dout0_38 vdout0_38ck194 = 1.8 time = 1950
* CHECK dout0_39 vdout0_39ck194 = 1.8 time = 1950
* CHECK dout0_40 vdout0_40ck194 = 0 time = 1950
* CHECK dout0_41 vdout0_41ck194 = 1.8 time = 1950
* CHECK dout0_42 vdout0_42ck194 = 1.8 time = 1950
* CHECK dout0_43 vdout0_43ck194 = 1.8 time = 1950
* CHECK dout0_44 vdout0_44ck194 = 0 time = 1950
* CHECK dout0_45 vdout0_45ck194 = 1.8 time = 1950
* CHECK dout0_46 vdout0_46ck194 = 1.8 time = 1950
* CHECK dout0_47 vdout0_47ck194 = 1.8 time = 1950
* CHECK dout0_48 vdout0_48ck194 = 1.8 time = 1950
* CHECK dout0_49 vdout0_49ck194 = 1.8 time = 1950
* CHECK dout0_50 vdout0_50ck194 = 0 time = 1950
* CHECK dout0_51 vdout0_51ck194 = 0 time = 1950
* CHECK dout0_52 vdout0_52ck194 = 0 time = 1950
* CHECK dout0_53 vdout0_53ck194 = 1.8 time = 1950
* CHECK dout0_54 vdout0_54ck194 = 1.8 time = 1950
* CHECK dout0_55 vdout0_55ck194 = 0 time = 1950
* CHECK dout0_56 vdout0_56ck194 = 0 time = 1950
* CHECK dout0_57 vdout0_57ck194 = 1.8 time = 1950
* CHECK dout0_58 vdout0_58ck194 = 0 time = 1950
* CHECK dout0_59 vdout0_59ck194 = 1.8 time = 1950
* CHECK dout0_60 vdout0_60ck194 = 0 time = 1950
* CHECK dout0_61 vdout0_61ck194 = 1.8 time = 1950
* CHECK dout0_62 vdout0_62ck194 = 1.8 time = 1950
* CHECK dout0_63 vdout0_63ck194 = 1.8 time = 1950
* CHECK dout0_0 vdout0_0ck195 = 0 time = 1960
* CHECK dout0_1 vdout0_1ck195 = 1.8 time = 1960
* CHECK dout0_2 vdout0_2ck195 = 0 time = 1960
* CHECK dout0_3 vdout0_3ck195 = 0 time = 1960
* CHECK dout0_4 vdout0_4ck195 = 0 time = 1960
* CHECK dout0_5 vdout0_5ck195 = 1.8 time = 1960
* CHECK dout0_6 vdout0_6ck195 = 0 time = 1960
* CHECK dout0_7 vdout0_7ck195 = 1.8 time = 1960
* CHECK dout0_8 vdout0_8ck195 = 1.8 time = 1960
* CHECK dout0_9 vdout0_9ck195 = 0 time = 1960
* CHECK dout0_10 vdout0_10ck195 = 1.8 time = 1960
* CHECK dout0_11 vdout0_11ck195 = 1.8 time = 1960
* CHECK dout0_12 vdout0_12ck195 = 1.8 time = 1960
* CHECK dout0_13 vdout0_13ck195 = 0 time = 1960
* CHECK dout0_14 vdout0_14ck195 = 0 time = 1960
* CHECK dout0_15 vdout0_15ck195 = 1.8 time = 1960
* CHECK dout0_16 vdout0_16ck195 = 1.8 time = 1960
* CHECK dout0_17 vdout0_17ck195 = 1.8 time = 1960
* CHECK dout0_18 vdout0_18ck195 = 0 time = 1960
* CHECK dout0_19 vdout0_19ck195 = 1.8 time = 1960
* CHECK dout0_20 vdout0_20ck195 = 1.8 time = 1960
* CHECK dout0_21 vdout0_21ck195 = 1.8 time = 1960
* CHECK dout0_22 vdout0_22ck195 = 0 time = 1960
* CHECK dout0_23 vdout0_23ck195 = 1.8 time = 1960
* CHECK dout0_24 vdout0_24ck195 = 0 time = 1960
* CHECK dout0_25 vdout0_25ck195 = 1.8 time = 1960
* CHECK dout0_26 vdout0_26ck195 = 0 time = 1960
* CHECK dout0_27 vdout0_27ck195 = 1.8 time = 1960
* CHECK dout0_28 vdout0_28ck195 = 0 time = 1960
* CHECK dout0_29 vdout0_29ck195 = 0 time = 1960
* CHECK dout0_30 vdout0_30ck195 = 0 time = 1960
* CHECK dout0_31 vdout0_31ck195 = 0 time = 1960
* CHECK dout0_32 vdout0_32ck195 = 0 time = 1960
* CHECK dout0_33 vdout0_33ck195 = 0 time = 1960
* CHECK dout0_34 vdout0_34ck195 = 1.8 time = 1960
* CHECK dout0_35 vdout0_35ck195 = 0 time = 1960
* CHECK dout0_36 vdout0_36ck195 = 0 time = 1960
* CHECK dout0_37 vdout0_37ck195 = 1.8 time = 1960
* CHECK dout0_38 vdout0_38ck195 = 1.8 time = 1960
* CHECK dout0_39 vdout0_39ck195 = 0 time = 1960
* CHECK dout0_40 vdout0_40ck195 = 0 time = 1960
* CHECK dout0_41 vdout0_41ck195 = 1.8 time = 1960
* CHECK dout0_42 vdout0_42ck195 = 1.8 time = 1960
* CHECK dout0_43 vdout0_43ck195 = 0 time = 1960
* CHECK dout0_44 vdout0_44ck195 = 0 time = 1960
* CHECK dout0_45 vdout0_45ck195 = 0 time = 1960
* CHECK dout0_46 vdout0_46ck195 = 1.8 time = 1960
* CHECK dout0_47 vdout0_47ck195 = 0 time = 1960
* CHECK dout0_48 vdout0_48ck195 = 1.8 time = 1960
* CHECK dout0_49 vdout0_49ck195 = 1.8 time = 1960
* CHECK dout0_50 vdout0_50ck195 = 1.8 time = 1960
* CHECK dout0_51 vdout0_51ck195 = 1.8 time = 1960
* CHECK dout0_52 vdout0_52ck195 = 1.8 time = 1960
* CHECK dout0_53 vdout0_53ck195 = 1.8 time = 1960
* CHECK dout0_54 vdout0_54ck195 = 0 time = 1960
* CHECK dout0_55 vdout0_55ck195 = 1.8 time = 1960
* CHECK dout0_56 vdout0_56ck195 = 0 time = 1960
* CHECK dout0_57 vdout0_57ck195 = 1.8 time = 1960
* CHECK dout0_58 vdout0_58ck195 = 0 time = 1960
* CHECK dout0_59 vdout0_59ck195 = 1.8 time = 1960
* CHECK dout0_60 vdout0_60ck195 = 1.8 time = 1960
* CHECK dout0_61 vdout0_61ck195 = 0 time = 1960
* CHECK dout0_62 vdout0_62ck195 = 0 time = 1960
* CHECK dout0_63 vdout0_63ck195 = 1.8 time = 1960
* CHECK dout0_0 vdout0_0ck196 = 1.8 time = 1970
* CHECK dout0_1 vdout0_1ck196 = 0 time = 1970
* CHECK dout0_2 vdout0_2ck196 = 1.8 time = 1970
* CHECK dout0_3 vdout0_3ck196 = 1.8 time = 1970
* CHECK dout0_4 vdout0_4ck196 = 1.8 time = 1970
* CHECK dout0_5 vdout0_5ck196 = 0 time = 1970
* CHECK dout0_6 vdout0_6ck196 = 1.8 time = 1970
* CHECK dout0_7 vdout0_7ck196 = 0 time = 1970
* CHECK dout0_8 vdout0_8ck196 = 1.8 time = 1970
* CHECK dout0_9 vdout0_9ck196 = 1.8 time = 1970
* CHECK dout0_10 vdout0_10ck196 = 1.8 time = 1970
* CHECK dout0_11 vdout0_11ck196 = 1.8 time = 1970
* CHECK dout0_12 vdout0_12ck196 = 1.8 time = 1970
* CHECK dout0_13 vdout0_13ck196 = 0 time = 1970
* CHECK dout0_14 vdout0_14ck196 = 0 time = 1970
* CHECK dout0_15 vdout0_15ck196 = 1.8 time = 1970
* CHECK dout0_16 vdout0_16ck196 = 0 time = 1970
* CHECK dout0_17 vdout0_17ck196 = 0 time = 1970
* CHECK dout0_18 vdout0_18ck196 = 0 time = 1970
* CHECK dout0_19 vdout0_19ck196 = 0 time = 1970
* CHECK dout0_20 vdout0_20ck196 = 0 time = 1970
* CHECK dout0_21 vdout0_21ck196 = 1.8 time = 1970
* CHECK dout0_22 vdout0_22ck196 = 0 time = 1970
* CHECK dout0_23 vdout0_23ck196 = 1.8 time = 1970
* CHECK dout0_24 vdout0_24ck196 = 0 time = 1970
* CHECK dout0_25 vdout0_25ck196 = 0 time = 1970
* CHECK dout0_26 vdout0_26ck196 = 1.8 time = 1970
* CHECK dout0_27 vdout0_27ck196 = 0 time = 1970
* CHECK dout0_28 vdout0_28ck196 = 1.8 time = 1970
* CHECK dout0_29 vdout0_29ck196 = 1.8 time = 1970
* CHECK dout0_30 vdout0_30ck196 = 0 time = 1970
* CHECK dout0_31 vdout0_31ck196 = 1.8 time = 1970
* CHECK dout0_32 vdout0_32ck196 = 1.8 time = 1970
* CHECK dout0_33 vdout0_33ck196 = 0 time = 1970
* CHECK dout0_34 vdout0_34ck196 = 1.8 time = 1970
* CHECK dout0_35 vdout0_35ck196 = 0 time = 1970
* CHECK dout0_36 vdout0_36ck196 = 1.8 time = 1970
* CHECK dout0_37 vdout0_37ck196 = 0 time = 1970
* CHECK dout0_38 vdout0_38ck196 = 0 time = 1970
* CHECK dout0_39 vdout0_39ck196 = 0 time = 1970
* CHECK dout0_40 vdout0_40ck196 = 0 time = 1970
* CHECK dout0_41 vdout0_41ck196 = 1.8 time = 1970
* CHECK dout0_42 vdout0_42ck196 = 1.8 time = 1970
* CHECK dout0_43 vdout0_43ck196 = 0 time = 1970
* CHECK dout0_44 vdout0_44ck196 = 1.8 time = 1970
* CHECK dout0_45 vdout0_45ck196 = 0 time = 1970
* CHECK dout0_46 vdout0_46ck196 = 0 time = 1970
* CHECK dout0_47 vdout0_47ck196 = 0 time = 1970
* CHECK dout0_48 vdout0_48ck196 = 1.8 time = 1970
* CHECK dout0_49 vdout0_49ck196 = 1.8 time = 1970
* CHECK dout0_50 vdout0_50ck196 = 1.8 time = 1970
* CHECK dout0_51 vdout0_51ck196 = 0 time = 1970
* CHECK dout0_52 vdout0_52ck196 = 1.8 time = 1970
* CHECK dout0_53 vdout0_53ck196 = 1.8 time = 1970
* CHECK dout0_54 vdout0_54ck196 = 0 time = 1970
* CHECK dout0_55 vdout0_55ck196 = 1.8 time = 1970
* CHECK dout0_56 vdout0_56ck196 = 1.8 time = 1970
* CHECK dout0_57 vdout0_57ck196 = 0 time = 1970
* CHECK dout0_58 vdout0_58ck196 = 1.8 time = 1970
* CHECK dout0_59 vdout0_59ck196 = 1.8 time = 1970
* CHECK dout0_60 vdout0_60ck196 = 1.8 time = 1970
* CHECK dout0_61 vdout0_61ck196 = 1.8 time = 1970
* CHECK dout0_62 vdout0_62ck196 = 1.8 time = 1970
* CHECK dout0_63 vdout0_63ck196 = 1.8 time = 1970
* CHECK dout0_0 vdout0_0ck197 = 0 time = 1980
* CHECK dout0_1 vdout0_1ck197 = 1.8 time = 1980
* CHECK dout0_2 vdout0_2ck197 = 0 time = 1980
* CHECK dout0_3 vdout0_3ck197 = 0 time = 1980
* CHECK dout0_4 vdout0_4ck197 = 0 time = 1980
* CHECK dout0_5 vdout0_5ck197 = 1.8 time = 1980
* CHECK dout0_6 vdout0_6ck197 = 0 time = 1980
* CHECK dout0_7 vdout0_7ck197 = 1.8 time = 1980
* CHECK dout0_8 vdout0_8ck197 = 1.8 time = 1980
* CHECK dout0_9 vdout0_9ck197 = 0 time = 1980
* CHECK dout0_10 vdout0_10ck197 = 1.8 time = 1980
* CHECK dout0_11 vdout0_11ck197 = 1.8 time = 1980
* CHECK dout0_12 vdout0_12ck197 = 1.8 time = 1980
* CHECK dout0_13 vdout0_13ck197 = 0 time = 1980
* CHECK dout0_14 vdout0_14ck197 = 0 time = 1980
* CHECK dout0_15 vdout0_15ck197 = 1.8 time = 1980
* CHECK dout0_16 vdout0_16ck197 = 1.8 time = 1980
* CHECK dout0_17 vdout0_17ck197 = 1.8 time = 1980
* CHECK dout0_18 vdout0_18ck197 = 0 time = 1980
* CHECK dout0_19 vdout0_19ck197 = 1.8 time = 1980
* CHECK dout0_20 vdout0_20ck197 = 1.8 time = 1980
* CHECK dout0_21 vdout0_21ck197 = 1.8 time = 1980
* CHECK dout0_22 vdout0_22ck197 = 0 time = 1980
* CHECK dout0_23 vdout0_23ck197 = 1.8 time = 1980
* CHECK dout0_24 vdout0_24ck197 = 0 time = 1980
* CHECK dout0_25 vdout0_25ck197 = 1.8 time = 1980
* CHECK dout0_26 vdout0_26ck197 = 0 time = 1980
* CHECK dout0_27 vdout0_27ck197 = 1.8 time = 1980
* CHECK dout0_28 vdout0_28ck197 = 0 time = 1980
* CHECK dout0_29 vdout0_29ck197 = 0 time = 1980
* CHECK dout0_30 vdout0_30ck197 = 0 time = 1980
* CHECK dout0_31 vdout0_31ck197 = 0 time = 1980
* CHECK dout0_32 vdout0_32ck197 = 0 time = 1980
* CHECK dout0_33 vdout0_33ck197 = 0 time = 1980
* CHECK dout0_34 vdout0_34ck197 = 1.8 time = 1980
* CHECK dout0_35 vdout0_35ck197 = 0 time = 1980
* CHECK dout0_36 vdout0_36ck197 = 0 time = 1980
* CHECK dout0_37 vdout0_37ck197 = 1.8 time = 1980
* CHECK dout0_38 vdout0_38ck197 = 1.8 time = 1980
* CHECK dout0_39 vdout0_39ck197 = 0 time = 1980
* CHECK dout0_40 vdout0_40ck197 = 0 time = 1980
* CHECK dout0_41 vdout0_41ck197 = 1.8 time = 1980
* CHECK dout0_42 vdout0_42ck197 = 1.8 time = 1980
* CHECK dout0_43 vdout0_43ck197 = 0 time = 1980
* CHECK dout0_44 vdout0_44ck197 = 0 time = 1980
* CHECK dout0_45 vdout0_45ck197 = 0 time = 1980
* CHECK dout0_46 vdout0_46ck197 = 1.8 time = 1980
* CHECK dout0_47 vdout0_47ck197 = 0 time = 1980
* CHECK dout0_48 vdout0_48ck197 = 1.8 time = 1980
* CHECK dout0_49 vdout0_49ck197 = 1.8 time = 1980
* CHECK dout0_50 vdout0_50ck197 = 1.8 time = 1980
* CHECK dout0_51 vdout0_51ck197 = 1.8 time = 1980
* CHECK dout0_52 vdout0_52ck197 = 1.8 time = 1980
* CHECK dout0_53 vdout0_53ck197 = 1.8 time = 1980
* CHECK dout0_54 vdout0_54ck197 = 0 time = 1980
* CHECK dout0_55 vdout0_55ck197 = 1.8 time = 1980
* CHECK dout0_56 vdout0_56ck197 = 0 time = 1980
* CHECK dout0_57 vdout0_57ck197 = 1.8 time = 1980
* CHECK dout0_58 vdout0_58ck197 = 0 time = 1980
* CHECK dout0_59 vdout0_59ck197 = 1.8 time = 1980
* CHECK dout0_60 vdout0_60ck197 = 1.8 time = 1980
* CHECK dout0_61 vdout0_61ck197 = 0 time = 1980
* CHECK dout0_62 vdout0_62ck197 = 0 time = 1980
* CHECK dout0_63 vdout0_63ck197 = 1.8 time = 1980
* CHECK dout1_0 vdout1_0ck197 = 1.8 time = 1980
* CHECK dout1_1 vdout1_1ck197 = 0 time = 1980
* CHECK dout1_2 vdout1_2ck197 = 1.8 time = 1980
* CHECK dout1_3 vdout1_3ck197 = 0 time = 1980
* CHECK dout1_4 vdout1_4ck197 = 1.8 time = 1980
* CHECK dout1_5 vdout1_5ck197 = 0 time = 1980
* CHECK dout1_6 vdout1_6ck197 = 0 time = 1980
* CHECK dout1_7 vdout1_7ck197 = 1.8 time = 1980
* CHECK dout1_8 vdout1_8ck197 = 0 time = 1980
* CHECK dout1_9 vdout1_9ck197 = 0 time = 1980
* CHECK dout1_10 vdout1_10ck197 = 0 time = 1980
* CHECK dout1_11 vdout1_11ck197 = 0 time = 1980
* CHECK dout1_12 vdout1_12ck197 = 0 time = 1980
* CHECK dout1_13 vdout1_13ck197 = 1.8 time = 1980
* CHECK dout1_14 vdout1_14ck197 = 1.8 time = 1980
* CHECK dout1_15 vdout1_15ck197 = 0 time = 1980
* CHECK dout1_16 vdout1_16ck197 = 0 time = 1980
* CHECK dout1_17 vdout1_17ck197 = 1.8 time = 1980
* CHECK dout1_18 vdout1_18ck197 = 0 time = 1980
* CHECK dout1_19 vdout1_19ck197 = 0 time = 1980
* CHECK dout1_20 vdout1_20ck197 = 0 time = 1980
* CHECK dout1_21 vdout1_21ck197 = 1.8 time = 1980
* CHECK dout1_22 vdout1_22ck197 = 1.8 time = 1980
* CHECK dout1_23 vdout1_23ck197 = 0 time = 1980
* CHECK dout1_24 vdout1_24ck197 = 0 time = 1980
* CHECK dout1_25 vdout1_25ck197 = 0 time = 1980
* CHECK dout1_26 vdout1_26ck197 = 1.8 time = 1980
* CHECK dout1_27 vdout1_27ck197 = 0 time = 1980
* CHECK dout1_28 vdout1_28ck197 = 0 time = 1980
* CHECK dout1_29 vdout1_29ck197 = 0 time = 1980
* CHECK dout1_30 vdout1_30ck197 = 1.8 time = 1980
* CHECK dout1_31 vdout1_31ck197 = 0 time = 1980
* CHECK dout1_32 vdout1_32ck197 = 1.8 time = 1980
* CHECK dout1_33 vdout1_33ck197 = 0 time = 1980
* CHECK dout1_34 vdout1_34ck197 = 0 time = 1980
* CHECK dout1_35 vdout1_35ck197 = 1.8 time = 1980
* CHECK dout1_36 vdout1_36ck197 = 1.8 time = 1980
* CHECK dout1_37 vdout1_37ck197 = 0 time = 1980
* CHECK dout1_38 vdout1_38ck197 = 1.8 time = 1980
* CHECK dout1_39 vdout1_39ck197 = 1.8 time = 1980
* CHECK dout1_40 vdout1_40ck197 = 0 time = 1980
* CHECK dout1_41 vdout1_41ck197 = 1.8 time = 1980
* CHECK dout1_42 vdout1_42ck197 = 1.8 time = 1980
* CHECK dout1_43 vdout1_43ck197 = 1.8 time = 1980
* CHECK dout1_44 vdout1_44ck197 = 0 time = 1980
* CHECK dout1_45 vdout1_45ck197 = 1.8 time = 1980
* CHECK dout1_46 vdout1_46ck197 = 1.8 time = 1980
* CHECK dout1_47 vdout1_47ck197 = 1.8 time = 1980
* CHECK dout1_48 vdout1_48ck197 = 1.8 time = 1980
* CHECK dout1_49 vdout1_49ck197 = 1.8 time = 1980
* CHECK dout1_50 vdout1_50ck197 = 0 time = 1980
* CHECK dout1_51 vdout1_51ck197 = 0 time = 1980
* CHECK dout1_52 vdout1_52ck197 = 0 time = 1980
* CHECK dout1_53 vdout1_53ck197 = 1.8 time = 1980
* CHECK dout1_54 vdout1_54ck197 = 1.8 time = 1980
* CHECK dout1_55 vdout1_55ck197 = 0 time = 1980
* CHECK dout1_56 vdout1_56ck197 = 0 time = 1980
* CHECK dout1_57 vdout1_57ck197 = 1.8 time = 1980
* CHECK dout1_58 vdout1_58ck197 = 0 time = 1980
* CHECK dout1_59 vdout1_59ck197 = 1.8 time = 1980
* CHECK dout1_60 vdout1_60ck197 = 0 time = 1980
* CHECK dout1_61 vdout1_61ck197 = 1.8 time = 1980
* CHECK dout1_62 vdout1_62ck197 = 1.8 time = 1980
* CHECK dout1_63 vdout1_63ck197 = 1.8 time = 1980
* CHECK dout1_0 vdout1_0ck198 = 1.8 time = 1990
* CHECK dout1_1 vdout1_1ck198 = 0 time = 1990
* CHECK dout1_2 vdout1_2ck198 = 1.8 time = 1990
* CHECK dout1_3 vdout1_3ck198 = 1.8 time = 1990
* CHECK dout1_4 vdout1_4ck198 = 1.8 time = 1990
* CHECK dout1_5 vdout1_5ck198 = 0 time = 1990
* CHECK dout1_6 vdout1_6ck198 = 1.8 time = 1990
* CHECK dout1_7 vdout1_7ck198 = 0 time = 1990
* CHECK dout1_8 vdout1_8ck198 = 1.8 time = 1990
* CHECK dout1_9 vdout1_9ck198 = 1.8 time = 1990
* CHECK dout1_10 vdout1_10ck198 = 1.8 time = 1990
* CHECK dout1_11 vdout1_11ck198 = 1.8 time = 1990
* CHECK dout1_12 vdout1_12ck198 = 1.8 time = 1990
* CHECK dout1_13 vdout1_13ck198 = 0 time = 1990
* CHECK dout1_14 vdout1_14ck198 = 0 time = 1990
* CHECK dout1_15 vdout1_15ck198 = 1.8 time = 1990
* CHECK dout1_16 vdout1_16ck198 = 0 time = 1990
* CHECK dout1_17 vdout1_17ck198 = 0 time = 1990
* CHECK dout1_18 vdout1_18ck198 = 0 time = 1990
* CHECK dout1_19 vdout1_19ck198 = 0 time = 1990
* CHECK dout1_20 vdout1_20ck198 = 0 time = 1990
* CHECK dout1_21 vdout1_21ck198 = 1.8 time = 1990
* CHECK dout1_22 vdout1_22ck198 = 0 time = 1990
* CHECK dout1_23 vdout1_23ck198 = 1.8 time = 1990
* CHECK dout1_24 vdout1_24ck198 = 0 time = 1990
* CHECK dout1_25 vdout1_25ck198 = 0 time = 1990
* CHECK dout1_26 vdout1_26ck198 = 1.8 time = 1990
* CHECK dout1_27 vdout1_27ck198 = 0 time = 1990
* CHECK dout1_28 vdout1_28ck198 = 1.8 time = 1990
* CHECK dout1_29 vdout1_29ck198 = 1.8 time = 1990
* CHECK dout1_30 vdout1_30ck198 = 0 time = 1990
* CHECK dout1_31 vdout1_31ck198 = 1.8 time = 1990
* CHECK dout1_32 vdout1_32ck198 = 1.8 time = 1990
* CHECK dout1_33 vdout1_33ck198 = 0 time = 1990
* CHECK dout1_34 vdout1_34ck198 = 1.8 time = 1990
* CHECK dout1_35 vdout1_35ck198 = 0 time = 1990
* CHECK dout1_36 vdout1_36ck198 = 1.8 time = 1990
* CHECK dout1_37 vdout1_37ck198 = 0 time = 1990
* CHECK dout1_38 vdout1_38ck198 = 0 time = 1990
* CHECK dout1_39 vdout1_39ck198 = 0 time = 1990
* CHECK dout1_40 vdout1_40ck198 = 0 time = 1990
* CHECK dout1_41 vdout1_41ck198 = 1.8 time = 1990
* CHECK dout1_42 vdout1_42ck198 = 1.8 time = 1990
* CHECK dout1_43 vdout1_43ck198 = 0 time = 1990
* CHECK dout1_44 vdout1_44ck198 = 1.8 time = 1990
* CHECK dout1_45 vdout1_45ck198 = 0 time = 1990
* CHECK dout1_46 vdout1_46ck198 = 0 time = 1990
* CHECK dout1_47 vdout1_47ck198 = 0 time = 1990
* CHECK dout1_48 vdout1_48ck198 = 1.8 time = 1990
* CHECK dout1_49 vdout1_49ck198 = 1.8 time = 1990
* CHECK dout1_50 vdout1_50ck198 = 1.8 time = 1990
* CHECK dout1_51 vdout1_51ck198 = 0 time = 1990
* CHECK dout1_52 vdout1_52ck198 = 1.8 time = 1990
* CHECK dout1_53 vdout1_53ck198 = 1.8 time = 1990
* CHECK dout1_54 vdout1_54ck198 = 0 time = 1990
* CHECK dout1_55 vdout1_55ck198 = 1.8 time = 1990
* CHECK dout1_56 vdout1_56ck198 = 1.8 time = 1990
* CHECK dout1_57 vdout1_57ck198 = 0 time = 1990
* CHECK dout1_58 vdout1_58ck198 = 1.8 time = 1990
* CHECK dout1_59 vdout1_59ck198 = 1.8 time = 1990
* CHECK dout1_60 vdout1_60ck198 = 1.8 time = 1990
* CHECK dout1_61 vdout1_61ck198 = 1.8 time = 1990
* CHECK dout1_62 vdout1_62ck198 = 1.8 time = 1990
* CHECK dout1_63 vdout1_63ck198 = 1.8 time = 1990
* CHECK dout1_0 vdout1_0ck199 = 0 time = 2000
* CHECK dout1_1 vdout1_1ck199 = 1.8 time = 2000
* CHECK dout1_2 vdout1_2ck199 = 0 time = 2000
* CHECK dout1_3 vdout1_3ck199 = 0 time = 2000
* CHECK dout1_4 vdout1_4ck199 = 0 time = 2000
* CHECK dout1_5 vdout1_5ck199 = 1.8 time = 2000
* CHECK dout1_6 vdout1_6ck199 = 0 time = 2000
* CHECK dout1_7 vdout1_7ck199 = 1.8 time = 2000
* CHECK dout1_8 vdout1_8ck199 = 1.8 time = 2000
* CHECK dout1_9 vdout1_9ck199 = 0 time = 2000
* CHECK dout1_10 vdout1_10ck199 = 1.8 time = 2000
* CHECK dout1_11 vdout1_11ck199 = 1.8 time = 2000
* CHECK dout1_12 vdout1_12ck199 = 1.8 time = 2000
* CHECK dout1_13 vdout1_13ck199 = 0 time = 2000
* CHECK dout1_14 vdout1_14ck199 = 0 time = 2000
* CHECK dout1_15 vdout1_15ck199 = 1.8 time = 2000
* CHECK dout1_16 vdout1_16ck199 = 1.8 time = 2000
* CHECK dout1_17 vdout1_17ck199 = 1.8 time = 2000
* CHECK dout1_18 vdout1_18ck199 = 0 time = 2000
* CHECK dout1_19 vdout1_19ck199 = 1.8 time = 2000
* CHECK dout1_20 vdout1_20ck199 = 1.8 time = 2000
* CHECK dout1_21 vdout1_21ck199 = 1.8 time = 2000
* CHECK dout1_22 vdout1_22ck199 = 0 time = 2000
* CHECK dout1_23 vdout1_23ck199 = 1.8 time = 2000
* CHECK dout1_24 vdout1_24ck199 = 0 time = 2000
* CHECK dout1_25 vdout1_25ck199 = 1.8 time = 2000
* CHECK dout1_26 vdout1_26ck199 = 0 time = 2000
* CHECK dout1_27 vdout1_27ck199 = 1.8 time = 2000
* CHECK dout1_28 vdout1_28ck199 = 0 time = 2000
* CHECK dout1_29 vdout1_29ck199 = 0 time = 2000
* CHECK dout1_30 vdout1_30ck199 = 0 time = 2000
* CHECK dout1_31 vdout1_31ck199 = 0 time = 2000
* CHECK dout1_32 vdout1_32ck199 = 0 time = 2000
* CHECK dout1_33 vdout1_33ck199 = 0 time = 2000
* CHECK dout1_34 vdout1_34ck199 = 1.8 time = 2000
* CHECK dout1_35 vdout1_35ck199 = 0 time = 2000
* CHECK dout1_36 vdout1_36ck199 = 0 time = 2000
* CHECK dout1_37 vdout1_37ck199 = 1.8 time = 2000
* CHECK dout1_38 vdout1_38ck199 = 1.8 time = 2000
* CHECK dout1_39 vdout1_39ck199 = 0 time = 2000
* CHECK dout1_40 vdout1_40ck199 = 0 time = 2000
* CHECK dout1_41 vdout1_41ck199 = 1.8 time = 2000
* CHECK dout1_42 vdout1_42ck199 = 1.8 time = 2000
* CHECK dout1_43 vdout1_43ck199 = 0 time = 2000
* CHECK dout1_44 vdout1_44ck199 = 0 time = 2000
* CHECK dout1_45 vdout1_45ck199 = 0 time = 2000
* CHECK dout1_46 vdout1_46ck199 = 1.8 time = 2000
* CHECK dout1_47 vdout1_47ck199 = 0 time = 2000
* CHECK dout1_48 vdout1_48ck199 = 1.8 time = 2000
* CHECK dout1_49 vdout1_49ck199 = 1.8 time = 2000
* CHECK dout1_50 vdout1_50ck199 = 1.8 time = 2000
* CHECK dout1_51 vdout1_51ck199 = 1.8 time = 2000
* CHECK dout1_52 vdout1_52ck199 = 1.8 time = 2000
* CHECK dout1_53 vdout1_53ck199 = 1.8 time = 2000
* CHECK dout1_54 vdout1_54ck199 = 0 time = 2000
* CHECK dout1_55 vdout1_55ck199 = 1.8 time = 2000
* CHECK dout1_56 vdout1_56ck199 = 0 time = 2000
* CHECK dout1_57 vdout1_57ck199 = 1.8 time = 2000
* CHECK dout1_58 vdout1_58ck199 = 0 time = 2000
* CHECK dout1_59 vdout1_59ck199 = 1.8 time = 2000
* CHECK dout1_60 vdout1_60ck199 = 1.8 time = 2000
* CHECK dout1_61 vdout1_61ck199 = 0 time = 2000
* CHECK dout1_62 vdout1_62ck199 = 0 time = 2000
* CHECK dout1_63 vdout1_63ck199 = 1.8 time = 2000
* CHECK dout0_0 vdout0_0ck201 = 1.8 time = 2020
* CHECK dout0_1 vdout0_1ck201 = 0 time = 2020
* CHECK dout0_2 vdout0_2ck201 = 1.8 time = 2020
* CHECK dout0_3 vdout0_3ck201 = 0 time = 2020
* CHECK dout0_4 vdout0_4ck201 = 1.8 time = 2020
* CHECK dout0_5 vdout0_5ck201 = 0 time = 2020
* CHECK dout0_6 vdout0_6ck201 = 0 time = 2020
* CHECK dout0_7 vdout0_7ck201 = 1.8 time = 2020
* CHECK dout0_8 vdout0_8ck201 = 0 time = 2020
* CHECK dout0_9 vdout0_9ck201 = 0 time = 2020
* CHECK dout0_10 vdout0_10ck201 = 0 time = 2020
* CHECK dout0_11 vdout0_11ck201 = 0 time = 2020
* CHECK dout0_12 vdout0_12ck201 = 0 time = 2020
* CHECK dout0_13 vdout0_13ck201 = 1.8 time = 2020
* CHECK dout0_14 vdout0_14ck201 = 1.8 time = 2020
* CHECK dout0_15 vdout0_15ck201 = 0 time = 2020
* CHECK dout0_16 vdout0_16ck201 = 0 time = 2020
* CHECK dout0_17 vdout0_17ck201 = 1.8 time = 2020
* CHECK dout0_18 vdout0_18ck201 = 0 time = 2020
* CHECK dout0_19 vdout0_19ck201 = 0 time = 2020
* CHECK dout0_20 vdout0_20ck201 = 0 time = 2020
* CHECK dout0_21 vdout0_21ck201 = 1.8 time = 2020
* CHECK dout0_22 vdout0_22ck201 = 1.8 time = 2020
* CHECK dout0_23 vdout0_23ck201 = 0 time = 2020
* CHECK dout0_24 vdout0_24ck201 = 0 time = 2020
* CHECK dout0_25 vdout0_25ck201 = 0 time = 2020
* CHECK dout0_26 vdout0_26ck201 = 1.8 time = 2020
* CHECK dout0_27 vdout0_27ck201 = 0 time = 2020
* CHECK dout0_28 vdout0_28ck201 = 0 time = 2020
* CHECK dout0_29 vdout0_29ck201 = 0 time = 2020
* CHECK dout0_30 vdout0_30ck201 = 1.8 time = 2020
* CHECK dout0_31 vdout0_31ck201 = 0 time = 2020
* CHECK dout0_32 vdout0_32ck201 = 1.8 time = 2020
* CHECK dout0_33 vdout0_33ck201 = 0 time = 2020
* CHECK dout0_34 vdout0_34ck201 = 0 time = 2020
* CHECK dout0_35 vdout0_35ck201 = 1.8 time = 2020
* CHECK dout0_36 vdout0_36ck201 = 1.8 time = 2020
* CHECK dout0_37 vdout0_37ck201 = 0 time = 2020
* CHECK dout0_38 vdout0_38ck201 = 1.8 time = 2020
* CHECK dout0_39 vdout0_39ck201 = 1.8 time = 2020
* CHECK dout0_40 vdout0_40ck201 = 0 time = 2020
* CHECK dout0_41 vdout0_41ck201 = 1.8 time = 2020
* CHECK dout0_42 vdout0_42ck201 = 1.8 time = 2020
* CHECK dout0_43 vdout0_43ck201 = 1.8 time = 2020
* CHECK dout0_44 vdout0_44ck201 = 0 time = 2020
* CHECK dout0_45 vdout0_45ck201 = 1.8 time = 2020
* CHECK dout0_46 vdout0_46ck201 = 1.8 time = 2020
* CHECK dout0_47 vdout0_47ck201 = 1.8 time = 2020
* CHECK dout0_48 vdout0_48ck201 = 1.8 time = 2020
* CHECK dout0_49 vdout0_49ck201 = 1.8 time = 2020
* CHECK dout0_50 vdout0_50ck201 = 0 time = 2020
* CHECK dout0_51 vdout0_51ck201 = 0 time = 2020
* CHECK dout0_52 vdout0_52ck201 = 0 time = 2020
* CHECK dout0_53 vdout0_53ck201 = 1.8 time = 2020
* CHECK dout0_54 vdout0_54ck201 = 1.8 time = 2020
* CHECK dout0_55 vdout0_55ck201 = 0 time = 2020
* CHECK dout0_56 vdout0_56ck201 = 0 time = 2020
* CHECK dout0_57 vdout0_57ck201 = 1.8 time = 2020
* CHECK dout0_58 vdout0_58ck201 = 0 time = 2020
* CHECK dout0_59 vdout0_59ck201 = 1.8 time = 2020
* CHECK dout0_60 vdout0_60ck201 = 0 time = 2020
* CHECK dout0_61 vdout0_61ck201 = 1.8 time = 2020
* CHECK dout0_62 vdout0_62ck201 = 1.8 time = 2020
* CHECK dout0_63 vdout0_63ck201 = 1.8 time = 2020
* CHECK dout0_0 vdout0_0ck202 = 0 time = 2030
* CHECK dout0_1 vdout0_1ck202 = 0 time = 2030
* CHECK dout0_2 vdout0_2ck202 = 0 time = 2030
* CHECK dout0_3 vdout0_3ck202 = 1.8 time = 2030
* CHECK dout0_4 vdout0_4ck202 = 1.8 time = 2030
* CHECK dout0_5 vdout0_5ck202 = 1.8 time = 2030
* CHECK dout0_6 vdout0_6ck202 = 1.8 time = 2030
* CHECK dout0_7 vdout0_7ck202 = 1.8 time = 2030
* CHECK dout0_8 vdout0_8ck202 = 0 time = 2030
* CHECK dout0_9 vdout0_9ck202 = 0 time = 2030
* CHECK dout0_10 vdout0_10ck202 = 0 time = 2030
* CHECK dout0_11 vdout0_11ck202 = 0 time = 2030
* CHECK dout0_12 vdout0_12ck202 = 1.8 time = 2030
* CHECK dout0_13 vdout0_13ck202 = 1.8 time = 2030
* CHECK dout0_14 vdout0_14ck202 = 1.8 time = 2030
* CHECK dout0_15 vdout0_15ck202 = 0 time = 2030
* CHECK dout0_16 vdout0_16ck202 = 0 time = 2030
* CHECK dout0_17 vdout0_17ck202 = 0 time = 2030
* CHECK dout0_18 vdout0_18ck202 = 1.8 time = 2030
* CHECK dout0_19 vdout0_19ck202 = 1.8 time = 2030
* CHECK dout0_20 vdout0_20ck202 = 0 time = 2030
* CHECK dout0_21 vdout0_21ck202 = 0 time = 2030
* CHECK dout0_22 vdout0_22ck202 = 0 time = 2030
* CHECK dout0_23 vdout0_23ck202 = 0 time = 2030
* CHECK dout0_24 vdout0_24ck202 = 1.8 time = 2030
* CHECK dout0_25 vdout0_25ck202 = 0 time = 2030
* CHECK dout0_26 vdout0_26ck202 = 1.8 time = 2030
* CHECK dout0_27 vdout0_27ck202 = 1.8 time = 2030
* CHECK dout0_28 vdout0_28ck202 = 1.8 time = 2030
* CHECK dout0_29 vdout0_29ck202 = 1.8 time = 2030
* CHECK dout0_30 vdout0_30ck202 = 0 time = 2030
* CHECK dout0_31 vdout0_31ck202 = 0 time = 2030
* CHECK dout0_32 vdout0_32ck202 = 0 time = 2030
* CHECK dout0_33 vdout0_33ck202 = 1.8 time = 2030
* CHECK dout0_34 vdout0_34ck202 = 1.8 time = 2030
* CHECK dout0_35 vdout0_35ck202 = 1.8 time = 2030
* CHECK dout0_36 vdout0_36ck202 = 1.8 time = 2030
* CHECK dout0_37 vdout0_37ck202 = 1.8 time = 2030
* CHECK dout0_38 vdout0_38ck202 = 0 time = 2030
* CHECK dout0_39 vdout0_39ck202 = 1.8 time = 2030
* CHECK dout0_40 vdout0_40ck202 = 0 time = 2030
* CHECK dout0_41 vdout0_41ck202 = 1.8 time = 2030
* CHECK dout0_42 vdout0_42ck202 = 0 time = 2030
* CHECK dout0_43 vdout0_43ck202 = 1.8 time = 2030
* CHECK dout0_44 vdout0_44ck202 = 0 time = 2030
* CHECK dout0_45 vdout0_45ck202 = 1.8 time = 2030
* CHECK dout0_46 vdout0_46ck202 = 0 time = 2030
* CHECK dout0_47 vdout0_47ck202 = 1.8 time = 2030
* CHECK dout0_48 vdout0_48ck202 = 0 time = 2030
* CHECK dout0_49 vdout0_49ck202 = 1.8 time = 2030
* CHECK dout0_50 vdout0_50ck202 = 0 time = 2030
* CHECK dout0_51 vdout0_51ck202 = 1.8 time = 2030
* CHECK dout0_52 vdout0_52ck202 = 0 time = 2030
* CHECK dout0_53 vdout0_53ck202 = 0 time = 2030
* CHECK dout0_54 vdout0_54ck202 = 1.8 time = 2030
* CHECK dout0_55 vdout0_55ck202 = 1.8 time = 2030
* CHECK dout0_56 vdout0_56ck202 = 1.8 time = 2030
* CHECK dout0_57 vdout0_57ck202 = 1.8 time = 2030
* CHECK dout0_58 vdout0_58ck202 = 1.8 time = 2030
* CHECK dout0_59 vdout0_59ck202 = 0 time = 2030
* CHECK dout0_60 vdout0_60ck202 = 0 time = 2030
* CHECK dout0_61 vdout0_61ck202 = 0 time = 2030
* CHECK dout0_62 vdout0_62ck202 = 0 time = 2030
* CHECK dout0_63 vdout0_63ck202 = 0 time = 2030
* CHECK dout0_0 vdout0_0ck204 = 1.8 time = 2050
* CHECK dout0_1 vdout0_1ck204 = 1.8 time = 2050
* CHECK dout0_2 vdout0_2ck204 = 1.8 time = 2050
* CHECK dout0_3 vdout0_3ck204 = 1.8 time = 2050
* CHECK dout0_4 vdout0_4ck204 = 1.8 time = 2050
* CHECK dout0_5 vdout0_5ck204 = 1.8 time = 2050
* CHECK dout0_6 vdout0_6ck204 = 1.8 time = 2050
* CHECK dout0_7 vdout0_7ck204 = 0 time = 2050
* CHECK dout0_8 vdout0_8ck204 = 0 time = 2050
* CHECK dout0_9 vdout0_9ck204 = 0 time = 2050
* CHECK dout0_10 vdout0_10ck204 = 0 time = 2050
* CHECK dout0_11 vdout0_11ck204 = 1.8 time = 2050
* CHECK dout0_12 vdout0_12ck204 = 0 time = 2050
* CHECK dout0_13 vdout0_13ck204 = 1.8 time = 2050
* CHECK dout0_14 vdout0_14ck204 = 1.8 time = 2050
* CHECK dout0_15 vdout0_15ck204 = 0 time = 2050
* CHECK dout0_16 vdout0_16ck204 = 1.8 time = 2050
* CHECK dout0_17 vdout0_17ck204 = 1.8 time = 2050
* CHECK dout0_18 vdout0_18ck204 = 0 time = 2050
* CHECK dout0_19 vdout0_19ck204 = 0 time = 2050
* CHECK dout0_20 vdout0_20ck204 = 1.8 time = 2050
* CHECK dout0_21 vdout0_21ck204 = 0 time = 2050
* CHECK dout0_22 vdout0_22ck204 = 1.8 time = 2050
* CHECK dout0_23 vdout0_23ck204 = 0 time = 2050
* CHECK dout0_24 vdout0_24ck204 = 1.8 time = 2050
* CHECK dout0_25 vdout0_25ck204 = 0 time = 2050
* CHECK dout0_26 vdout0_26ck204 = 0 time = 2050
* CHECK dout0_27 vdout0_27ck204 = 0 time = 2050
* CHECK dout0_28 vdout0_28ck204 = 1.8 time = 2050
* CHECK dout0_29 vdout0_29ck204 = 0 time = 2050
* CHECK dout0_30 vdout0_30ck204 = 1.8 time = 2050
* CHECK dout0_31 vdout0_31ck204 = 0 time = 2050
* CHECK dout0_32 vdout0_32ck204 = 1.8 time = 2050
* CHECK dout0_33 vdout0_33ck204 = 0 time = 2050
* CHECK dout0_34 vdout0_34ck204 = 1.8 time = 2050
* CHECK dout0_35 vdout0_35ck204 = 0 time = 2050
* CHECK dout0_36 vdout0_36ck204 = 1.8 time = 2050
* CHECK dout0_37 vdout0_37ck204 = 0 time = 2050
* CHECK dout0_38 vdout0_38ck204 = 0 time = 2050
* CHECK dout0_39 vdout0_39ck204 = 0 time = 2050
* CHECK dout0_40 vdout0_40ck204 = 0 time = 2050
* CHECK dout0_41 vdout0_41ck204 = 0 time = 2050
* CHECK dout0_42 vdout0_42ck204 = 0 time = 2050
* CHECK dout0_43 vdout0_43ck204 = 1.8 time = 2050
* CHECK dout0_44 vdout0_44ck204 = 0 time = 2050
* CHECK dout0_45 vdout0_45ck204 = 0 time = 2050
* CHECK dout0_46 vdout0_46ck204 = 1.8 time = 2050
* CHECK dout0_47 vdout0_47ck204 = 1.8 time = 2050
* CHECK dout0_48 vdout0_48ck204 = 0 time = 2050
* CHECK dout0_49 vdout0_49ck204 = 0 time = 2050
* CHECK dout0_50 vdout0_50ck204 = 1.8 time = 2050
* CHECK dout0_51 vdout0_51ck204 = 1.8 time = 2050
* CHECK dout0_52 vdout0_52ck204 = 0 time = 2050
* CHECK dout0_53 vdout0_53ck204 = 0 time = 2050
* CHECK dout0_54 vdout0_54ck204 = 1.8 time = 2050
* CHECK dout0_55 vdout0_55ck204 = 1.8 time = 2050
* CHECK dout0_56 vdout0_56ck204 = 0 time = 2050
* CHECK dout0_57 vdout0_57ck204 = 0 time = 2050
* CHECK dout0_58 vdout0_58ck204 = 1.8 time = 2050
* CHECK dout0_59 vdout0_59ck204 = 0 time = 2050
* CHECK dout0_60 vdout0_60ck204 = 1.8 time = 2050
* CHECK dout0_61 vdout0_61ck204 = 1.8 time = 2050
* CHECK dout0_62 vdout0_62ck204 = 1.8 time = 2050
* CHECK dout0_63 vdout0_63ck204 = 1.8 time = 2050
* CHECK dout1_0 vdout1_0ck204 = 0 time = 2050
* CHECK dout1_1 vdout1_1ck204 = 1.8 time = 2050
* CHECK dout1_2 vdout1_2ck204 = 0 time = 2050
* CHECK dout1_3 vdout1_3ck204 = 0 time = 2050
* CHECK dout1_4 vdout1_4ck204 = 0 time = 2050
* CHECK dout1_5 vdout1_5ck204 = 1.8 time = 2050
* CHECK dout1_6 vdout1_6ck204 = 0 time = 2050
* CHECK dout1_7 vdout1_7ck204 = 1.8 time = 2050
* CHECK dout1_8 vdout1_8ck204 = 1.8 time = 2050
* CHECK dout1_9 vdout1_9ck204 = 0 time = 2050
* CHECK dout1_10 vdout1_10ck204 = 1.8 time = 2050
* CHECK dout1_11 vdout1_11ck204 = 1.8 time = 2050
* CHECK dout1_12 vdout1_12ck204 = 1.8 time = 2050
* CHECK dout1_13 vdout1_13ck204 = 0 time = 2050
* CHECK dout1_14 vdout1_14ck204 = 0 time = 2050
* CHECK dout1_15 vdout1_15ck204 = 1.8 time = 2050
* CHECK dout1_16 vdout1_16ck204 = 1.8 time = 2050
* CHECK dout1_17 vdout1_17ck204 = 1.8 time = 2050
* CHECK dout1_18 vdout1_18ck204 = 0 time = 2050
* CHECK dout1_19 vdout1_19ck204 = 1.8 time = 2050
* CHECK dout1_20 vdout1_20ck204 = 1.8 time = 2050
* CHECK dout1_21 vdout1_21ck204 = 1.8 time = 2050
* CHECK dout1_22 vdout1_22ck204 = 0 time = 2050
* CHECK dout1_23 vdout1_23ck204 = 1.8 time = 2050
* CHECK dout1_24 vdout1_24ck204 = 0 time = 2050
* CHECK dout1_25 vdout1_25ck204 = 1.8 time = 2050
* CHECK dout1_26 vdout1_26ck204 = 0 time = 2050
* CHECK dout1_27 vdout1_27ck204 = 1.8 time = 2050
* CHECK dout1_28 vdout1_28ck204 = 0 time = 2050
* CHECK dout1_29 vdout1_29ck204 = 0 time = 2050
* CHECK dout1_30 vdout1_30ck204 = 0 time = 2050
* CHECK dout1_31 vdout1_31ck204 = 0 time = 2050
* CHECK dout1_32 vdout1_32ck204 = 0 time = 2050
* CHECK dout1_33 vdout1_33ck204 = 0 time = 2050
* CHECK dout1_34 vdout1_34ck204 = 1.8 time = 2050
* CHECK dout1_35 vdout1_35ck204 = 0 time = 2050
* CHECK dout1_36 vdout1_36ck204 = 0 time = 2050
* CHECK dout1_37 vdout1_37ck204 = 1.8 time = 2050
* CHECK dout1_38 vdout1_38ck204 = 1.8 time = 2050
* CHECK dout1_39 vdout1_39ck204 = 0 time = 2050
* CHECK dout1_40 vdout1_40ck204 = 0 time = 2050
* CHECK dout1_41 vdout1_41ck204 = 1.8 time = 2050
* CHECK dout1_42 vdout1_42ck204 = 1.8 time = 2050
* CHECK dout1_43 vdout1_43ck204 = 0 time = 2050
* CHECK dout1_44 vdout1_44ck204 = 0 time = 2050
* CHECK dout1_45 vdout1_45ck204 = 0 time = 2050
* CHECK dout1_46 vdout1_46ck204 = 1.8 time = 2050
* CHECK dout1_47 vdout1_47ck204 = 0 time = 2050
* CHECK dout1_48 vdout1_48ck204 = 1.8 time = 2050
* CHECK dout1_49 vdout1_49ck204 = 1.8 time = 2050
* CHECK dout1_50 vdout1_50ck204 = 1.8 time = 2050
* CHECK dout1_51 vdout1_51ck204 = 1.8 time = 2050
* CHECK dout1_52 vdout1_52ck204 = 1.8 time = 2050
* CHECK dout1_53 vdout1_53ck204 = 1.8 time = 2050
* CHECK dout1_54 vdout1_54ck204 = 0 time = 2050
* CHECK dout1_55 vdout1_55ck204 = 1.8 time = 2050
* CHECK dout1_56 vdout1_56ck204 = 0 time = 2050
* CHECK dout1_57 vdout1_57ck204 = 1.8 time = 2050
* CHECK dout1_58 vdout1_58ck204 = 0 time = 2050
* CHECK dout1_59 vdout1_59ck204 = 1.8 time = 2050
* CHECK dout1_60 vdout1_60ck204 = 1.8 time = 2050
* CHECK dout1_61 vdout1_61ck204 = 0 time = 2050
* CHECK dout1_62 vdout1_62ck204 = 0 time = 2050
* CHECK dout1_63 vdout1_63ck204 = 1.8 time = 2050
.include /home/lukas/Projects/neorv32-openram-sky130/openram/spiral_min/out/sram_1rw1r_64x64_wpr2/functional_meas.sp
* probe is used for hspice/xa, while plot is used in ngspice
.plot V(*)
.end
